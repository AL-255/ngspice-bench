* GF180 Post-PEX 16-bit Switched-Capacitor Sigma-Delta ADC (120 cycles, 37.5 us, unsaturated in-band sine)
.include "../pdk/gf180mcu/gf180mcuD/libs.tech/ngspice/design.ngspice"
.param sw_stat_global=0
.param sw_stat_mismatch=0
.lib "../pdk/gf180mcu/gf180mcuD/libs.tech/ngspice/sm141064.ngspice" typical
.lib "../pdk/gf180mcu/gf180mcuD/libs.tech/ngspice/sm141064.ngspice" res_typical
.lib "../pdk/gf180mcu/gf180mcuD/libs.tech/ngspice/sm141064.ngspice" mimcap_typical
.lib "../pdk/gf180mcu/gf180mcuD/libs.tech/ngspice/sm141064.ngspice" cap_mim
.lib "../pdk/gf180mcu/gf180mcuD/libs.tech/ngspice/sm141064.ngspice" moscap_typical
.include "../pdk/gf180mcu/gf180mcuD/libs.ref/gf180mcu_fd_sc_mcu7t5v0/spice/gf180mcu_fd_sc_mcu7t5v0.spice"
.subckt nfet_06v0_nvt_mm d g s b W=1.6u L=1.8u nf=1 ad=0.7p as=0.7p pd=2.5u ps=2.5u
.param sig = '0.0116 / sqrt((W*1e6) * (L*1e6))'
.param dvth = 'agauss(0, sig, 1) * sw_stat_mismatch'
Voff g gi dc {dvth}
XM0 d gi s b nfet_06v0_nvt W={W} L={L} nf={nf} ad={ad} as={as} pd={pd} ps={ps}
.ends nfet_06v0_nvt_mm
.temp 27
.options reltol=2.5e-3 abstol=1e-11 vntol=1e-5 method=gear maxord=2 itl4=100
.include "../circuits/sdm_16b_1v8_mim_cifb_split.spice"

Vvdd vdd 0 DC 1.8
Vvss vss 0 DC 0
Vvcm vcm 0 DC 0.9
Vclk clk 0 PULSE(0 1.8 2.50000e-08 1.0e-9 1.0e-9 1.50000e-07 3.12500e-07)
Vrst rst_int 0 PWL(0 1.8 1.10938e-06 1.8 1.11138e-06 0)
Ibias_s1 vdd ib_s1 10.625u
Ibias_s2 vdd ib_s2 8.750u
Ibias_vcm vdd ib_vcm 1.625u
Vinp vin_p 0 SIN(0.9 0.15000 26666.667 1.10938e-06)
Vinn vin_n 0 SIN(0.9 -0.15000 26666.667 1.10938e-06)

Xdut vin_p vin_n vcm clk rst_int ib_s1 ib_s2 ib_vcm dout_0 dout_1 dout_2 dout_3 dout_4 dout_5 dout_6 dout_7 dout_8 dout_9 dout_10 dout_11 dout_12 dout_13 dout_14 dout_15 dout_valid vdd vss sdm_adc_sdm_16b_1v8_mim_cifb_split

.save v(vin_p) v(vin_n) v(clk) v(xdut.phi1) v(xdut.phi2) v(xdut.dac_p) v(xdut.dac_n) v(xdut.vout1_p) v(xdut.vout1_n) v(xdut.vout2_p) v(xdut.vout2_n) v(xdut.pdm_bit) v(dout_0) v(dout_valid) i(Vvdd)
.control
tran 1.56250e-08 3.75000e-05 uic
rusage all
write sdm16_120cyc.raw v(vin_p) v(vin_n) v(clk) v(xdut.phi1) v(xdut.phi2) v(xdut.dac_p) v(xdut.dac_n) v(xdut.vout1_p) v(xdut.vout1_n) v(xdut.vout2_p) v(xdut.vout2_n) v(xdut.pdm_bit) v(dout_0) v(dout_valid) i(Vvdd)
quit
.endc
.end
