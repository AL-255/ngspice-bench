* GF180 Post-PEX 12-bit SAR ADC Coherent FFT Transient (16 cycles)
.include "../pdk/gf180mcu/gf180mcuD/libs.tech/ngspice/design.ngspice"
.param sw_stat_global=0
.param sw_stat_mismatch=0
.lib "../pdk/gf180mcu/gf180mcuD/libs.tech/ngspice/sm141064.ngspice" typical
.lib "../pdk/gf180mcu/gf180mcuD/libs.tech/ngspice/sm141064.ngspice" res_typical
.lib "../pdk/gf180mcu/gf180mcuD/libs.tech/ngspice/sm141064.ngspice" mimcap_typical
.lib "../pdk/gf180mcu/gf180mcuD/libs.tech/ngspice/sm141064.ngspice" cap_mim
.lib "../pdk/gf180mcu/gf180mcuD/libs.tech/ngspice/sm141064.ngspice" moscap_typical
.include "../pdk/gf180mcu/gf180mcuD/libs.ref/gf180mcu_fd_sc_mcu7t5v0/spice/gf180mcu_fd_sc_mcu7t5v0.spice"
.subckt nfet_06v0_nvt_mm d g s b W=1.6u L=1.8u nf=1 ad=0.7p as=0.7p pd=2.5u ps=2.5u
.param sig = '0.0116 / sqrt((W*1e6) * (L*1e6))'
.param dvth = 'agauss(0, sig, 1) * sw_stat_mismatch'
Voff g gi dc {dvth}
XM0 d gi s b nfet_06v0_nvt W={W} L={L} nf={nf} ad={ad} as={as} pd={pd} ps={ps}
.ends nfet_06v0_nvt_mm
.temp 27
.option method=gear gmin=1e-12 reltol=1e-3 abstol=5e-12 vntol=2e-5 itl4=150 cshunt=1.5e-16
.include "../circuits/sar_12b_1v8_mvote_mim.spice"

Vvdd vdd 0 1.8
Vvss vss 0 0
Vvcm vcm 0 0.9
Vphis phi_s 0 PWL(0 0 1.80000e-09 0 1.90000e-09 1.8000 2.79000e-08 1.8000 2.80000e-08 0 4.12400e-07 0 4.12500e-07 1.8000 4.40400e-07 1.8000 4.40500e-07 0 8.24900e-07 0 8.25000e-07 1.8000 8.52900e-07 1.8000 8.53000e-07 0 1.23740e-06 0 1.23750e-06 1.8000 1.26540e-06 1.8000 1.26550e-06 0 1.64990e-06 0 1.65000e-06 1.8000 1.67790e-06 1.8000 1.67800e-06 0 2.06240e-06 0 2.06250e-06 1.8000 2.09040e-06 1.8000 2.09050e-06 0 2.47490e-06 0 2.47500e-06 1.8000 2.50290e-06 1.8000 2.50300e-06 0 2.88740e-06 0 2.88750e-06 1.8000 2.91540e-06 1.8000 2.91550e-06 0 3.29990e-06 0 3.30000e-06 1.8000 3.32790e-06 1.8000 3.32800e-06 0 3.71240e-06 0 3.71250e-06 1.8000 3.74040e-06 1.8000 3.74050e-06 0 4.12490e-06 0 4.12500e-06 1.8000 4.15290e-06 1.8000 4.15300e-06 0 4.53740e-06 0 4.53750e-06 1.8000 4.56540e-06 1.8000 4.56550e-06 0 4.94990e-06 0 4.95000e-06 1.8000 4.97790e-06 1.8000 4.97800e-06 0 5.36240e-06 0 5.36250e-06 1.8000 5.39040e-06 1.8000 5.39050e-06 0 5.77490e-06 0 5.77500e-06 1.8000 5.80290e-06 1.8000 5.80300e-06 0 6.18740e-06 0 6.18750e-06 1.8000 6.21540e-06 1.8000 6.21550e-06 0 6.60000e-06 0)
Vvip vip 0 PWL(0 1.012203 1.00000e-10 1.012203 3.08000e-08 1.012203 4.12600e-07 1.641773 4.43300e-07 1.641773 8.25100e-07 1.355525 8.55800e-07 1.355525 1.23760e-06 0.506871 1.26830e-06 0.506871 1.65010e-06 0.143587 1.68080e-06 0.143587 2.06260e-06 0.714196 2.09330e-06 0.714196 2.47510e-06 1.514204 2.50580e-06 1.514204 2.88760e-06 1.555896 2.91830e-06 1.555896 3.30010e-06 0.787797 3.33080e-06 0.787797 3.71260e-06 0.158227 3.74330e-06 0.158227 4.12510e-06 0.444475 4.15580e-06 0.444475 4.53760e-06 1.293129 4.56830e-06 1.293129 4.95010e-06 1.656413 4.98080e-06 1.656413 5.36260e-06 1.085804 5.39330e-06 1.085804 5.77510e-06 0.285796 5.80580e-06 0.285796 6.18760e-06 0.244104 6.21830e-06 0.244104)
Vvin vin 0 PWL(0 0.787797 1.00000e-10 0.787797 3.08000e-08 0.787797 4.12600e-07 0.158227 4.43300e-07 0.158227 8.25100e-07 0.444475 8.55800e-07 0.444475 1.23760e-06 1.293129 1.26830e-06 1.293129 1.65010e-06 1.656413 1.68080e-06 1.656413 2.06260e-06 1.085804 2.09330e-06 1.085804 2.47510e-06 0.285796 2.50580e-06 0.285796 2.88760e-06 0.244104 2.91830e-06 0.244104 3.30010e-06 1.012203 3.33080e-06 1.012203 3.71260e-06 1.641773 3.74330e-06 1.641773 4.12510e-06 1.355525 4.15580e-06 1.355525 4.53760e-06 0.506871 4.56830e-06 0.506871 4.95010e-06 0.143587 4.98080e-06 0.143587 5.36260e-06 0.714196 5.39330e-06 0.714196 5.77510e-06 1.514204 5.80580e-06 1.514204 6.18760e-06 1.555896 6.21830e-06 1.555896)
Xdut vip vin vcm phi_s vdd vss comp_clk eoc bit_0 bit_1 bit_2 bit_3 bit_4 bit_5 bit_6 bit_7 bit_8 bit_9 bit_10 bit_11 bit_12 bit_13 bit_14 sar_adc_sar_12b_1v8_mvote_mim
Cmeta_cmp xdut.comp_outp 0 0.4f

.save v(phi_s) v(comp_clk) v(eoc) i(Vvdd) v(bit_0) v(bit_1) v(bit_2) v(bit_3) v(bit_4) v(bit_5) v(bit_6) v(bit_7) v(bit_8) v(bit_9) v(bit_10) v(bit_11) v(bit_12) v(bit_13) v(bit_14)
.control
tran 150p 6.60000e-06
rusage all
write sar12_hero_16cyc.raw v(phi_s) v(comp_clk) v(eoc) i(Vvdd) v(bit_0) v(bit_1) v(bit_2) v(bit_3) v(bit_4) v(bit_5) v(bit_6) v(bit_7) v(bit_8) v(bit_9) v(bit_10) v(bit_11) v(bit_12) v(bit_13) v(bit_14)
quit
.endc
.end
