* Accumulation-mode MOS varactor cap_nmos_03v3_b wrapper (exact in AC and TRAN)
.subckt aux_amos g w c_width=5e-6 c_length=2e-6 dtemp=0
Ex x 0 g w 1
Rs x y 10
Cs y 0 1p
Bq g w I = (v(x)-v(y))*1e11*(cap_nmos_03v3_b_corner*c_width*c_length)*(0.002458+0.001533*tanh(1.515152*v(g,w)+0.560606))
.ends aux_amos

* Post-PEX extracted netlist for cml_dco_idac_n3_1v8_1p2g
.subckt cml_dco_idac_n3_1v8_1p2g vdd vss out outn b0 b1 b2
X0 outn vss vdd vdd pfet_03v3 ad=0.972p pd=4.44u as=0.4536p ps=2.18u w=1.62u l=0.52u nf=1
X1 a_1242_900_h a_1898_10742_h outn vss nfet_03v3 ad=0.448p pd=2.16u as=0.448p ps=2.16u w=1.6u l=0.52u nf=1
X2 vss vdd a_1242_900_h vss nfet_03v3 ad=0.504p pd=2.88u as=0.2352p ps=1.4u w=0.84u l=1.34u nf=1
X3 a_1242_900_h b0 vss vss nfet_03v3 ad=0.2352p pd=1.4u as=0.2352p ps=1.4u w=0.84u l=1.34u nf=1
X4 a_1242_900_h b1 vss vss nfet_03v3 ad=0.2352p pd=1.4u as=0.2352p ps=1.4u w=0.84u l=1.34u nf=1
X5 vss b1 a_1242_900_h vss nfet_03v3 ad=0.2352p pd=1.4u as=0.2352p ps=1.4u w=0.84u l=1.34u nf=1
X6 a_1242_900_h b2 vss vss nfet_03v3 ad=0.2352p pd=1.4u as=0.2352p ps=1.4u w=0.84u l=1.34u nf=1
X7 vdd vss out vdd pfet_03v3 ad=0.4536p pd=2.18u as=0.972p ps=4.44u w=1.62u l=0.52u nf=1
X8 a_1242_900_h a_1562_6726_h a_1562_8948_h vss nfet_03v3 ad=0.448p pd=2.16u as=0.96p ps=4.4u w=1.6u l=0.52u nf=1
X9 outn a_1898_10742_h a_1242_900_h vss nfet_03v3 ad=0.448p pd=2.16u as=0.448p ps=2.16u w=1.6u l=0.52u nf=1
X10 a_1242_900_h b2 vss vss nfet_03v3 ad=0.2352p pd=1.4u as=0.504p ps=2.88u w=0.84u l=1.34u nf=1
X11 vdd vss a_1562_6726_h vdd pfet_03v3 ad=0.4536p pd=2.18u as=0.972p ps=4.44u w=1.62u l=0.52u nf=1
X12 vss vdd a_1242_900_h vss nfet_03v3 ad=0.2352p pd=1.4u as=0.2352p ps=1.4u w=0.84u l=1.34u nf=1
X13 a_1898_8520_h vss vdd vdd pfet_03v3 ad=0.972p pd=4.44u as=0.4536p ps=2.18u w=1.62u l=0.52u nf=1
X14 a_1242_900_h a_1562_8948_h out vss nfet_03v3 ad=0.448p pd=2.16u as=0.96p ps=4.4u w=1.6u l=0.52u nf=1
X15 a_1562_6726_h out a_1242_900_h vss nfet_03v3 ad=0.96p pd=4.4u as=0.448p ps=2.16u w=1.6u l=0.52u nf=1
X16 vss b2 a_1242_900_h vss nfet_03v3 ad=0.504p pd=2.88u as=0.2352p ps=1.4u w=0.84u l=1.34u nf=1
X17 out a_1562_8948_h a_1242_900_h vss nfet_03v3 ad=0.96p pd=4.4u as=0.448p ps=2.16u w=1.6u l=0.52u nf=1
X18 a_1898_8520_h outn a_1242_900_h vss nfet_03v3 ad=0.448p pd=2.16u as=0.448p ps=2.16u w=1.6u l=0.52u nf=1
X19 a_1242_900_h outn a_1898_8520_h vss nfet_03v3 ad=0.448p pd=2.16u as=0.448p ps=2.16u w=1.6u l=0.52u nf=1
X20 a_1898_10742_h vss vdd vdd pfet_03v3 ad=0.972p pd=4.44u as=0.4536p ps=2.18u w=1.62u l=0.52u nf=1
X21 vss b2 a_1242_900_h vss nfet_03v3 ad=0.2352p pd=1.4u as=0.2352p ps=1.4u w=0.84u l=1.34u nf=1
X22 a_1242_900_h vdd vss vss nfet_03v3 ad=0.2352p pd=1.4u as=0.504p ps=2.88u w=0.84u l=1.34u nf=1
X23 vdd vss a_1562_8948_h vdd pfet_03v3 ad=0.4536p pd=2.18u as=0.972p ps=4.44u w=1.62u l=0.52u nf=1
X24 a_1562_8948_h a_1562_6726_h a_1242_900_h vss nfet_03v3 ad=0.96p pd=4.4u as=0.448p ps=2.16u w=1.6u l=0.52u nf=1
X25 a_1242_900_h out a_1562_6726_h vss nfet_03v3 ad=0.448p pd=2.16u as=0.96p ps=4.4u w=1.6u l=0.52u nf=1
X26 a_1898_10742_h a_1898_8520_h a_1242_900_h vss nfet_03v3 ad=0.448p pd=2.16u as=0.448p ps=2.16u w=1.6u l=0.52u nf=1
X27 a_1242_900_h a_1898_8520_h a_1898_10742_h vss nfet_03v3 ad=0.448p pd=2.16u as=0.448p ps=2.16u w=1.6u l=0.52u nf=1
C0 a_1898_10742_h a_1242_900_h 0.75076f
C1 out a_1562_6726_h 0.14623f
C2 a_1242_900_h a_1898_8520_h 2.03605f
C3 a_1242_900_h b2 0.41736f
C4 vdd outn 2.70028f
C5 a_1242_900_h a_1562_8948_h 1.91245f
C6 b1 b2 1.05676f
C7 vdd a_1898_10742_h 1.82441f
C8 vdd a_1898_8520_h 1.80463f
C9 a_1242_900_h a_1562_6726_h 1.39552f
C10 a_1898_10742_h outn 1.57837f
C11 outn a_1898_8520_h 0.09498f
C12 vdd a_1562_8948_h 3.13543f
C13 a_1898_10742_h a_1898_8520_h 0.08651f
C14 vdd a_1562_6726_h 1.43901f
C15 outn a_1562_8948_h 0.04274f
C16 a_1898_10742_h a_1562_8948_h 1.38318f
C17 outn a_1562_6726_h 1.35817f
C18 a_1242_900_h out 4.05495f
C19 a_1898_10742_h a_1562_6726_h 0.07091f
C20 a_1562_6726_h a_1898_8520_h 1.35427f
C21 a_1242_900_h b0 0.09588f
C22 a_1562_6726_h a_1562_8948_h 0.13988f
C23 vdd out 1.94744f
C24 b1 a_1242_900_h 0.09671f
C25 vdd b0 0.79833f
C26 out outn 1.38091f
C27 a_1898_10742_h out 0.01227f
C28 out a_1898_8520_h 0.411f
C29 vdd a_1242_900_h 1.38754f
C30 out a_1562_8948_h 0.22634f
C31 a_1242_900_h outn 0.75634f
C32 b1 vss 3.26894f
C33 b2 vss 3.00863f
C34 b0 vss 1.99728f
C35 outn vss 4.85292f
C36 out vss 5.26141f
C37 vdd vss 30.6218f
C38 a_1898_8520_h vss 4.39954f
C39 a_1562_6726_h vss 4.24344f
C40 a_1242_900_h vss 11.7695f
C41 a_1898_10742_h vss 4.43259f
C42 a_1562_8948_h vss 5.06313f
.ends cml_dco_idac_n3_1v8_1p2g

* Post-PEX extracted netlist for div_cml_div2_1v8_1p5g
.subckt div_cml_div2_1v8_1p5g vdd vss clk clkb out outb ibias
X0 a_3299_8489_h clk a_3312_13236_h vdd pfet_03v3 ad=2.25p pd=7.5u as=1.29p ps=3.86u w=3u l=0.28u nf=1
X1 ibias clkb vdd vdd pfet_03v3 ad=2.25p pd=7.5u as=1.29p ps=3.86u w=3u l=0.28u nf=1
X2 a_3312_13236_h outb vdd vdd pfet_03v3 ad=1.29p pd=3.86u as=2.25p ps=7.5u w=3u l=0.28u nf=1
X3 a_2898_10844_h clk vss vss nfet_03v3 ad=0.7095p pd=2.51u as=1.2375p ps=4.8u w=1.65u l=0.28u nf=1
X4 outb a_2994_3466_h vdd vdd pfet_03v3 ad=1.806p pd=5.06u as=1.806p ps=5.06u w=4.2u l=0.28u nf=1
X5 vss clk a_2898_10844_h vss nfet_03v3 ad=1.2375p pd=4.8u as=0.7095p ps=2.51u w=1.65u l=0.28u nf=1
X6 ibias vss vss ppolyf_u_1k r_width=2u r_length=2.16u
X7 a_3097_6337_h clk outb vss nfet_03v3 ad=1.2375p pd=4.8u as=0.7095p ps=2.51u w=1.65u l=0.28u nf=1
X8 vdd ibias vss ppolyf_u_1k r_width=2u r_length=2.16u
X9 outb clk a_3097_6337_h vss nfet_03v3 ad=1.2375p pd=4.8u as=1.2375p ps=4.8u w=1.65u l=0.28u nf=1
X10 vdd clk a_2994_3466_h vdd pfet_03v3 ad=1.806p pd=5.06u as=3.15p ps=9.9u w=4.2u l=0.28u nf=1
X11 a_2898_10844_h clk vss vss nfet_03v3 ad=1.2375p pd=4.8u as=1.2375p ps=4.8u w=1.65u l=0.28u nf=1
X12 vdd a_2994_3466_h outb vdd pfet_03v3 ad=1.806p pd=5.06u as=1.806p ps=5.06u w=4.2u l=0.28u nf=1
X13 a_3312_13236_h outb vdd vdd pfet_03v3 ad=1.29p pd=3.86u as=1.29p ps=3.86u w=3u l=0.28u nf=1
X14 clkb vss vss ppolyf_u_1k r_width=2u r_length=2.16u
X15 outb a_2994_3466_h vdd vdd pfet_03v3 ad=1.806p pd=5.06u as=1.806p ps=5.06u w=4.2u l=0.28u nf=1
X16 vdd outb a_3312_13236_h vdd pfet_03v3 ad=1.29p pd=3.86u as=1.29p ps=3.86u w=3u l=0.28u nf=1
X17 outb clk a_3097_6337_h vss nfet_03v3 ad=0.7095p pd=2.51u as=1.2375p ps=4.8u w=1.65u l=0.28u nf=1
X18 a_3299_8489_h outb vss vss nfet_03v3 ad=0.9p pd=3.9u as=0.9p ps=3.9u w=1.2u l=0.28u nf=1
X19 a_2994_3466_h clk vdd vdd pfet_03v3 ad=3.15p pd=9.9u as=3.15p ps=9.9u w=4.2u l=0.28u nf=1
X20 vss a_2994_3466_h a_3097_6337_h vss nfet_03v3 ad=0.7095p pd=2.51u as=0.7095p ps=2.51u w=1.65u l=0.28u nf=1
X21 a_2994_3466_h a_3299_8489_h a_2898_10844_h vss nfet_03v3 ad=0.516p pd=2.06u as=0.9p ps=3.9u w=1.2u l=0.28u nf=1
X22 vdd a_2994_3466_h outb vdd pfet_03v3 ad=1.806p pd=5.06u as=1.806p ps=5.06u w=4.2u l=0.28u nf=1
X23 clkb ibias vss ppolyf_u_1k r_width=2u r_length=2.16u
X24 a_2898_10844_h a_3299_8489_h a_2994_3466_h vss nfet_03v3 ad=0.9p pd=3.9u as=0.516p ps=2.06u w=1.2u l=0.28u nf=1
X25 a_3097_6337_h a_2994_3466_h vss vss nfet_03v3 ad=0.7095p pd=2.51u as=1.2375p ps=4.8u w=1.65u l=0.28u nf=1
X26 out outb vss vss nfet_03v3 ad=1.2375p pd=4.8u as=0.7095p ps=2.51u w=1.65u l=0.28u nf=1
X27 outb a_2994_3466_h vdd vdd pfet_03v3 ad=3.15p pd=9.9u as=1.806p ps=5.06u w=4.2u l=0.28u nf=1
X28 a_2994_3466_h a_3299_8489_h a_2898_10844_h vss nfet_03v3 ad=0.9p pd=3.9u as=0.9p ps=3.9u w=1.2u l=0.28u nf=1
X29 vdd outb out vdd pfet_03v3 ad=1.29p pd=3.86u as=2.25p ps=7.5u w=3u l=0.28u nf=1
X30 a_3299_8489_h clk a_3312_13236_h vdd pfet_03v3 ad=1.29p pd=3.86u as=1.29p ps=3.86u w=3u l=0.28u nf=1
X31 a_3312_13236_h clk a_3299_8489_h vdd pfet_03v3 ad=1.29p pd=3.86u as=1.29p ps=3.86u w=3u l=0.28u nf=1
X32 a_3097_6337_h a_2994_3466_h vss vss nfet_03v3 ad=1.2375p pd=4.8u as=1.2375p ps=4.8u w=1.65u l=0.28u nf=1
C0 a_2898_10844_h vdd 1.19603f
C1 a_2994_3466_h outb 3.28047f
C2 a_2994_3466_h a_3299_8489_h 1.03543f
C3 clk a_3097_6337_h 1.0236f
C4 a_3312_13236_h outb 0.22677f
C5 out a_2994_3466_h 0.10619f
C6 a_2994_3466_h vdd 8.84069f
C7 a_3312_13236_h a_3299_8489_h 2.27149f
C8 vdd a_3312_13236_h 2.92231f
C9 outb a_3299_8489_h 0.88474f
C10 clkb ibias 0.22073f
C11 out outb 0.31387f
C12 vdd outb 9.21346f
C13 vdd a_3299_8489_h 1.99967f
C14 out vdd 2.65747f
C15 a_2898_10844_h a_3097_6337_h 1.69208f
C16 clk a_2898_10844_h 2.08152f
C17 a_3097_6337_h a_2994_3466_h 0.93442f
C18 clk a_2994_3466_h 1.36612f
C19 clkb outb 1.46789f
C20 clk a_3312_13236_h 0.10497f
C21 a_3097_6337_h outb 2.09206f
C22 a_3097_6337_h a_3299_8489_h 0.54919f
C23 out clkb 0.01389f
C24 clkb vdd 1.29559f
C25 out a_3097_6337_h 0.69661f
C26 a_3097_6337_h vdd 0.01841f
C27 clk outb 4.56711f
C28 clk a_3299_8489_h 0.41188f
C29 clk vdd 4.15697f
C30 a_2898_10844_h a_2994_3466_h 0.8448f
C31 ibias outb 0.04033f
C32 out ibias 1.27367f
C33 ibias vdd 2.72909f
C34 a_2898_10844_h outb 1.98385f
C35 a_2898_10844_h a_3299_8489_h 1.86761f
C36 ibias vss 3.75977f
C37 clkb vss 4.18238f
C38 out vss 3.8767f
C39 clk vss 5.89231f
C40 outb vss 11.4316f
C41 vdd vss 49.7144f
C42 a_2994_3466_h vss 7.06316f
C43 a_3097_6337_h vss 6.11731f
C44 a_2898_10844_h vss 5.26236f
C45 a_3299_8489_h vss 5.32592f
C46 a_3312_13236_h vss 0.21554f
.ends div_cml_div2_1v8_1p5g

* Post-PEX extracted netlist for bm_lv_cascode_1v8_10u
.subckt bm_lv_cascode_1v8_10u vdd vss iout vbias b0 b1 b2
X0 iout vbias a_854_2667_h vdd pfet_03v3 ad=2.408p pd=6.46u as=2.408p ps=6.46u w=5.6u l=0.28u nf=1
X1 vss vbias vbias vss nfet_03v3 ad=2.88p pd=10.8u as=1.344p ps=5.36u w=4.8u l=0.66u nf=1
X2 vdd a_974_472_h a_854_2667_h vdd pfet_03v3 ad=0.912p pd=4.24u as=0.4256p ps=2.08u w=1.52u l=1u nf=1
X3 vbias a_974_472_h vdd vdd pfet_03v3 ad=0.84p pd=4u as=0.392p ps=1.96u w=1.4u l=1.6u nf=1
X4 b1 a_974_472_h a_854_2667_h vdd pfet_03v3 ad=0.4256p pd=2.08u as=0.4256p ps=2.08u w=1.52u l=1u nf=1
X5 iout vbias a_854_2667_h vdd pfet_03v3 ad=2.408p pd=6.46u as=2.408p ps=6.46u w=5.6u l=0.28u nf=1
X6 a_974_472_h vbias a_6484_2707_h vss nfet_03v3 ad=1.344p pd=5.36u as=1.344p ps=5.36u w=4.8u l=0.66u nf=1
X7 vdd a_974_472_h a_854_2667_h vdd pfet_03v3 ad=0.4256p pd=2.08u as=0.4256p ps=2.08u w=1.52u l=1u nf=1
X8 b2 a_974_472_h a_854_2667_h vdd pfet_03v3 ad=0.4256p pd=2.08u as=0.912p ps=4.24u w=1.52u l=1u nf=1
X9 a_6484_2707_h vbias a_974_472_h vss nfet_03v3 ad=1.344p pd=5.36u as=1.344p ps=5.36u w=4.8u l=0.66u nf=1
X10 vdd a_974_472_h vbias vdd pfet_03v3 ad=0.392p pd=1.96u as=0.84p ps=4u w=1.4u l=1.6u nf=1
X11 a_854_2667_h a_974_472_h b0 vdd pfet_03v3 ad=0.4256p pd=2.08u as=0.912p ps=4.24u w=1.52u l=1u nf=1
X12 a_854_2667_h vbias iout vdd pfet_03v3 ad=2.408p pd=6.46u as=2.408p ps=6.46u w=5.6u l=0.28u nf=1
X13 a_854_2667_h vbias iout vdd pfet_03v3 ad=2.408p pd=6.46u as=2.408p ps=6.46u w=5.6u l=0.28u nf=1
X14 a_974_472_h vbias a_6484_2707_h vss nfet_03v3 ad=1.344p pd=5.36u as=2.88p ps=10.8u w=4.8u l=0.66u nf=1
X15 a_974_472_h vbias a_6484_2707_h vss nfet_03v3 ad=1.344p pd=5.36u as=2.88p ps=10.8u w=4.8u l=0.66u nf=1
X16 a_974_472_h a_974_472_h vdd vdd pfet_03v3 ad=0.392p pd=1.96u as=0.392p ps=1.96u w=1.4u l=1.6u nf=1
X17 b2 a_974_472_h a_854_2667_h vdd pfet_03v3 ad=0.4256p pd=2.08u as=0.4256p ps=2.08u w=1.52u l=1u nf=1
X18 iout vbias a_854_2667_h vdd pfet_03v3 ad=2.408p pd=6.46u as=2.408p ps=6.46u w=5.6u l=0.28u nf=1
X19 a_854_2667_h a_974_472_h vdd vdd pfet_03v3 ad=0.912p pd=4.24u as=0.4256p ps=2.08u w=1.52u l=1u nf=1
X20 a_974_472_h vbias a_6484_2707_h vss nfet_03v3 ad=1.344p pd=5.36u as=1.344p ps=5.36u w=4.8u l=0.66u nf=1
X21 a_854_2667_h vbias iout vdd pfet_03v3 ad=2.408p pd=6.46u as=2.408p ps=6.46u w=5.6u l=0.28u nf=1
X22 a_854_2667_h vbias iout vdd pfet_03v3 ad=4.2p pd=12.7u as=2.408p ps=6.46u w=5.6u l=0.28u nf=1
X23 a_6484_2707_h vbias a_974_472_h vss nfet_03v3 ad=1.344p pd=5.36u as=1.344p ps=5.36u w=4.8u l=0.66u nf=1
X24 vss a_9598_5319_h vss ppolyf_u_1k r_width=1u r_length=13.38u
X25 a_6484_2707_h vbias a_974_472_h vss nfet_03v3 ad=2.88p pd=10.8u as=1.344p ps=5.36u w=4.8u l=0.66u nf=1
X26 a_854_2667_h a_974_472_h b2 vdd pfet_03v3 ad=0.4256p pd=2.08u as=0.4256p ps=2.08u w=1.52u l=1u nf=1
X27 a_6484_2707_h vbias a_974_472_h vss nfet_03v3 ad=1.344p pd=5.36u as=1.344p ps=5.36u w=4.8u l=0.66u nf=1
X28 vbias vbias vss vss nfet_03v3 ad=2.88p pd=10.8u as=2.88p ps=10.8u w=4.8u l=0.66u nf=1
X29 iout vbias a_854_2667_h vdd pfet_03v3 ad=2.408p pd=6.46u as=2.408p ps=6.46u w=5.6u l=0.28u nf=1
X30 vdd a_974_472_h a_974_472_h vdd pfet_03v3 ad=0.392p pd=1.96u as=0.392p ps=1.96u w=1.4u l=1.6u nf=1
X31 vbias vbias vss vss nfet_03v3 ad=1.344p pd=5.36u as=2.88p ps=10.8u w=4.8u l=0.66u nf=1
X32 a_6484_2707_h a_9598_5319_h vss ppolyf_u_1k r_width=1u r_length=13.38u
X33 iout vbias a_854_2667_h vdd pfet_03v3 ad=2.408p pd=6.46u as=4.2p ps=12.7u w=5.6u l=0.28u nf=1
X34 iout vbias a_854_2667_h vdd pfet_03v3 ad=2.408p pd=6.46u as=2.408p ps=6.46u w=5.6u l=0.28u nf=1
X35 a_974_472_h vbias a_6484_2707_h vss nfet_03v3 ad=2.88p pd=10.8u as=1.344p ps=5.36u w=4.8u l=0.66u nf=1
X36 a_854_2667_h a_974_472_h vdd vdd pfet_03v3 ad=0.4256p pd=2.08u as=0.912p ps=4.24u w=1.52u l=1u nf=1
X37 a_854_2667_h a_974_472_h b2 vdd pfet_03v3 ad=0.912p pd=4.24u as=0.4256p ps=2.08u w=1.52u l=1u nf=1
X38 a_854_2667_h vbias iout vdd pfet_03v3 ad=2.408p pd=6.46u as=2.408p ps=6.46u w=5.6u l=0.28u nf=1
X39 a_854_2667_h vbias iout vdd pfet_03v3 ad=2.408p pd=6.46u as=2.408p ps=6.46u w=5.6u l=0.28u nf=1
X40 a_854_2667_h a_974_472_h b1 vdd pfet_03v3 ad=0.4256p pd=2.08u as=0.4256p ps=2.08u w=1.52u l=1u nf=1
X41 vbias a_974_472_h vdd vdd pfet_03v3 ad=0.504p pd=2.88u as=0.504p ps=2.88u w=0.84u l=3.4u nf=1
C0 a_974_472_h vdd 19.2674f
C1 vdd b1 0.45505f
C2 vdd a_6484_2707_h 0.01736f
C3 a_974_472_h b1 0.20444f
C4 a_974_472_h a_6484_2707_h 6.99614f
C5 a_9598_5319_h a_6484_2707_h 0.01186f
C6 a_854_2667_h b2 1.09269f
C7 vbias a_854_2667_h 1.36851f
C8 a_854_2667_h b0 1.21698f
C9 vbias b0 0.0184f
C10 iout a_854_2667_h 11.2524f
C11 vbias iout 1.30295f
C12 vdd b2 0.37292f
C13 a_974_472_h b2 0.5849f
C14 a_854_2667_h vdd 7.51809f
C15 vbias vdd 12.1782f
C16 b0 vdd 1.75684f
C17 a_974_472_h a_854_2667_h 2.30602f
C18 b2 b1 0.9726f
C19 vbias a_974_472_h 6.02626f
C20 a_974_472_h b0 0.10984f
C21 iout vdd 2.51757f
C22 a_974_472_h iout 0.07476f
C23 a_854_2667_h b1 1.45164f
C24 vbias a_6484_2707_h 3.72502f
C25 b0 vss 0.12912f
C26 iout vss 0.15263f
C27 vbias vss 12.7547f
C28 b1 vss 0.15507f
C29 b2 vss 0.10548f
C30 vdd vss 70.9425f
C31 a_6484_2707_h vss 6.8978f
C32 a_9598_5319_h vss 0.69602f
C33 a_854_2667_h vss 1.50807f
C34 a_974_472_h vss 10.9314f
.ends bm_lv_cascode_1v8_10u

* Post-PEX extracted netlist for cm_cascode_1v8_8u
.subckt cm_cascode_1v8_8u vdd vss iref iout
X0 iout iref a_1906_5666_h vss nfet_03v3 ad=1.372p pd=5.46u as=2.94p ps=11u w=4.9u l=1.2u nf=1
X1 iref iref a_926_5666_h vss nfet_03v3 ad=1.372p pd=5.46u as=2.94p ps=11u w=4.9u l=1.2u nf=1
X2 a_926_5666_h a_926_5666_h vss vss nfet_03v3 ad=1.568p pd=6.16u as=3.36p ps=12.4u w=5.6u l=1.6u nf=1
X3 a_1906_5666_h iref iout vss nfet_03v3 ad=2.94p pd=11u as=1.372p ps=5.46u w=4.9u l=1.2u nf=1
X4 vss a_926_5666_h a_926_5666_h vss nfet_03v3 ad=3.36p pd=12.4u as=1.568p ps=6.16u w=5.6u l=1.6u nf=1
X5 vss a_926_5666_h a_1906_5666_h vss nfet_03v3 ad=1.568p pd=6.16u as=1.568p ps=6.16u w=5.6u l=1.6u nf=1
X6 a_1906_5666_h iref iout vss nfet_03v3 ad=1.372p pd=5.46u as=1.372p ps=5.46u w=4.9u l=1.2u nf=1
X7 a_1906_5666_h a_926_5666_h vss vss nfet_03v3 ad=1.568p pd=6.16u as=1.568p ps=6.16u w=5.6u l=1.6u nf=1
X8 a_926_5666_h a_926_5666_h vss vss nfet_03v3 ad=1.568p pd=6.16u as=1.568p ps=6.16u w=5.6u l=1.6u nf=1
X9 iref iref a_926_5666_h vss nfet_03v3 ad=1.372p pd=5.46u as=2.94p ps=11u w=4.9u l=1.2u nf=1
X10 iout iref a_1906_5666_h vss nfet_03v3 ad=1.372p pd=5.46u as=1.372p ps=5.46u w=4.9u l=1.2u nf=1
X11 vss a_926_5666_h a_926_5666_h vss nfet_03v3 ad=1.568p pd=6.16u as=1.568p ps=6.16u w=5.6u l=1.6u nf=1
X12 a_926_5666_h iref iref vss nfet_03v3 ad=2.94p pd=11u as=1.372p ps=5.46u w=4.9u l=1.2u nf=1
X13 vdd vss vss vss nfet_03v3 ad=2.94p pd=11u as=2.94p ps=11u w=4.9u l=1.2u nf=1
X14 a_926_5666_h iref iref vss nfet_03v3 ad=2.94p pd=11u as=1.372p ps=5.46u w=4.9u l=1.2u nf=1
X15 vss a_926_5666_h a_1906_5666_h vss nfet_03v3 ad=1.568p pd=6.16u as=1.568p ps=6.16u w=5.6u l=1.6u nf=1
X16 a_1906_5666_h a_926_5666_h vss vss nfet_03v3 ad=1.568p pd=6.16u as=1.568p ps=6.16u w=5.6u l=1.6u nf=1
C0 a_926_5666_h iout 0.1577f
C1 a_1906_5666_h iref 2.61166f
C2 iout iref 2.51631f
C3 a_926_5666_h iref 3.17272f
C4 a_1906_5666_h iout 1.73898f
C5 a_926_5666_h a_1906_5666_h 5.63225f
C6 vdd vss 2.71403f
C7 iout vss 2.50568f
C8 iref vss 8.00664f
C9 a_1906_5666_h vss 5.87166f
C10 a_926_5666_h vss 18.4599f
.ends cm_cascode_1v8_8u

* Post-PEX extracted netlist for tcap_var_sw_cap_gnd_1v8_1p6p
.subckt tcap_var_sw_cap_gnd_1v8_1p6p vdd vss port b0 b1 b2
X0 port b2 a_484_286_h vss nfet_03v3 ad=1.29p pd=3.86u as=2.25p ps=7.5u w=3u l=0.28u nf=1
X1 vdd b0 a_612_5652_h vdd pfet_03v3 ad=0.28p pd=1.56u as=0.6p ps=3.2u w=1u l=2u nf=1
X2 a_3410_6267_h vss aux_amos c_width=11.07u c_length=5.54u
X3 a_484_286_h b2 vdd vdd pfet_03v3 ad=0.6p pd=3.2u as=0.6p ps=3.2u w=1u l=2u nf=1
X4 a_484_286_h b2 port vss nfet_03v3 ad=1.29p pd=3.86u as=1.29p ps=3.86u w=3u l=0.28u nf=1
X5 a_484_286_h b2 port vss nfet_03v3 ad=2.25p pd=7.5u as=1.29p ps=3.86u w=3u l=0.28u nf=1
X6 a_484_286_h vss aux_amos c_width=12.78u c_length=6.39u
X7 port b2 a_484_286_h vss nfet_03v3 ad=1.29p pd=3.86u as=1.29p ps=3.86u w=3u l=0.28u nf=1
X8 a_3410_6267_h vss aux_amos c_width=11.07u c_length=5.54u
X9 a_484_286_h vss aux_amos c_width=12.78u c_length=6.39u
X10 a_612_5652_h vss aux_amos c_width=11.07u c_length=5.54u
X11 a_3410_6267_h b1 vdd vdd pfet_03v3 ad=0.6p pd=3.2u as=0.28p ps=1.56u w=1u l=2u nf=1
X12 a_484_286_h vss aux_amos c_width=12.78u c_length=6.39u
X13 a_612_5652_h b0 port vss nfet_03v3 ad=2.25p pd=7.5u as=1.29p ps=3.86u w=3u l=0.28u nf=1
X14 port b1 a_3410_6267_h vss nfet_03v3 ad=2.25p pd=7.5u as=2.25p ps=7.5u w=3u l=0.28u nf=1
X15 port b1 a_3410_6267_h vss nfet_03v3 ad=1.29p pd=3.86u as=2.25p ps=7.5u w=3u l=0.28u nf=1
C0 vdd b0 1.89145f
C1 b0 port 0.45601f
C2 a_484_286_h vdd 1.65409f
C3 a_484_286_h port 2.48583f
C4 b0 b1 1.32782f
C5 a_3410_6267_h vdd 1.51053f
C6 a_3410_6267_h port 1.09451f
C7 a_484_286_h b2 1.46659f
C8 vdd port 0.34766f
C9 vdd b2 1.55021f
C10 b0 a_612_5652_h 1.08249f
C11 port b2 0.31148f
C12 a_3410_6267_h b1 0.3041f
C13 vdd b1 3.1409f
C14 b1 port 0.75976f
C15 a_3410_6267_h a_612_5652_h 1.53911f
C16 vdd a_612_5652_h 1.48435f
C17 port a_612_5652_h 1.8763f
C18 b1 a_612_5652_h 0.45635f
C19 a_3410_6267_h b0 0.94505f
C20 b2 vss 2.55962f
C21 port vss 3.7939f
C22 b1 vss 1.41073f
C23 b0 vss 3.02505f
C24 vdd vss 16.2581f
C25 a_484_286_h vss 14.4466f
C26 a_3410_6267_h vss 10.0328f
C27 a_612_5652_h vss 5.00921f
.ends tcap_var_sw_cap_gnd_1v8_1p6p

* Post-PEX extracted netlist for dl_cmos_tap_1v8_1p0n
.subckt dl_cmos_tap_1v8_1p0n vdd vss in out tap1 tap2
X0 vss tap1 a_3207_5673_h vss nfet_03v3 ad=0.392p pd=1.96u as=0.84p ps=4u w=1.4u l=0.38u nf=1
X1 tap2 a_3207_5673_h vdd vdd pfet_03v3 ad=1.68p pd=6.8u as=0.784p ps=3.36u w=2.8u l=0.38u nf=1
X2 out tap1 vdd vdd pfet_03v3 ad=2.1p pd=7.1u as=2.1p ps=7.1u w=2.8u l=0.28u nf=1
X3 vss in a_3207_964_h vss nfet_03v3 ad=0.392p pd=1.96u as=0.84p ps=4u w=1.4u l=0.38u nf=1
X4 vdd in a_3207_964_h vdd pfet_03v3 ad=0.784p pd=3.36u as=1.68p ps=6.8u w=2.8u l=0.38u nf=1
X5 tap2 a_3207_5673_h vss vss nfet_03v3 ad=0.84p pd=4u as=0.392p ps=1.96u w=1.4u l=0.38u nf=1
X6 tap1 a_3207_964_h vss vss nfet_03v3 ad=0.84p pd=4u as=0.392p ps=1.96u w=1.4u l=0.38u nf=1
X7 tap1 a_3207_964_h vdd vdd pfet_03v3 ad=1.68p pd=6.8u as=0.784p ps=3.36u w=2.8u l=0.38u nf=1
X8 vss a_3207_964_h cap_mim_2f0fF c_width=5.37u c_length=5.37u
X9 vdd tap1 a_3207_5673_h vdd pfet_03v3 ad=0.784p pd=3.36u as=1.68p ps=6.8u w=2.8u l=0.38u nf=1
X10 out tap1 vss vss nfet_03v3 ad=1.05p pd=4.3u as=1.05p ps=4.3u w=1.4u l=0.28u nf=1
C0 in a_3207_964_h 1.90876f
C1 vdd tap2 1.82939f
C2 out tap1 0.21579f
C3 vdd tap1 4.19518f
C4 vdd a_3207_5673_h 2.69521f
C5 vdd in 0.67107f
C6 tap2 tap1 0.43402f
C7 tap2 a_3207_5673_h 0.75269f
C8 vdd a_3207_964_h 2.74561f
C9 tap1 a_3207_5673_h 1.87131f
C10 in tap1 0.08109f
C11 vdd out 1.74763f
C12 a_3207_964_h tap1 0.79518f
C13 in vss 1.94961f
C14 out vss 2.20953f
C15 tap2 vss 2.70603f
C16 tap1 vss 9.49319f
C17 vdd vss 24.6448f
C18 a_3207_964_h vss 6.05265f
C19 a_3207_5673_h vss 3.82781f
.ends dl_cmos_tap_1v8_1p0n

* Post-PEX R+C extracted netlist for nmos__1p8v__10u_100u
.subckt nmos__1p8v__10u_100u in out ck vdd vss
X0 ck_g__t2 ckb vss__t4 vss__t3 nfet_03v3 ad=0.75p pd=3.5u as=0.75p ps=3.5u w=1u l=0.28u nf=1
X1 ck_g__t3 ckb__t5 vdd__t7 vdd__t6 pfet_03v3 ad=1.5p pd=5.5u as=1.5p ps=5.5u w=2u l=0.28u nf=1
X2 ck_g__t1 ckb__t3 vss__t2 vss__t1 nfet_03v3 ad=0.75p pd=3.5u as=0.75p ps=3.5u w=1u l=0.28u nf=1
X3 in__t1 ck_g out__t1 vss__t5 nfet_03v3 ad=5.685p pd=16.66u as=5.685p ps=16.66u w=7.58u l=0.28u nf=1
X4 ckb__t1 ck__t1 vdd__t3 vdd__t2 pfet_03v3 ad=0.75p pd=3.5u as=0.75p ps=3.5u w=1u l=0.28u nf=1
X5 in__t0 ck_g__t4 out__t0 vss__t0 nfet_03v3 ad=5.685p pd=16.66u as=5.685p ps=16.66u w=7.58u l=0.28u nf=1
X6 ck_g__t0 ckb__t6 vdd__t1 vdd__t0 pfet_03v3 ad=1.5p pd=5.5u as=1.5p ps=5.5u w=2u l=0.28u nf=1
X7 ckb__t0 ck__t2 vdd__t5 vdd__t4 pfet_03v3 ad=0.75p pd=3.5u as=0.75p ps=3.5u w=1u l=0.28u nf=1
X8 ckb__t2 ck__t0 vss__t7 vss__t6 nfet_03v3 ad=0.75p pd=3.5u as=0.75p ps=3.5u w=1u l=0.28u nf=1
Rpar0 ck ck__n0 30.983
Rpar1 ck ck__t0 43.437
Rpar2 ck__n0 ck__t1 43.718
Rpar3 ck__n0 ck__t2 43.265
Rpar4 ck_g ck_g__n1 129.04
Rpar5 ck_g__n0 ck_g__n2 10.467
Rpar6 ck_g__n0 ck_g__t1 14.366
Rpar7 ck_g__n0 ck_g__t2 13.912
Rpar8 ck_g__n1 ck_g__n2 9.5747
Rpar9 ck_g__n1 ck_g__t4 129.49
Rpar10 ck_g__n2 ck_g__n3 19.401
Rpar11 ck_g__n3 ck_g__t0 8.6875
Rpar12 ck_g__n3 ck_g__t3 8.2339
Rpar13 ckb ckb__n1 43.265
Rpar14 ckb__n0 ckb__n3 24.036
Rpar15 ckb__n0 ckb__t5 56.754
Rpar16 ckb__n0 ckb__t6 56.3
Rpar17 ckb__n1 ckb__n2 9.5243
Rpar18 ckb__n1 ckb__t3 43.718
Rpar19 ckb__n2 ckb__n3 9.3632
Rpar20 ckb__n2 ckb__t2 24.378
Rpar21 ckb__n3 ckb__n4 19.857
Rpar22 ckb__n4 ckb__t0 13.567
Rpar23 ckb__n4 ckb__t1 13.114
Rpar24 in in__n0 0.275
Rpar25 in__n0 in__t0 6.7006
Rpar26 in__n0 in__t1 6.247
Rpar27 out out__n0 0.0698
Rpar28 out__n0 out__t0 6.544
Rpar29 out__n0 out__t1 6.0904
Rpar30 vdd vdd__t0 214.74
Rpar31 vdd vdd__t1 93.789
Rpar32 vdd vdd__t2 39.332
Rpar33 vdd vdd__t3 23.134
Rpar34 vdd vdd__t4 39.238
Rpar35 vdd vdd__t5 23.944
Rpar36 vdd vdd__t6 207.89
Rpar37 vdd vdd__t7 88.802
Rpar38 vdd__t0 vdd__t1 98.673
Rpar39 vdd__t0 vdd__t2 5.6501e+05
Rpar40 vdd__t0 vdd__t3 3.5426e+05
Rpar41 vdd__t0 vdd__t4 6.3149e+05
Rpar42 vdd__t0 vdd__t5 3.6666e+05
Rpar43 vdd__t0 vdd__t6 195.29
Rpar44 vdd__t0 vdd__t7 93.427
Rpar45 vdd__t1 vdd__t2 2.4677e+05
Rpar46 vdd__t1 vdd__t3 1.5473e+05
Rpar47 vdd__t1 vdd__t4 2.7581e+05
Rpar48 vdd__t1 vdd__t5 1.6014e+05
Rpar49 vdd__t1 vdd__t6 99.019
Rpar50 vdd__t1 vdd__t7 22.558
Rpar51 vdd__t2 vdd__t3 464.77
Rpar52 vdd__t2 vdd__t4 1044.3
Rpar53 vdd__t2 vdd__t5 481.04
Rpar54 vdd__t2 vdd__t6 5.4699e+05
Rpar55 vdd__t2 vdd__t7 2.3365e+05
Rpar56 vdd__t3 vdd__t4 471.87
Rpar57 vdd__t3 vdd__t5 68.607
Rpar58 vdd__t3 vdd__t6 3.4296e+05
Rpar59 vdd__t3 vdd__t7 1.465e+05
Rpar60 vdd__t4 vdd__t5 488.39
Rpar61 vdd__t4 vdd__t6 6.1135e+05
Rpar62 vdd__t4 vdd__t7 2.6114e+05
Rpar63 vdd__t5 vdd__t6 3.5497e+05
Rpar64 vdd__t5 vdd__t7 1.5163e+05
Rpar65 vdd__t6 vdd__t7 93.754
Rpar66 vss vss__t0 29.175
Rpar67 vss vss__t1 34.581
Rpar68 vss vss__t2 54.631
Rpar69 vss vss__t4 56.433
Rpar70 vss vss__t5 49.487
Rpar71 vss vss__t6 14.745
Rpar72 vss vss__t7 52.429
Rpar73 vss__t0 vss__t1 28.488
Rpar74 vss__t0 vss__t2 102.77
Rpar75 vss__t0 vss__t4 106.16
Rpar76 vss__t0 vss__t5 119.61
Rpar77 vss__t0 vss__t6 176.89
Rpar78 vss__t0 vss__t7 137.03
Rpar79 vss__t1 vss__t2 711.05
Rpar80 vss__t1 vss__t4 734.5
Rpar81 vss__t1 vss__t5 678.57
Rpar82 vss__t1 vss__t6 301.18
Rpar83 vss__t1 vss__t7 720.6
Rpar84 vss__t2 vss__t4 69.044
Rpar85 vss__t2 vss__t5 180.87
Rpar86 vss__t2 vss__t6 306.34
Rpar87 vss__t2 vss__t7 199.33
Rpar88 vss__t3 vss__t5 30.953
Rpar89 vss__t3 vss__t6 0.55322
Rpar90 vss__t4 vss__t5 186.84
Rpar91 vss__t4 vss__t6 316.45
Rpar92 vss__t4 vss__t7 205.9
Rpar93 vss__t5 vss__t6 261.39
Rpar94 vss__t5 vss__t7 109.24
Rpar95 vss__t6 vss__t7 291.33
Cpar0 ck ckb 0.2256f
Cpar1 ck vdd 1.6255f
Cpar2 ck vss 1.5414f
Cpar3 ck__n0 vss 0.5242f
Cpar4 ck__t0 vss 0.021f
Cpar5 ck__t1 vss 0.0216f
Cpar6 ck__t2 vss 0.0207f
Cpar7 ck_g ckb 1.2248f
Cpar8 ck_g in 0.2496f
Cpar9 ck_g out 0.2711f
Cpar10 ck_g vdd 2.9524f
Cpar11 ck_g vss 0.224f
Cpar12 ck_g__n0 vss 0.599f
Cpar13 ck_g__n1 vss 0.7313f
Cpar14 ck_g__n2 vss 0.6757f
Cpar15 ck_g__n3 vss 0.9018f
Cpar16 ck_g__t0 vss 0.3832f
Cpar17 ck_g__t1 vss 0.1168f
Cpar18 ck_g__t2 vss 0.1109f
Cpar19 ck_g__t3 vss 0.3647f
Cpar20 ck_g__t4 vss 0.225f
Cpar21 ckb out 0.015f
Cpar22 ckb vdd 4.7157f
Cpar23 ckb vss 0.0417f
Cpar24 ckb__n0 vss 1.054f
Cpar25 ckb__n1 vss 0.4909f
Cpar26 ckb__n2 vss 0.5953f
Cpar27 ckb__n3 vss 1.7005f
Cpar28 ckb__n4 vss 0.6058f
Cpar29 ckb__t0 vss 0.1006f
Cpar30 ckb__t1 vss 0.0931f
Cpar31 ckb__t2 vss 0.2287f
Cpar32 ckb__t3 vss 0.0436f
Cpar33 ckb__t5 vss 0.0647f
Cpar34 ckb__t6 vss 0.0632f
Cpar35 in out 3.4092f
Cpar36 in vss 0.6445f
Cpar37 in__n0 vss 0.2021f
Cpar38 in__t0 vss 0.5096f
Cpar39 in__t1 vss 0.5027f
Cpar40 out vss 0.348f
Cpar41 out__n0 vss 0.1665f
Cpar42 out__t0 vss 0.401f
Cpar43 out__t1 vss 0.3942f
Cpar44 vdd vss 12.8685f
Cpar45 vdd__t0 vss 0.506f
Cpar46 vdd__t1 vss 0.8683f
Cpar47 vdd__t2 vss 0.1815f
Cpar48 vdd__t3 vss 0.2017f
Cpar49 vdd__t4 vss 0.1816f
Cpar50 vdd__t5 vss 0.197f
Cpar51 vdd__t6 vss 0.5033f
Cpar52 vdd__t7 vss 0.9089f
.ends nmos__1p8v__10u_100u

* san-lv-1v8-wi  (StrongARM, NMOS input, mix=lv, VDD=1.8 V, target=wi) — Post-PEX (Magic whole-cell)
.subckt comp INP INN CLK CLKB OUTP OUTN VDD VDDB VSS
XM1 X1 INP TAIL VSS nfet_03v3 W=0.94u L=0.5u nf=1 ad=0.263p as=0.263p pd=1.500u ps=1.500u
XM1_f1 X1 INP TAIL VSS nfet_03v3 W=0.94u L=0.5u nf=1 ad=0.263p as=0.263p pd=1.500u ps=1.500u
XM1_f2 X1 INP TAIL VSS nfet_03v3 W=0.94u L=0.5u nf=1 ad=0.263p as=0.263p pd=1.500u ps=1.500u
XM1_f3 X1 INP TAIL VSS nfet_03v3 W=0.94u L=0.5u nf=1 ad=0.263p as=0.263p pd=1.500u ps=1.500u
XM1_f4 X1 INP TAIL VSS nfet_03v3 W=0.94u L=0.5u nf=1 ad=0.263p as=0.564p pd=1.500u ps=3.080u
XM1_f5 X1 INP TAIL VSS nfet_03v3 W=0.94u L=0.5u nf=1 ad=0.263p as=0.263p pd=1.500u ps=1.500u
XM1_f6 X1 INP TAIL VSS nfet_03v3 W=0.94u L=0.5u nf=1 ad=0.263p as=0.263p pd=1.500u ps=1.500u
XM1_f7 X1 INP TAIL VSS nfet_03v3 W=0.94u L=0.5u nf=1 ad=0.263p as=0.564p pd=1.500u ps=3.080u
XM2 X2 INN TAIL VSS nfet_03v3 W=0.94u L=0.5u nf=1 ad=0.263p as=0.263p pd=1.500u ps=1.500u
XM2_f1 X2 INN TAIL VSS nfet_03v3 W=0.94u L=0.5u nf=1 ad=0.263p as=0.263p pd=1.500u ps=1.500u
XM2_f2 X2 INN TAIL VSS nfet_03v3 W=0.94u L=0.5u nf=1 ad=0.263p as=0.263p pd=1.500u ps=1.500u
XM2_f3 X2 INN TAIL VSS nfet_03v3 W=0.94u L=0.5u nf=1 ad=0.263p as=0.564p pd=1.500u ps=3.080u
XM2_f4 X2 INN TAIL VSS nfet_03v3 W=0.94u L=0.5u nf=1 ad=0.263p as=0.263p pd=1.500u ps=1.500u
XM2_f5 X2 INN TAIL VSS nfet_03v3 W=0.94u L=0.5u nf=1 ad=0.263p as=0.263p pd=1.500u ps=1.500u
XM2_f6 X2 INN TAIL VSS nfet_03v3 W=0.94u L=0.5u nf=1 ad=0.263p as=0.263p pd=1.500u ps=1.500u
XM2_f7 X2 INN TAIL VSS nfet_03v3 W=0.94u L=0.5u nf=1 ad=0.263p as=0.564p pd=1.500u ps=3.080u
XM0 TAIL CLK VSS VSS nfet_03v3 W=0.5u L=0.28u nf=1 ad=0.215p as=0.375p pd=1.360u ps=2.500u
XM0_f1 TAIL CLK VSS VSS nfet_03v3 W=0.5u L=0.28u nf=1 ad=0.215p as=0.375p pd=1.360u ps=2.500u
XM3 LO1 LO2 X1 VSS nfet_03v3 W=0.5u L=0.28u nf=1 ad=0.375p as=0.375p pd=2.500u ps=2.500u
XM3_f1 LO1 LO2 X1 VSS nfet_03v3 W=0.5u L=0.28u nf=1 ad=0.375p as=0.375p pd=2.500u ps=2.500u
XM4 LO2 LO1 X2 VSS nfet_03v3 W=0.5u L=0.28u nf=1 ad=0.375p as=0.375p pd=2.500u ps=2.500u
XM4_f1 LO2 LO1 X2 VSS nfet_03v3 W=0.5u L=0.28u nf=1 ad=0.375p as=0.375p pd=2.500u ps=2.500u
XM5 LO1 LO2 VDD VDD pfet_03v3 W=0.5u L=0.28u nf=1 ad=0.375p as=0.215p pd=2.500u ps=1.360u
XM5_f1 LO1 LO2 VDD VDD pfet_03v3 W=0.5u L=0.28u nf=1 ad=0.375p as=0.215p pd=2.500u ps=1.360u
XM6 LO2 LO1 VDD VDD pfet_03v3 W=0.5u L=0.28u nf=1 ad=0.375p as=0.215p pd=2.500u ps=1.360u
XM6_f1 LO2 LO1 VDD VDD pfet_03v3 W=0.5u L=0.28u nf=1 ad=0.375p as=0.215p pd=2.500u ps=1.360u
XMR1 LO1 CLK VDD VDD pfet_03v3 W=0.5u L=0.28u nf=1 ad=0.375p as=0.375p pd=2.500u ps=2.500u
XMR2 LO2 CLK VDD VDD pfet_03v3 W=0.5u L=0.28u nf=1 ad=0.375p as=0.375p pd=2.500u ps=2.500u
XMR3 X1 CLK VDD VDD pfet_03v3 W=0.5u L=0.28u nf=1 ad=0.375p as=0.375p pd=2.500u ps=2.500u
XMR4 X2 CLK VDD VDD pfet_03v3 W=0.5u L=0.28u nf=1 ad=0.375p as=0.375p pd=2.500u ps=2.500u
XMEVP EV CLKB VDD VDD pfet_03v3 W=0.6u L=2.16u nf=1 ad=0.168p as=0.360p pd=1.160u ps=2.400u
XMEVP_f1 EV CLKB VDD VDD pfet_03v3 W=0.6u L=2.16u nf=1 ad=0.168p as=0.360p pd=1.160u ps=2.400u
XMEVN EV CLK VSS VSS nfet_03v3 W=0.6u L=2.16u nf=1 ad=0.168p as=0.360p pd=1.160u ps=2.400u
XMEVN_f1 EV CLK VSS VSS nfet_03v3 W=0.6u L=2.16u nf=1 ad=0.168p as=0.360p pd=1.160u ps=2.400u
XMBp0N bp0 LO1 VSS VSS nfet_03v3 W=0.5u L=0.28u nf=1 ad=0.375p as=0.375p pd=2.500u ps=2.500u
XMBp0P bp0 LO1 VDDB VDDB pfet_03v3 W=0.5u L=0.28u nf=1 ad=0.215p as=0.375p pd=1.360u ps=2.500u
XMBp0P_f1 bp0 LO1 VDDB VDDB pfet_03v3 W=0.5u L=0.28u nf=1 ad=0.215p as=0.375p pd=1.360u ps=2.500u
XMBp1N bp1 bp0 VSS VSS nfet_03v3 W=1u L=0.28u nf=1 ad=0.430p as=0.750p pd=1.860u ps=3.500u
XMBp1N_f1 bp1 bp0 VSS VSS nfet_03v3 W=1u L=0.28u nf=1 ad=0.430p as=0.750p pd=1.860u ps=3.500u
XMBp1P bp1 bp0 VDDB VDDB pfet_03v3 W=1u L=0.28u nf=1 ad=0.430p as=0.750p pd=1.860u ps=3.500u
XMBp1P_f1 bp1 bp0 VDDB VDDB pfet_03v3 W=1u L=0.28u nf=1 ad=0.430p as=0.430p pd=1.860u ps=1.860u
XMBp1P_f2 bp1 bp0 VDDB VDDB pfet_03v3 W=1u L=0.28u nf=1 ad=0.430p as=0.430p pd=1.860u ps=1.860u
XMBp1P_f3 bp1 bp0 VDDB VDDB pfet_03v3 W=1u L=0.28u nf=1 ad=0.430p as=0.750p pd=1.860u ps=3.500u
XMBp2N OUTP bp1 VSS VSS nfet_03v3 W=1u L=0.28u nf=1 ad=0.430p as=0.430p pd=1.860u ps=1.860u
XMBp2N_f1 OUTP bp1 VSS VSS nfet_03v3 W=1u L=0.28u nf=1 ad=0.430p as=0.430p pd=1.860u ps=1.860u
XMBp2N_f2 OUTP bp1 VSS VSS nfet_03v3 W=1u L=0.28u nf=1 ad=0.430p as=0.750p pd=1.860u ps=3.500u
XMBp2N_f3 OUTP bp1 VSS VSS nfet_03v3 W=1u L=0.28u nf=1 ad=0.430p as=0.430p pd=1.860u ps=1.860u
XMBp2N_f4 OUTP bp1 VSS VSS nfet_03v3 W=1u L=0.28u nf=1 ad=0.430p as=0.430p pd=1.860u ps=1.860u
XMBp2N_f5 OUTP bp1 VSS VSS nfet_03v3 W=1u L=0.28u nf=1 ad=0.430p as=0.430p pd=1.860u ps=1.860u
XMBp2N_f6 OUTP bp1 VSS VSS nfet_03v3 W=1u L=0.28u nf=1 ad=0.430p as=0.430p pd=1.860u ps=1.860u
XMBp2N_f7 OUTP bp1 VSS VSS nfet_03v3 W=1u L=0.28u nf=1 ad=0.430p as=0.750p pd=1.860u ps=3.500u
XMBp2P OUTP bp1 VDDB VDDB pfet_03v3 W=1.6u L=0.28u nf=1 ad=0.688p as=0.688p pd=2.460u ps=2.460u
XMBp2P_f1 OUTP bp1 VDDB VDDB pfet_03v3 W=1.6u L=0.28u nf=1 ad=0.688p as=0.688p pd=2.460u ps=2.460u
XMBp2P_f2 OUTP bp1 VDDB VDDB pfet_03v3 W=1.6u L=0.28u nf=1 ad=1.200p as=0.688p pd=4.700u ps=2.460u
XMBp2P_f3 OUTP bp1 VDDB VDDB pfet_03v3 W=1.6u L=0.28u nf=1 ad=1.200p as=0.688p pd=4.700u ps=2.460u
XMBp2P_f4 OUTP bp1 VDDB VDDB pfet_03v3 W=1.6u L=0.28u nf=1 ad=0.688p as=0.688p pd=2.460u ps=2.460u
XMBp2P_f5 OUTP bp1 VDDB VDDB pfet_03v3 W=1.6u L=0.28u nf=1 ad=0.688p as=0.688p pd=2.460u ps=2.460u
XMBp2P_f6 OUTP bp1 VDDB VDDB pfet_03v3 W=1.6u L=0.28u nf=1 ad=0.688p as=1.200p pd=2.460u ps=4.700u
XMBp2P_f7 OUTP bp1 VDDB VDDB pfet_03v3 W=1.6u L=0.28u nf=1 ad=0.688p as=0.688p pd=2.460u ps=2.460u
XMBp2P_f8 OUTP bp1 VDDB VDDB pfet_03v3 W=1.6u L=0.28u nf=1 ad=0.688p as=1.200p pd=2.460u ps=4.700u
XMBp2P_f9 OUTP bp1 VDDB VDDB pfet_03v3 W=1.6u L=0.28u nf=1 ad=0.688p as=0.688p pd=2.460u ps=2.460u
XMBn0N bn0 LO2 VSS VSS nfet_03v3 W=0.5u L=0.28u nf=1 ad=0.375p as=0.375p pd=2.500u ps=2.500u
XMBn0P bn0 LO2 VDDB VDDB pfet_03v3 W=0.5u L=0.28u nf=1 ad=0.215p as=0.375p pd=1.360u ps=2.500u
XMBn0P_f1 bn0 LO2 VDDB VDDB pfet_03v3 W=0.5u L=0.28u nf=1 ad=0.215p as=0.375p pd=1.360u ps=2.500u
XMBn1N bn1 bn0 VSS VSS nfet_03v3 W=1u L=0.28u nf=1 ad=0.430p as=0.750p pd=1.860u ps=3.500u
XMBn1N_f1 bn1 bn0 VSS VSS nfet_03v3 W=1u L=0.28u nf=1 ad=0.430p as=0.750p pd=1.860u ps=3.500u
XMBn1P bn1 bn0 VDDB VDDB pfet_03v3 W=1u L=0.28u nf=1 ad=0.430p as=0.750p pd=1.860u ps=3.500u
XMBn1P_f1 bn1 bn0 VDDB VDDB pfet_03v3 W=1u L=0.28u nf=1 ad=0.430p as=0.430p pd=1.860u ps=1.860u
XMBn1P_f2 bn1 bn0 VDDB VDDB pfet_03v3 W=1u L=0.28u nf=1 ad=0.430p as=0.750p pd=1.860u ps=3.500u
XMBn1P_f3 bn1 bn0 VDDB VDDB pfet_03v3 W=1u L=0.28u nf=1 ad=0.430p as=0.430p pd=1.860u ps=1.860u
XMBn2N OUTN bn1 VSS VSS nfet_03v3 W=1u L=0.28u nf=1 ad=0.430p as=0.430p pd=1.860u ps=1.860u
XMBn2N_f1 OUTN bn1 VSS VSS nfet_03v3 W=1u L=0.28u nf=1 ad=0.430p as=0.430p pd=1.860u ps=1.860u
XMBn2N_f2 OUTN bn1 VSS VSS nfet_03v3 W=1u L=0.28u nf=1 ad=0.430p as=0.430p pd=1.860u ps=1.860u
XMBn2N_f3 OUTN bn1 VSS VSS nfet_03v3 W=1u L=0.28u nf=1 ad=0.430p as=0.750p pd=1.860u ps=3.500u
XMBn2N_f4 OUTN bn1 VSS VSS nfet_03v3 W=1u L=0.28u nf=1 ad=0.430p as=0.430p pd=1.860u ps=1.860u
XMBn2N_f5 OUTN bn1 VSS VSS nfet_03v3 W=1u L=0.28u nf=1 ad=0.430p as=0.430p pd=1.860u ps=1.860u
XMBn2N_f6 OUTN bn1 VSS VSS nfet_03v3 W=1u L=0.28u nf=1 ad=0.430p as=0.750p pd=1.860u ps=3.500u
XMBn2N_f7 OUTN bn1 VSS VSS nfet_03v3 W=1u L=0.28u nf=1 ad=0.430p as=0.430p pd=1.860u ps=1.860u
XMBn2P OUTN bn1 VDDB VDDB pfet_03v3 W=1.6u L=0.28u nf=1 ad=1.200p as=0.688p pd=4.700u ps=2.460u
XMBn2P_f1 OUTN bn1 VDDB VDDB pfet_03v3 W=1.6u L=0.28u nf=1 ad=0.688p as=0.688p pd=2.460u ps=2.460u
XMBn2P_f2 OUTN bn1 VDDB VDDB pfet_03v3 W=1.6u L=0.28u nf=1 ad=1.200p as=0.688p pd=4.700u ps=2.460u
XMBn2P_f3 OUTN bn1 VDDB VDDB pfet_03v3 W=1.6u L=0.28u nf=1 ad=0.688p as=0.688p pd=2.460u ps=2.460u
XMBn2P_f4 OUTN bn1 VDDB VDDB pfet_03v3 W=1.6u L=0.28u nf=1 ad=0.688p as=0.688p pd=2.460u ps=2.460u
XMBn2P_f5 OUTN bn1 VDDB VDDB pfet_03v3 W=1.6u L=0.28u nf=1 ad=0.688p as=0.688p pd=2.460u ps=2.460u
XMBn2P_f6 OUTN bn1 VDDB VDDB pfet_03v3 W=1.6u L=0.28u nf=1 ad=0.688p as=0.688p pd=2.460u ps=2.460u
XMBn2P_f7 OUTN bn1 VDDB VDDB pfet_03v3 W=1.6u L=0.28u nf=1 ad=0.688p as=0.688p pd=2.460u ps=2.460u
XMBn2P_f8 OUTN bn1 VDDB VDDB pfet_03v3 W=1.6u L=0.28u nf=1 ad=0.688p as=1.200p pd=2.460u ps=4.700u
XMBn2P_f9 OUTN bn1 VDDB VDDB pfet_03v3 W=1.6u L=0.28u nf=1 ad=0.688p as=1.200p pd=2.460u ps=4.700u
Cp0 CLK EV 0.2827f
Cp1 CLK INN 0.02415f
Cp2 CLK INP 0.02415f
Cp3 CLK LO1 1.373f
Cp4 CLK LO2 1.346f
Cp5 CLK TAIL 4.334f
Cp6 CLK VDD 10.03f
Cp7 CLK VDDB 2.809f
Cp8 CLK VSS 19.33f
Cp9 CLK X1 0.6756f
Cp10 CLK X2 0.6863f
Cp11 CLKB EV 0.1579f
Cp12 CLKB LO1 0.01325f
Cp13 CLKB LO2 0.01407f
Cp14 CLKB VDD 3.337f
Cp15 CLKB VDDB 0.01356f
Cp16 CLKB VSS 0.1725f
Cp17 EV LO1 0.7957f
Cp18 EV LO2 0.7957f
Cp19 EV VDD 2.786f
Cp20 EV VDDB 0.01146f
Cp21 EV VSS 3.765f
Cp22 INN TAIL 0.6717f
Cp23 INN VSS 4.046f
Cp24 INN X2 0.5094f
Cp25 INP TAIL 0.6717f
Cp26 INP VSS 4.04f
Cp27 INP X1 0.508f
Cp28 LO1 LO2 3.891f
Cp29 LO1 OUTP 0.0482f
Cp30 LO1 TAIL 1.352f
Cp31 LO1 VDD 9.236f
Cp32 LO1 VDDB 2.282f
Cp33 LO1 VSS 13.89f
Cp34 LO1 X1 4.092f
Cp35 LO1 X2 0.8962f
Cp36 LO1 bp0 0.235f
Cp37 LO2 OUTN 0.03689f
Cp38 LO2 TAIL 1.346f
Cp39 LO2 VDD 8.1f
Cp40 LO2 VDDB 3.779f
Cp41 LO2 VSS 13.79f
Cp42 LO2 X1 0.8027f
Cp43 LO2 X2 4.041f
Cp44 LO2 bn0 0.235f
Cp45 OUTN VDDB 8.338f
Cp46 OUTN VSS 7.387f
Cp47 OUTN X2 0.05103f
Cp48 OUTN bn0 0.4102f
Cp49 OUTN bn1 3.017f
Cp50 OUTP VDDB 8.315f
Cp51 OUTP VSS 7.387f
Cp52 OUTP X1 0.05103f
Cp53 OUTP bp0 0.4102f
Cp54 OUTP bp1 3.017f
Cp55 TAIL VDD 0.9939f
Cp56 TAIL VDDB 0.7789f
Cp57 TAIL VSS 15.46f
Cp58 TAIL X1 3.251f
Cp59 TAIL X2 3.251f
Cp60 VDD VDDB 1.166f
Cp61 VDD VSS 70.3f
Cp62 VDD X1 1.837f
Cp63 VDD X2 1.835f
Cp64 VDDB VSS 83.44f
Cp65 VDDB X1 0.3191f
Cp66 VDDB X2 0.09911f
Cp67 VDDB bn0 4.853f
Cp68 VDDB bn1 9.943f
Cp69 VDDB bp0 4.853f
Cp70 VDDB bp1 9.933f
Cp71 VSS X1 7.826f
Cp72 VSS X2 8.01f
Cp73 VSS bn0 6.812f
Cp74 VSS bn1 9.868f
Cp75 VSS bp0 6.812f
Cp76 VSS bp1 9.872f
Cp77 X1 X2 1.154f
Cp78 X1 bp0 0.01186f
Cp79 X1 bp1 0.02801f
Cp80 X2 bn0 0.01186f
Cp81 X2 bn1 0.02801f
Cp82 bn0 bn1 2.004f
Cp83 bp0 bp1 2.003f
.ends comp

* Post-Layout Magic PEX Extracted Netlist for TOP1_DCVS (ls-gen-gemini4)
.subckt TOP1_DCVS in out vddl vssl vddh vssh
XINV1_MP inb in vddl vddl pfet_03v3 w=2u l=0.28u nf=1 m=1 ad=1.5p pd=5.5u as=1.5p ps=5.5u
XINV1_MN inb in vssl vssl nfet_03v3 w=1u l=0.28u nf=1 m=1 ad=0.75p pd=3.5u as=0.75p ps=3.5u
XINV2_MP inp inb vddl vddl pfet_03v3 w=4u l=0.28u nf=1 m=1 ad=3p pd=9.5u as=3p ps=9.5u
XINV2_MN inp inb vssl vssl nfet_03v3 w=2u l=0.28u nf=1 m=1 ad=1.5p pd=5.5u as=1.5p ps=5.5u
XMN1 qn inp vssl vssl nfet_03v3 w=4u l=0.28u nf=1 m=1 ad=3p pd=9.5u as=1.72p ps=4.86u
XMN1_f1 qn inp vssl vssl nfet_03v3 w=4u l=0.28u nf=1 m=1 ad=3p pd=9.5u as=1.72p ps=4.86u
XMN2 qp inb vssl vssl nfet_03v3 w=4u l=0.28u nf=1 m=1 ad=1.72p pd=4.86u as=1.72p ps=4.86u
XMN2_f1 qp inb vssl vssl nfet_03v3 w=4u l=0.28u nf=1 m=1 ad=1.72p pd=4.86u as=1.72p ps=4.86u
XMP1 qn qp vddh vddh pfet_03v3 w=1u l=0.5u nf=1 m=1 ad=0.6p pd=3.2u as=0.28p ps=1.56u
XMP2 qp qn vddh vddh pfet_03v3 w=1u l=0.5u nf=1 m=1 ad=0.6p pd=3.2u as=0.28p ps=1.56u
XOUT1_MP outb qp vddh vddh pfet_03v3 w=2u l=0.28u nf=1 m=1 ad=1.5p pd=5.5u as=1.5p ps=5.5u
XOUT1_MN outb qp vssh vssh nfet_03v3 w=1u l=0.28u nf=1 m=1 ad=0.75p pd=3.5u as=0.75p ps=3.5u
XOUT2_MP out outb vddh vddh pfet_03v3 w=4u l=0.28u nf=1 m=1 ad=3p pd=9.5u as=3p ps=9.5u
XOUT2_MN out outb vssh vssh nfet_03v3 w=2u l=0.28u nf=1 m=1 ad=1.5p pd=5.5u as=1.5p ps=5.5u
Cp0 in inb 0.963f
Cp1 in inp 0.00461f
Cp2 in out 0.0183f
Cp3 in outb 0.177f
Cp4 in qn 0.11f
Cp5 in qp 0.306f
Cp6 in vddh 0.157f
Cp7 in vddl 0.489f
Cp8 in vssh 0.429f
Cp9 in w_n2378_1190_h 0.000448f
Cp10 inb inp 0.995f
Cp11 inb out 0.161f
Cp12 inb outb 0.0393f
Cp13 inb qn 0.191f
Cp14 inb qp 0.245f
Cp15 inb vddh 0.0193f
Cp16 inb vddl 2.13f
Cp17 inb vssh 0.0994f
Cp18 inp out 0.1f
Cp19 inp qn 1.13f
Cp20 inp qp 0.216f
Cp21 inp vddh 0.00144f
Cp22 inp vddl 1.34f
Cp23 inp vssh 0.00745f
Cp24 out outb 1.11f
Cp25 out qn 0.694f
Cp26 out qp 0.777f
Cp27 out vddh 2.2f
Cp28 out vddl 0.705f
Cp29 out vssh 0.676f
Cp30 outb qn 0.184f
Cp31 outb qp 1.12f
Cp32 outb vddh 2.42f
Cp33 outb vddl 0.0396f
Cp34 outb vssh 1.8f
Cp35 outb w_n2378_1190_h 0.00165f
Cp36 qn qp 2.49f
Cp37 qn vddh 1.53f
Cp38 qn vddl 0.0778f
Cp39 qn vssh 0.00292f
Cp40 qp vddh 2.79f
Cp41 qp vddl 0.00453f
Cp42 qp vssh 1.16f
Cp43 qp w_n2378_1190_h 0.00139f
Cp44 vddh vddl 3.75f
Cp45 vddh vssh 0.381f
.ends TOP1_DCVS

* Magic 8.3 post-PEX CMOS decoupling capacitor (pll_decap_lg)
.subckt pll_decap_lg vdd vss
X0 vdd vss vdd vdd pfet_03v3 ad=1.536p pd=5.44u as=14.976p ps=54.24u w=4.8u l=2.3u nf=1
X1 vss vdd vss vss nfet_03v3 ad=2.88p pd=10.8u as=14.976p ps=54.24u w=4.8u l=2.3u nf=1
X2 vss vdd vss vss nfet_03v3 ad=1.536p pd=5.44u as=0 ps=0 w=4.8u l=2.3u nf=1
X3 vss vdd vss vss nfet_03v3 ad=1.536p pd=5.44u as=0 ps=0 w=4.8u l=2.3u nf=1
X4 vss vdd vss vss nfet_03v3 ad=1.536p pd=5.44u as=0 ps=0 w=4.8u l=2.3u nf=1
X5 vdd vss vdd vdd pfet_03v3 ad=2.88p pd=10.8u as=0 ps=0 w=4.8u l=2.3u nf=1
X6 vdd vss vdd vdd pfet_03v3 ad=1.536p pd=5.44u as=0 ps=0 w=4.8u l=2.3u nf=1
X7 vdd vss vdd vdd pfet_03v3 ad=1.536p pd=5.44u as=0 ps=0 w=4.8u l=2.3u nf=1
C0 vdd vss 22.7581f
.ends pll_decap_lg

* Magic 8.3 post-PEX CMOS decoupling capacitor (pll_decap_sm)
.subckt pll_decap_sm vdd vss
X0 vdd vss vdd vdd pfet_03v3 ad=0.352p pd=1.74u as=2.024p ps=10.28u w=1.1u l=1.24u nf=1
X1 vss vdd vss vss nfet_03v3 ad=0.66p pd=3.4u as=2.024p ps=10.28u w=1.1u l=1.24u nf=1
X2 vdd vss vdd vdd pfet_03v3 ad=0.66p pd=3.4u as=0 ps=0 w=1.1u l=1.24u nf=1
X3 vss vdd vss vss nfet_03v3 ad=0.352p pd=1.74u as=0 ps=0 w=1.1u l=1.24u nf=1
C0 vdd vss 6.22681f
.ends pll_decap_sm

* Self-contained gate-level SPICE subcircuit for dlf_pi_dsm
.subckt dlf_pi_dsm clk_ref rst_n phase_err_0 phase_err_1 phase_err_2 phase_err_3 phase_err_4 dco_coarse_0 dco_coarse_1 dco_coarse_2 dsm_out vdd vss
XM_1__148__i_1_1 n_1__148__net_0_0 _038_ vss vss nfet_05v0 w=8.2e-07 l=6e-07 nf=1 m=1
XM_1__148__i_0_1 _094_ _138_ n_1__148__net_0_0 vss nfet_05v0 w=8.2e-07 l=6e-07 nf=1 m=1
XM_1__148__i_0_0 n_1__148__net_0_1 _138_ _094_ vss nfet_05v0 w=8.2e-07 l=6e-07 nf=1 m=1
XM_1__148__i_1_0 vss _038_ n_1__148__net_0_1 vss nfet_05v0 w=8.2e-07 l=6e-07 nf=1 m=1
XM_1__148__i_3_1 _094_ _038_ vdd vdd pfet_05v0 w=1.13e-06 l=5e-07 nf=1 m=1
XM_1__148__i_2_1 vdd _138_ _094_ vdd pfet_05v0 w=1.13e-06 l=5e-07 nf=1 m=1
XM_1__148__i_2_0 _094_ _138_ vdd vdd pfet_05v0 w=1.13e-06 l=5e-07 nf=1 m=1
XM_1__148__i_3_0 vdd _038_ _094_ vdd pfet_05v0 w=1.13e-06 l=5e-07 nf=1 m=1
XM_2__149__i_1 n_2__149__net_0 _039_ vss vss nfet_05v0 w=8.2e-07 l=6e-07 nf=1 m=1
XM_2__149__i_0 _095_ _139_ n_2__149__net_0 vss nfet_05v0 w=8.2e-07 l=6e-07 nf=1 m=1
XM_2__149__i_3 _095_ _039_ vdd vdd pfet_05v0 w=1.13e-06 l=5e-07 nf=1 m=1
XM_2__149__i_2 vdd _139_ _095_ vdd pfet_05v0 w=1.13e-06 l=5e-07 nf=1 m=1
XM_3__150__i_1 _096_ _039_ vss vss nfet_05v0 w=5.65e-07 l=6e-07 nf=1 m=1
XM_3__150__i_0 vss _139_ _096_ vss nfet_05v0 w=5.65e-07 l=6e-07 nf=1 m=1
XM_3__150__i_3 n_3__150__net_0 _039_ vdd vdd pfet_05v0 w=1.22e-06 l=5e-07 nf=1 m=1
XM_3__150__i_2 _096_ _139_ n_3__150__net_0 vdd pfet_05v0 w=1.22e-06 l=5e-07 nf=1 m=1
XM_4__151__i_12 n_4__151__I _094_ vss vss nfet_05v0 w=3.6e-07 l=6e-07 nf=1 m=1
XM_4__151__i_13 vss _139_ n_4__151__I vss nfet_05v0 w=3.6e-07 l=6e-07 nf=1 m=1
XM_4__151__i_2 n_4__151__I2 n_4__151__I vss vss nfet_05v0 w=3.6e-07 l=6e-07 nf=1 m=1
XM_4__151__i_0 n_4__151__net_0 _139_ n_4__151__I2 vss nfet_05v0 w=3.6e-07 l=6e-07 nf=1 m=1
XM_4__151__i_1 vss _094_ n_4__151__net_0 vss nfet_05v0 w=3.6e-07 l=6e-07 nf=1 m=1
XM_4__151__i_16 n_4__151__net_5 n_4__151__I2 n_4__151__I3 vss nfet_05v0 w=3.6e-07 l=6e-07 nf=1 m=1
XM_4__151__i_17 vss _039_ n_4__151__net_5 vss nfet_05v0 w=3.6e-07 l=6e-07 nf=1 m=1
XM_4__151__i_8 n_4__151__net_2 n_4__151__I3 vss vss nfet_05v0 w=8.2e-07 l=6e-07 nf=1 m=1
XM_4__151__i_6 _097_ _039_ n_4__151__net_2 vss nfet_05v0 w=8.2e-07 l=6e-07 nf=1 m=1
XM_4__151__i_7 n_4__151__net_2 n_4__151__I2 _097_ vss nfet_05v0 w=8.2e-07 l=6e-07 nf=1 m=1
XM_4__151__i_14 n_4__151__net_4 _094_ n_4__151__I vdd pfet_05v0 w=3.6e-07 l=5e-07 nf=1 m=1
XM_4__151__i_15 vdd _139_ n_4__151__net_4 vdd pfet_05v0 w=3.6e-07 l=5e-07 nf=1 m=1
XM_4__151__i_5 n_4__151__net_1 n_4__151__I vdd vdd pfet_05v0 w=5.6e-07 l=5e-07 nf=1 m=1
XM_4__151__i_3 n_4__151__I2 _139_ n_4__151__net_1 vdd pfet_05v0 w=5.6e-07 l=5e-07 nf=1 m=1
XM_4__151__i_4 n_4__151__net_1 _094_ n_4__151__I2 vdd pfet_05v0 w=5.6e-07 l=5e-07 nf=1 m=1
XM_4__151__i_18 n_4__151__I3 n_4__151__I2 vdd vdd pfet_05v0 w=5.6e-07 l=5e-07 nf=1 m=1
XM_4__151__i_19 vdd _039_ n_4__151__I3 vdd pfet_05v0 w=5.6e-07 l=5e-07 nf=1 m=1
XM_4__151__i_11 _097_ n_4__151__I3 vdd vdd pfet_05v0 w=1.095e-06 l=5e-07 nf=1 m=1
XM_4__151__i_9 n_4__151__net_3 _039_ _097_ vdd pfet_05v0 w=1.095e-06 l=5e-07 nf=1 m=1
XM_4__151__i_10 vdd n_4__151__I2 n_4__151__net_3 vdd pfet_05v0 w=1.095e-06 l=5e-07 nf=1 m=1
XM_5__152__i_1 n_5__152__net_0 _097_ vss vss nfet_05v0 w=8.2e-07 l=6e-07 nf=1 m=1
XM_5__152__i_0 _098_ _028_ n_5__152__net_0 vss nfet_05v0 w=8.2e-07 l=6e-07 nf=1 m=1
XM_5__152__i_3 _098_ _097_ vdd vdd pfet_05v0 w=1.13e-06 l=5e-07 nf=1 m=1
XM_5__152__i_2 vdd _028_ _098_ vdd pfet_05v0 w=1.13e-06 l=5e-07 nf=1 m=1
XM_6__153__i_6 n_6__153__I _038_ vss vss nfet_05v0 w=3.6e-07 l=6e-07 nf=1 m=1
XM_6__153__i_7 vss _138_ n_6__153__I vss nfet_05v0 w=3.6e-07 l=6e-07 nf=1 m=1
XM_6__153__i_2 _099_ n_6__153__I vss vss nfet_05v0 w=8.2e-07 l=6e-07 nf=1 m=1
XM_6__153__i_0 n_6__153__net_0 _138_ _099_ vss nfet_05v0 w=8.2e-07 l=6e-07 nf=1 m=1
XM_6__153__i_1 vss _038_ n_6__153__net_0 vss nfet_05v0 w=8.2e-07 l=6e-07 nf=1 m=1
XM_6__153__i_8 n_6__153__net_2 _038_ n_6__153__I vdd pfet_05v0 w=5.6e-07 l=5e-07 nf=1 m=1
XM_6__153__i_9 vdd _138_ n_6__153__net_2 vdd pfet_05v0 w=5.6e-07 l=5e-07 nf=1 m=1
XM_6__153__i_5 n_6__153__net_1 n_6__153__I vdd vdd pfet_05v0 w=1.22e-06 l=5e-07 nf=1 m=1
XM_6__153__i_3 _099_ _138_ n_6__153__net_1 vdd pfet_05v0 w=1.22e-06 l=5e-07 nf=1 m=1
XM_6__153__i_4 n_6__153__net_1 _038_ _099_ vdd pfet_05v0 w=1.22e-06 l=5e-07 nf=1 m=1
XM_7__154__i_1 n_7__154__net_0 _099_ vss vss nfet_05v0 w=8.2e-07 l=6e-07 nf=1 m=1
XM_7__154__i_0 _100_ _027_ n_7__154__net_0 vss nfet_05v0 w=8.2e-07 l=6e-07 nf=1 m=1
XM_7__154__i_3 _100_ _099_ vdd vdd pfet_05v0 w=1.13e-06 l=5e-07 nf=1 m=1
XM_7__154__i_2 vdd _027_ _100_ vdd pfet_05v0 w=1.13e-06 l=5e-07 nf=1 m=1
XM_8__155__i_0 _101_ _100_ vss vss nfet_05v0 w=4.8e-07 l=6e-07 nf=1 m=1
XM_8__155__i_1 _101_ _100_ vdd vdd pfet_05v0 w=1.22e-06 l=5e-07 nf=1 m=1
XM_9__156__i_1 n_9__156__net_0 _026_ vss vss nfet_05v0 w=8.2e-07 l=6e-07 nf=1 m=1
XM_9__156__i_0 _102_ _037_ n_9__156__net_0 vss nfet_05v0 w=8.2e-07 l=6e-07 nf=1 m=1
XM_9__156__i_3 _102_ _026_ vdd vdd pfet_05v0 w=1.13e-06 l=5e-07 nf=1 m=1
XM_9__156__i_2 vdd _037_ _102_ vdd pfet_05v0 w=1.13e-06 l=5e-07 nf=1 m=1
XM_10__157__i_1 n_10__157__net_0 _025_ vss vss nfet_05v0 w=8.2e-07 l=6e-07 nf=1 m=1
XM_10__157__i_0 _103_ _034_ n_10__157__net_0 vss nfet_05v0 w=8.2e-07 l=6e-07 nf=1 m=1
XM_10__157__i_3 _103_ _025_ vdd vdd pfet_05v0 w=1.13e-06 l=5e-07 nf=1 m=1
XM_10__157__i_2 vdd _034_ _103_ vdd pfet_05v0 w=1.13e-06 l=5e-07 nf=1 m=1
XM_11__158__i_1 _104_ _026_ vss vss nfet_05v0 w=5.65e-07 l=6e-07 nf=1 m=1
XM_11__158__i_0 vss _037_ _104_ vss nfet_05v0 w=5.65e-07 l=6e-07 nf=1 m=1
XM_11__158__i_3 n_11__158__net_0 _026_ vdd vdd pfet_05v0 w=1.22e-06 l=5e-07 nf=1 m=1
XM_11__158__i_2 _104_ _037_ n_11__158__net_0 vdd pfet_05v0 w=1.22e-06 l=5e-07 nf=1 m=1
XM_12__159__i_1 _105_ _104_ n_12__159__net_0 vss nfet_05v0 w=8.2e-07 l=6e-07 nf=1 m=1
XM_12__159__i_0 n_12__159__net_0 _103_ _105_ vss nfet_05v0 w=8.2e-07 l=6e-07 nf=1 m=1
XM_12__159__i_2 vss _102_ n_12__159__net_0 vss nfet_05v0 w=8.2e-07 l=6e-07 nf=1 m=1
XM_12__159__i_4 n_12__159__net_1 _104_ vdd vdd pfet_05v0 w=1.22e-06 l=5e-07 nf=1 m=1
XM_12__159__i_3 _105_ _103_ n_12__159__net_1 vdd pfet_05v0 w=1.22e-06 l=5e-07 nf=1 m=1
XM_12__159__i_5 vdd _102_ _105_ vdd pfet_05v0 w=1.13e-06 l=5e-07 nf=1 m=1
XM_13__160__i_6 n_13__160__I _099_ vss vss nfet_05v0 w=3.6e-07 l=6e-07 nf=1 m=1
XM_13__160__i_7 vss _027_ n_13__160__I vss nfet_05v0 w=3.6e-07 l=6e-07 nf=1 m=1
XM_13__160__i_2 _106_ n_13__160__I vss vss nfet_05v0 w=8.2e-07 l=6e-07 nf=1 m=1
XM_13__160__i_0 n_13__160__net_0 _027_ _106_ vss nfet_05v0 w=8.2e-07 l=6e-07 nf=1 m=1
XM_13__160__i_1 vss _099_ n_13__160__net_0 vss nfet_05v0 w=8.2e-07 l=6e-07 nf=1 m=1
XM_13__160__i_8 n_13__160__net_2 _099_ n_13__160__I vdd pfet_05v0 w=5.6e-07 l=5e-07 nf=1 m=1
XM_13__160__i_9 vdd _027_ n_13__160__net_2 vdd pfet_05v0 w=5.6e-07 l=5e-07 nf=1 m=1
XM_13__160__i_5 n_13__160__net_1 n_13__160__I vdd vdd pfet_05v0 w=1.22e-06 l=5e-07 nf=1 m=1
XM_13__160__i_3 _106_ _027_ n_13__160__net_1 vdd pfet_05v0 w=1.22e-06 l=5e-07 nf=1 m=1
XM_13__160__i_4 n_13__160__net_1 _099_ _106_ vdd pfet_05v0 w=1.22e-06 l=5e-07 nf=1 m=1
XM_14__161__i_2 n_14__161__net_0 _105_ n_14__161__Z_neg vss nfet_05v0 w=3.65e-07 l=6e-07 nf=1 m=1
XM_14__161__i_3 vss _106_ n_14__161__net_0 vss nfet_05v0 w=3.65e-07 l=6e-07 nf=1 m=1
XM_14__161__i_0 _107_ n_14__161__Z_neg vss vss nfet_05v0 w=8.15e-07 l=6e-07 nf=1 m=1
XM_14__161__i_4 n_14__161__Z_neg _105_ vdd vdd pfet_05v0 w=6e-07 l=5e-07 nf=1 m=1
XM_14__161__i_5 vdd _106_ n_14__161__Z_neg vdd pfet_05v0 w=6e-07 l=5e-07 nf=1 m=1
XM_14__161__i_1 _107_ n_14__161__Z_neg vdd vdd pfet_05v0 w=1.215e-06 l=5e-07 nf=1 m=1
XM_15__162__i_1 _108_ _107_ vss vss nfet_05v0 w=5.65e-07 l=6e-07 nf=1 m=1
XM_15__162__i_0 vss _101_ _108_ vss nfet_05v0 w=5.65e-07 l=6e-07 nf=1 m=1
XM_15__162__i_3 n_15__162__net_0 _107_ vdd vdd pfet_05v0 w=1.22e-06 l=5e-07 nf=1 m=1
XM_15__162__i_2 _108_ _101_ n_15__162__net_0 vdd pfet_05v0 w=1.22e-06 l=5e-07 nf=1 m=1
XM_16__163__i_8 n_16__163__net_2 _028_ n_16__163__I vss nfet_05v0 w=3.6e-07 l=6e-07 nf=1 m=1
XM_16__163__i_9 vss _097_ n_16__163__net_2 vss nfet_05v0 w=3.6e-07 l=6e-07 nf=1 m=1
XM_16__163__i_4 n_16__163__net_0 n_16__163__I vss vss nfet_05v0 w=8.2e-07 l=6e-07 nf=1 m=1
XM_16__163__i_2 n_16__163__Z_neg _097_ n_16__163__net_0 vss nfet_05v0 w=8.2e-07 l=6e-07 nf=1 m=1
XM_16__163__i_3 n_16__163__net_0 _028_ n_16__163__Z_neg vss nfet_05v0 w=8.2e-07 l=6e-07 nf=1 m=1
XM_16__163__i_0_0 _109_ n_16__163__Z_neg vss vss nfet_05v0 w=8.2e-07 l=6e-07 nf=1 m=1
XM_16__163__i_0_1 vss n_16__163__Z_neg _109_ vss nfet_05v0 w=8.2e-07 l=6e-07 nf=1 m=1
XM_16__163__i_10 n_16__163__I _028_ vdd vdd pfet_05v0 w=5.6e-07 l=5e-07 nf=1 m=1
XM_16__163__i_11 vdd _097_ n_16__163__I vdd pfet_05v0 w=5.6e-07 l=5e-07 nf=1 m=1
XM_16__163__i_7 n_16__163__Z_neg n_16__163__I vdd vdd pfet_05v0 w=1.095e-06 l=5e-07 nf=1 m=1
XM_16__163__i_5 n_16__163__net_1 _097_ n_16__163__Z_neg vdd pfet_05v0 w=1.095e-06 l=5e-07 nf=1 m=1
XM_16__163__i_6 vdd _028_ n_16__163__net_1 vdd pfet_05v0 w=1.095e-06 l=5e-07 nf=1 m=1
XM_16__163__i_1_0 _109_ n_16__163__Z_neg vdd vdd pfet_05v0 w=1.22e-06 l=5e-07 nf=1 m=1
XM_16__163__i_1_1 vdd n_16__163__Z_neg _109_ vdd pfet_05v0 w=1.22e-06 l=5e-07 nf=1 m=1
XM_17__164__i_1_3 _110_ _107_ n_17__164__net_0 vss nfet_05v0 w=8.2e-07 l=6e-07 nf=1 m=1
XM_17__164__i_0_3 n_17__164__net_0 _101_ _110_ vss nfet_05v0 w=8.2e-07 l=6e-07 nf=1 m=1
XM_17__164__i_0_2 _110_ _101_ n_17__164__net_0 vss nfet_05v0 w=8.2e-07 l=6e-07 nf=1 m=1
XM_17__164__i_1_2 n_17__164__net_0 _107_ _110_ vss nfet_05v0 w=8.2e-07 l=6e-07 nf=1 m=1
XM_17__164__i_1_1 _110_ _107_ n_17__164__net_0 vss nfet_05v0 w=8.2e-07 l=6e-07 nf=1 m=1
XM_17__164__i_0_1 n_17__164__net_0 _101_ _110_ vss nfet_05v0 w=8.2e-07 l=6e-07 nf=1 m=1
XM_17__164__i_0_0 _110_ _101_ n_17__164__net_0 vss nfet_05v0 w=8.2e-07 l=6e-07 nf=1 m=1
XM_17__164__i_1_0 n_17__164__net_0 _107_ _110_ vss nfet_05v0 w=8.2e-07 l=6e-07 nf=1 m=1
XM_17__164__i_2_3 vss _109_ n_17__164__net_0 vss nfet_05v0 w=8.2e-07 l=6e-07 nf=1 m=1
XM_17__164__i_2_2 n_17__164__net_0 _109_ vss vss nfet_05v0 w=8.2e-07 l=6e-07 nf=1 m=1
XM_17__164__i_2_1 vss _109_ n_17__164__net_0 vss nfet_05v0 w=8.2e-07 l=6e-07 nf=1 m=1
XM_17__164__i_2_0 n_17__164__net_0 _109_ vss vss nfet_05v0 w=8.2e-07 l=6e-07 nf=1 m=1
XM_17__164__i_4_3 n_17__164__net_1_0 _107_ vdd vdd pfet_05v0 w=1.095e-06 l=5e-07 nf=1 m=1
XM_17__164__i_3_3 _110_ _101_ n_17__164__net_1_0 vdd pfet_05v0 w=1.095e-06 l=5e-07 nf=1 m=1
XM_17__164__i_3_2 n_17__164__net_1_1 _101_ _110_ vdd pfet_05v0 w=1.095e-06 l=5e-07 nf=1 m=1
XM_17__164__i_4_2 vdd _107_ n_17__164__net_1_1 vdd pfet_05v0 w=1.095e-06 l=5e-07 nf=1 m=1
XM_17__164__i_4_1 n_17__164__net_1_2 _107_ vdd vdd pfet_05v0 w=1.095e-06 l=5e-07 nf=1 m=1
XM_17__164__i_3_1 _110_ _101_ n_17__164__net_1_2 vdd pfet_05v0 w=1.095e-06 l=5e-07 nf=1 m=1
XM_17__164__i_3_0 n_17__164__net_1_3 _101_ _110_ vdd pfet_05v0 w=1.095e-06 l=5e-07 nf=1 m=1
XM_17__164__i_4_0 vdd _107_ n_17__164__net_1_3 vdd pfet_05v0 w=1.095e-06 l=5e-07 nf=1 m=1
XM_17__164__i_5_3 _110_ _109_ vdd vdd pfet_05v0 w=9.55e-07 l=5e-07 nf=1 m=1
XM_17__164__i_5_2 vdd _109_ _110_ vdd pfet_05v0 w=9.55e-07 l=5e-07 nf=1 m=1
XM_17__164__i_5_1 _110_ _109_ vdd vdd pfet_05v0 w=9.55e-07 l=5e-07 nf=1 m=1
XM_17__164__i_5_0 vdd _109_ _110_ vdd pfet_05v0 w=9.55e-07 l=5e-07 nf=1 m=1
XM_18__165__i_2_1 vss _095_ n_18__165__net_0 vss nfet_05v0 w=8.2e-07 l=6e-07 nf=1 m=1
XM_18__165__i_2_0 n_18__165__net_0 _095_ vss vss nfet_05v0 w=8.2e-07 l=6e-07 nf=1 m=1
XM_18__165__i_1_1 _111_ _094_ n_18__165__net_0 vss nfet_05v0 w=8.2e-07 l=6e-07 nf=1 m=1
XM_18__165__i_0_1 n_18__165__net_0 _096_ _111_ vss nfet_05v0 w=8.2e-07 l=6e-07 nf=1 m=1
XM_18__165__i_0_0 _111_ _096_ n_18__165__net_0 vss nfet_05v0 w=8.2e-07 l=6e-07 nf=1 m=1
XM_18__165__i_1_0 n_18__165__net_0 _094_ _111_ vss nfet_05v0 w=8.2e-07 l=6e-07 nf=1 m=1
XM_18__165__i_5_1 _111_ _095_ vdd vdd pfet_05v0 w=9.55e-07 l=5e-07 nf=1 m=1
XM_18__165__i_5_0 vdd _095_ _111_ vdd pfet_05v0 w=9.55e-07 l=5e-07 nf=1 m=1
XM_18__165__i_4_1 n_18__165__net_1_0 _094_ vdd vdd pfet_05v0 w=1.095e-06 l=5e-07 nf=1 m=1
XM_18__165__i_3_1 _111_ _096_ n_18__165__net_1_0 vdd pfet_05v0 w=1.095e-06 l=5e-07 nf=1 m=1
XM_18__165__i_3_0 n_18__165__net_1_1 _096_ _111_ vdd pfet_05v0 w=1.095e-06 l=5e-07 nf=1 m=1
XM_18__165__i_4_0 vdd _094_ n_18__165__net_1_1 vdd pfet_05v0 w=1.095e-06 l=5e-07 nf=1 m=1
XM_19__166__i_1 n_19__166__net_0 _040_ vss vss nfet_05v0 w=8.2e-07 l=6e-07 nf=1 m=1
XM_19__166__i_0 _112_ _140_ n_19__166__net_0 vss nfet_05v0 w=8.2e-07 l=6e-07 nf=1 m=1
XM_19__166__i_3 _112_ _040_ vdd vdd pfet_05v0 w=1.13e-06 l=5e-07 nf=1 m=1
XM_19__166__i_2 vdd _140_ _112_ vdd pfet_05v0 w=1.13e-06 l=5e-07 nf=1 m=1
XM_20__167__i_0 _113_ _112_ vss vss nfet_05v0 w=4.8e-07 l=6e-07 nf=1 m=1
XM_20__167__i_1 _113_ _112_ vdd vdd pfet_05v0 w=1.22e-06 l=5e-07 nf=1 m=1
XM_21__168__i_6 n_21__168__I _040_ vss vss nfet_05v0 w=3.6e-07 l=6e-07 nf=1 m=1
XM_21__168__i_7 vss _140_ n_21__168__I vss nfet_05v0 w=3.6e-07 l=6e-07 nf=1 m=1
XM_21__168__i_2 _114_ n_21__168__I vss vss nfet_05v0 w=8.2e-07 l=6e-07 nf=1 m=1
XM_21__168__i_0 n_21__168__net_0 _140_ _114_ vss nfet_05v0 w=8.2e-07 l=6e-07 nf=1 m=1
XM_21__168__i_1 vss _040_ n_21__168__net_0 vss nfet_05v0 w=8.2e-07 l=6e-07 nf=1 m=1
XM_21__168__i_8 n_21__168__net_2 _040_ n_21__168__I vdd pfet_05v0 w=5.6e-07 l=5e-07 nf=1 m=1
XM_21__168__i_9 vdd _140_ n_21__168__net_2 vdd pfet_05v0 w=5.6e-07 l=5e-07 nf=1 m=1
XM_21__168__i_5 n_21__168__net_1 n_21__168__I vdd vdd pfet_05v0 w=1.22e-06 l=5e-07 nf=1 m=1
XM_21__168__i_3 _114_ _140_ n_21__168__net_1 vdd pfet_05v0 w=1.22e-06 l=5e-07 nf=1 m=1
XM_21__168__i_4 n_21__168__net_1 _040_ _114_ vdd pfet_05v0 w=1.22e-06 l=5e-07 nf=1 m=1
XM_22__169__i_6 n_22__169__I _114_ vss vss nfet_05v0 w=3.6e-07 l=6e-07 nf=1 m=1
XM_22__169__i_7 vss _111_ n_22__169__I vss nfet_05v0 w=3.6e-07 l=6e-07 nf=1 m=1
XM_22__169__i_2 _115_ n_22__169__I vss vss nfet_05v0 w=8.2e-07 l=6e-07 nf=1 m=1
XM_22__169__i_0 n_22__169__net_0 _111_ _115_ vss nfet_05v0 w=8.2e-07 l=6e-07 nf=1 m=1
XM_22__169__i_1 vss _114_ n_22__169__net_0 vss nfet_05v0 w=8.2e-07 l=6e-07 nf=1 m=1
XM_22__169__i_8 n_22__169__net_2 _114_ n_22__169__I vdd pfet_05v0 w=5.6e-07 l=5e-07 nf=1 m=1
XM_22__169__i_9 vdd _111_ n_22__169__net_2 vdd pfet_05v0 w=5.6e-07 l=5e-07 nf=1 m=1
XM_22__169__i_5 n_22__169__net_1 n_22__169__I vdd vdd pfet_05v0 w=1.22e-06 l=5e-07 nf=1 m=1
XM_22__169__i_3 _115_ _111_ n_22__169__net_1 vdd pfet_05v0 w=1.22e-06 l=5e-07 nf=1 m=1
XM_22__169__i_4 n_22__169__net_1 _114_ _115_ vdd pfet_05v0 w=1.22e-06 l=5e-07 nf=1 m=1
XM_23__170__i_1 n_23__170__net_0 _115_ vss vss nfet_05v0 w=8.2e-07 l=6e-07 nf=1 m=1
XM_23__170__i_0 _116_ _029_ n_23__170__net_0 vss nfet_05v0 w=8.2e-07 l=6e-07 nf=1 m=1
XM_23__170__i_3 _116_ _115_ vdd vdd pfet_05v0 w=1.13e-06 l=5e-07 nf=1 m=1
XM_23__170__i_2 vdd _029_ _116_ vdd pfet_05v0 w=1.13e-06 l=5e-07 nf=1 m=1
XM_24__171__i_0 _117_ _116_ vss vss nfet_05v0 w=4.8e-07 l=6e-07 nf=1 m=1
XM_24__171__i_1 _117_ _116_ vdd vdd pfet_05v0 w=1.22e-06 l=5e-07 nf=1 m=1
XM_25__172__i_6 n_25__172__net_2 _115_ n_25__172__I vss nfet_05v0 w=3.6e-07 l=6e-07 nf=1 m=1
XM_25__172__i_7 vss _029_ n_25__172__net_2 vss nfet_05v0 w=3.6e-07 l=6e-07 nf=1 m=1
XM_25__172__i_2 n_25__172__net_0 n_25__172__I vss vss nfet_05v0 w=8.2e-07 l=6e-07 nf=1 m=1
XM_25__172__i_0 _118_ _029_ n_25__172__net_0 vss nfet_05v0 w=8.2e-07 l=6e-07 nf=1 m=1
XM_25__172__i_1 n_25__172__net_0 _115_ _118_ vss nfet_05v0 w=8.2e-07 l=6e-07 nf=1 m=1
XM_25__172__i_8 n_25__172__I _115_ vdd vdd pfet_05v0 w=5.6e-07 l=5e-07 nf=1 m=1
XM_25__172__i_9 vdd _029_ n_25__172__I vdd pfet_05v0 w=5.6e-07 l=5e-07 nf=1 m=1
XM_25__172__i_5 _118_ n_25__172__I vdd vdd pfet_05v0 w=1.095e-06 l=5e-07 nf=1 m=1
XM_25__172__i_3 n_25__172__net_1 _029_ _118_ vdd pfet_05v0 w=1.095e-06 l=5e-07 nf=1 m=1
XM_25__172__i_4 vdd _115_ n_25__172__net_1 vdd pfet_05v0 w=1.095e-06 l=5e-07 nf=1 m=1
XM_26__173__i_2_0 _119_ _118_ vss vss nfet_05v0 w=5.65e-07 l=6e-07 nf=1 m=1
XM_26__173__i_2_1 vss _118_ _119_ vss nfet_05v0 w=5.65e-07 l=6e-07 nf=1 m=1
XM_26__173__i_1_0 n_26__173__net_0_0 _098_ vss vss nfet_05v0 w=7.75e-07 l=6e-07 nf=1 m=1
XM_26__173__i_0_1 _119_ _110_ n_26__173__net_0_0 vss nfet_05v0 w=7.75e-07 l=6e-07 nf=1 m=1
XM_26__173__i_0_0 n_26__173__net_0_1 _110_ _119_ vss nfet_05v0 w=7.75e-07 l=6e-07 nf=1 m=1
XM_26__173__i_1_1 vss _098_ n_26__173__net_0_1 vss nfet_05v0 w=7.75e-07 l=6e-07 nf=1 m=1
XM_26__173__i_5_0 vdd _118_ n_26__173__net_1 vdd pfet_05v0 w=1.215e-06 l=5e-07 nf=1 m=1
XM_26__173__i_5_1 n_26__173__net_1 _118_ vdd vdd pfet_05v0 w=1.215e-06 l=5e-07 nf=1 m=1
XM_26__173__i_4_0 _119_ _098_ n_26__173__net_1 vdd pfet_05v0 w=1.215e-06 l=5e-07 nf=1 m=1
XM_26__173__i_3_1 n_26__173__net_1 _110_ _119_ vdd pfet_05v0 w=1.215e-06 l=5e-07 nf=1 m=1
XM_26__173__i_3_0 _119_ _110_ n_26__173__net_1 vdd pfet_05v0 w=1.215e-06 l=5e-07 nf=1 m=1
XM_26__173__i_4_1 n_26__173__net_1 _098_ _119_ vdd pfet_05v0 w=1.215e-06 l=5e-07 nf=1 m=1
XM_27__174__i_2 n_27__174__net_0 _098_ n_27__174__Z_neg vss nfet_05v0 w=3.8e-07 l=6e-07 nf=1 m=1
XM_27__174__i_3 n_27__174__net_1 _110_ n_27__174__net_0 vss nfet_05v0 w=3.8e-07 l=6e-07 nf=1 m=1
XM_27__174__i_4 vss _118_ n_27__174__net_1 vss nfet_05v0 w=3.8e-07 l=6e-07 nf=1 m=1
XM_27__174__i_0 _120_ n_27__174__Z_neg vss vss nfet_05v0 w=7.75e-07 l=6e-07 nf=1 m=1
XM_27__174__i_5 vdd _098_ n_27__174__Z_neg vdd pfet_05v0 w=5.35e-07 l=5e-07 nf=1 m=1
XM_27__174__i_6 n_27__174__Z_neg _110_ vdd vdd pfet_05v0 w=5.35e-07 l=5e-07 nf=1 m=1
XM_27__174__i_7 vdd _118_ n_27__174__Z_neg vdd pfet_05v0 w=5.35e-07 l=5e-07 nf=1 m=1
XM_27__174__i_1 _120_ n_27__174__Z_neg vdd vdd pfet_05v0 w=1.215e-06 l=5e-07 nf=1 m=1
XM_28__175__i_1 _005_ _120_ vss vss nfet_05v0 w=5.65e-07 l=6e-07 nf=1 m=1
XM_28__175__i_0 vss _119_ _005_ vss nfet_05v0 w=5.65e-07 l=6e-07 nf=1 m=1
XM_28__175__i_3 n_28__175__net_0 _120_ vdd vdd pfet_05v0 w=1.22e-06 l=5e-07 nf=1 m=1
XM_28__175__i_2 _005_ _119_ n_28__175__net_0 vdd pfet_05v0 w=1.22e-06 l=5e-07 nf=1 m=1
XM_29__176__i_6 n_29__176__net_2 _109_ n_29__176__I vss nfet_05v0 w=3.6e-07 l=6e-07 nf=1 m=1
XM_29__176__i_7 vss _108_ n_29__176__net_2 vss nfet_05v0 w=3.6e-07 l=6e-07 nf=1 m=1
XM_29__176__i_2 n_29__176__net_0 n_29__176__I vss vss nfet_05v0 w=8.2e-07 l=6e-07 nf=1 m=1
XM_29__176__i_0 _004_ _108_ n_29__176__net_0 vss nfet_05v0 w=8.2e-07 l=6e-07 nf=1 m=1
XM_29__176__i_1 n_29__176__net_0 _109_ _004_ vss nfet_05v0 w=8.2e-07 l=6e-07 nf=1 m=1
XM_29__176__i_8 n_29__176__I _109_ vdd vdd pfet_05v0 w=5.6e-07 l=5e-07 nf=1 m=1
XM_29__176__i_9 vdd _108_ n_29__176__I vdd pfet_05v0 w=5.6e-07 l=5e-07 nf=1 m=1
XM_29__176__i_5 _004_ n_29__176__I vdd vdd pfet_05v0 w=1.095e-06 l=5e-07 nf=1 m=1
XM_29__176__i_3 n_29__176__net_1 _108_ _004_ vdd pfet_05v0 w=1.095e-06 l=5e-07 nf=1 m=1
XM_29__176__i_4 vdd _109_ n_29__176__net_1 vdd pfet_05v0 w=1.095e-06 l=5e-07 nf=1 m=1
XM_30__177__i_6 n_30__177__I _106_ vss vss nfet_05v0 w=3.6e-07 l=6e-07 nf=1 m=1
XM_30__177__i_7 vss _105_ n_30__177__I vss nfet_05v0 w=3.6e-07 l=6e-07 nf=1 m=1
XM_30__177__i_2 _003_ n_30__177__I vss vss nfet_05v0 w=8.2e-07 l=6e-07 nf=1 m=1
XM_30__177__i_0 n_30__177__net_0 _105_ _003_ vss nfet_05v0 w=8.2e-07 l=6e-07 nf=1 m=1
XM_30__177__i_1 vss _106_ n_30__177__net_0 vss nfet_05v0 w=8.2e-07 l=6e-07 nf=1 m=1
XM_30__177__i_8 n_30__177__net_2 _106_ n_30__177__I vdd pfet_05v0 w=5.6e-07 l=5e-07 nf=1 m=1
XM_30__177__i_9 vdd _105_ n_30__177__net_2 vdd pfet_05v0 w=5.6e-07 l=5e-07 nf=1 m=1
XM_30__177__i_5 n_30__177__net_1 n_30__177__I vdd vdd pfet_05v0 w=1.22e-06 l=5e-07 nf=1 m=1
XM_30__177__i_3 _003_ _105_ n_30__177__net_1 vdd pfet_05v0 w=1.22e-06 l=5e-07 nf=1 m=1
XM_30__177__i_4 n_30__177__net_1 _106_ _003_ vdd pfet_05v0 w=1.22e-06 l=5e-07 nf=1 m=1
XM_31__178__i_12 n_31__178__I _026_ vss vss nfet_05v0 w=3.6e-07 l=6e-07 nf=1 m=1
XM_31__178__i_13 vss _037_ n_31__178__I vss nfet_05v0 w=3.6e-07 l=6e-07 nf=1 m=1
XM_31__178__i_2 n_31__178__I2 n_31__178__I vss vss nfet_05v0 w=3.6e-07 l=6e-07 nf=1 m=1
XM_31__178__i_0 n_31__178__net_0 _037_ n_31__178__I2 vss nfet_05v0 w=3.6e-07 l=6e-07 nf=1 m=1
XM_31__178__i_1 vss _026_ n_31__178__net_0 vss nfet_05v0 w=3.6e-07 l=6e-07 nf=1 m=1
XM_31__178__i_16 n_31__178__net_5 n_31__178__I2 n_31__178__I3 vss nfet_05v0 w=3.6e-07 l=6e-07 nf=1 m=1
XM_31__178__i_17 vss _103_ n_31__178__net_5 vss nfet_05v0 w=3.6e-07 l=6e-07 nf=1 m=1
XM_31__178__i_8 n_31__178__net_2 n_31__178__I3 vss vss nfet_05v0 w=8.2e-07 l=6e-07 nf=1 m=1
XM_31__178__i_6 _002_ _103_ n_31__178__net_2 vss nfet_05v0 w=8.2e-07 l=6e-07 nf=1 m=1
XM_31__178__i_7 n_31__178__net_2 n_31__178__I2 _002_ vss nfet_05v0 w=8.2e-07 l=6e-07 nf=1 m=1
XM_31__178__i_14 n_31__178__net_4 _026_ n_31__178__I vdd pfet_05v0 w=3.6e-07 l=5e-07 nf=1 m=1
XM_31__178__i_15 vdd _037_ n_31__178__net_4 vdd pfet_05v0 w=3.6e-07 l=5e-07 nf=1 m=1
XM_31__178__i_5 n_31__178__net_1 n_31__178__I vdd vdd pfet_05v0 w=5.6e-07 l=5e-07 nf=1 m=1
XM_31__178__i_3 n_31__178__I2 _037_ n_31__178__net_1 vdd pfet_05v0 w=5.6e-07 l=5e-07 nf=1 m=1
XM_31__178__i_4 n_31__178__net_1 _026_ n_31__178__I2 vdd pfet_05v0 w=5.6e-07 l=5e-07 nf=1 m=1
XM_31__178__i_18 n_31__178__I3 n_31__178__I2 vdd vdd pfet_05v0 w=5.6e-07 l=5e-07 nf=1 m=1
XM_31__178__i_19 vdd _103_ n_31__178__I3 vdd pfet_05v0 w=5.6e-07 l=5e-07 nf=1 m=1
XM_31__178__i_11 _002_ n_31__178__I3 vdd vdd pfet_05v0 w=1.095e-06 l=5e-07 nf=1 m=1
XM_31__178__i_9 n_31__178__net_3 _103_ _002_ vdd pfet_05v0 w=1.095e-06 l=5e-07 nf=1 m=1
XM_31__178__i_10 vdd n_31__178__I2 n_31__178__net_3 vdd pfet_05v0 w=1.095e-06 l=5e-07 nf=1 m=1
XM_32__179__i_1 n_32__179__net_0 _041_ vss vss nfet_05v0 w=8.2e-07 l=6e-07 nf=1 m=1
XM_32__179__i_0 _121_ _141_ n_32__179__net_0 vss nfet_05v0 w=8.2e-07 l=6e-07 nf=1 m=1
XM_32__179__i_3 _121_ _041_ vdd vdd pfet_05v0 w=1.13e-06 l=5e-07 nf=1 m=1
XM_32__179__i_2 vdd _141_ _121_ vdd pfet_05v0 w=1.13e-06 l=5e-07 nf=1 m=1
XM_33__180__i_1 n_33__180__net_0 _114_ vss vss nfet_05v0 w=8.2e-07 l=6e-07 nf=1 m=1
XM_33__180__i_0 _122_ _111_ n_33__180__net_0 vss nfet_05v0 w=8.2e-07 l=6e-07 nf=1 m=1
XM_33__180__i_2 vss _113_ _122_ vss nfet_05v0 w=5.1e-07 l=6e-07 nf=1 m=1
XM_33__180__i_4 _122_ _114_ n_33__180__net_1 vdd pfet_05v0 w=1.215e-06 l=5e-07 nf=1 m=1
XM_33__180__i_3 n_33__180__net_1 _111_ _122_ vdd pfet_05v0 w=1.215e-06 l=5e-07 nf=1 m=1
XM_33__180__i_5 vdd _113_ n_33__180__net_1 vdd pfet_05v0 w=1.215e-06 l=5e-07 nf=1 m=1
XM_34__181__i_1 _123_ _041_ vss vss nfet_05v0 w=5.65e-07 l=6e-07 nf=1 m=1
XM_34__181__i_0 vss _141_ _123_ vss nfet_05v0 w=5.65e-07 l=6e-07 nf=1 m=1
XM_34__181__i_3 n_34__181__net_0 _041_ vdd vdd pfet_05v0 w=1.22e-06 l=5e-07 nf=1 m=1
XM_34__181__i_2 _123_ _141_ n_34__181__net_0 vdd pfet_05v0 w=1.22e-06 l=5e-07 nf=1 m=1
XM_35__182__i_1 _124_ _122_ n_35__182__net_0 vss nfet_05v0 w=8.2e-07 l=6e-07 nf=1 m=1
XM_35__182__i_0 n_35__182__net_0 _123_ _124_ vss nfet_05v0 w=8.2e-07 l=6e-07 nf=1 m=1
XM_35__182__i_2 vss _121_ n_35__182__net_0 vss nfet_05v0 w=8.2e-07 l=6e-07 nf=1 m=1
XM_35__182__i_4 n_35__182__net_1 _122_ vdd vdd pfet_05v0 w=1.22e-06 l=5e-07 nf=1 m=1
XM_35__182__i_3 _124_ _123_ n_35__182__net_1 vdd pfet_05v0 w=1.22e-06 l=5e-07 nf=1 m=1
XM_35__182__i_5 vdd _121_ _124_ vdd pfet_05v0 w=1.13e-06 l=5e-07 nf=1 m=1
XM_36__183__i_1 n_36__183__net_0 _042_ vss vss nfet_05v0 w=8.2e-07 l=6e-07 nf=1 m=1
XM_36__183__i_0 _125_ _142_ n_36__183__net_0 vss nfet_05v0 w=8.2e-07 l=6e-07 nf=1 m=1
XM_36__183__i_3 _125_ _042_ vdd vdd pfet_05v0 w=1.13e-06 l=5e-07 nf=1 m=1
XM_36__183__i_2 vdd _142_ _125_ vdd pfet_05v0 w=1.13e-06 l=5e-07 nf=1 m=1
XM_37__184__i_6 n_37__184__I _042_ vss vss nfet_05v0 w=3.6e-07 l=6e-07 nf=1 m=1
XM_37__184__i_7 vss _142_ n_37__184__I vss nfet_05v0 w=3.6e-07 l=6e-07 nf=1 m=1
XM_37__184__i_2 _126_ n_37__184__I vss vss nfet_05v0 w=8.2e-07 l=6e-07 nf=1 m=1
XM_37__184__i_0 n_37__184__net_0 _142_ _126_ vss nfet_05v0 w=8.2e-07 l=6e-07 nf=1 m=1
XM_37__184__i_1 vss _042_ n_37__184__net_0 vss nfet_05v0 w=8.2e-07 l=6e-07 nf=1 m=1
XM_37__184__i_8 n_37__184__net_2 _042_ n_37__184__I vdd pfet_05v0 w=5.6e-07 l=5e-07 nf=1 m=1
XM_37__184__i_9 vdd _142_ n_37__184__net_2 vdd pfet_05v0 w=5.6e-07 l=5e-07 nf=1 m=1
XM_37__184__i_5 n_37__184__net_1 n_37__184__I vdd vdd pfet_05v0 w=1.22e-06 l=5e-07 nf=1 m=1
XM_37__184__i_3 _126_ _142_ n_37__184__net_1 vdd pfet_05v0 w=1.22e-06 l=5e-07 nf=1 m=1
XM_37__184__i_4 n_37__184__net_1 _042_ _126_ vdd pfet_05v0 w=1.22e-06 l=5e-07 nf=1 m=1
XM_38__185__i_1 n_38__185__net_0 _126_ vss vss nfet_05v0 w=8.2e-07 l=6e-07 nf=1 m=1
XM_38__185__i_0 _127_ _124_ n_38__185__net_0 vss nfet_05v0 w=8.2e-07 l=6e-07 nf=1 m=1
XM_38__185__i_3 _127_ _126_ vdd vdd pfet_05v0 w=1.13e-06 l=5e-07 nf=1 m=1
XM_38__185__i_2 vdd _124_ _127_ vdd pfet_05v0 w=1.13e-06 l=5e-07 nf=1 m=1
XM_39__186__i_6 n_39__186__I _126_ vss vss nfet_05v0 w=3.6e-07 l=6e-07 nf=1 m=1
XM_39__186__i_7 vss _124_ n_39__186__I vss nfet_05v0 w=3.6e-07 l=6e-07 nf=1 m=1
XM_39__186__i_2 _128_ n_39__186__I vss vss nfet_05v0 w=8.2e-07 l=6e-07 nf=1 m=1
XM_39__186__i_0 n_39__186__net_0 _124_ _128_ vss nfet_05v0 w=8.2e-07 l=6e-07 nf=1 m=1
XM_39__186__i_1 vss _126_ n_39__186__net_0 vss nfet_05v0 w=8.2e-07 l=6e-07 nf=1 m=1
XM_39__186__i_8 n_39__186__net_2 _126_ n_39__186__I vdd pfet_05v0 w=5.6e-07 l=5e-07 nf=1 m=1
XM_39__186__i_9 vdd _124_ n_39__186__net_2 vdd pfet_05v0 w=5.6e-07 l=5e-07 nf=1 m=1
XM_39__186__i_5 n_39__186__net_1 n_39__186__I vdd vdd pfet_05v0 w=1.22e-06 l=5e-07 nf=1 m=1
XM_39__186__i_3 _128_ _124_ n_39__186__net_1 vdd pfet_05v0 w=1.22e-06 l=5e-07 nf=1 m=1
XM_39__186__i_4 n_39__186__net_1 _126_ _128_ vdd pfet_05v0 w=1.22e-06 l=5e-07 nf=1 m=1
XM_40__187__i_1 n_40__187__net_0 _128_ vss vss nfet_05v0 w=8.2e-07 l=6e-07 nf=1 m=1
XM_40__187__i_0 _129_ _031_ n_40__187__net_0 vss nfet_05v0 w=8.2e-07 l=6e-07 nf=1 m=1
XM_40__187__i_3 _129_ _128_ vdd vdd pfet_05v0 w=1.13e-06 l=5e-07 nf=1 m=1
XM_40__187__i_2 vdd _031_ _129_ vdd pfet_05v0 w=1.13e-06 l=5e-07 nf=1 m=1
XM_41__188__i_12 n_41__188__I _041_ vss vss nfet_05v0 w=3.6e-07 l=6e-07 nf=1 m=1
XM_41__188__i_13 vss _141_ n_41__188__I vss nfet_05v0 w=3.6e-07 l=6e-07 nf=1 m=1
XM_41__188__i_2 n_41__188__I2 n_41__188__I vss vss nfet_05v0 w=3.6e-07 l=6e-07 nf=1 m=1
XM_41__188__i_0 n_41__188__net_0 _141_ n_41__188__I2 vss nfet_05v0 w=3.6e-07 l=6e-07 nf=1 m=1
XM_41__188__i_1 vss _041_ n_41__188__net_0 vss nfet_05v0 w=3.6e-07 l=6e-07 nf=1 m=1
XM_41__188__i_16 n_41__188__net_5 n_41__188__I2 n_41__188__I3 vss nfet_05v0 w=3.6e-07 l=6e-07 nf=1 m=1
XM_41__188__i_17 vss _122_ n_41__188__net_5 vss nfet_05v0 w=3.6e-07 l=6e-07 nf=1 m=1
XM_41__188__i_8 n_41__188__net_2 n_41__188__I3 vss vss nfet_05v0 w=8.2e-07 l=6e-07 nf=1 m=1
XM_41__188__i_6 _130_ _122_ n_41__188__net_2 vss nfet_05v0 w=8.2e-07 l=6e-07 nf=1 m=1
XM_41__188__i_7 n_41__188__net_2 n_41__188__I2 _130_ vss nfet_05v0 w=8.2e-07 l=6e-07 nf=1 m=1
XM_41__188__i_14 n_41__188__net_4 _041_ n_41__188__I vdd pfet_05v0 w=3.6e-07 l=5e-07 nf=1 m=1
XM_41__188__i_15 vdd _141_ n_41__188__net_4 vdd pfet_05v0 w=3.6e-07 l=5e-07 nf=1 m=1
XM_41__188__i_5 n_41__188__net_1 n_41__188__I vdd vdd pfet_05v0 w=5.6e-07 l=5e-07 nf=1 m=1
XM_41__188__i_3 n_41__188__I2 _141_ n_41__188__net_1 vdd pfet_05v0 w=5.6e-07 l=5e-07 nf=1 m=1
XM_41__188__i_4 n_41__188__net_1 _041_ n_41__188__I2 vdd pfet_05v0 w=5.6e-07 l=5e-07 nf=1 m=1
XM_41__188__i_18 n_41__188__I3 n_41__188__I2 vdd vdd pfet_05v0 w=5.6e-07 l=5e-07 nf=1 m=1
XM_41__188__i_19 vdd _122_ n_41__188__I3 vdd pfet_05v0 w=5.6e-07 l=5e-07 nf=1 m=1
XM_41__188__i_11 _130_ n_41__188__I3 vdd vdd pfet_05v0 w=1.095e-06 l=5e-07 nf=1 m=1
XM_41__188__i_9 n_41__188__net_3 _122_ _130_ vdd pfet_05v0 w=1.095e-06 l=5e-07 nf=1 m=1
XM_41__188__i_10 vdd n_41__188__I2 n_41__188__net_3 vdd pfet_05v0 w=1.095e-06 l=5e-07 nf=1 m=1
XM_42__189__i_1 n_42__189__net_0 _130_ vss vss nfet_05v0 w=8.2e-07 l=6e-07 nf=1 m=1
XM_42__189__i_0 _131_ _030_ n_42__189__net_0 vss nfet_05v0 w=8.2e-07 l=6e-07 nf=1 m=1
XM_42__189__i_3 _131_ _130_ vdd vdd pfet_05v0 w=1.13e-06 l=5e-07 nf=1 m=1
XM_42__189__i_2 vdd _030_ _131_ vdd pfet_05v0 w=1.13e-06 l=5e-07 nf=1 m=1
XM_43__190__i_6 n_43__190__I _130_ vss vss nfet_05v0 w=3.6e-07 l=6e-07 nf=1 m=1
XM_43__190__i_7 vss _030_ n_43__190__I vss nfet_05v0 w=3.6e-07 l=6e-07 nf=1 m=1
XM_43__190__i_2 _132_ n_43__190__I vss vss nfet_05v0 w=8.2e-07 l=6e-07 nf=1 m=1
XM_43__190__i_0 n_43__190__net_0 _030_ _132_ vss nfet_05v0 w=8.2e-07 l=6e-07 nf=1 m=1
XM_43__190__i_1 vss _130_ n_43__190__net_0 vss nfet_05v0 w=8.2e-07 l=6e-07 nf=1 m=1
XM_43__190__i_8 n_43__190__net_2 _130_ n_43__190__I vdd pfet_05v0 w=5.6e-07 l=5e-07 nf=1 m=1
XM_43__190__i_9 vdd _030_ n_43__190__net_2 vdd pfet_05v0 w=5.6e-07 l=5e-07 nf=1 m=1
XM_43__190__i_5 n_43__190__net_1 n_43__190__I vdd vdd pfet_05v0 w=1.22e-06 l=5e-07 nf=1 m=1
XM_43__190__i_3 _132_ _030_ n_43__190__net_1 vdd pfet_05v0 w=1.22e-06 l=5e-07 nf=1 m=1
XM_43__190__i_4 n_43__190__net_1 _130_ _132_ vdd pfet_05v0 w=1.22e-06 l=5e-07 nf=1 m=1
XM_44__191__i_1 _133_ _117_ n_44__191__net_0 vss nfet_05v0 w=8.2e-07 l=6e-07 nf=1 m=1
XM_44__191__i_0 n_44__191__net_0 _119_ _133_ vss nfet_05v0 w=8.2e-07 l=6e-07 nf=1 m=1
XM_44__191__i_2 vss _132_ n_44__191__net_0 vss nfet_05v0 w=8.2e-07 l=6e-07 nf=1 m=1
XM_44__191__i_4 n_44__191__net_1 _117_ vdd vdd pfet_05v0 w=1.22e-06 l=5e-07 nf=1 m=1
XM_44__191__i_3 _133_ _119_ n_44__191__net_1 vdd pfet_05v0 w=1.22e-06 l=5e-07 nf=1 m=1
XM_44__191__i_5 vdd _132_ _133_ vdd pfet_05v0 w=1.13e-06 l=5e-07 nf=1 m=1
XM_45__192__i_2 n_45__192__net_0 _133_ n_45__192__Z_neg vss nfet_05v0 w=8.15e-07 l=6e-07 nf=1 m=1
XM_45__192__i_3 vss _131_ n_45__192__net_0 vss nfet_05v0 w=8.15e-07 l=6e-07 nf=1 m=1
XM_45__192__i_0_0 _134_ n_45__192__Z_neg vss vss nfet_05v0 w=8.15e-07 l=6e-07 nf=1 m=1
XM_45__192__i_0_1 vss n_45__192__Z_neg _134_ vss nfet_05v0 w=8.15e-07 l=6e-07 nf=1 m=1
XM_45__192__i_4 n_45__192__Z_neg _133_ vdd vdd pfet_05v0 w=1.07e-06 l=5e-07 nf=1 m=1
XM_45__192__i_5 vdd _131_ n_45__192__Z_neg vdd pfet_05v0 w=1.07e-06 l=5e-07 nf=1 m=1
XM_45__192__i_1_0 _134_ n_45__192__Z_neg vdd vdd pfet_05v0 w=1.215e-06 l=5e-07 nf=1 m=1
XM_45__192__i_1_1 vdd n_45__192__Z_neg _134_ vdd pfet_05v0 w=1.215e-06 l=5e-07 nf=1 m=1
XM_46__193__i_1 _135_ _128_ vss vss nfet_05v0 w=5.65e-07 l=6e-07 nf=1 m=1
XM_46__193__i_0 vss _031_ _135_ vss nfet_05v0 w=5.65e-07 l=6e-07 nf=1 m=1
XM_46__193__i_3 n_46__193__net_0 _128_ vdd vdd pfet_05v0 w=1.22e-06 l=5e-07 nf=1 m=1
XM_46__193__i_2 _135_ _031_ n_46__193__net_0 vdd pfet_05v0 w=1.22e-06 l=5e-07 nf=1 m=1
XM_47__194__i_1_3 _136_ _135_ n_47__194__net_0 vss nfet_05v0 w=8.2e-07 l=6e-07 nf=1 m=1
XM_47__194__i_0_3 n_47__194__net_0 _134_ _136_ vss nfet_05v0 w=8.2e-07 l=6e-07 nf=1 m=1
XM_47__194__i_0_2 _136_ _134_ n_47__194__net_0 vss nfet_05v0 w=8.2e-07 l=6e-07 nf=1 m=1
XM_47__194__i_1_2 n_47__194__net_0 _135_ _136_ vss nfet_05v0 w=8.2e-07 l=6e-07 nf=1 m=1
XM_47__194__i_1_1 _136_ _135_ n_47__194__net_0 vss nfet_05v0 w=8.2e-07 l=6e-07 nf=1 m=1
XM_47__194__i_0_1 n_47__194__net_0 _134_ _136_ vss nfet_05v0 w=8.2e-07 l=6e-07 nf=1 m=1
XM_47__194__i_0_0 _136_ _134_ n_47__194__net_0 vss nfet_05v0 w=8.2e-07 l=6e-07 nf=1 m=1
XM_47__194__i_1_0 n_47__194__net_0 _135_ _136_ vss nfet_05v0 w=8.2e-07 l=6e-07 nf=1 m=1
XM_47__194__i_2_3 vss _129_ n_47__194__net_0 vss nfet_05v0 w=8.2e-07 l=6e-07 nf=1 m=1
XM_47__194__i_2_2 n_47__194__net_0 _129_ vss vss nfet_05v0 w=8.2e-07 l=6e-07 nf=1 m=1
XM_47__194__i_2_1 vss _129_ n_47__194__net_0 vss nfet_05v0 w=8.2e-07 l=6e-07 nf=1 m=1
XM_47__194__i_2_0 n_47__194__net_0 _129_ vss vss nfet_05v0 w=8.2e-07 l=6e-07 nf=1 m=1
XM_47__194__i_4_3 n_47__194__net_1_0 _135_ vdd vdd pfet_05v0 w=1.095e-06 l=5e-07 nf=1 m=1
XM_47__194__i_3_3 _136_ _134_ n_47__194__net_1_0 vdd pfet_05v0 w=1.095e-06 l=5e-07 nf=1 m=1
XM_47__194__i_3_2 n_47__194__net_1_1 _134_ _136_ vdd pfet_05v0 w=1.095e-06 l=5e-07 nf=1 m=1
XM_47__194__i_4_2 vdd _135_ n_47__194__net_1_1 vdd pfet_05v0 w=1.095e-06 l=5e-07 nf=1 m=1
XM_47__194__i_4_1 n_47__194__net_1_2 _135_ vdd vdd pfet_05v0 w=1.095e-06 l=5e-07 nf=1 m=1
XM_47__194__i_3_1 _136_ _134_ n_47__194__net_1_2 vdd pfet_05v0 w=1.095e-06 l=5e-07 nf=1 m=1
XM_47__194__i_3_0 n_47__194__net_1_3 _134_ _136_ vdd pfet_05v0 w=1.095e-06 l=5e-07 nf=1 m=1
XM_47__194__i_4_0 vdd _135_ n_47__194__net_1_3 vdd pfet_05v0 w=1.095e-06 l=5e-07 nf=1 m=1
XM_47__194__i_5_3 _136_ _129_ vdd vdd pfet_05v0 w=9.55e-07 l=5e-07 nf=1 m=1
XM_47__194__i_5_2 vdd _129_ _136_ vdd pfet_05v0 w=9.55e-07 l=5e-07 nf=1 m=1
XM_47__194__i_5_1 _136_ _129_ vdd vdd pfet_05v0 w=9.55e-07 l=5e-07 nf=1 m=1
XM_47__194__i_5_0 vdd _129_ _136_ vdd pfet_05v0 w=9.55e-07 l=5e-07 nf=1 m=1
XM_48__195__i_2 n_48__195__net_0 _125_ n_48__195__Z_neg vss nfet_05v0 w=3.65e-07 l=6e-07 nf=1 m=1
XM_48__195__i_3 vss _127_ n_48__195__net_0 vss nfet_05v0 w=3.65e-07 l=6e-07 nf=1 m=1
XM_48__195__i_0 _137_ n_48__195__Z_neg vss vss nfet_05v0 w=8.15e-07 l=6e-07 nf=1 m=1
XM_48__195__i_4 n_48__195__Z_neg _125_ vdd vdd pfet_05v0 w=6e-07 l=5e-07 nf=1 m=1
XM_48__195__i_5 vdd _127_ n_48__195__Z_neg vdd pfet_05v0 w=6e-07 l=5e-07 nf=1 m=1
XM_48__195__i_1 _137_ n_48__195__Z_neg vdd vdd pfet_05v0 w=1.215e-06 l=5e-07 nf=1 m=1
XM_49__196__i_6 n_49__196__net_2 _043_ n_49__196__I vss nfet_05v0 w=3.6e-07 l=6e-07 nf=1 m=1
XM_49__196__i_7 vss _142_ n_49__196__net_2 vss nfet_05v0 w=3.6e-07 l=6e-07 nf=1 m=1
XM_49__196__i_2 n_49__196__net_0 n_49__196__I vss vss nfet_05v0 w=8.2e-07 l=6e-07 nf=1 m=1
XM_49__196__i_0 _046_ _142_ n_49__196__net_0 vss nfet_05v0 w=8.2e-07 l=6e-07 nf=1 m=1
XM_49__196__i_1 n_49__196__net_0 _043_ _046_ vss nfet_05v0 w=8.2e-07 l=6e-07 nf=1 m=1
XM_49__196__i_8 n_49__196__I _043_ vdd vdd pfet_05v0 w=5.6e-07 l=5e-07 nf=1 m=1
XM_49__196__i_9 vdd _142_ n_49__196__I vdd pfet_05v0 w=5.6e-07 l=5e-07 nf=1 m=1
XM_49__196__i_5 _046_ n_49__196__I vdd vdd pfet_05v0 w=1.095e-06 l=5e-07 nf=1 m=1
XM_49__196__i_3 n_49__196__net_1 _142_ _046_ vdd pfet_05v0 w=1.095e-06 l=5e-07 nf=1 m=1
XM_49__196__i_4 vdd _043_ n_49__196__net_1 vdd pfet_05v0 w=1.095e-06 l=5e-07 nf=1 m=1
XM_50__197__i_6 n_50__197__I _046_ vss vss nfet_05v0 w=3.6e-07 l=6e-07 nf=1 m=1
XM_50__197__i_7 vss _137_ n_50__197__I vss nfet_05v0 w=3.6e-07 l=6e-07 nf=1 m=1
XM_50__197__i_2 _047_ n_50__197__I vss vss nfet_05v0 w=8.2e-07 l=6e-07 nf=1 m=1
XM_50__197__i_0 n_50__197__net_0 _137_ _047_ vss nfet_05v0 w=8.2e-07 l=6e-07 nf=1 m=1
XM_50__197__i_1 vss _046_ n_50__197__net_0 vss nfet_05v0 w=8.2e-07 l=6e-07 nf=1 m=1
XM_50__197__i_8 n_50__197__net_2 _046_ n_50__197__I vdd pfet_05v0 w=5.6e-07 l=5e-07 nf=1 m=1
XM_50__197__i_9 vdd _137_ n_50__197__net_2 vdd pfet_05v0 w=5.6e-07 l=5e-07 nf=1 m=1
XM_50__197__i_5 n_50__197__net_1 n_50__197__I vdd vdd pfet_05v0 w=1.22e-06 l=5e-07 nf=1 m=1
XM_50__197__i_3 _047_ _137_ n_50__197__net_1 vdd pfet_05v0 w=1.22e-06 l=5e-07 nf=1 m=1
XM_50__197__i_4 n_50__197__net_1 _046_ _047_ vdd pfet_05v0 w=1.22e-06 l=5e-07 nf=1 m=1
XM_51__198__i_2 n_51__198__net_0 _032_ n_51__198__Z_neg vss nfet_05v0 w=3.65e-07 l=6e-07 nf=1 m=1
XM_51__198__i_3 vss _047_ n_51__198__net_0 vss nfet_05v0 w=3.65e-07 l=6e-07 nf=1 m=1
XM_51__198__i_0 _048_ n_51__198__Z_neg vss vss nfet_05v0 w=8.15e-07 l=6e-07 nf=1 m=1
XM_51__198__i_4 n_51__198__Z_neg _032_ vdd vdd pfet_05v0 w=6e-07 l=5e-07 nf=1 m=1
XM_51__198__i_5 vdd _047_ n_51__198__Z_neg vdd pfet_05v0 w=6e-07 l=5e-07 nf=1 m=1
XM_51__198__i_1 _048_ n_51__198__Z_neg vdd vdd pfet_05v0 w=1.215e-06 l=5e-07 nf=1 m=1
XM_52__199__i_6 n_52__199__I _047_ vss vss nfet_05v0 w=3.6e-07 l=6e-07 nf=1 m=1
XM_52__199__i_7 vss _032_ n_52__199__I vss nfet_05v0 w=3.6e-07 l=6e-07 nf=1 m=1
XM_52__199__i_2 _049_ n_52__199__I vss vss nfet_05v0 w=8.2e-07 l=6e-07 nf=1 m=1
XM_52__199__i_0 n_52__199__net_0 _032_ _049_ vss nfet_05v0 w=8.2e-07 l=6e-07 nf=1 m=1
XM_52__199__i_1 vss _047_ n_52__199__net_0 vss nfet_05v0 w=8.2e-07 l=6e-07 nf=1 m=1
XM_52__199__i_8 n_52__199__net_2 _047_ n_52__199__I vdd pfet_05v0 w=5.6e-07 l=5e-07 nf=1 m=1
XM_52__199__i_9 vdd _032_ n_52__199__net_2 vdd pfet_05v0 w=5.6e-07 l=5e-07 nf=1 m=1
XM_52__199__i_5 n_52__199__net_1 n_52__199__I vdd vdd pfet_05v0 w=1.22e-06 l=5e-07 nf=1 m=1
XM_52__199__i_3 _049_ _032_ n_52__199__net_1 vdd pfet_05v0 w=1.22e-06 l=5e-07 nf=1 m=1
XM_52__199__i_4 n_52__199__net_1 _047_ _049_ vdd pfet_05v0 w=1.22e-06 l=5e-07 nf=1 m=1
XM_53__200__i_6 n_53__200__I _049_ vss vss nfet_05v0 w=3.6e-07 l=6e-07 nf=1 m=1
XM_53__200__i_7 vss _136_ n_53__200__I vss nfet_05v0 w=3.6e-07 l=6e-07 nf=1 m=1
XM_53__200__i_2 _008_ n_53__200__I vss vss nfet_05v0 w=8.2e-07 l=6e-07 nf=1 m=1
XM_53__200__i_0 n_53__200__net_0 _136_ _008_ vss nfet_05v0 w=8.2e-07 l=6e-07 nf=1 m=1
XM_53__200__i_1 vss _049_ n_53__200__net_0 vss nfet_05v0 w=8.2e-07 l=6e-07 nf=1 m=1
XM_53__200__i_8 n_53__200__net_2 _049_ n_53__200__I vdd pfet_05v0 w=5.6e-07 l=5e-07 nf=1 m=1
XM_53__200__i_9 vdd _136_ n_53__200__net_2 vdd pfet_05v0 w=5.6e-07 l=5e-07 nf=1 m=1
XM_53__200__i_5 n_53__200__net_1 n_53__200__I vdd vdd pfet_05v0 w=1.22e-06 l=5e-07 nf=1 m=1
XM_53__200__i_3 _008_ _136_ n_53__200__net_1 vdd pfet_05v0 w=1.22e-06 l=5e-07 nf=1 m=1
XM_53__200__i_4 n_53__200__net_1 _049_ _008_ vdd pfet_05v0 w=1.22e-06 l=5e-07 nf=1 m=1
XM_54__201__i_12 n_54__201__I _128_ vss vss nfet_05v0 w=3.6e-07 l=6e-07 nf=1 m=1
XM_54__201__i_13 vss _031_ n_54__201__I vss nfet_05v0 w=3.6e-07 l=6e-07 nf=1 m=1
XM_54__201__i_2 n_54__201__I2 n_54__201__I vss vss nfet_05v0 w=3.6e-07 l=6e-07 nf=1 m=1
XM_54__201__i_0 n_54__201__net_0 _031_ n_54__201__I2 vss nfet_05v0 w=3.6e-07 l=6e-07 nf=1 m=1
XM_54__201__i_1 vss _128_ n_54__201__net_0 vss nfet_05v0 w=3.6e-07 l=6e-07 nf=1 m=1
XM_54__201__i_16 n_54__201__net_5 n_54__201__I2 n_54__201__I3 vss nfet_05v0 w=3.6e-07 l=6e-07 nf=1 m=1
XM_54__201__i_17 vss _134_ n_54__201__net_5 vss nfet_05v0 w=3.6e-07 l=6e-07 nf=1 m=1
XM_54__201__i_8 n_54__201__net_2 n_54__201__I3 vss vss nfet_05v0 w=8.2e-07 l=6e-07 nf=1 m=1
XM_54__201__i_6 _007_ _134_ n_54__201__net_2 vss nfet_05v0 w=8.2e-07 l=6e-07 nf=1 m=1
XM_54__201__i_7 n_54__201__net_2 n_54__201__I2 _007_ vss nfet_05v0 w=8.2e-07 l=6e-07 nf=1 m=1
XM_54__201__i_14 n_54__201__net_4 _128_ n_54__201__I vdd pfet_05v0 w=3.6e-07 l=5e-07 nf=1 m=1
XM_54__201__i_15 vdd _031_ n_54__201__net_4 vdd pfet_05v0 w=3.6e-07 l=5e-07 nf=1 m=1
XM_54__201__i_5 n_54__201__net_1 n_54__201__I vdd vdd pfet_05v0 w=5.6e-07 l=5e-07 nf=1 m=1
XM_54__201__i_3 n_54__201__I2 _031_ n_54__201__net_1 vdd pfet_05v0 w=5.6e-07 l=5e-07 nf=1 m=1
XM_54__201__i_4 n_54__201__net_1 _128_ n_54__201__I2 vdd pfet_05v0 w=5.6e-07 l=5e-07 nf=1 m=1
XM_54__201__i_18 n_54__201__I3 n_54__201__I2 vdd vdd pfet_05v0 w=5.6e-07 l=5e-07 nf=1 m=1
XM_54__201__i_19 vdd _134_ n_54__201__I3 vdd pfet_05v0 w=5.6e-07 l=5e-07 nf=1 m=1
XM_54__201__i_11 _007_ n_54__201__I3 vdd vdd pfet_05v0 w=1.095e-06 l=5e-07 nf=1 m=1
XM_54__201__i_9 n_54__201__net_3 _134_ _007_ vdd pfet_05v0 w=1.095e-06 l=5e-07 nf=1 m=1
XM_54__201__i_10 vdd n_54__201__I2 n_54__201__net_3 vdd pfet_05v0 w=1.095e-06 l=5e-07 nf=1 m=1
XM_55__202__i_2 vss _117_ n_55__202__Z_neg vss nfet_05v0 w=4e-07 l=6e-07 nf=1 m=1
XM_55__202__i_3 n_55__202__Z_neg _119_ vss vss nfet_05v0 w=4e-07 l=6e-07 nf=1 m=1
XM_55__202__i_4 vss _132_ n_55__202__Z_neg vss nfet_05v0 w=4e-07 l=6e-07 nf=1 m=1
XM_55__202__i_0 _050_ n_55__202__Z_neg vss vss nfet_05v0 w=8.2e-07 l=6e-07 nf=1 m=1
XM_55__202__i_5 n_55__202__net_0 _117_ n_55__202__Z_neg vdd pfet_05v0 w=5.6e-07 l=5e-07 nf=1 m=1
XM_55__202__i_6 n_55__202__net_1 _119_ n_55__202__net_0 vdd pfet_05v0 w=5.6e-07 l=5e-07 nf=1 m=1
XM_55__202__i_7 vdd _132_ n_55__202__net_1 vdd pfet_05v0 w=5.6e-07 l=5e-07 nf=1 m=1
XM_55__202__i_1 _050_ n_55__202__Z_neg vdd vdd pfet_05v0 w=1.22e-06 l=5e-07 nf=1 m=1
XM_56__203__i_2 n_56__203__net_0 _133_ n_56__203__Z_neg vss nfet_05v0 w=3.65e-07 l=6e-07 nf=1 m=1
XM_56__203__i_3 vss _050_ n_56__203__net_0 vss nfet_05v0 w=3.65e-07 l=6e-07 nf=1 m=1
XM_56__203__i_0 _006_ n_56__203__Z_neg vss vss nfet_05v0 w=8.15e-07 l=6e-07 nf=1 m=1
XM_56__203__i_4 n_56__203__Z_neg _133_ vdd vdd pfet_05v0 w=6e-07 l=5e-07 nf=1 m=1
XM_56__203__i_5 vdd _050_ n_56__203__Z_neg vdd pfet_05v0 w=6e-07 l=5e-07 nf=1 m=1
XM_56__203__i_1 _006_ n_56__203__Z_neg vdd vdd pfet_05v0 w=1.215e-06 l=5e-07 nf=1 m=1
XM_57__204__i_1 n_57__204__net_0 _035_ vss vss nfet_05v0 w=8.2e-07 l=6e-07 nf=1 m=1
XM_57__204__i_0 _051_ _142_ n_57__204__net_0 vss nfet_05v0 w=8.2e-07 l=6e-07 nf=1 m=1
XM_57__204__i_3 _051_ _035_ vdd vdd pfet_05v0 w=1.13e-06 l=5e-07 nf=1 m=1
XM_57__204__i_2 vdd _142_ _051_ vdd pfet_05v0 w=1.13e-06 l=5e-07 nf=1 m=1
XM_58__205__i_0 _052_ _051_ vss vss nfet_05v0 w=4.8e-07 l=6e-07 nf=1 m=1
XM_58__205__i_1 _052_ _051_ vdd vdd pfet_05v0 w=1.22e-06 l=5e-07 nf=1 m=1
XM_59__206__i_2 n_59__206__net_0 _041_ n_59__206__Z_neg vss nfet_05v0 w=3.65e-07 l=6e-07 nf=1 m=1
XM_59__206__i_3 vss _142_ n_59__206__net_0 vss nfet_05v0 w=3.65e-07 l=6e-07 nf=1 m=1
XM_59__206__i_0 _053_ n_59__206__Z_neg vss vss nfet_05v0 w=8.15e-07 l=6e-07 nf=1 m=1
XM_59__206__i_4 n_59__206__Z_neg _041_ vdd vdd pfet_05v0 w=6e-07 l=5e-07 nf=1 m=1
XM_59__206__i_5 vdd _142_ n_59__206__Z_neg vdd pfet_05v0 w=6e-07 l=5e-07 nf=1 m=1
XM_59__206__i_1 _053_ n_59__206__Z_neg vdd vdd pfet_05v0 w=1.215e-06 l=5e-07 nf=1 m=1
XM_60__207__i_2 n_60__207__Z_neg _041_ vss vss nfet_05v0 w=3.6e-07 l=6e-07 nf=1 m=1
XM_60__207__i_3 vss _142_ n_60__207__Z_neg vss nfet_05v0 w=3.6e-07 l=6e-07 nf=1 m=1
XM_60__207__i_0 _054_ n_60__207__Z_neg vss vss nfet_05v0 w=8.2e-07 l=6e-07 nf=1 m=1
XM_60__207__i_4 n_60__207__net_0 _041_ n_60__207__Z_neg vdd pfet_05v0 w=5.65e-07 l=5e-07 nf=1 m=1
XM_60__207__i_5 vdd _142_ n_60__207__net_0 vdd pfet_05v0 w=5.65e-07 l=5e-07 nf=1 m=1
XM_60__207__i_1 _054_ n_60__207__Z_neg vdd vdd pfet_05v0 w=1.22e-06 l=5e-07 nf=1 m=1
XM_61__208__i_1 n_61__208__net_0 _142_ vss vss nfet_05v0 w=8.2e-07 l=6e-07 nf=1 m=1
XM_61__208__i_0 _055_ _040_ n_61__208__net_0 vss nfet_05v0 w=8.2e-07 l=6e-07 nf=1 m=1
XM_61__208__i_3 _055_ _142_ vdd vdd pfet_05v0 w=1.13e-06 l=5e-07 nf=1 m=1
XM_61__208__i_2 vdd _040_ _055_ vdd pfet_05v0 w=1.13e-06 l=5e-07 nf=1 m=1
XM_62__209__i_1 _056_ _142_ vss vss nfet_05v0 w=5.65e-07 l=6e-07 nf=1 m=1
XM_62__209__i_0 vss _040_ _056_ vss nfet_05v0 w=5.65e-07 l=6e-07 nf=1 m=1
XM_62__209__i_3 n_62__209__net_0 _142_ vdd vdd pfet_05v0 w=1.22e-06 l=5e-07 nf=1 m=1
XM_62__209__i_2 _056_ _040_ n_62__209__net_0 vdd pfet_05v0 w=1.22e-06 l=5e-07 nf=1 m=1
XM_63__210__i_1 _057_ _141_ vss vss nfet_05v0 w=5.65e-07 l=6e-07 nf=1 m=1
XM_63__210__i_0 vss _039_ _057_ vss nfet_05v0 w=5.65e-07 l=6e-07 nf=1 m=1
XM_63__210__i_3 n_63__210__net_0 _141_ vdd vdd pfet_05v0 w=1.22e-06 l=5e-07 nf=1 m=1
XM_63__210__i_2 _057_ _039_ n_63__210__net_0 vdd pfet_05v0 w=1.22e-06 l=5e-07 nf=1 m=1
XM_64__211__i_2 n_64__211__net_0 _038_ n_64__211__Z_neg vss nfet_05v0 w=3.65e-07 l=6e-07 nf=1 m=1
XM_64__211__i_3 vss _140_ n_64__211__net_0 vss nfet_05v0 w=3.65e-07 l=6e-07 nf=1 m=1
XM_64__211__i_0 _058_ n_64__211__Z_neg vss vss nfet_05v0 w=8.15e-07 l=6e-07 nf=1 m=1
XM_64__211__i_4 n_64__211__Z_neg _038_ vdd vdd pfet_05v0 w=6e-07 l=5e-07 nf=1 m=1
XM_64__211__i_5 vdd _140_ n_64__211__Z_neg vdd pfet_05v0 w=6e-07 l=5e-07 nf=1 m=1
XM_64__211__i_1 _058_ n_64__211__Z_neg vdd vdd pfet_05v0 w=1.215e-06 l=5e-07 nf=1 m=1
XM_65__212__i_1 n_65__212__net_0 _037_ vss vss nfet_05v0 w=8.2e-07 l=6e-07 nf=1 m=1
XM_65__212__i_0 _059_ _139_ n_65__212__net_0 vss nfet_05v0 w=8.2e-07 l=6e-07 nf=1 m=1
XM_65__212__i_3 _059_ _037_ vdd vdd pfet_05v0 w=1.13e-06 l=5e-07 nf=1 m=1
XM_65__212__i_2 vdd _139_ _059_ vdd pfet_05v0 w=1.13e-06 l=5e-07 nf=1 m=1
XM_66__213__i_1 n_66__213__net_0 _034_ vss vss nfet_05v0 w=8.2e-07 l=6e-07 nf=1 m=1
XM_66__213__i_0 _060_ _138_ n_66__213__net_0 vss nfet_05v0 w=8.2e-07 l=6e-07 nf=1 m=1
XM_66__213__i_3 _060_ _034_ vdd vdd pfet_05v0 w=1.13e-06 l=5e-07 nf=1 m=1
XM_66__213__i_2 vdd _138_ _060_ vdd pfet_05v0 w=1.13e-06 l=5e-07 nf=1 m=1
XM_67__214__i_1 _061_ _037_ vss vss nfet_05v0 w=5.65e-07 l=6e-07 nf=1 m=1
XM_67__214__i_0 vss _139_ _061_ vss nfet_05v0 w=5.65e-07 l=6e-07 nf=1 m=1
XM_67__214__i_3 n_67__214__net_0 _037_ vdd vdd pfet_05v0 w=1.22e-06 l=5e-07 nf=1 m=1
XM_67__214__i_2 _061_ _139_ n_67__214__net_0 vdd pfet_05v0 w=1.22e-06 l=5e-07 nf=1 m=1
XM_68__215__i_2_1 vss _059_ n_68__215__net_0 vss nfet_05v0 w=8.2e-07 l=6e-07 nf=1 m=1
XM_68__215__i_2_0 n_68__215__net_0 _059_ vss vss nfet_05v0 w=8.2e-07 l=6e-07 nf=1 m=1
XM_68__215__i_1_1 _062_ _061_ n_68__215__net_0 vss nfet_05v0 w=8.2e-07 l=6e-07 nf=1 m=1
XM_68__215__i_0_1 n_68__215__net_0 _060_ _062_ vss nfet_05v0 w=8.2e-07 l=6e-07 nf=1 m=1
XM_68__215__i_0_0 _062_ _060_ n_68__215__net_0 vss nfet_05v0 w=8.2e-07 l=6e-07 nf=1 m=1
XM_68__215__i_1_0 n_68__215__net_0 _061_ _062_ vss nfet_05v0 w=8.2e-07 l=6e-07 nf=1 m=1
XM_68__215__i_5_1 _062_ _059_ vdd vdd pfet_05v0 w=9.55e-07 l=5e-07 nf=1 m=1
XM_68__215__i_5_0 vdd _059_ _062_ vdd pfet_05v0 w=9.55e-07 l=5e-07 nf=1 m=1
XM_68__215__i_4_1 n_68__215__net_1_0 _061_ vdd vdd pfet_05v0 w=1.095e-06 l=5e-07 nf=1 m=1
XM_68__215__i_3_1 _062_ _060_ n_68__215__net_1_0 vdd pfet_05v0 w=1.095e-06 l=5e-07 nf=1 m=1
XM_68__215__i_3_0 n_68__215__net_1_1 _060_ _062_ vdd pfet_05v0 w=1.095e-06 l=5e-07 nf=1 m=1
XM_68__215__i_4_0 vdd _061_ n_68__215__net_1_1 vdd pfet_05v0 w=1.095e-06 l=5e-07 nf=1 m=1
XM_69__216__i_8 n_69__216__net_2 _140_ n_69__216__I vss nfet_05v0 w=3.6e-07 l=6e-07 nf=1 m=1
XM_69__216__i_9 vss _038_ n_69__216__net_2 vss nfet_05v0 w=3.6e-07 l=6e-07 nf=1 m=1
XM_69__216__i_4 n_69__216__net_0 n_69__216__I vss vss nfet_05v0 w=8.2e-07 l=6e-07 nf=1 m=1
XM_69__216__i_2 n_69__216__Z_neg _038_ n_69__216__net_0 vss nfet_05v0 w=8.2e-07 l=6e-07 nf=1 m=1
XM_69__216__i_3 n_69__216__net_0 _140_ n_69__216__Z_neg vss nfet_05v0 w=8.2e-07 l=6e-07 nf=1 m=1
XM_69__216__i_0_0 _063_ n_69__216__Z_neg vss vss nfet_05v0 w=8.2e-07 l=6e-07 nf=1 m=1
XM_69__216__i_0_1 vss n_69__216__Z_neg _063_ vss nfet_05v0 w=8.2e-07 l=6e-07 nf=1 m=1
XM_69__216__i_10 n_69__216__I _140_ vdd vdd pfet_05v0 w=5.6e-07 l=5e-07 nf=1 m=1
XM_69__216__i_11 vdd _038_ n_69__216__I vdd pfet_05v0 w=5.6e-07 l=5e-07 nf=1 m=1
XM_69__216__i_7 n_69__216__Z_neg n_69__216__I vdd vdd pfet_05v0 w=1.095e-06 l=5e-07 nf=1 m=1
XM_69__216__i_5 n_69__216__net_1 _038_ n_69__216__Z_neg vdd pfet_05v0 w=1.095e-06 l=5e-07 nf=1 m=1
XM_69__216__i_6 vdd _140_ n_69__216__net_1 vdd pfet_05v0 w=1.095e-06 l=5e-07 nf=1 m=1
XM_69__216__i_1_0 _063_ n_69__216__Z_neg vdd vdd pfet_05v0 w=1.22e-06 l=5e-07 nf=1 m=1
XM_69__216__i_1_1 vdd n_69__216__Z_neg _063_ vdd pfet_05v0 w=1.22e-06 l=5e-07 nf=1 m=1
XM_70__217__i_1 n_70__217__net_0 _063_ vss vss nfet_05v0 w=8.2e-07 l=6e-07 nf=1 m=1
XM_70__217__i_0 _064_ _062_ n_70__217__net_0 vss nfet_05v0 w=8.2e-07 l=6e-07 nf=1 m=1
XM_70__217__i_2 vss _058_ _064_ vss nfet_05v0 w=5.1e-07 l=6e-07 nf=1 m=1
XM_70__217__i_4 _064_ _063_ n_70__217__net_1 vdd pfet_05v0 w=1.215e-06 l=5e-07 nf=1 m=1
XM_70__217__i_3 n_70__217__net_1 _062_ _064_ vdd pfet_05v0 w=1.215e-06 l=5e-07 nf=1 m=1
XM_70__217__i_5 vdd _058_ n_70__217__net_1 vdd pfet_05v0 w=1.215e-06 l=5e-07 nf=1 m=1
XM_71__218__i_2_1 vss _058_ _065_ vss nfet_05v0 w=4.05e-07 l=6e-07 nf=1 m=1
XM_71__218__i_4_1 n_71__218__net_1_0 _063_ vss vss nfet_05v0 w=7.15e-07 l=6e-07 nf=1 m=1
XM_71__218__i_3_1 _065_ _062_ n_71__218__net_1_0 vss nfet_05v0 w=7.15e-07 l=6e-07 nf=1 m=1
XM_71__218__i_3_0 n_71__218__net_1_1 _062_ _065_ vss nfet_05v0 w=7.15e-07 l=6e-07 nf=1 m=1
XM_71__218__i_4_0 vss _063_ n_71__218__net_1_1 vss nfet_05v0 w=7.15e-07 l=6e-07 nf=1 m=1
XM_71__218__i_2_0 _065_ _058_ vss vss nfet_05v0 w=5.75e-07 l=6e-07 nf=1 m=1
XM_71__218__i_0_1 n_71__218__net_0_0 _039_ _065_ vss nfet_05v0 w=7.15e-07 l=6e-07 nf=1 m=1
XM_71__218__i_1_1 vss _141_ n_71__218__net_0_0 vss nfet_05v0 w=7.15e-07 l=6e-07 nf=1 m=1
XM_71__218__i_1_0 n_71__218__net_0_1 _141_ vss vss nfet_05v0 w=7.15e-07 l=6e-07 nf=1 m=1
XM_71__218__i_0_0 _065_ _039_ n_71__218__net_0_1 vss nfet_05v0 w=7.15e-07 l=6e-07 nf=1 m=1
XM_71__218__i_7_1 n_71__218__net_3 _058_ n_71__218__net_2 vdd pfet_05v0 w=1.12e-06 l=5e-07 nf=1 m=1
XM_71__218__i_9_1 vdd _063_ n_71__218__net_3 vdd pfet_05v0 w=1.12e-06 l=5e-07 nf=1 m=1
XM_71__218__i_8_1 n_71__218__net_3 _062_ vdd vdd pfet_05v0 w=1.12e-06 l=5e-07 nf=1 m=1
XM_71__218__i_8_0 vdd _062_ n_71__218__net_3 vdd pfet_05v0 w=1.12e-06 l=5e-07 nf=1 m=1
XM_71__218__i_9_0 n_71__218__net_3 _063_ vdd vdd pfet_05v0 w=1.12e-06 l=5e-07 nf=1 m=1
XM_71__218__i_7_0 n_71__218__net_2 _058_ n_71__218__net_3 vdd pfet_05v0 w=1.12e-06 l=5e-07 nf=1 m=1
XM_71__218__i_5_1 _065_ _039_ n_71__218__net_2 vdd pfet_05v0 w=1.12e-06 l=5e-07 nf=1 m=1
XM_71__218__i_6_1 n_71__218__net_2 _141_ _065_ vdd pfet_05v0 w=1.12e-06 l=5e-07 nf=1 m=1
XM_71__218__i_6_0 _065_ _141_ n_71__218__net_2 vdd pfet_05v0 w=1.12e-06 l=5e-07 nf=1 m=1
XM_71__218__i_5_0 n_71__218__net_2 _039_ _065_ vdd pfet_05v0 w=1.12e-06 l=5e-07 nf=1 m=1
XM_72__219__i_1 _066_ _065_ vss vss nfet_05v0 w=5.65e-07 l=6e-07 nf=1 m=1
XM_72__219__i_0 vss _057_ _066_ vss nfet_05v0 w=5.65e-07 l=6e-07 nf=1 m=1
XM_72__219__i_3 n_72__219__net_0 _065_ vdd vdd pfet_05v0 w=1.22e-06 l=5e-07 nf=1 m=1
XM_72__219__i_2 _066_ _057_ n_72__219__net_0 vdd pfet_05v0 w=1.22e-06 l=5e-07 nf=1 m=1
XM_73__220__i_3_1 vss _055_ n_73__220__net_0 vss nfet_05v0 w=8.2e-07 l=6e-07 nf=1 m=1
XM_73__220__i_3_0 n_73__220__net_0 _055_ vss vss nfet_05v0 w=8.2e-07 l=6e-07 nf=1 m=1
XM_73__220__i_2_1 _067_ _056_ n_73__220__net_0 vss nfet_05v0 w=8.2e-07 l=6e-07 nf=1 m=1
XM_73__220__i_1_1 n_73__220__net_0 _057_ _067_ vss nfet_05v0 w=8.2e-07 l=6e-07 nf=1 m=1
XM_73__220__i_0_1 _067_ _065_ n_73__220__net_0 vss nfet_05v0 w=8.2e-07 l=6e-07 nf=1 m=1
XM_73__220__i_0_0 n_73__220__net_0 _065_ _067_ vss nfet_05v0 w=8.2e-07 l=6e-07 nf=1 m=1
XM_73__220__i_1_0 _067_ _057_ n_73__220__net_0 vss nfet_05v0 w=8.2e-07 l=6e-07 nf=1 m=1
XM_73__220__i_2_0 n_73__220__net_0 _056_ _067_ vss nfet_05v0 w=8.2e-07 l=6e-07 nf=1 m=1
XM_73__220__i_7_1 _067_ _055_ vdd vdd pfet_05v0 w=1.08e-06 l=5e-07 nf=1 m=1
XM_73__220__i_7_0 vdd _055_ _067_ vdd pfet_05v0 w=1.08e-06 l=5e-07 nf=1 m=1
XM_73__220__i_6_1 n_73__220__net_2_0 _056_ vdd vdd pfet_05v0 w=1.095e-06 l=5e-07 nf=1 m=1
XM_73__220__i_5_1 n_73__220__net_1_0 _057_ n_73__220__net_2_0 vdd pfet_05v0 w=1.095e-06 l=5e-07 nf=1 m=1
XM_73__220__i_4_1 _067_ _065_ n_73__220__net_1_0 vdd pfet_05v0 w=1.095e-06 l=5e-07 nf=1 m=1
XM_73__220__i_4_0 n_73__220__net_1_1 _065_ _067_ vdd pfet_05v0 w=1.095e-06 l=5e-07 nf=1 m=1
XM_73__220__i_5_0 n_73__220__net_2_1 _057_ n_73__220__net_1_1 vdd pfet_05v0 w=1.095e-06 l=5e-07 nf=1 m=1
XM_73__220__i_6_0 vdd _056_ n_73__220__net_2_1 vdd pfet_05v0 w=1.095e-06 l=5e-07 nf=1 m=1
XM_74__221__i_1 _068_ _067_ n_74__221__net_0 vss nfet_05v0 w=8.2e-07 l=6e-07 nf=1 m=1
XM_74__221__i_0 n_74__221__net_0 _053_ _068_ vss nfet_05v0 w=8.2e-07 l=6e-07 nf=1 m=1
XM_74__221__i_2 vss _054_ n_74__221__net_0 vss nfet_05v0 w=8.2e-07 l=6e-07 nf=1 m=1
XM_74__221__i_4 n_74__221__net_1 _067_ vdd vdd pfet_05v0 w=1.22e-06 l=5e-07 nf=1 m=1
XM_74__221__i_3 _068_ _053_ n_74__221__net_1 vdd pfet_05v0 w=1.22e-06 l=5e-07 nf=1 m=1
XM_74__221__i_5 vdd _054_ _068_ vdd pfet_05v0 w=1.13e-06 l=5e-07 nf=1 m=1
XM_75__222__i_1 _069_ _053_ n_75__222__net_0 vss nfet_05v0 w=8.2e-07 l=6e-07 nf=1 m=1
XM_75__222__i_0 n_75__222__net_0 _067_ _069_ vss nfet_05v0 w=8.2e-07 l=6e-07 nf=1 m=1
XM_75__222__i_2 n_75__222__net_1 _054_ n_75__222__net_0 vss nfet_05v0 w=8.2e-07 l=6e-07 nf=1 m=1
XM_75__222__i_3 vss _126_ n_75__222__net_1 vss nfet_05v0 w=8.2e-07 l=6e-07 nf=1 m=1
XM_75__222__i_5 n_75__222__net_2 _053_ vdd vdd pfet_05v0 w=1.22e-06 l=5e-07 nf=1 m=1
XM_75__222__i_4 _069_ _067_ n_75__222__net_2 vdd pfet_05v0 w=1.22e-06 l=5e-07 nf=1 m=1
XM_75__222__i_6 vdd _054_ _069_ vdd pfet_05v0 w=9.85e-07 l=5e-07 nf=1 m=1
XM_75__222__i_7 _069_ _126_ vdd vdd pfet_05v0 w=9.85e-07 l=5e-07 nf=1 m=1
XM_76__223__i_1 _070_ _043_ n_76__223__net_0 vss nfet_05v0 w=8.2e-07 l=6e-07 nf=1 m=1
XM_76__223__i_0 n_76__223__net_0 _042_ _070_ vss nfet_05v0 w=8.2e-07 l=6e-07 nf=1 m=1
XM_76__223__i_2 vss _142_ n_76__223__net_0 vss nfet_05v0 w=8.2e-07 l=6e-07 nf=1 m=1
XM_76__223__i_4 n_76__223__net_1 _043_ vdd vdd pfet_05v0 w=1.22e-06 l=5e-07 nf=1 m=1
XM_76__223__i_3 _070_ _042_ n_76__223__net_1 vdd pfet_05v0 w=1.22e-06 l=5e-07 nf=1 m=1
XM_76__223__i_5 vdd _142_ _070_ vdd pfet_05v0 w=1.13e-06 l=5e-07 nf=1 m=1
XM_77__224__i_1 _071_ _046_ n_77__224__net_0 vss nfet_05v0 w=8.2e-07 l=6e-07 nf=1 m=1
XM_77__224__i_0 n_77__224__net_0 _069_ _071_ vss nfet_05v0 w=8.2e-07 l=6e-07 nf=1 m=1
XM_77__224__i_2 vss _070_ n_77__224__net_0 vss nfet_05v0 w=8.2e-07 l=6e-07 nf=1 m=1
XM_77__224__i_4 n_77__224__net_1 _046_ vdd vdd pfet_05v0 w=1.22e-06 l=5e-07 nf=1 m=1
XM_77__224__i_3 _071_ _069_ n_77__224__net_1 vdd pfet_05v0 w=1.22e-06 l=5e-07 nf=1 m=1
XM_77__224__i_5 vdd _070_ _071_ vdd pfet_05v0 w=1.13e-06 l=5e-07 nf=1 m=1
XM_78__225__i_1 n_78__225__net_0 _044_ vss vss nfet_05v0 w=8.2e-07 l=6e-07 nf=1 m=1
XM_78__225__i_0 _072_ _142_ n_78__225__net_0 vss nfet_05v0 w=8.2e-07 l=6e-07 nf=1 m=1
XM_78__225__i_3 _072_ _044_ vdd vdd pfet_05v0 w=1.13e-06 l=5e-07 nf=1 m=1
XM_78__225__i_2 vdd _142_ _072_ vdd pfet_05v0 w=1.13e-06 l=5e-07 nf=1 m=1
XM_79__226__i_6 n_79__226__I _044_ vss vss nfet_05v0 w=3.6e-07 l=6e-07 nf=1 m=1
XM_79__226__i_7 vss _142_ n_79__226__I vss nfet_05v0 w=3.6e-07 l=6e-07 nf=1 m=1
XM_79__226__i_2 _073_ n_79__226__I vss vss nfet_05v0 w=8.2e-07 l=6e-07 nf=1 m=1
XM_79__226__i_0 n_79__226__net_0 _142_ _073_ vss nfet_05v0 w=8.2e-07 l=6e-07 nf=1 m=1
XM_79__226__i_1 vss _044_ n_79__226__net_0 vss nfet_05v0 w=8.2e-07 l=6e-07 nf=1 m=1
XM_79__226__i_8 n_79__226__net_2 _044_ n_79__226__I vdd pfet_05v0 w=5.6e-07 l=5e-07 nf=1 m=1
XM_79__226__i_9 vdd _142_ n_79__226__net_2 vdd pfet_05v0 w=5.6e-07 l=5e-07 nf=1 m=1
XM_79__226__i_5 n_79__226__net_1 n_79__226__I vdd vdd pfet_05v0 w=1.22e-06 l=5e-07 nf=1 m=1
XM_79__226__i_3 _073_ _142_ n_79__226__net_1 vdd pfet_05v0 w=1.22e-06 l=5e-07 nf=1 m=1
XM_79__226__i_4 n_79__226__net_1 _044_ _073_ vdd pfet_05v0 w=1.22e-06 l=5e-07 nf=1 m=1
XM_80__227__i_1 n_80__227__net_0 _073_ vss vss nfet_05v0 w=8.2e-07 l=6e-07 nf=1 m=1
XM_80__227__i_0 _074_ _071_ n_80__227__net_0 vss nfet_05v0 w=8.2e-07 l=6e-07 nf=1 m=1
XM_80__227__i_3 _074_ _073_ vdd vdd pfet_05v0 w=1.13e-06 l=5e-07 nf=1 m=1
XM_80__227__i_2 vdd _071_ _074_ vdd pfet_05v0 w=1.13e-06 l=5e-07 nf=1 m=1
XM_81__228__i_6 n_81__228__I _045_ vss vss nfet_05v0 w=3.6e-07 l=6e-07 nf=1 m=1
XM_81__228__i_7 vss _142_ n_81__228__I vss nfet_05v0 w=3.6e-07 l=6e-07 nf=1 m=1
XM_81__228__i_2 _075_ n_81__228__I vss vss nfet_05v0 w=8.2e-07 l=6e-07 nf=1 m=1
XM_81__228__i_0 n_81__228__net_0 _142_ _075_ vss nfet_05v0 w=8.2e-07 l=6e-07 nf=1 m=1
XM_81__228__i_1 vss _045_ n_81__228__net_0 vss nfet_05v0 w=8.2e-07 l=6e-07 nf=1 m=1
XM_81__228__i_8 n_81__228__net_2 _045_ n_81__228__I vdd pfet_05v0 w=5.6e-07 l=5e-07 nf=1 m=1
XM_81__228__i_9 vdd _142_ n_81__228__net_2 vdd pfet_05v0 w=5.6e-07 l=5e-07 nf=1 m=1
XM_81__228__i_5 n_81__228__net_1 n_81__228__I vdd vdd pfet_05v0 w=1.22e-06 l=5e-07 nf=1 m=1
XM_81__228__i_3 _075_ _142_ n_81__228__net_1 vdd pfet_05v0 w=1.22e-06 l=5e-07 nf=1 m=1
XM_81__228__i_4 n_81__228__net_1 _045_ _075_ vdd pfet_05v0 w=1.22e-06 l=5e-07 nf=1 m=1
XM_82__229__i_6 n_82__229__net_2 _045_ n_82__229__I vss nfet_05v0 w=3.6e-07 l=6e-07 nf=1 m=1
XM_82__229__i_7 vss _142_ n_82__229__net_2 vss nfet_05v0 w=3.6e-07 l=6e-07 nf=1 m=1
XM_82__229__i_2 n_82__229__net_0 n_82__229__I vss vss nfet_05v0 w=8.2e-07 l=6e-07 nf=1 m=1
XM_82__229__i_0 _076_ _142_ n_82__229__net_0 vss nfet_05v0 w=8.2e-07 l=6e-07 nf=1 m=1
XM_82__229__i_1 n_82__229__net_0 _045_ _076_ vss nfet_05v0 w=8.2e-07 l=6e-07 nf=1 m=1
XM_82__229__i_8 n_82__229__I _045_ vdd vdd pfet_05v0 w=5.6e-07 l=5e-07 nf=1 m=1
XM_82__229__i_9 vdd _142_ n_82__229__I vdd pfet_05v0 w=5.6e-07 l=5e-07 nf=1 m=1
XM_82__229__i_5 _076_ n_82__229__I vdd vdd pfet_05v0 w=1.095e-06 l=5e-07 nf=1 m=1
XM_82__229__i_3 n_82__229__net_1 _142_ _076_ vdd pfet_05v0 w=1.095e-06 l=5e-07 nf=1 m=1
XM_82__229__i_4 vdd _045_ n_82__229__net_1 vdd pfet_05v0 w=1.095e-06 l=5e-07 nf=1 m=1
XM_83__230__i_1 _077_ _045_ n_83__230__net_0 vss nfet_05v0 w=8.2e-07 l=6e-07 nf=1 m=1
XM_83__230__i_0 n_83__230__net_0 _044_ _077_ vss nfet_05v0 w=8.2e-07 l=6e-07 nf=1 m=1
XM_83__230__i_2 vss _142_ n_83__230__net_0 vss nfet_05v0 w=8.2e-07 l=6e-07 nf=1 m=1
XM_83__230__i_4 n_83__230__net_1 _045_ vdd vdd pfet_05v0 w=1.22e-06 l=5e-07 nf=1 m=1
XM_83__230__i_3 _077_ _044_ n_83__230__net_1 vdd pfet_05v0 w=1.22e-06 l=5e-07 nf=1 m=1
XM_83__230__i_5 vdd _142_ _077_ vdd pfet_05v0 w=1.13e-06 l=5e-07 nf=1 m=1
XM_84__231__i_2_1 vss _077_ n_84__231__net_0 vss nfet_05v0 w=8.2e-07 l=6e-07 nf=1 m=1
XM_84__231__i_2_0 n_84__231__net_0 _077_ vss vss nfet_05v0 w=8.2e-07 l=6e-07 nf=1 m=1
XM_84__231__i_1_1 _078_ _076_ n_84__231__net_0 vss nfet_05v0 w=8.2e-07 l=6e-07 nf=1 m=1
XM_84__231__i_0_1 n_84__231__net_0 _074_ _078_ vss nfet_05v0 w=8.2e-07 l=6e-07 nf=1 m=1
XM_84__231__i_0_0 _078_ _074_ n_84__231__net_0 vss nfet_05v0 w=8.2e-07 l=6e-07 nf=1 m=1
XM_84__231__i_1_0 n_84__231__net_0 _076_ _078_ vss nfet_05v0 w=8.2e-07 l=6e-07 nf=1 m=1
XM_84__231__i_5_1 _078_ _077_ vdd vdd pfet_05v0 w=9.55e-07 l=5e-07 nf=1 m=1
XM_84__231__i_5_0 vdd _077_ _078_ vdd pfet_05v0 w=9.55e-07 l=5e-07 nf=1 m=1
XM_84__231__i_4_1 n_84__231__net_1_0 _076_ vdd vdd pfet_05v0 w=1.095e-06 l=5e-07 nf=1 m=1
XM_84__231__i_3_1 _078_ _074_ n_84__231__net_1_0 vdd pfet_05v0 w=1.095e-06 l=5e-07 nf=1 m=1
XM_84__231__i_3_0 n_84__231__net_1_1 _074_ _078_ vdd pfet_05v0 w=1.095e-06 l=5e-07 nf=1 m=1
XM_84__231__i_4_0 vdd _076_ n_84__231__net_1_1 vdd pfet_05v0 w=1.095e-06 l=5e-07 nf=1 m=1
XM_85__232__i_6 n_85__232__I _035_ vss vss nfet_05v0 w=3.6e-07 l=6e-07 nf=1 m=1
XM_85__232__i_7 vss _142_ n_85__232__I vss nfet_05v0 w=3.6e-07 l=6e-07 nf=1 m=1
XM_85__232__i_2 _079_ n_85__232__I vss vss nfet_05v0 w=8.2e-07 l=6e-07 nf=1 m=1
XM_85__232__i_0 n_85__232__net_0 _142_ _079_ vss nfet_05v0 w=8.2e-07 l=6e-07 nf=1 m=1
XM_85__232__i_1 vss _035_ n_85__232__net_0 vss nfet_05v0 w=8.2e-07 l=6e-07 nf=1 m=1
XM_85__232__i_8 n_85__232__net_2 _035_ n_85__232__I vdd pfet_05v0 w=5.6e-07 l=5e-07 nf=1 m=1
XM_85__232__i_9 vdd _142_ n_85__232__net_2 vdd pfet_05v0 w=5.6e-07 l=5e-07 nf=1 m=1
XM_85__232__i_5 n_85__232__net_1 n_85__232__I vdd vdd pfet_05v0 w=1.22e-06 l=5e-07 nf=1 m=1
XM_85__232__i_3 _079_ _142_ n_85__232__net_1 vdd pfet_05v0 w=1.22e-06 l=5e-07 nf=1 m=1
XM_85__232__i_4 n_85__232__net_1 _035_ _079_ vdd pfet_05v0 w=1.22e-06 l=5e-07 nf=1 m=1
XM_86__233__i_1 n_86__233__net_0 _079_ vss vss nfet_05v0 w=8.2e-07 l=6e-07 nf=1 m=1
XM_86__233__i_0 _080_ _078_ n_86__233__net_0 vss nfet_05v0 w=8.2e-07 l=6e-07 nf=1 m=1
XM_86__233__i_2 vss _052_ _080_ vss nfet_05v0 w=5.1e-07 l=6e-07 nf=1 m=1
XM_86__233__i_4 _080_ _079_ n_86__233__net_1 vdd pfet_05v0 w=1.215e-06 l=5e-07 nf=1 m=1
XM_86__233__i_3 n_86__233__net_1 _078_ _080_ vdd pfet_05v0 w=1.215e-06 l=5e-07 nf=1 m=1
XM_86__233__i_5 vdd _052_ n_86__233__net_1 vdd pfet_05v0 w=1.215e-06 l=5e-07 nf=1 m=1
XM_87__234__i_6 n_87__234__I _036_ vss vss nfet_05v0 w=3.6e-07 l=6e-07 nf=1 m=1
XM_87__234__i_7 vss _142_ n_87__234__I vss nfet_05v0 w=3.6e-07 l=6e-07 nf=1 m=1
XM_87__234__i_2 _081_ n_87__234__I vss vss nfet_05v0 w=8.2e-07 l=6e-07 nf=1 m=1
XM_87__234__i_0 n_87__234__net_0 _142_ _081_ vss nfet_05v0 w=8.2e-07 l=6e-07 nf=1 m=1
XM_87__234__i_1 vss _036_ n_87__234__net_0 vss nfet_05v0 w=8.2e-07 l=6e-07 nf=1 m=1
XM_87__234__i_8 n_87__234__net_2 _036_ n_87__234__I vdd pfet_05v0 w=5.6e-07 l=5e-07 nf=1 m=1
XM_87__234__i_9 vdd _142_ n_87__234__net_2 vdd pfet_05v0 w=5.6e-07 l=5e-07 nf=1 m=1
XM_87__234__i_5 n_87__234__net_1 n_87__234__I vdd vdd pfet_05v0 w=1.22e-06 l=5e-07 nf=1 m=1
XM_87__234__i_3 _081_ _142_ n_87__234__net_1 vdd pfet_05v0 w=1.22e-06 l=5e-07 nf=1 m=1
XM_87__234__i_4 n_87__234__net_1 _036_ _081_ vdd pfet_05v0 w=1.22e-06 l=5e-07 nf=1 m=1
XM_88__235__i_0 _082_ _081_ vss vss nfet_05v0 w=4.8e-07 l=6e-07 nf=1 m=1
XM_88__235__i_1 _082_ _081_ vdd vdd pfet_05v0 w=1.22e-06 l=5e-07 nf=1 m=1
XM_89__236__i_6 n_89__236__I _082_ vss vss nfet_05v0 w=3.6e-07 l=6e-07 nf=1 m=1
XM_89__236__i_7 vss _080_ n_89__236__I vss nfet_05v0 w=3.6e-07 l=6e-07 nf=1 m=1
XM_89__236__i_2 _012_ n_89__236__I vss vss nfet_05v0 w=8.2e-07 l=6e-07 nf=1 m=1
XM_89__236__i_0 n_89__236__net_0 _080_ _012_ vss nfet_05v0 w=8.2e-07 l=6e-07 nf=1 m=1
XM_89__236__i_1 vss _082_ n_89__236__net_0 vss nfet_05v0 w=8.2e-07 l=6e-07 nf=1 m=1
XM_89__236__i_8 n_89__236__net_2 _082_ n_89__236__I vdd pfet_05v0 w=5.6e-07 l=5e-07 nf=1 m=1
XM_89__236__i_9 vdd _080_ n_89__236__net_2 vdd pfet_05v0 w=5.6e-07 l=5e-07 nf=1 m=1
XM_89__236__i_5 n_89__236__net_1 n_89__236__I vdd vdd pfet_05v0 w=1.22e-06 l=5e-07 nf=1 m=1
XM_89__236__i_3 _012_ _080_ n_89__236__net_1 vdd pfet_05v0 w=1.22e-06 l=5e-07 nf=1 m=1
XM_89__236__i_4 n_89__236__net_1 _082_ _012_ vdd pfet_05v0 w=1.22e-06 l=5e-07 nf=1 m=1
XM_90__237__i_6 n_90__237__I _079_ vss vss nfet_05v0 w=3.6e-07 l=6e-07 nf=1 m=1
XM_90__237__i_7 vss _078_ n_90__237__I vss nfet_05v0 w=3.6e-07 l=6e-07 nf=1 m=1
XM_90__237__i_2 _011_ n_90__237__I vss vss nfet_05v0 w=8.2e-07 l=6e-07 nf=1 m=1
XM_90__237__i_0 n_90__237__net_0 _078_ _011_ vss nfet_05v0 w=8.2e-07 l=6e-07 nf=1 m=1
XM_90__237__i_1 vss _079_ n_90__237__net_0 vss nfet_05v0 w=8.2e-07 l=6e-07 nf=1 m=1
XM_90__237__i_8 n_90__237__net_2 _079_ n_90__237__I vdd pfet_05v0 w=5.6e-07 l=5e-07 nf=1 m=1
XM_90__237__i_9 vdd _078_ n_90__237__net_2 vdd pfet_05v0 w=5.6e-07 l=5e-07 nf=1 m=1
XM_90__237__i_5 n_90__237__net_1 n_90__237__I vdd vdd pfet_05v0 w=1.22e-06 l=5e-07 nf=1 m=1
XM_90__237__i_3 _011_ _078_ n_90__237__net_1 vdd pfet_05v0 w=1.22e-06 l=5e-07 nf=1 m=1
XM_90__237__i_4 n_90__237__net_1 _079_ _011_ vdd pfet_05v0 w=1.22e-06 l=5e-07 nf=1 m=1
XM_91__238__i_1 n_91__238__net_0 _074_ vss vss nfet_05v0 w=8.2e-07 l=6e-07 nf=1 m=1
XM_91__238__i_0 _083_ _072_ n_91__238__net_0 vss nfet_05v0 w=8.2e-07 l=6e-07 nf=1 m=1
XM_91__238__i_3 _083_ _074_ vdd vdd pfet_05v0 w=1.13e-06 l=5e-07 nf=1 m=1
XM_91__238__i_2 vdd _072_ _083_ vdd pfet_05v0 w=1.13e-06 l=5e-07 nf=1 m=1
XM_92__239__i_6 n_92__239__I _083_ vss vss nfet_05v0 w=3.6e-07 l=6e-07 nf=1 m=1
XM_92__239__i_7 vss _075_ n_92__239__I vss nfet_05v0 w=3.6e-07 l=6e-07 nf=1 m=1
XM_92__239__i_2 _021_ n_92__239__I vss vss nfet_05v0 w=8.2e-07 l=6e-07 nf=1 m=1
XM_92__239__i_0 n_92__239__net_0 _075_ _021_ vss nfet_05v0 w=8.2e-07 l=6e-07 nf=1 m=1
XM_92__239__i_1 vss _083_ n_92__239__net_0 vss nfet_05v0 w=8.2e-07 l=6e-07 nf=1 m=1
XM_92__239__i_8 n_92__239__net_2 _083_ n_92__239__I vdd pfet_05v0 w=5.6e-07 l=5e-07 nf=1 m=1
XM_92__239__i_9 vdd _075_ n_92__239__net_2 vdd pfet_05v0 w=5.6e-07 l=5e-07 nf=1 m=1
XM_92__239__i_5 n_92__239__net_1 n_92__239__I vdd vdd pfet_05v0 w=1.22e-06 l=5e-07 nf=1 m=1
XM_92__239__i_3 _021_ _075_ n_92__239__net_1 vdd pfet_05v0 w=1.22e-06 l=5e-07 nf=1 m=1
XM_92__239__i_4 n_92__239__net_1 _083_ _021_ vdd pfet_05v0 w=1.22e-06 l=5e-07 nf=1 m=1
XM_93__240__i_6 n_93__240__I _073_ vss vss nfet_05v0 w=3.6e-07 l=6e-07 nf=1 m=1
XM_93__240__i_7 vss _071_ n_93__240__I vss nfet_05v0 w=3.6e-07 l=6e-07 nf=1 m=1
XM_93__240__i_2 _020_ n_93__240__I vss vss nfet_05v0 w=8.2e-07 l=6e-07 nf=1 m=1
XM_93__240__i_0 n_93__240__net_0 _071_ _020_ vss nfet_05v0 w=8.2e-07 l=6e-07 nf=1 m=1
XM_93__240__i_1 vss _073_ n_93__240__net_0 vss nfet_05v0 w=8.2e-07 l=6e-07 nf=1 m=1
XM_93__240__i_8 n_93__240__net_2 _073_ n_93__240__I vdd pfet_05v0 w=5.6e-07 l=5e-07 nf=1 m=1
XM_93__240__i_9 vdd _071_ n_93__240__net_2 vdd pfet_05v0 w=5.6e-07 l=5e-07 nf=1 m=1
XM_93__240__i_5 n_93__240__net_1 n_93__240__I vdd vdd pfet_05v0 w=1.22e-06 l=5e-07 nf=1 m=1
XM_93__240__i_3 _020_ _071_ n_93__240__net_1 vdd pfet_05v0 w=1.22e-06 l=5e-07 nf=1 m=1
XM_93__240__i_4 n_93__240__net_1 _073_ _020_ vdd pfet_05v0 w=1.22e-06 l=5e-07 nf=1 m=1
XM_94__241__i_1 n_94__241__net_0 _069_ vss vss nfet_05v0 w=8.2e-07 l=6e-07 nf=1 m=1
XM_94__241__i_0 _084_ _125_ n_94__241__net_0 vss nfet_05v0 w=8.2e-07 l=6e-07 nf=1 m=1
XM_94__241__i_3 _084_ _069_ vdd vdd pfet_05v0 w=1.13e-06 l=5e-07 nf=1 m=1
XM_94__241__i_2 vdd _125_ _084_ vdd pfet_05v0 w=1.13e-06 l=5e-07 nf=1 m=1
XM_95__242__i_6 n_95__242__net_2 _084_ n_95__242__I vss nfet_05v0 w=3.6e-07 l=6e-07 nf=1 m=1
XM_95__242__i_7 vss _046_ n_95__242__net_2 vss nfet_05v0 w=3.6e-07 l=6e-07 nf=1 m=1
XM_95__242__i_2 n_95__242__net_0 n_95__242__I vss vss nfet_05v0 w=8.2e-07 l=6e-07 nf=1 m=1
XM_95__242__i_0 _019_ _046_ n_95__242__net_0 vss nfet_05v0 w=8.2e-07 l=6e-07 nf=1 m=1
XM_95__242__i_1 n_95__242__net_0 _084_ _019_ vss nfet_05v0 w=8.2e-07 l=6e-07 nf=1 m=1
XM_95__242__i_8 n_95__242__I _084_ vdd vdd pfet_05v0 w=5.6e-07 l=5e-07 nf=1 m=1
XM_95__242__i_9 vdd _046_ n_95__242__I vdd pfet_05v0 w=5.6e-07 l=5e-07 nf=1 m=1
XM_95__242__i_5 _019_ n_95__242__I vdd vdd pfet_05v0 w=1.095e-06 l=5e-07 nf=1 m=1
XM_95__242__i_3 n_95__242__net_1 _046_ _019_ vdd pfet_05v0 w=1.095e-06 l=5e-07 nf=1 m=1
XM_95__242__i_4 vdd _084_ n_95__242__net_1 vdd pfet_05v0 w=1.095e-06 l=5e-07 nf=1 m=1
XM_96__243__i_6 n_96__243__net_2 _068_ n_96__243__I vss nfet_05v0 w=3.6e-07 l=6e-07 nf=1 m=1
XM_96__243__i_7 vss _126_ n_96__243__net_2 vss nfet_05v0 w=3.6e-07 l=6e-07 nf=1 m=1
XM_96__243__i_2 n_96__243__net_0 n_96__243__I vss vss nfet_05v0 w=8.2e-07 l=6e-07 nf=1 m=1
XM_96__243__i_0 _018_ _126_ n_96__243__net_0 vss nfet_05v0 w=8.2e-07 l=6e-07 nf=1 m=1
XM_96__243__i_1 n_96__243__net_0 _068_ _018_ vss nfet_05v0 w=8.2e-07 l=6e-07 nf=1 m=1
XM_96__243__i_8 n_96__243__I _068_ vdd vdd pfet_05v0 w=5.6e-07 l=5e-07 nf=1 m=1
XM_96__243__i_9 vdd _126_ n_96__243__I vdd pfet_05v0 w=5.6e-07 l=5e-07 nf=1 m=1
XM_96__243__i_5 _018_ n_96__243__I vdd vdd pfet_05v0 w=1.095e-06 l=5e-07 nf=1 m=1
XM_96__243__i_3 n_96__243__net_1 _126_ _018_ vdd pfet_05v0 w=1.095e-06 l=5e-07 nf=1 m=1
XM_96__243__i_4 vdd _068_ n_96__243__net_1 vdd pfet_05v0 w=1.095e-06 l=5e-07 nf=1 m=1
XM_97__244__i_12 n_97__244__I _142_ vss vss nfet_05v0 w=3.6e-07 l=6e-07 nf=1 m=1
XM_97__244__i_13 vss _041_ n_97__244__I vss nfet_05v0 w=3.6e-07 l=6e-07 nf=1 m=1
XM_97__244__i_2 n_97__244__I2 n_97__244__I vss vss nfet_05v0 w=3.6e-07 l=6e-07 nf=1 m=1
XM_97__244__i_0 n_97__244__net_0 _041_ n_97__244__I2 vss nfet_05v0 w=3.6e-07 l=6e-07 nf=1 m=1
XM_97__244__i_1 vss _142_ n_97__244__net_0 vss nfet_05v0 w=3.6e-07 l=6e-07 nf=1 m=1
XM_97__244__i_16 n_97__244__I3 n_97__244__I2 vss vss nfet_05v0 w=3.6e-07 l=6e-07 nf=1 m=1
XM_97__244__i_17 vss _067_ n_97__244__I3 vss nfet_05v0 w=3.6e-07 l=6e-07 nf=1 m=1
XM_97__244__i_8 _017_ n_97__244__I3 vss vss nfet_05v0 w=8.2e-07 l=6e-07 nf=1 m=1
XM_97__244__i_6 n_97__244__net_2 _067_ _017_ vss nfet_05v0 w=8.2e-07 l=6e-07 nf=1 m=1
XM_97__244__i_7 vss n_97__244__I2 n_97__244__net_2 vss nfet_05v0 w=8.2e-07 l=6e-07 nf=1 m=1
XM_97__244__i_14 n_97__244__net_4 _142_ n_97__244__I vdd pfet_05v0 w=3.6e-07 l=5e-07 nf=1 m=1
XM_97__244__i_15 vdd _041_ n_97__244__net_4 vdd pfet_05v0 w=3.6e-07 l=5e-07 nf=1 m=1
XM_97__244__i_5 n_97__244__net_1 n_97__244__I vdd vdd pfet_05v0 w=5.65e-07 l=5e-07 nf=1 m=1
XM_97__244__i_3 n_97__244__I2 _041_ n_97__244__net_1 vdd pfet_05v0 w=5.65e-07 l=5e-07 nf=1 m=1
XM_97__244__i_4 n_97__244__net_1 _142_ n_97__244__I2 vdd pfet_05v0 w=5.65e-07 l=5e-07 nf=1 m=1
XM_97__244__i_18 n_97__244__net_5 n_97__244__I2 n_97__244__I3 vdd pfet_05v0 w=5.65e-07 l=5e-07 nf=1 m=1
XM_97__244__i_19 vdd _067_ n_97__244__net_5 vdd pfet_05v0 w=5.65e-07 l=5e-07 nf=1 m=1
XM_97__244__i_11 n_97__244__net_3 n_97__244__I3 vdd vdd pfet_05v0 w=1.22e-06 l=5e-07 nf=1 m=1
XM_97__244__i_9 _017_ _067_ n_97__244__net_3 vdd pfet_05v0 w=1.22e-06 l=5e-07 nf=1 m=1
XM_97__244__i_10 n_97__244__net_3 n_97__244__I2 _017_ vdd pfet_05v0 w=1.22e-06 l=5e-07 nf=1 m=1
XM_98__245__i_12 n_98__245__I _142_ vss vss nfet_05v0 w=3.6e-07 l=6e-07 nf=1 m=1
XM_98__245__i_13 vss _040_ n_98__245__I vss nfet_05v0 w=3.6e-07 l=6e-07 nf=1 m=1
XM_98__245__i_2 n_98__245__I2 n_98__245__I vss vss nfet_05v0 w=3.6e-07 l=6e-07 nf=1 m=1
XM_98__245__i_0 n_98__245__net_0 _040_ n_98__245__I2 vss nfet_05v0 w=3.6e-07 l=6e-07 nf=1 m=1
XM_98__245__i_1 vss _142_ n_98__245__net_0 vss nfet_05v0 w=3.6e-07 l=6e-07 nf=1 m=1
XM_98__245__i_16 n_98__245__I3 n_98__245__I2 vss vss nfet_05v0 w=3.6e-07 l=6e-07 nf=1 m=1
XM_98__245__i_17 vss _066_ n_98__245__I3 vss nfet_05v0 w=3.6e-07 l=6e-07 nf=1 m=1
XM_98__245__i_8 _016_ n_98__245__I3 vss vss nfet_05v0 w=8.2e-07 l=6e-07 nf=1 m=1
XM_98__245__i_6 n_98__245__net_2 _066_ _016_ vss nfet_05v0 w=8.2e-07 l=6e-07 nf=1 m=1
XM_98__245__i_7 vss n_98__245__I2 n_98__245__net_2 vss nfet_05v0 w=8.2e-07 l=6e-07 nf=1 m=1
XM_98__245__i_14 n_98__245__net_4 _142_ n_98__245__I vdd pfet_05v0 w=3.6e-07 l=5e-07 nf=1 m=1
XM_98__245__i_15 vdd _040_ n_98__245__net_4 vdd pfet_05v0 w=3.6e-07 l=5e-07 nf=1 m=1
XM_98__245__i_5 n_98__245__net_1 n_98__245__I vdd vdd pfet_05v0 w=5.65e-07 l=5e-07 nf=1 m=1
XM_98__245__i_3 n_98__245__I2 _040_ n_98__245__net_1 vdd pfet_05v0 w=5.65e-07 l=5e-07 nf=1 m=1
XM_98__245__i_4 n_98__245__net_1 _142_ n_98__245__I2 vdd pfet_05v0 w=5.65e-07 l=5e-07 nf=1 m=1
XM_98__245__i_18 n_98__245__net_5 n_98__245__I2 n_98__245__I3 vdd pfet_05v0 w=5.65e-07 l=5e-07 nf=1 m=1
XM_98__245__i_19 vdd _066_ n_98__245__net_5 vdd pfet_05v0 w=5.65e-07 l=5e-07 nf=1 m=1
XM_98__245__i_11 n_98__245__net_3 n_98__245__I3 vdd vdd pfet_05v0 w=1.22e-06 l=5e-07 nf=1 m=1
XM_98__245__i_9 _016_ _066_ n_98__245__net_3 vdd pfet_05v0 w=1.22e-06 l=5e-07 nf=1 m=1
XM_98__245__i_10 n_98__245__net_3 n_98__245__I2 _016_ vdd pfet_05v0 w=1.22e-06 l=5e-07 nf=1 m=1
XM_99__246__i_12 n_99__246__I _141_ vss vss nfet_05v0 w=3.6e-07 l=6e-07 nf=1 m=1
XM_99__246__i_13 vss _039_ n_99__246__I vss nfet_05v0 w=3.6e-07 l=6e-07 nf=1 m=1
XM_99__246__i_2 n_99__246__I2 n_99__246__I vss vss nfet_05v0 w=3.6e-07 l=6e-07 nf=1 m=1
XM_99__246__i_0 n_99__246__net_0 _039_ n_99__246__I2 vss nfet_05v0 w=3.6e-07 l=6e-07 nf=1 m=1
XM_99__246__i_1 vss _141_ n_99__246__net_0 vss nfet_05v0 w=3.6e-07 l=6e-07 nf=1 m=1
XM_99__246__i_16 n_99__246__net_5 n_99__246__I2 n_99__246__I3 vss nfet_05v0 w=3.6e-07 l=6e-07 nf=1 m=1
XM_99__246__i_17 vss _064_ n_99__246__net_5 vss nfet_05v0 w=3.6e-07 l=6e-07 nf=1 m=1
XM_99__246__i_8 n_99__246__net_2 n_99__246__I3 vss vss nfet_05v0 w=8.2e-07 l=6e-07 nf=1 m=1
XM_99__246__i_6 _015_ _064_ n_99__246__net_2 vss nfet_05v0 w=8.2e-07 l=6e-07 nf=1 m=1
XM_99__246__i_7 n_99__246__net_2 n_99__246__I2 _015_ vss nfet_05v0 w=8.2e-07 l=6e-07 nf=1 m=1
XM_99__246__i_14 n_99__246__net_4 _141_ n_99__246__I vdd pfet_05v0 w=3.6e-07 l=5e-07 nf=1 m=1
XM_99__246__i_15 vdd _039_ n_99__246__net_4 vdd pfet_05v0 w=3.6e-07 l=5e-07 nf=1 m=1
XM_99__246__i_5 n_99__246__net_1 n_99__246__I vdd vdd pfet_05v0 w=5.6e-07 l=5e-07 nf=1 m=1
XM_99__246__i_3 n_99__246__I2 _039_ n_99__246__net_1 vdd pfet_05v0 w=5.6e-07 l=5e-07 nf=1 m=1
XM_99__246__i_4 n_99__246__net_1 _141_ n_99__246__I2 vdd pfet_05v0 w=5.6e-07 l=5e-07 nf=1 m=1
XM_99__246__i_18 n_99__246__I3 n_99__246__I2 vdd vdd pfet_05v0 w=5.6e-07 l=5e-07 nf=1 m=1
XM_99__246__i_19 vdd _064_ n_99__246__I3 vdd pfet_05v0 w=5.6e-07 l=5e-07 nf=1 m=1
XM_99__246__i_11 _015_ n_99__246__I3 vdd vdd pfet_05v0 w=1.095e-06 l=5e-07 nf=1 m=1
XM_99__246__i_9 n_99__246__net_3 _064_ _015_ vdd pfet_05v0 w=1.095e-06 l=5e-07 nf=1 m=1
XM_99__246__i_10 vdd n_99__246__I2 n_99__246__net_3 vdd pfet_05v0 w=1.095e-06 l=5e-07 nf=1 m=1
XM_100__247__i_6 n_100__247__I _063_ vss vss nfet_05v0 w=3.6e-07 l=6e-07 nf=1 m=1
XM_100__247__i_7 vss _062_ n_100__247__I vss nfet_05v0 w=3.6e-07 l=6e-07 nf=1 m=1
XM_100__247__i_2 _014_ n_100__247__I vss vss nfet_05v0 w=8.2e-07 l=6e-07 nf=1 m=1
XM_100__247__i_0 n_100__247__net_0 _062_ _014_ vss nfet_05v0 w=8.2e-07 l=6e-07 nf=1 m=1
XM_100__247__i_1 vss _063_ n_100__247__net_0 vss nfet_05v0 w=8.2e-07 l=6e-07 nf=1 m=1
XM_100__247__i_8 n_100__247__net_2 _063_ n_100__247__I vdd pfet_05v0 w=5.6e-07 l=5e-07 nf=1 m=1
XM_100__247__i_9 vdd _062_ n_100__247__net_2 vdd pfet_05v0 w=5.6e-07 l=5e-07 nf=1 m=1
XM_100__247__i_5 n_100__247__net_1 n_100__247__I vdd vdd pfet_05v0 w=1.22e-06 l=5e-07 nf=1 m=1
XM_100__247__i_3 _014_ _062_ n_100__247__net_1 vdd pfet_05v0 w=1.22e-06 l=5e-07 nf=1 m=1
XM_100__247__i_4 n_100__247__net_1 _063_ _014_ vdd pfet_05v0 w=1.22e-06 l=5e-07 nf=1 m=1
XM_101__248__i_12 n_101__248__I _037_ vss vss nfet_05v0 w=3.6e-07 l=6e-07 nf=1 m=1
XM_101__248__i_13 vss _139_ n_101__248__I vss nfet_05v0 w=3.6e-07 l=6e-07 nf=1 m=1
XM_101__248__i_2 n_101__248__I2 n_101__248__I vss vss nfet_05v0 w=3.6e-07 l=6e-07 nf=1 m=1
XM_101__248__i_0 n_101__248__net_0 _139_ n_101__248__I2 vss nfet_05v0 w=3.6e-07 l=6e-07 nf=1 m=1
XM_101__248__i_1 vss _037_ n_101__248__net_0 vss nfet_05v0 w=3.6e-07 l=6e-07 nf=1 m=1
XM_101__248__i_16 n_101__248__net_5 n_101__248__I2 n_101__248__I3 vss nfet_05v0 w=3.6e-07 l=6e-07 nf=1 m=1
XM_101__248__i_17 vss _060_ n_101__248__net_5 vss nfet_05v0 w=3.6e-07 l=6e-07 nf=1 m=1
XM_101__248__i_8 n_101__248__net_2 n_101__248__I3 vss vss nfet_05v0 w=8.2e-07 l=6e-07 nf=1 m=1
XM_101__248__i_6 _013_ _060_ n_101__248__net_2 vss nfet_05v0 w=8.2e-07 l=6e-07 nf=1 m=1
XM_101__248__i_7 n_101__248__net_2 n_101__248__I2 _013_ vss nfet_05v0 w=8.2e-07 l=6e-07 nf=1 m=1
XM_101__248__i_14 n_101__248__net_4 _037_ n_101__248__I vdd pfet_05v0 w=3.6e-07 l=5e-07 nf=1 m=1
XM_101__248__i_15 vdd _139_ n_101__248__net_4 vdd pfet_05v0 w=3.6e-07 l=5e-07 nf=1 m=1
XM_101__248__i_5 n_101__248__net_1 n_101__248__I vdd vdd pfet_05v0 w=5.6e-07 l=5e-07 nf=1 m=1
XM_101__248__i_3 n_101__248__I2 _139_ n_101__248__net_1 vdd pfet_05v0 w=5.6e-07 l=5e-07 nf=1 m=1
XM_101__248__i_4 n_101__248__net_1 _037_ n_101__248__I2 vdd pfet_05v0 w=5.6e-07 l=5e-07 nf=1 m=1
XM_101__248__i_18 n_101__248__I3 n_101__248__I2 vdd vdd pfet_05v0 w=5.6e-07 l=5e-07 nf=1 m=1
XM_101__248__i_19 vdd _060_ n_101__248__I3 vdd pfet_05v0 w=5.6e-07 l=5e-07 nf=1 m=1
XM_101__248__i_11 _013_ n_101__248__I3 vdd vdd pfet_05v0 w=1.095e-06 l=5e-07 nf=1 m=1
XM_101__248__i_9 n_101__248__net_3 _060_ _013_ vdd pfet_05v0 w=1.095e-06 l=5e-07 nf=1 m=1
XM_101__248__i_10 vdd n_101__248__I2 n_101__248__net_3 vdd pfet_05v0 w=1.095e-06 l=5e-07 nf=1 m=1
XM_102__249__i_6 n_102__249__I _034_ vss vss nfet_05v0 w=3.6e-07 l=6e-07 nf=1 m=1
XM_102__249__i_7 vss _138_ n_102__249__I vss nfet_05v0 w=3.6e-07 l=6e-07 nf=1 m=1
XM_102__249__i_2 _010_ n_102__249__I vss vss nfet_05v0 w=8.2e-07 l=6e-07 nf=1 m=1
XM_102__249__i_0 n_102__249__net_0 _138_ _010_ vss nfet_05v0 w=8.2e-07 l=6e-07 nf=1 m=1
XM_102__249__i_1 vss _034_ n_102__249__net_0 vss nfet_05v0 w=8.2e-07 l=6e-07 nf=1 m=1
XM_102__249__i_8 n_102__249__net_2 _034_ n_102__249__I vdd pfet_05v0 w=5.6e-07 l=5e-07 nf=1 m=1
XM_102__249__i_9 vdd _138_ n_102__249__net_2 vdd pfet_05v0 w=5.6e-07 l=5e-07 nf=1 m=1
XM_102__249__i_5 n_102__249__net_1 n_102__249__I vdd vdd pfet_05v0 w=1.22e-06 l=5e-07 nf=1 m=1
XM_102__249__i_3 _010_ _138_ n_102__249__net_1 vdd pfet_05v0 w=1.22e-06 l=5e-07 nf=1 m=1
XM_102__249__i_4 n_102__249__net_1 _034_ _010_ vdd pfet_05v0 w=1.22e-06 l=5e-07 nf=1 m=1
XM_103__250__i_1 _085_ _046_ n_103__250__net_0 vss nfet_05v0 w=8.2e-07 l=6e-07 nf=1 m=1
XM_103__250__i_0 n_103__250__net_0 _127_ _085_ vss nfet_05v0 w=8.2e-07 l=6e-07 nf=1 m=1
XM_103__250__i_2 vss _070_ n_103__250__net_0 vss nfet_05v0 w=8.2e-07 l=6e-07 nf=1 m=1
XM_103__250__i_4 n_103__250__net_1 _046_ vdd vdd pfet_05v0 w=1.22e-06 l=5e-07 nf=1 m=1
XM_103__250__i_3 _085_ _127_ n_103__250__net_1 vdd pfet_05v0 w=1.22e-06 l=5e-07 nf=1 m=1
XM_103__250__i_5 vdd _070_ _085_ vdd pfet_05v0 w=1.13e-06 l=5e-07 nf=1 m=1
XM_104__251__i_1 n_104__251__net_0 _085_ vss vss nfet_05v0 w=8.2e-07 l=6e-07 nf=1 m=1
XM_104__251__i_0 _086_ _073_ n_104__251__net_0 vss nfet_05v0 w=8.2e-07 l=6e-07 nf=1 m=1
XM_104__251__i_3 _086_ _085_ vdd vdd pfet_05v0 w=1.13e-06 l=5e-07 nf=1 m=1
XM_104__251__i_2 vdd _073_ _086_ vdd pfet_05v0 w=1.13e-06 l=5e-07 nf=1 m=1
XM_105__252__i_6 n_105__252__I _085_ vss vss nfet_05v0 w=3.6e-07 l=6e-07 nf=1 m=1
XM_105__252__i_7 vss _073_ n_105__252__I vss nfet_05v0 w=3.6e-07 l=6e-07 nf=1 m=1
XM_105__252__i_2 _087_ n_105__252__I vss vss nfet_05v0 w=8.2e-07 l=6e-07 nf=1 m=1
XM_105__252__i_0 n_105__252__net_0 _073_ _087_ vss nfet_05v0 w=8.2e-07 l=6e-07 nf=1 m=1
XM_105__252__i_1 vss _085_ n_105__252__net_0 vss nfet_05v0 w=8.2e-07 l=6e-07 nf=1 m=1
XM_105__252__i_8 n_105__252__net_2 _085_ n_105__252__I vdd pfet_05v0 w=5.6e-07 l=5e-07 nf=1 m=1
XM_105__252__i_9 vdd _073_ n_105__252__net_2 vdd pfet_05v0 w=5.6e-07 l=5e-07 nf=1 m=1
XM_105__252__i_5 n_105__252__net_1 n_105__252__I vdd vdd pfet_05v0 w=1.22e-06 l=5e-07 nf=1 m=1
XM_105__252__i_3 _087_ _073_ n_105__252__net_1 vdd pfet_05v0 w=1.22e-06 l=5e-07 nf=1 m=1
XM_105__252__i_4 n_105__252__net_1 _085_ _087_ vdd pfet_05v0 w=1.22e-06 l=5e-07 nf=1 m=1
XM_106__253__i_1 n_106__253__net_0 _087_ vss vss nfet_05v0 w=8.2e-07 l=6e-07 nf=1 m=1
XM_106__253__i_0 _088_ _033_ n_106__253__net_0 vss nfet_05v0 w=8.2e-07 l=6e-07 nf=1 m=1
XM_106__253__i_3 _088_ _087_ vdd vdd pfet_05v0 w=1.13e-06 l=5e-07 nf=1 m=1
XM_106__253__i_2 vdd _033_ _088_ vdd pfet_05v0 w=1.13e-06 l=5e-07 nf=1 m=1
XM_107__254__i_2_0 _089_ _048_ vss vss nfet_05v0 w=5.65e-07 l=6e-07 nf=1 m=1
XM_107__254__i_2_1 vss _048_ _089_ vss nfet_05v0 w=5.65e-07 l=6e-07 nf=1 m=1
XM_107__254__i_1_0 n_107__254__net_0_0 _136_ vss vss nfet_05v0 w=7.75e-07 l=6e-07 nf=1 m=1
XM_107__254__i_0_1 _089_ _049_ n_107__254__net_0_0 vss nfet_05v0 w=7.75e-07 l=6e-07 nf=1 m=1
XM_107__254__i_0_0 n_107__254__net_0_1 _049_ _089_ vss nfet_05v0 w=7.75e-07 l=6e-07 nf=1 m=1
XM_107__254__i_1_1 vss _136_ n_107__254__net_0_1 vss nfet_05v0 w=7.75e-07 l=6e-07 nf=1 m=1
XM_107__254__i_5_0 vdd _048_ n_107__254__net_1 vdd pfet_05v0 w=1.215e-06 l=5e-07 nf=1 m=1
XM_107__254__i_5_1 n_107__254__net_1 _048_ vdd vdd pfet_05v0 w=1.215e-06 l=5e-07 nf=1 m=1
XM_107__254__i_4_0 _089_ _136_ n_107__254__net_1 vdd pfet_05v0 w=1.215e-06 l=5e-07 nf=1 m=1
XM_107__254__i_3_1 n_107__254__net_1 _049_ _089_ vdd pfet_05v0 w=1.215e-06 l=5e-07 nf=1 m=1
XM_107__254__i_3_0 _089_ _049_ n_107__254__net_1 vdd pfet_05v0 w=1.215e-06 l=5e-07 nf=1 m=1
XM_107__254__i_4_1 n_107__254__net_1 _136_ _089_ vdd pfet_05v0 w=1.215e-06 l=5e-07 nf=1 m=1
XM_108__255__i_6 n_108__255__net_2 _087_ n_108__255__I vss nfet_05v0 w=3.6e-07 l=6e-07 nf=1 m=1
XM_108__255__i_7 vss _033_ n_108__255__net_2 vss nfet_05v0 w=3.6e-07 l=6e-07 nf=1 m=1
XM_108__255__i_2 n_108__255__net_0 n_108__255__I vss vss nfet_05v0 w=8.2e-07 l=6e-07 nf=1 m=1
XM_108__255__i_0 _090_ _033_ n_108__255__net_0 vss nfet_05v0 w=8.2e-07 l=6e-07 nf=1 m=1
XM_108__255__i_1 n_108__255__net_0 _087_ _090_ vss nfet_05v0 w=8.2e-07 l=6e-07 nf=1 m=1
XM_108__255__i_8 n_108__255__I _087_ vdd vdd pfet_05v0 w=5.6e-07 l=5e-07 nf=1 m=1
XM_108__255__i_9 vdd _033_ n_108__255__I vdd pfet_05v0 w=5.6e-07 l=5e-07 nf=1 m=1
XM_108__255__i_5 _090_ n_108__255__I vdd vdd pfet_05v0 w=1.095e-06 l=5e-07 nf=1 m=1
XM_108__255__i_3 n_108__255__net_1 _033_ _090_ vdd pfet_05v0 w=1.095e-06 l=5e-07 nf=1 m=1
XM_108__255__i_4 vdd _087_ n_108__255__net_1 vdd pfet_05v0 w=1.095e-06 l=5e-07 nf=1 m=1
XM_109__256__i_1 _000_ _090_ n_109__256__net_0 vss nfet_05v0 w=8.2e-07 l=6e-07 nf=1 m=1
XM_109__256__i_0 n_109__256__net_0 _089_ _000_ vss nfet_05v0 w=8.2e-07 l=6e-07 nf=1 m=1
XM_109__256__i_2 vss _088_ n_109__256__net_0 vss nfet_05v0 w=8.2e-07 l=6e-07 nf=1 m=1
XM_109__256__i_4 n_109__256__net_1 _090_ vdd vdd pfet_05v0 w=1.22e-06 l=5e-07 nf=1 m=1
XM_109__256__i_3 _000_ _089_ n_109__256__net_1 vdd pfet_05v0 w=1.22e-06 l=5e-07 nf=1 m=1
XM_109__256__i_5 vdd _088_ _000_ vdd pfet_05v0 w=1.13e-06 l=5e-07 nf=1 m=1
XM_110__257__i_1 _091_ _086_ n_110__257__net_0 vss nfet_05v0 w=8.2e-07 l=6e-07 nf=1 m=1
XM_110__257__i_0 n_110__257__net_0 _076_ _091_ vss nfet_05v0 w=8.2e-07 l=6e-07 nf=1 m=1
XM_110__257__i_2 vss _077_ n_110__257__net_0 vss nfet_05v0 w=8.2e-07 l=6e-07 nf=1 m=1
XM_110__257__i_4 n_110__257__net_1 _086_ vdd vdd pfet_05v0 w=1.22e-06 l=5e-07 nf=1 m=1
XM_110__257__i_3 _091_ _076_ n_110__257__net_1 vdd pfet_05v0 w=1.22e-06 l=5e-07 nf=1 m=1
XM_110__257__i_5 vdd _077_ _091_ vdd pfet_05v0 w=1.13e-06 l=5e-07 nf=1 m=1
XM_111__258__i_1 n_111__258__net_0 _091_ vss vss nfet_05v0 w=8.2e-07 l=6e-07 nf=1 m=1
XM_111__258__i_0 _092_ _079_ n_111__258__net_0 vss nfet_05v0 w=8.2e-07 l=6e-07 nf=1 m=1
XM_111__258__i_2 vss _052_ _092_ vss nfet_05v0 w=5.1e-07 l=6e-07 nf=1 m=1
XM_111__258__i_4 _092_ _091_ n_111__258__net_1 vdd pfet_05v0 w=1.215e-06 l=5e-07 nf=1 m=1
XM_111__258__i_3 n_111__258__net_1 _079_ _092_ vdd pfet_05v0 w=1.215e-06 l=5e-07 nf=1 m=1
XM_111__258__i_5 vdd _052_ n_111__258__net_1 vdd pfet_05v0 w=1.215e-06 l=5e-07 nf=1 m=1
XM_112__259__i_6 n_112__259__I _092_ vss vss nfet_05v0 w=3.6e-07 l=6e-07 nf=1 m=1
XM_112__259__i_7 vss _082_ n_112__259__I vss nfet_05v0 w=3.6e-07 l=6e-07 nf=1 m=1
XM_112__259__i_2 _024_ n_112__259__I vss vss nfet_05v0 w=8.2e-07 l=6e-07 nf=1 m=1
XM_112__259__i_0 n_112__259__net_0 _082_ _024_ vss nfet_05v0 w=8.2e-07 l=6e-07 nf=1 m=1
XM_112__259__i_1 vss _092_ n_112__259__net_0 vss nfet_05v0 w=8.2e-07 l=6e-07 nf=1 m=1
XM_112__259__i_8 n_112__259__net_2 _092_ n_112__259__I vdd pfet_05v0 w=5.6e-07 l=5e-07 nf=1 m=1
XM_112__259__i_9 vdd _082_ n_112__259__net_2 vdd pfet_05v0 w=5.6e-07 l=5e-07 nf=1 m=1
XM_112__259__i_5 n_112__259__net_1 n_112__259__I vdd vdd pfet_05v0 w=1.22e-06 l=5e-07 nf=1 m=1
XM_112__259__i_3 _024_ _082_ n_112__259__net_1 vdd pfet_05v0 w=1.22e-06 l=5e-07 nf=1 m=1
XM_112__259__i_4 n_112__259__net_1 _092_ _024_ vdd pfet_05v0 w=1.22e-06 l=5e-07 nf=1 m=1
XM_113__260__i_6 n_113__260__I _091_ vss vss nfet_05v0 w=3.6e-07 l=6e-07 nf=1 m=1
XM_113__260__i_7 vss _079_ n_113__260__I vss nfet_05v0 w=3.6e-07 l=6e-07 nf=1 m=1
XM_113__260__i_2 _023_ n_113__260__I vss vss nfet_05v0 w=8.2e-07 l=6e-07 nf=1 m=1
XM_113__260__i_0 n_113__260__net_0 _079_ _023_ vss nfet_05v0 w=8.2e-07 l=6e-07 nf=1 m=1
XM_113__260__i_1 vss _091_ n_113__260__net_0 vss nfet_05v0 w=8.2e-07 l=6e-07 nf=1 m=1
XM_113__260__i_8 n_113__260__net_2 _091_ n_113__260__I vdd pfet_05v0 w=5.6e-07 l=5e-07 nf=1 m=1
XM_113__260__i_9 vdd _079_ n_113__260__net_2 vdd pfet_05v0 w=5.6e-07 l=5e-07 nf=1 m=1
XM_113__260__i_5 n_113__260__net_1 n_113__260__I vdd vdd pfet_05v0 w=1.22e-06 l=5e-07 nf=1 m=1
XM_113__260__i_3 _023_ _079_ n_113__260__net_1 vdd pfet_05v0 w=1.22e-06 l=5e-07 nf=1 m=1
XM_113__260__i_4 n_113__260__net_1 _091_ _023_ vdd pfet_05v0 w=1.22e-06 l=5e-07 nf=1 m=1
XM_114__261__i_1 n_114__261__net_0 _086_ vss vss nfet_05v0 w=8.2e-07 l=6e-07 nf=1 m=1
XM_114__261__i_0 _093_ _072_ n_114__261__net_0 vss nfet_05v0 w=8.2e-07 l=6e-07 nf=1 m=1
XM_114__261__i_3 _093_ _086_ vdd vdd pfet_05v0 w=1.13e-06 l=5e-07 nf=1 m=1
XM_114__261__i_2 vdd _072_ _093_ vdd pfet_05v0 w=1.13e-06 l=5e-07 nf=1 m=1
XM_115__262__i_6 n_115__262__I _093_ vss vss nfet_05v0 w=3.6e-07 l=6e-07 nf=1 m=1
XM_115__262__i_7 vss _075_ n_115__262__I vss nfet_05v0 w=3.6e-07 l=6e-07 nf=1 m=1
XM_115__262__i_2 _022_ n_115__262__I vss vss nfet_05v0 w=8.2e-07 l=6e-07 nf=1 m=1
XM_115__262__i_0 n_115__262__net_0 _075_ _022_ vss nfet_05v0 w=8.2e-07 l=6e-07 nf=1 m=1
XM_115__262__i_1 vss _093_ n_115__262__net_0 vss nfet_05v0 w=8.2e-07 l=6e-07 nf=1 m=1
XM_115__262__i_8 n_115__262__net_2 _093_ n_115__262__I vdd pfet_05v0 w=5.6e-07 l=5e-07 nf=1 m=1
XM_115__262__i_9 vdd _075_ n_115__262__net_2 vdd pfet_05v0 w=5.6e-07 l=5e-07 nf=1 m=1
XM_115__262__i_5 n_115__262__net_1 n_115__262__I vdd vdd pfet_05v0 w=1.22e-06 l=5e-07 nf=1 m=1
XM_115__262__i_3 _022_ _075_ n_115__262__net_1 vdd pfet_05v0 w=1.22e-06 l=5e-07 nf=1 m=1
XM_115__262__i_4 n_115__262__net_1 _093_ _022_ vdd pfet_05v0 w=1.22e-06 l=5e-07 nf=1 m=1
XM_116__263__i_6 n_116__263__I _025_ vss vss nfet_05v0 w=3.6e-07 l=6e-07 nf=1 m=1
XM_116__263__i_7 vss _034_ n_116__263__I vss nfet_05v0 w=3.6e-07 l=6e-07 nf=1 m=1
XM_116__263__i_2 _001_ n_116__263__I vss vss nfet_05v0 w=8.2e-07 l=6e-07 nf=1 m=1
XM_116__263__i_0 n_116__263__net_0 _034_ _001_ vss nfet_05v0 w=8.2e-07 l=6e-07 nf=1 m=1
XM_116__263__i_1 vss _025_ n_116__263__net_0 vss nfet_05v0 w=8.2e-07 l=6e-07 nf=1 m=1
XM_116__263__i_8 n_116__263__net_2 _025_ n_116__263__I vdd pfet_05v0 w=5.6e-07 l=5e-07 nf=1 m=1
XM_116__263__i_9 vdd _034_ n_116__263__net_2 vdd pfet_05v0 w=5.6e-07 l=5e-07 nf=1 m=1
XM_116__263__i_5 n_116__263__net_1 n_116__263__I vdd vdd pfet_05v0 w=1.22e-06 l=5e-07 nf=1 m=1
XM_116__263__i_3 _001_ _034_ n_116__263__net_1 vdd pfet_05v0 w=1.22e-06 l=5e-07 nf=1 m=1
XM_116__263__i_4 n_116__263__net_1 _025_ _001_ vdd pfet_05v0 w=1.22e-06 l=5e-07 nf=1 m=1
XM_117__264__i_8 n_117__264__net_2 _090_ n_117__264__I vss nfet_05v0 w=3.6e-07 l=6e-07 nf=1 m=1
XM_117__264__i_9 vss _089_ n_117__264__net_2 vss nfet_05v0 w=3.6e-07 l=6e-07 nf=1 m=1
XM_117__264__i_4 n_117__264__net_0 n_117__264__I vss vss nfet_05v0 w=8.2e-07 l=6e-07 nf=1 m=1
XM_117__264__i_2 n_117__264__Z_neg _089_ n_117__264__net_0 vss nfet_05v0 w=8.2e-07 l=6e-07 nf=1 m=1
XM_117__264__i_3 n_117__264__net_0 _090_ n_117__264__Z_neg vss nfet_05v0 w=8.2e-07 l=6e-07 nf=1 m=1
XM_117__264__i_0_0 _009_ n_117__264__Z_neg vss vss nfet_05v0 w=8.2e-07 l=6e-07 nf=1 m=1
XM_117__264__i_0_1 vss n_117__264__Z_neg _009_ vss nfet_05v0 w=8.2e-07 l=6e-07 nf=1 m=1
XM_117__264__i_10 n_117__264__I _090_ vdd vdd pfet_05v0 w=5.6e-07 l=5e-07 nf=1 m=1
XM_117__264__i_11 vdd _089_ n_117__264__I vdd pfet_05v0 w=5.6e-07 l=5e-07 nf=1 m=1
XM_117__264__i_7 n_117__264__Z_neg n_117__264__I vdd vdd pfet_05v0 w=1.095e-06 l=5e-07 nf=1 m=1
XM_117__264__i_5 n_117__264__net_1 _089_ n_117__264__Z_neg vdd pfet_05v0 w=1.095e-06 l=5e-07 nf=1 m=1
XM_117__264__i_6 vdd _090_ n_117__264__net_1 vdd pfet_05v0 w=1.095e-06 l=5e-07 nf=1 m=1
XM_117__264__i_1_0 _009_ n_117__264__Z_neg vdd vdd pfet_05v0 w=1.22e-06 l=5e-07 nf=1 m=1
XM_117__264__i_1_1 vdd n_117__264__Z_neg _009_ vdd pfet_05v0 w=1.22e-06 l=5e-07 nf=1 m=1
XM_118__265__tn10 n_118__265__ncki clknet_1_0__leaf_clk_ref vss vss nfet_05v0 w=4.05e-07 l=6e-07 nf=1 m=1
XM_118__265__tn13 n_118__265__cki n_118__265__ncki vss vss nfet_05v0 w=4.05e-07 l=6e-07 nf=1 m=1
XM_118__265__tn11 n_118__265__net10 _144__0 vss vss nfet_05v0 w=3.6e-07 l=6e-07 nf=1 m=1
XM_118__265__tn15 n_118__265__net10 n_118__265__ncki n_118__265__net1 vss nfet_05v0 w=3.6e-07 l=6e-07 nf=1 m=1
XM_118__265__tn14 n_118__265__net1 n_118__265__cki n_118__265__net15 vss nfet_05v0 w=3.6e-07 l=6e-07 nf=1 m=1
XM_118__265__tn8 n_118__265__net12 n_118__265__net2 n_118__265__net15 vss nfet_05v0 w=3.6e-07 l=6e-07 nf=1 m=1
XM_118__265__tn9 vss rst_n n_118__265__net12 vss nfet_05v0 w=3.6e-07 l=6e-07 nf=1 m=1
XM_118__265__tn18 vss n_118__265__net1 n_118__265__net2 vss nfet_05v0 w=3.6e-07 l=6e-07 nf=1 m=1
XM_118__265__tn0 n_118__265__net8 n_118__265__cki n_118__265__net2 vss nfet_05v0 w=3.6e-07 l=6e-07 nf=1 m=1
XM_118__265__tn1 n_118__265__net11 n_118__265__ncki n_118__265__net8 vss nfet_05v0 w=3.6e-07 l=6e-07 nf=1 m=1
XM_118__265__tn12 n_118__265__net11 n_118__265__net4 vss vss nfet_05v0 w=3.6e-07 l=6e-07 nf=1 m=1
XM_118__265__tn5 n_118__265__net0 rst_n vss vss nfet_05v0 w=3.6e-07 l=6e-07 nf=1 m=1
XM_118__265__tn4 n_118__265__net4 n_118__265__net8 n_118__265__net0 vss nfet_05v0 w=4e-07 l=6e-07 nf=1 m=1
XM_118__265__tn3 dsm_acc1_0 n_118__265__net4 vss vss nfet_05v0 w=8.15e-07 l=6e-07 nf=1 m=1
XM_118__265__tp8 n_118__265__ncki clknet_1_0__leaf_clk_ref vdd vdd pfet_05v0 w=8.65e-07 l=5e-07 nf=1 m=1
XM_118__265__tp11 n_118__265__cki n_118__265__ncki vdd vdd pfet_05v0 w=8.65e-07 l=5e-07 nf=1 m=1
XM_118__265__tp9 vdd _144__0 n_118__265__net10 vdd pfet_05v0 w=7.8e-07 l=5e-07 nf=1 m=1
XM_118__265__tp15 n_118__265__net1 n_118__265__cki n_118__265__net10 vdd pfet_05v0 w=7.8e-07 l=5e-07 nf=1 m=1
XM_118__265__tp7 n_118__265__net9 n_118__265__ncki n_118__265__net1 vdd pfet_05v0 w=7.8e-07 l=5e-07 nf=1 m=1
XM_118__265__tp6 vdd n_118__265__net2 n_118__265__net9 vdd pfet_05v0 w=7.8e-07 l=5e-07 nf=1 m=1
XM_118__265__tp12 n_118__265__net9 rst_n vdd vdd pfet_05v0 w=7.8e-07 l=5e-07 nf=1 m=1
XM_118__265__tp18 vdd n_118__265__net1 n_118__265__net2 vdd pfet_05v0 w=5.05e-07 l=5e-07 nf=1 m=1
XM_118__265__tp2 n_118__265__net2 n_118__265__ncki n_118__265__net8 vdd pfet_05v0 w=5.05e-07 l=5e-07 nf=1 m=1
XM_118__265__tp3 n_118__265__net8 n_118__265__cki n_118__265__net11 vdd pfet_05v0 w=5.05e-07 l=5e-07 nf=1 m=1
XM_118__265__tp10 n_118__265__net11 n_118__265__net4 vdd vdd pfet_05v0 w=5.05e-07 l=5e-07 nf=1 m=1
XM_118__265__tp5 n_118__265__net4 rst_n vdd vdd pfet_05v0 w=1e-06 l=5e-07 nf=1 m=1
XM_118__265__tp4 vdd n_118__265__net8 n_118__265__net4 vdd pfet_05v0 w=1e-06 l=5e-07 nf=1 m=1
XM_118__265__tp1 dsm_acc1_0 n_118__265__net4 vdd vdd pfet_05v0 w=1.215e-06 l=5e-07 nf=1 m=1
XM_119__266__tn10 n_119__266__ncki clknet_1_0__leaf_clk_ref vss vss nfet_05v0 w=4.05e-07 l=6e-07 nf=1 m=1
XM_119__266__tn13 n_119__266__cki n_119__266__ncki vss vss nfet_05v0 w=4.05e-07 l=6e-07 nf=1 m=1
XM_119__266__tn11 n_119__266__net10 _145__1 vss vss nfet_05v0 w=3.6e-07 l=6e-07 nf=1 m=1
XM_119__266__tn15 n_119__266__net10 n_119__266__ncki n_119__266__net1 vss nfet_05v0 w=3.6e-07 l=6e-07 nf=1 m=1
XM_119__266__tn14 n_119__266__net1 n_119__266__cki n_119__266__net15 vss nfet_05v0 w=3.6e-07 l=6e-07 nf=1 m=1
XM_119__266__tn8 n_119__266__net12 n_119__266__net2 n_119__266__net15 vss nfet_05v0 w=3.6e-07 l=6e-07 nf=1 m=1
XM_119__266__tn9 vss rst_n n_119__266__net12 vss nfet_05v0 w=3.6e-07 l=6e-07 nf=1 m=1
XM_119__266__tn18 vss n_119__266__net1 n_119__266__net2 vss nfet_05v0 w=3.6e-07 l=6e-07 nf=1 m=1
XM_119__266__tn0 n_119__266__net8 n_119__266__cki n_119__266__net2 vss nfet_05v0 w=3.6e-07 l=6e-07 nf=1 m=1
XM_119__266__tn1 n_119__266__net11 n_119__266__ncki n_119__266__net8 vss nfet_05v0 w=3.6e-07 l=6e-07 nf=1 m=1
XM_119__266__tn12 n_119__266__net11 n_119__266__net4 vss vss nfet_05v0 w=3.6e-07 l=6e-07 nf=1 m=1
XM_119__266__tn5 n_119__266__net0 rst_n vss vss nfet_05v0 w=3.6e-07 l=6e-07 nf=1 m=1
XM_119__266__tn4 n_119__266__net4 n_119__266__net8 n_119__266__net0 vss nfet_05v0 w=4e-07 l=6e-07 nf=1 m=1
XM_119__266__tn3 dsm_acc1_1 n_119__266__net4 vss vss nfet_05v0 w=8.15e-07 l=6e-07 nf=1 m=1
XM_119__266__tp8 n_119__266__ncki clknet_1_0__leaf_clk_ref vdd vdd pfet_05v0 w=8.65e-07 l=5e-07 nf=1 m=1
XM_119__266__tp11 n_119__266__cki n_119__266__ncki vdd vdd pfet_05v0 w=8.65e-07 l=5e-07 nf=1 m=1
XM_119__266__tp9 vdd _145__1 n_119__266__net10 vdd pfet_05v0 w=7.8e-07 l=5e-07 nf=1 m=1
XM_119__266__tp15 n_119__266__net1 n_119__266__cki n_119__266__net10 vdd pfet_05v0 w=7.8e-07 l=5e-07 nf=1 m=1
XM_119__266__tp7 n_119__266__net9 n_119__266__ncki n_119__266__net1 vdd pfet_05v0 w=7.8e-07 l=5e-07 nf=1 m=1
XM_119__266__tp6 vdd n_119__266__net2 n_119__266__net9 vdd pfet_05v0 w=7.8e-07 l=5e-07 nf=1 m=1
XM_119__266__tp12 n_119__266__net9 rst_n vdd vdd pfet_05v0 w=7.8e-07 l=5e-07 nf=1 m=1
XM_119__266__tp18 vdd n_119__266__net1 n_119__266__net2 vdd pfet_05v0 w=5.05e-07 l=5e-07 nf=1 m=1
XM_119__266__tp2 n_119__266__net2 n_119__266__ncki n_119__266__net8 vdd pfet_05v0 w=5.05e-07 l=5e-07 nf=1 m=1
XM_119__266__tp3 n_119__266__net8 n_119__266__cki n_119__266__net11 vdd pfet_05v0 w=5.05e-07 l=5e-07 nf=1 m=1
XM_119__266__tp10 n_119__266__net11 n_119__266__net4 vdd vdd pfet_05v0 w=5.05e-07 l=5e-07 nf=1 m=1
XM_119__266__tp5 n_119__266__net4 rst_n vdd vdd pfet_05v0 w=1e-06 l=5e-07 nf=1 m=1
XM_119__266__tp4 vdd n_119__266__net8 n_119__266__net4 vdd pfet_05v0 w=1e-06 l=5e-07 nf=1 m=1
XM_119__266__tp1 dsm_acc1_1 n_119__266__net4 vdd vdd pfet_05v0 w=1.215e-06 l=5e-07 nf=1 m=1
XM_120__267__tn10 n_120__267__ncki clknet_1_0__leaf_clk_ref vss vss nfet_05v0 w=4.05e-07 l=6e-07 nf=1 m=1
XM_120__267__tn13 n_120__267__cki n_120__267__ncki vss vss nfet_05v0 w=4.05e-07 l=6e-07 nf=1 m=1
XM_120__267__tn11 n_120__267__net10 _145__2 vss vss nfet_05v0 w=3.6e-07 l=6e-07 nf=1 m=1
XM_120__267__tn15 n_120__267__net10 n_120__267__ncki n_120__267__net1 vss nfet_05v0 w=3.6e-07 l=6e-07 nf=1 m=1
XM_120__267__tn14 n_120__267__net1 n_120__267__cki n_120__267__net15 vss nfet_05v0 w=3.6e-07 l=6e-07 nf=1 m=1
XM_120__267__tn8 n_120__267__net12 n_120__267__net2 n_120__267__net15 vss nfet_05v0 w=3.6e-07 l=6e-07 nf=1 m=1
XM_120__267__tn9 vss rst_n n_120__267__net12 vss nfet_05v0 w=3.6e-07 l=6e-07 nf=1 m=1
XM_120__267__tn18 vss n_120__267__net1 n_120__267__net2 vss nfet_05v0 w=3.6e-07 l=6e-07 nf=1 m=1
XM_120__267__tn0 n_120__267__net8 n_120__267__cki n_120__267__net2 vss nfet_05v0 w=3.6e-07 l=6e-07 nf=1 m=1
XM_120__267__tn1 n_120__267__net11 n_120__267__ncki n_120__267__net8 vss nfet_05v0 w=3.6e-07 l=6e-07 nf=1 m=1
XM_120__267__tn12 n_120__267__net11 n_120__267__net4 vss vss nfet_05v0 w=3.6e-07 l=6e-07 nf=1 m=1
XM_120__267__tn5 n_120__267__net0 rst_n vss vss nfet_05v0 w=3.6e-07 l=6e-07 nf=1 m=1
XM_120__267__tn4 n_120__267__net4 n_120__267__net8 n_120__267__net0 vss nfet_05v0 w=4e-07 l=6e-07 nf=1 m=1
XM_120__267__tn3 dsm_acc1_2 n_120__267__net4 vss vss nfet_05v0 w=8.15e-07 l=6e-07 nf=1 m=1
XM_120__267__tp8 n_120__267__ncki clknet_1_0__leaf_clk_ref vdd vdd pfet_05v0 w=8.65e-07 l=5e-07 nf=1 m=1
XM_120__267__tp11 n_120__267__cki n_120__267__ncki vdd vdd pfet_05v0 w=8.65e-07 l=5e-07 nf=1 m=1
XM_120__267__tp9 vdd _145__2 n_120__267__net10 vdd pfet_05v0 w=7.8e-07 l=5e-07 nf=1 m=1
XM_120__267__tp15 n_120__267__net1 n_120__267__cki n_120__267__net10 vdd pfet_05v0 w=7.8e-07 l=5e-07 nf=1 m=1
XM_120__267__tp7 n_120__267__net9 n_120__267__ncki n_120__267__net1 vdd pfet_05v0 w=7.8e-07 l=5e-07 nf=1 m=1
XM_120__267__tp6 vdd n_120__267__net2 n_120__267__net9 vdd pfet_05v0 w=7.8e-07 l=5e-07 nf=1 m=1
XM_120__267__tp12 n_120__267__net9 rst_n vdd vdd pfet_05v0 w=7.8e-07 l=5e-07 nf=1 m=1
XM_120__267__tp18 vdd n_120__267__net1 n_120__267__net2 vdd pfet_05v0 w=5.05e-07 l=5e-07 nf=1 m=1
XM_120__267__tp2 n_120__267__net2 n_120__267__ncki n_120__267__net8 vdd pfet_05v0 w=5.05e-07 l=5e-07 nf=1 m=1
XM_120__267__tp3 n_120__267__net8 n_120__267__cki n_120__267__net11 vdd pfet_05v0 w=5.05e-07 l=5e-07 nf=1 m=1
XM_120__267__tp10 n_120__267__net11 n_120__267__net4 vdd vdd pfet_05v0 w=5.05e-07 l=5e-07 nf=1 m=1
XM_120__267__tp5 n_120__267__net4 rst_n vdd vdd pfet_05v0 w=1e-06 l=5e-07 nf=1 m=1
XM_120__267__tp4 vdd n_120__267__net8 n_120__267__net4 vdd pfet_05v0 w=1e-06 l=5e-07 nf=1 m=1
XM_120__267__tp1 dsm_acc1_2 n_120__267__net4 vdd vdd pfet_05v0 w=1.215e-06 l=5e-07 nf=1 m=1
XM_121__268__tn10 n_121__268__ncki clknet_1_1__leaf_clk_ref vss vss nfet_05v0 w=4.05e-07 l=6e-07 nf=1 m=1
XM_121__268__tn13 n_121__268__cki n_121__268__ncki vss vss nfet_05v0 w=4.05e-07 l=6e-07 nf=1 m=1
XM_121__268__tn11 n_121__268__net10 _145__3 vss vss nfet_05v0 w=3.6e-07 l=6e-07 nf=1 m=1
XM_121__268__tn15 n_121__268__net10 n_121__268__ncki n_121__268__net1 vss nfet_05v0 w=3.6e-07 l=6e-07 nf=1 m=1
XM_121__268__tn14 n_121__268__net1 n_121__268__cki n_121__268__net15 vss nfet_05v0 w=3.6e-07 l=6e-07 nf=1 m=1
XM_121__268__tn8 n_121__268__net12 n_121__268__net2 n_121__268__net15 vss nfet_05v0 w=3.6e-07 l=6e-07 nf=1 m=1
XM_121__268__tn9 vss rst_n n_121__268__net12 vss nfet_05v0 w=3.6e-07 l=6e-07 nf=1 m=1
XM_121__268__tn18 vss n_121__268__net1 n_121__268__net2 vss nfet_05v0 w=3.6e-07 l=6e-07 nf=1 m=1
XM_121__268__tn0 n_121__268__net8 n_121__268__cki n_121__268__net2 vss nfet_05v0 w=3.6e-07 l=6e-07 nf=1 m=1
XM_121__268__tn1 n_121__268__net11 n_121__268__ncki n_121__268__net8 vss nfet_05v0 w=3.6e-07 l=6e-07 nf=1 m=1
XM_121__268__tn12 n_121__268__net11 n_121__268__net4 vss vss nfet_05v0 w=3.6e-07 l=6e-07 nf=1 m=1
XM_121__268__tn5 n_121__268__net0 rst_n vss vss nfet_05v0 w=3.6e-07 l=6e-07 nf=1 m=1
XM_121__268__tn4 n_121__268__net4 n_121__268__net8 n_121__268__net0 vss nfet_05v0 w=4e-07 l=6e-07 nf=1 m=1
XM_121__268__tn3 dsm_acc1_3 n_121__268__net4 vss vss nfet_05v0 w=8.15e-07 l=6e-07 nf=1 m=1
XM_121__268__tp8 n_121__268__ncki clknet_1_1__leaf_clk_ref vdd vdd pfet_05v0 w=8.65e-07 l=5e-07 nf=1 m=1
XM_121__268__tp11 n_121__268__cki n_121__268__ncki vdd vdd pfet_05v0 w=8.65e-07 l=5e-07 nf=1 m=1
XM_121__268__tp9 vdd _145__3 n_121__268__net10 vdd pfet_05v0 w=7.8e-07 l=5e-07 nf=1 m=1
XM_121__268__tp15 n_121__268__net1 n_121__268__cki n_121__268__net10 vdd pfet_05v0 w=7.8e-07 l=5e-07 nf=1 m=1
XM_121__268__tp7 n_121__268__net9 n_121__268__ncki n_121__268__net1 vdd pfet_05v0 w=7.8e-07 l=5e-07 nf=1 m=1
XM_121__268__tp6 vdd n_121__268__net2 n_121__268__net9 vdd pfet_05v0 w=7.8e-07 l=5e-07 nf=1 m=1
XM_121__268__tp12 n_121__268__net9 rst_n vdd vdd pfet_05v0 w=7.8e-07 l=5e-07 nf=1 m=1
XM_121__268__tp18 vdd n_121__268__net1 n_121__268__net2 vdd pfet_05v0 w=5.05e-07 l=5e-07 nf=1 m=1
XM_121__268__tp2 n_121__268__net2 n_121__268__ncki n_121__268__net8 vdd pfet_05v0 w=5.05e-07 l=5e-07 nf=1 m=1
XM_121__268__tp3 n_121__268__net8 n_121__268__cki n_121__268__net11 vdd pfet_05v0 w=5.05e-07 l=5e-07 nf=1 m=1
XM_121__268__tp10 n_121__268__net11 n_121__268__net4 vdd vdd pfet_05v0 w=5.05e-07 l=5e-07 nf=1 m=1
XM_121__268__tp5 n_121__268__net4 rst_n vdd vdd pfet_05v0 w=1e-06 l=5e-07 nf=1 m=1
XM_121__268__tp4 vdd n_121__268__net8 n_121__268__net4 vdd pfet_05v0 w=1e-06 l=5e-07 nf=1 m=1
XM_121__268__tp1 dsm_acc1_3 n_121__268__net4 vdd vdd pfet_05v0 w=1.215e-06 l=5e-07 nf=1 m=1
XM_122__269__tn10 n_122__269__ncki clknet_1_1__leaf_clk_ref vss vss nfet_05v0 w=4.05e-07 l=6e-07 nf=1 m=1
XM_122__269__tn13 n_122__269__cki n_122__269__ncki vss vss nfet_05v0 w=4.05e-07 l=6e-07 nf=1 m=1
XM_122__269__tn11 n_122__269__net10 _145__4 vss vss nfet_05v0 w=3.6e-07 l=6e-07 nf=1 m=1
XM_122__269__tn15 n_122__269__net10 n_122__269__ncki n_122__269__net1 vss nfet_05v0 w=3.6e-07 l=6e-07 nf=1 m=1
XM_122__269__tn14 n_122__269__net1 n_122__269__cki n_122__269__net15 vss nfet_05v0 w=3.6e-07 l=6e-07 nf=1 m=1
XM_122__269__tn8 n_122__269__net12 n_122__269__net2 n_122__269__net15 vss nfet_05v0 w=3.6e-07 l=6e-07 nf=1 m=1
XM_122__269__tn9 vss rst_n n_122__269__net12 vss nfet_05v0 w=3.6e-07 l=6e-07 nf=1 m=1
XM_122__269__tn18 vss n_122__269__net1 n_122__269__net2 vss nfet_05v0 w=3.6e-07 l=6e-07 nf=1 m=1
XM_122__269__tn0 n_122__269__net8 n_122__269__cki n_122__269__net2 vss nfet_05v0 w=3.6e-07 l=6e-07 nf=1 m=1
XM_122__269__tn1 n_122__269__net11 n_122__269__ncki n_122__269__net8 vss nfet_05v0 w=3.6e-07 l=6e-07 nf=1 m=1
XM_122__269__tn12 n_122__269__net11 n_122__269__net4 vss vss nfet_05v0 w=3.6e-07 l=6e-07 nf=1 m=1
XM_122__269__tn5 n_122__269__net0 rst_n vss vss nfet_05v0 w=3.6e-07 l=6e-07 nf=1 m=1
XM_122__269__tn4 n_122__269__net4 n_122__269__net8 n_122__269__net0 vss nfet_05v0 w=4e-07 l=6e-07 nf=1 m=1
XM_122__269__tn3 dsm_acc1_4 n_122__269__net4 vss vss nfet_05v0 w=8.15e-07 l=6e-07 nf=1 m=1
XM_122__269__tp8 n_122__269__ncki clknet_1_1__leaf_clk_ref vdd vdd pfet_05v0 w=8.65e-07 l=5e-07 nf=1 m=1
XM_122__269__tp11 n_122__269__cki n_122__269__ncki vdd vdd pfet_05v0 w=8.65e-07 l=5e-07 nf=1 m=1
XM_122__269__tp9 vdd _145__4 n_122__269__net10 vdd pfet_05v0 w=7.8e-07 l=5e-07 nf=1 m=1
XM_122__269__tp15 n_122__269__net1 n_122__269__cki n_122__269__net10 vdd pfet_05v0 w=7.8e-07 l=5e-07 nf=1 m=1
XM_122__269__tp7 n_122__269__net9 n_122__269__ncki n_122__269__net1 vdd pfet_05v0 w=7.8e-07 l=5e-07 nf=1 m=1
XM_122__269__tp6 vdd n_122__269__net2 n_122__269__net9 vdd pfet_05v0 w=7.8e-07 l=5e-07 nf=1 m=1
XM_122__269__tp12 n_122__269__net9 rst_n vdd vdd pfet_05v0 w=7.8e-07 l=5e-07 nf=1 m=1
XM_122__269__tp18 vdd n_122__269__net1 n_122__269__net2 vdd pfet_05v0 w=5.05e-07 l=5e-07 nf=1 m=1
XM_122__269__tp2 n_122__269__net2 n_122__269__ncki n_122__269__net8 vdd pfet_05v0 w=5.05e-07 l=5e-07 nf=1 m=1
XM_122__269__tp3 n_122__269__net8 n_122__269__cki n_122__269__net11 vdd pfet_05v0 w=5.05e-07 l=5e-07 nf=1 m=1
XM_122__269__tp10 n_122__269__net11 n_122__269__net4 vdd vdd pfet_05v0 w=5.05e-07 l=5e-07 nf=1 m=1
XM_122__269__tp5 n_122__269__net4 rst_n vdd vdd pfet_05v0 w=1e-06 l=5e-07 nf=1 m=1
XM_122__269__tp4 vdd n_122__269__net8 n_122__269__net4 vdd pfet_05v0 w=1e-06 l=5e-07 nf=1 m=1
XM_122__269__tp1 dsm_acc1_4 n_122__269__net4 vdd vdd pfet_05v0 w=1.215e-06 l=5e-07 nf=1 m=1
XM_123__270__tn10 n_123__270__ncki clknet_1_1__leaf_clk_ref vss vss nfet_05v0 w=4.05e-07 l=6e-07 nf=1 m=1
XM_123__270__tn13 n_123__270__cki n_123__270__ncki vss vss nfet_05v0 w=4.05e-07 l=6e-07 nf=1 m=1
XM_123__270__tn11 n_123__270__net10 _145__5 vss vss nfet_05v0 w=3.6e-07 l=6e-07 nf=1 m=1
XM_123__270__tn15 n_123__270__net10 n_123__270__ncki n_123__270__net1 vss nfet_05v0 w=3.6e-07 l=6e-07 nf=1 m=1
XM_123__270__tn14 n_123__270__net1 n_123__270__cki n_123__270__net15 vss nfet_05v0 w=3.6e-07 l=6e-07 nf=1 m=1
XM_123__270__tn8 n_123__270__net12 n_123__270__net2 n_123__270__net15 vss nfet_05v0 w=3.6e-07 l=6e-07 nf=1 m=1
XM_123__270__tn9 vss rst_n n_123__270__net12 vss nfet_05v0 w=3.6e-07 l=6e-07 nf=1 m=1
XM_123__270__tn18 vss n_123__270__net1 n_123__270__net2 vss nfet_05v0 w=3.6e-07 l=6e-07 nf=1 m=1
XM_123__270__tn0 n_123__270__net8 n_123__270__cki n_123__270__net2 vss nfet_05v0 w=3.6e-07 l=6e-07 nf=1 m=1
XM_123__270__tn1 n_123__270__net11 n_123__270__ncki n_123__270__net8 vss nfet_05v0 w=3.6e-07 l=6e-07 nf=1 m=1
XM_123__270__tn12 n_123__270__net11 n_123__270__net4 vss vss nfet_05v0 w=3.6e-07 l=6e-07 nf=1 m=1
XM_123__270__tn5 n_123__270__net0 rst_n vss vss nfet_05v0 w=3.6e-07 l=6e-07 nf=1 m=1
XM_123__270__tn4 n_123__270__net4 n_123__270__net8 n_123__270__net0 vss nfet_05v0 w=4e-07 l=6e-07 nf=1 m=1
XM_123__270__tn3 dsm_acc1_5 n_123__270__net4 vss vss nfet_05v0 w=8.15e-07 l=6e-07 nf=1 m=1
XM_123__270__tp8 n_123__270__ncki clknet_1_1__leaf_clk_ref vdd vdd pfet_05v0 w=8.65e-07 l=5e-07 nf=1 m=1
XM_123__270__tp11 n_123__270__cki n_123__270__ncki vdd vdd pfet_05v0 w=8.65e-07 l=5e-07 nf=1 m=1
XM_123__270__tp9 vdd _145__5 n_123__270__net10 vdd pfet_05v0 w=7.8e-07 l=5e-07 nf=1 m=1
XM_123__270__tp15 n_123__270__net1 n_123__270__cki n_123__270__net10 vdd pfet_05v0 w=7.8e-07 l=5e-07 nf=1 m=1
XM_123__270__tp7 n_123__270__net9 n_123__270__ncki n_123__270__net1 vdd pfet_05v0 w=7.8e-07 l=5e-07 nf=1 m=1
XM_123__270__tp6 vdd n_123__270__net2 n_123__270__net9 vdd pfet_05v0 w=7.8e-07 l=5e-07 nf=1 m=1
XM_123__270__tp12 n_123__270__net9 rst_n vdd vdd pfet_05v0 w=7.8e-07 l=5e-07 nf=1 m=1
XM_123__270__tp18 vdd n_123__270__net1 n_123__270__net2 vdd pfet_05v0 w=5.05e-07 l=5e-07 nf=1 m=1
XM_123__270__tp2 n_123__270__net2 n_123__270__ncki n_123__270__net8 vdd pfet_05v0 w=5.05e-07 l=5e-07 nf=1 m=1
XM_123__270__tp3 n_123__270__net8 n_123__270__cki n_123__270__net11 vdd pfet_05v0 w=5.05e-07 l=5e-07 nf=1 m=1
XM_123__270__tp10 n_123__270__net11 n_123__270__net4 vdd vdd pfet_05v0 w=5.05e-07 l=5e-07 nf=1 m=1
XM_123__270__tp5 n_123__270__net4 rst_n vdd vdd pfet_05v0 w=1e-06 l=5e-07 nf=1 m=1
XM_123__270__tp4 vdd n_123__270__net8 n_123__270__net4 vdd pfet_05v0 w=1e-06 l=5e-07 nf=1 m=1
XM_123__270__tp1 dsm_acc1_5 n_123__270__net4 vdd vdd pfet_05v0 w=1.215e-06 l=5e-07 nf=1 m=1
XM_124__271__tn10 n_124__271__ncki clknet_1_1__leaf_clk_ref vss vss nfet_05v0 w=4.05e-07 l=6e-07 nf=1 m=1
XM_124__271__tn13 n_124__271__cki n_124__271__ncki vss vss nfet_05v0 w=4.05e-07 l=6e-07 nf=1 m=1
XM_124__271__tn11 n_124__271__net10 _145__6 vss vss nfet_05v0 w=3.6e-07 l=6e-07 nf=1 m=1
XM_124__271__tn15 n_124__271__net10 n_124__271__ncki n_124__271__net1 vss nfet_05v0 w=3.6e-07 l=6e-07 nf=1 m=1
XM_124__271__tn14 n_124__271__net1 n_124__271__cki n_124__271__net15 vss nfet_05v0 w=3.6e-07 l=6e-07 nf=1 m=1
XM_124__271__tn8 n_124__271__net12 n_124__271__net2 n_124__271__net15 vss nfet_05v0 w=3.6e-07 l=6e-07 nf=1 m=1
XM_124__271__tn9 vss rst_n n_124__271__net12 vss nfet_05v0 w=3.6e-07 l=6e-07 nf=1 m=1
XM_124__271__tn18 vss n_124__271__net1 n_124__271__net2 vss nfet_05v0 w=3.6e-07 l=6e-07 nf=1 m=1
XM_124__271__tn0 n_124__271__net8 n_124__271__cki n_124__271__net2 vss nfet_05v0 w=3.6e-07 l=6e-07 nf=1 m=1
XM_124__271__tn1 n_124__271__net11 n_124__271__ncki n_124__271__net8 vss nfet_05v0 w=3.6e-07 l=6e-07 nf=1 m=1
XM_124__271__tn12 n_124__271__net11 n_124__271__net4 vss vss nfet_05v0 w=3.6e-07 l=6e-07 nf=1 m=1
XM_124__271__tn5 n_124__271__net0 rst_n vss vss nfet_05v0 w=3.6e-07 l=6e-07 nf=1 m=1
XM_124__271__tn4 n_124__271__net4 n_124__271__net8 n_124__271__net0 vss nfet_05v0 w=4e-07 l=6e-07 nf=1 m=1
XM_124__271__tn3 dsm_acc1_6 n_124__271__net4 vss vss nfet_05v0 w=8.15e-07 l=6e-07 nf=1 m=1
XM_124__271__tp8 n_124__271__ncki clknet_1_1__leaf_clk_ref vdd vdd pfet_05v0 w=8.65e-07 l=5e-07 nf=1 m=1
XM_124__271__tp11 n_124__271__cki n_124__271__ncki vdd vdd pfet_05v0 w=8.65e-07 l=5e-07 nf=1 m=1
XM_124__271__tp9 vdd _145__6 n_124__271__net10 vdd pfet_05v0 w=7.8e-07 l=5e-07 nf=1 m=1
XM_124__271__tp15 n_124__271__net1 n_124__271__cki n_124__271__net10 vdd pfet_05v0 w=7.8e-07 l=5e-07 nf=1 m=1
XM_124__271__tp7 n_124__271__net9 n_124__271__ncki n_124__271__net1 vdd pfet_05v0 w=7.8e-07 l=5e-07 nf=1 m=1
XM_124__271__tp6 vdd n_124__271__net2 n_124__271__net9 vdd pfet_05v0 w=7.8e-07 l=5e-07 nf=1 m=1
XM_124__271__tp12 n_124__271__net9 rst_n vdd vdd pfet_05v0 w=7.8e-07 l=5e-07 nf=1 m=1
XM_124__271__tp18 vdd n_124__271__net1 n_124__271__net2 vdd pfet_05v0 w=5.05e-07 l=5e-07 nf=1 m=1
XM_124__271__tp2 n_124__271__net2 n_124__271__ncki n_124__271__net8 vdd pfet_05v0 w=5.05e-07 l=5e-07 nf=1 m=1
XM_124__271__tp3 n_124__271__net8 n_124__271__cki n_124__271__net11 vdd pfet_05v0 w=5.05e-07 l=5e-07 nf=1 m=1
XM_124__271__tp10 n_124__271__net11 n_124__271__net4 vdd vdd pfet_05v0 w=5.05e-07 l=5e-07 nf=1 m=1
XM_124__271__tp5 n_124__271__net4 rst_n vdd vdd pfet_05v0 w=1e-06 l=5e-07 nf=1 m=1
XM_124__271__tp4 vdd n_124__271__net8 n_124__271__net4 vdd pfet_05v0 w=1e-06 l=5e-07 nf=1 m=1
XM_124__271__tp1 dsm_acc1_6 n_124__271__net4 vdd vdd pfet_05v0 w=1.215e-06 l=5e-07 nf=1 m=1
XM_125__272__tn10 n_125__272__ncki clknet_1_1__leaf_clk_ref vss vss nfet_05v0 w=4.05e-07 l=6e-07 nf=1 m=1
XM_125__272__tn13 n_125__272__cki n_125__272__ncki vss vss nfet_05v0 w=4.05e-07 l=6e-07 nf=1 m=1
XM_125__272__tn11 n_125__272__net10 _145__7 vss vss nfet_05v0 w=3.6e-07 l=6e-07 nf=1 m=1
XM_125__272__tn15 n_125__272__net10 n_125__272__ncki n_125__272__net1 vss nfet_05v0 w=3.6e-07 l=6e-07 nf=1 m=1
XM_125__272__tn14 n_125__272__net1 n_125__272__cki n_125__272__net15 vss nfet_05v0 w=3.6e-07 l=6e-07 nf=1 m=1
XM_125__272__tn8 n_125__272__net12 n_125__272__net2 n_125__272__net15 vss nfet_05v0 w=3.6e-07 l=6e-07 nf=1 m=1
XM_125__272__tn9 vss rst_n n_125__272__net12 vss nfet_05v0 w=3.6e-07 l=6e-07 nf=1 m=1
XM_125__272__tn18 vss n_125__272__net1 n_125__272__net2 vss nfet_05v0 w=3.6e-07 l=6e-07 nf=1 m=1
XM_125__272__tn0 n_125__272__net8 n_125__272__cki n_125__272__net2 vss nfet_05v0 w=3.6e-07 l=6e-07 nf=1 m=1
XM_125__272__tn1 n_125__272__net11 n_125__272__ncki n_125__272__net8 vss nfet_05v0 w=3.6e-07 l=6e-07 nf=1 m=1
XM_125__272__tn12 n_125__272__net11 n_125__272__net4 vss vss nfet_05v0 w=3.6e-07 l=6e-07 nf=1 m=1
XM_125__272__tn5 n_125__272__net0 rst_n vss vss nfet_05v0 w=3.6e-07 l=6e-07 nf=1 m=1
XM_125__272__tn4 n_125__272__net4 n_125__272__net8 n_125__272__net0 vss nfet_05v0 w=4e-07 l=6e-07 nf=1 m=1
XM_125__272__tn3 dsm_acc1_7 n_125__272__net4 vss vss nfet_05v0 w=8.15e-07 l=6e-07 nf=1 m=1
XM_125__272__tp8 n_125__272__ncki clknet_1_1__leaf_clk_ref vdd vdd pfet_05v0 w=8.65e-07 l=5e-07 nf=1 m=1
XM_125__272__tp11 n_125__272__cki n_125__272__ncki vdd vdd pfet_05v0 w=8.65e-07 l=5e-07 nf=1 m=1
XM_125__272__tp9 vdd _145__7 n_125__272__net10 vdd pfet_05v0 w=7.8e-07 l=5e-07 nf=1 m=1
XM_125__272__tp15 n_125__272__net1 n_125__272__cki n_125__272__net10 vdd pfet_05v0 w=7.8e-07 l=5e-07 nf=1 m=1
XM_125__272__tp7 n_125__272__net9 n_125__272__ncki n_125__272__net1 vdd pfet_05v0 w=7.8e-07 l=5e-07 nf=1 m=1
XM_125__272__tp6 vdd n_125__272__net2 n_125__272__net9 vdd pfet_05v0 w=7.8e-07 l=5e-07 nf=1 m=1
XM_125__272__tp12 n_125__272__net9 rst_n vdd vdd pfet_05v0 w=7.8e-07 l=5e-07 nf=1 m=1
XM_125__272__tp18 vdd n_125__272__net1 n_125__272__net2 vdd pfet_05v0 w=5.05e-07 l=5e-07 nf=1 m=1
XM_125__272__tp2 n_125__272__net2 n_125__272__ncki n_125__272__net8 vdd pfet_05v0 w=5.05e-07 l=5e-07 nf=1 m=1
XM_125__272__tp3 n_125__272__net8 n_125__272__cki n_125__272__net11 vdd pfet_05v0 w=5.05e-07 l=5e-07 nf=1 m=1
XM_125__272__tp10 n_125__272__net11 n_125__272__net4 vdd vdd pfet_05v0 w=5.05e-07 l=5e-07 nf=1 m=1
XM_125__272__tp5 n_125__272__net4 rst_n vdd vdd pfet_05v0 w=1e-06 l=5e-07 nf=1 m=1
XM_125__272__tp4 vdd n_125__272__net8 n_125__272__net4 vdd pfet_05v0 w=1e-06 l=5e-07 nf=1 m=1
XM_125__272__tp1 dsm_acc1_7 n_125__272__net4 vdd vdd pfet_05v0 w=1.215e-06 l=5e-07 nf=1 m=1
XM_126__273__tn10 n_126__273__ncki clknet_1_1__leaf_clk_ref vss vss nfet_05v0 w=4.05e-07 l=6e-07 nf=1 m=1
XM_126__273__tn13 n_126__273__cki n_126__273__ncki vss vss nfet_05v0 w=4.05e-07 l=6e-07 nf=1 m=1
XM_126__273__tn11 n_126__273__net10 _145__8 vss vss nfet_05v0 w=3.6e-07 l=6e-07 nf=1 m=1
XM_126__273__tn15 n_126__273__net10 n_126__273__ncki n_126__273__net1 vss nfet_05v0 w=3.6e-07 l=6e-07 nf=1 m=1
XM_126__273__tn14 n_126__273__net1 n_126__273__cki n_126__273__net15 vss nfet_05v0 w=3.6e-07 l=6e-07 nf=1 m=1
XM_126__273__tn8 n_126__273__net12 n_126__273__net2 n_126__273__net15 vss nfet_05v0 w=3.6e-07 l=6e-07 nf=1 m=1
XM_126__273__tn9 vss rst_n n_126__273__net12 vss nfet_05v0 w=3.6e-07 l=6e-07 nf=1 m=1
XM_126__273__tn18 vss n_126__273__net1 n_126__273__net2 vss nfet_05v0 w=3.6e-07 l=6e-07 nf=1 m=1
XM_126__273__tn0 n_126__273__net8 n_126__273__cki n_126__273__net2 vss nfet_05v0 w=3.6e-07 l=6e-07 nf=1 m=1
XM_126__273__tn1 n_126__273__net11 n_126__273__ncki n_126__273__net8 vss nfet_05v0 w=3.6e-07 l=6e-07 nf=1 m=1
XM_126__273__tn12 n_126__273__net11 n_126__273__net4 vss vss nfet_05v0 w=3.6e-07 l=6e-07 nf=1 m=1
XM_126__273__tn5 n_126__273__net0 rst_n vss vss nfet_05v0 w=3.6e-07 l=6e-07 nf=1 m=1
XM_126__273__tn4 n_126__273__net4 n_126__273__net8 n_126__273__net0 vss nfet_05v0 w=4e-07 l=6e-07 nf=1 m=1
XM_126__273__tn3 dsm_acc1_8 n_126__273__net4 vss vss nfet_05v0 w=8.15e-07 l=6e-07 nf=1 m=1
XM_126__273__tp8 n_126__273__ncki clknet_1_1__leaf_clk_ref vdd vdd pfet_05v0 w=8.65e-07 l=5e-07 nf=1 m=1
XM_126__273__tp11 n_126__273__cki n_126__273__ncki vdd vdd pfet_05v0 w=8.65e-07 l=5e-07 nf=1 m=1
XM_126__273__tp9 vdd _145__8 n_126__273__net10 vdd pfet_05v0 w=7.8e-07 l=5e-07 nf=1 m=1
XM_126__273__tp15 n_126__273__net1 n_126__273__cki n_126__273__net10 vdd pfet_05v0 w=7.8e-07 l=5e-07 nf=1 m=1
XM_126__273__tp7 n_126__273__net9 n_126__273__ncki n_126__273__net1 vdd pfet_05v0 w=7.8e-07 l=5e-07 nf=1 m=1
XM_126__273__tp6 vdd n_126__273__net2 n_126__273__net9 vdd pfet_05v0 w=7.8e-07 l=5e-07 nf=1 m=1
XM_126__273__tp12 n_126__273__net9 rst_n vdd vdd pfet_05v0 w=7.8e-07 l=5e-07 nf=1 m=1
XM_126__273__tp18 vdd n_126__273__net1 n_126__273__net2 vdd pfet_05v0 w=5.05e-07 l=5e-07 nf=1 m=1
XM_126__273__tp2 n_126__273__net2 n_126__273__ncki n_126__273__net8 vdd pfet_05v0 w=5.05e-07 l=5e-07 nf=1 m=1
XM_126__273__tp3 n_126__273__net8 n_126__273__cki n_126__273__net11 vdd pfet_05v0 w=5.05e-07 l=5e-07 nf=1 m=1
XM_126__273__tp10 n_126__273__net11 n_126__273__net4 vdd vdd pfet_05v0 w=5.05e-07 l=5e-07 nf=1 m=1
XM_126__273__tp5 n_126__273__net4 rst_n vdd vdd pfet_05v0 w=1e-06 l=5e-07 nf=1 m=1
XM_126__273__tp4 vdd n_126__273__net8 n_126__273__net4 vdd pfet_05v0 w=1e-06 l=5e-07 nf=1 m=1
XM_126__273__tp1 dsm_acc1_8 n_126__273__net4 vdd vdd pfet_05v0 w=1.215e-06 l=5e-07 nf=1 m=1
XM_127__274__tn10 n_127__274__ncki clknet_1_0__leaf_clk_ref vss vss nfet_05v0 w=4.05e-07 l=6e-07 nf=1 m=1
XM_127__274__tn13 n_127__274__cki n_127__274__ncki vss vss nfet_05v0 w=4.05e-07 l=6e-07 nf=1 m=1
XM_127__274__tn11 n_127__274__net10 _143__8 vss vss nfet_05v0 w=3.6e-07 l=6e-07 nf=1 m=1
XM_127__274__tn15 n_127__274__net10 n_127__274__ncki n_127__274__net1 vss nfet_05v0 w=3.6e-07 l=6e-07 nf=1 m=1
XM_127__274__tn14 n_127__274__net1 n_127__274__cki n_127__274__net15 vss nfet_05v0 w=3.6e-07 l=6e-07 nf=1 m=1
XM_127__274__tn8 n_127__274__net12 n_127__274__net2 n_127__274__net15 vss nfet_05v0 w=3.6e-07 l=6e-07 nf=1 m=1
XM_127__274__tn9 vss rst_n n_127__274__net12 vss nfet_05v0 w=3.6e-07 l=6e-07 nf=1 m=1
XM_127__274__tn18 vss n_127__274__net1 n_127__274__net2 vss nfet_05v0 w=3.6e-07 l=6e-07 nf=1 m=1
XM_127__274__tn0 n_127__274__net8 n_127__274__cki n_127__274__net2 vss nfet_05v0 w=3.6e-07 l=6e-07 nf=1 m=1
XM_127__274__tn1 n_127__274__net11 n_127__274__ncki n_127__274__net8 vss nfet_05v0 w=3.6e-07 l=6e-07 nf=1 m=1
XM_127__274__tn12 n_127__274__net11 n_127__274__net4 vss vss nfet_05v0 w=3.6e-07 l=6e-07 nf=1 m=1
XM_127__274__tn5 n_127__274__net0 rst_n vss vss nfet_05v0 w=3.6e-07 l=6e-07 nf=1 m=1
XM_127__274__tn4 n_127__274__net4 n_127__274__net8 n_127__274__net0 vss nfet_05v0 w=4e-07 l=6e-07 nf=1 m=1
XM_127__274__tn3 dsm_acc1_9 n_127__274__net4 vss vss nfet_05v0 w=8.15e-07 l=6e-07 nf=1 m=1
XM_127__274__tp8 n_127__274__ncki clknet_1_0__leaf_clk_ref vdd vdd pfet_05v0 w=8.65e-07 l=5e-07 nf=1 m=1
XM_127__274__tp11 n_127__274__cki n_127__274__ncki vdd vdd pfet_05v0 w=8.65e-07 l=5e-07 nf=1 m=1
XM_127__274__tp9 vdd _143__8 n_127__274__net10 vdd pfet_05v0 w=7.8e-07 l=5e-07 nf=1 m=1
XM_127__274__tp15 n_127__274__net1 n_127__274__cki n_127__274__net10 vdd pfet_05v0 w=7.8e-07 l=5e-07 nf=1 m=1
XM_127__274__tp7 n_127__274__net9 n_127__274__ncki n_127__274__net1 vdd pfet_05v0 w=7.8e-07 l=5e-07 nf=1 m=1
XM_127__274__tp6 vdd n_127__274__net2 n_127__274__net9 vdd pfet_05v0 w=7.8e-07 l=5e-07 nf=1 m=1
XM_127__274__tp12 n_127__274__net9 rst_n vdd vdd pfet_05v0 w=7.8e-07 l=5e-07 nf=1 m=1
XM_127__274__tp18 vdd n_127__274__net1 n_127__274__net2 vdd pfet_05v0 w=5.05e-07 l=5e-07 nf=1 m=1
XM_127__274__tp2 n_127__274__net2 n_127__274__ncki n_127__274__net8 vdd pfet_05v0 w=5.05e-07 l=5e-07 nf=1 m=1
XM_127__274__tp3 n_127__274__net8 n_127__274__cki n_127__274__net11 vdd pfet_05v0 w=5.05e-07 l=5e-07 nf=1 m=1
XM_127__274__tp10 n_127__274__net11 n_127__274__net4 vdd vdd pfet_05v0 w=5.05e-07 l=5e-07 nf=1 m=1
XM_127__274__tp5 n_127__274__net4 rst_n vdd vdd pfet_05v0 w=1e-06 l=5e-07 nf=1 m=1
XM_127__274__tp4 vdd n_127__274__net8 n_127__274__net4 vdd pfet_05v0 w=1e-06 l=5e-07 nf=1 m=1
XM_127__274__tp1 dsm_acc1_9 n_127__274__net4 vdd vdd pfet_05v0 w=1.215e-06 l=5e-07 nf=1 m=1
XM_128__275__tn10 n_128__275__ncki clknet_1_0__leaf_clk_ref vss vss nfet_05v0 w=4.05e-07 l=6e-07 nf=1 m=1
XM_128__275__tn13 n_128__275__cki n_128__275__ncki vss vss nfet_05v0 w=4.05e-07 l=6e-07 nf=1 m=1
XM_128__275__tn11 n_128__275__net10 _146__0 vss vss nfet_05v0 w=3.6e-07 l=6e-07 nf=1 m=1
XM_128__275__tn15 n_128__275__net10 n_128__275__ncki n_128__275__net1 vss nfet_05v0 w=3.6e-07 l=6e-07 nf=1 m=1
XM_128__275__tn14 n_128__275__net1 n_128__275__cki n_128__275__net15 vss nfet_05v0 w=3.6e-07 l=6e-07 nf=1 m=1
XM_128__275__tn8 n_128__275__net12 n_128__275__net2 n_128__275__net15 vss nfet_05v0 w=3.6e-07 l=6e-07 nf=1 m=1
XM_128__275__tn9 vss rst_n n_128__275__net12 vss nfet_05v0 w=3.6e-07 l=6e-07 nf=1 m=1
XM_128__275__tn18 vss n_128__275__net1 n_128__275__net2 vss nfet_05v0 w=3.6e-07 l=6e-07 nf=1 m=1
XM_128__275__tn0 n_128__275__net8 n_128__275__cki n_128__275__net2 vss nfet_05v0 w=3.6e-07 l=6e-07 nf=1 m=1
XM_128__275__tn1 n_128__275__net11 n_128__275__ncki n_128__275__net8 vss nfet_05v0 w=3.6e-07 l=6e-07 nf=1 m=1
XM_128__275__tn12 n_128__275__net11 n_128__275__net4 vss vss nfet_05v0 w=3.6e-07 l=6e-07 nf=1 m=1
XM_128__275__tn5 n_128__275__net0 rst_n vss vss nfet_05v0 w=3.6e-07 l=6e-07 nf=1 m=1
XM_128__275__tn4 n_128__275__net4 n_128__275__net8 n_128__275__net0 vss nfet_05v0 w=4e-07 l=6e-07 nf=1 m=1
XM_128__275__tn3 integ_0 n_128__275__net4 vss vss nfet_05v0 w=8.15e-07 l=6e-07 nf=1 m=1
XM_128__275__tp8 n_128__275__ncki clknet_1_0__leaf_clk_ref vdd vdd pfet_05v0 w=8.65e-07 l=5e-07 nf=1 m=1
XM_128__275__tp11 n_128__275__cki n_128__275__ncki vdd vdd pfet_05v0 w=8.65e-07 l=5e-07 nf=1 m=1
XM_128__275__tp9 vdd _146__0 n_128__275__net10 vdd pfet_05v0 w=7.8e-07 l=5e-07 nf=1 m=1
XM_128__275__tp15 n_128__275__net1 n_128__275__cki n_128__275__net10 vdd pfet_05v0 w=7.8e-07 l=5e-07 nf=1 m=1
XM_128__275__tp7 n_128__275__net9 n_128__275__ncki n_128__275__net1 vdd pfet_05v0 w=7.8e-07 l=5e-07 nf=1 m=1
XM_128__275__tp6 vdd n_128__275__net2 n_128__275__net9 vdd pfet_05v0 w=7.8e-07 l=5e-07 nf=1 m=1
XM_128__275__tp12 n_128__275__net9 rst_n vdd vdd pfet_05v0 w=7.8e-07 l=5e-07 nf=1 m=1
XM_128__275__tp18 vdd n_128__275__net1 n_128__275__net2 vdd pfet_05v0 w=5.05e-07 l=5e-07 nf=1 m=1
XM_128__275__tp2 n_128__275__net2 n_128__275__ncki n_128__275__net8 vdd pfet_05v0 w=5.05e-07 l=5e-07 nf=1 m=1
XM_128__275__tp3 n_128__275__net8 n_128__275__cki n_128__275__net11 vdd pfet_05v0 w=5.05e-07 l=5e-07 nf=1 m=1
XM_128__275__tp10 n_128__275__net11 n_128__275__net4 vdd vdd pfet_05v0 w=5.05e-07 l=5e-07 nf=1 m=1
XM_128__275__tp5 n_128__275__net4 rst_n vdd vdd pfet_05v0 w=1e-06 l=5e-07 nf=1 m=1
XM_128__275__tp4 vdd n_128__275__net8 n_128__275__net4 vdd pfet_05v0 w=1e-06 l=5e-07 nf=1 m=1
XM_128__275__tp1 integ_0 n_128__275__net4 vdd vdd pfet_05v0 w=1.215e-06 l=5e-07 nf=1 m=1
XM_129__276__tn10 n_129__276__ncki clknet_1_0__leaf_clk_ref vss vss nfet_05v0 w=4.05e-07 l=6e-07 nf=1 m=1
XM_129__276__tn13 n_129__276__cki n_129__276__ncki vss vss nfet_05v0 w=4.05e-07 l=6e-07 nf=1 m=1
XM_129__276__tn11 n_129__276__net10 _147__1 vss vss nfet_05v0 w=3.6e-07 l=6e-07 nf=1 m=1
XM_129__276__tn15 n_129__276__net10 n_129__276__ncki n_129__276__net1 vss nfet_05v0 w=3.6e-07 l=6e-07 nf=1 m=1
XM_129__276__tn14 n_129__276__net1 n_129__276__cki n_129__276__net15 vss nfet_05v0 w=3.6e-07 l=6e-07 nf=1 m=1
XM_129__276__tn8 n_129__276__net12 n_129__276__net2 n_129__276__net15 vss nfet_05v0 w=3.6e-07 l=6e-07 nf=1 m=1
XM_129__276__tn9 vss rst_n n_129__276__net12 vss nfet_05v0 w=3.6e-07 l=6e-07 nf=1 m=1
XM_129__276__tn18 vss n_129__276__net1 n_129__276__net2 vss nfet_05v0 w=3.6e-07 l=6e-07 nf=1 m=1
XM_129__276__tn0 n_129__276__net8 n_129__276__cki n_129__276__net2 vss nfet_05v0 w=3.6e-07 l=6e-07 nf=1 m=1
XM_129__276__tn1 n_129__276__net11 n_129__276__ncki n_129__276__net8 vss nfet_05v0 w=3.6e-07 l=6e-07 nf=1 m=1
XM_129__276__tn12 n_129__276__net11 n_129__276__net4 vss vss nfet_05v0 w=3.6e-07 l=6e-07 nf=1 m=1
XM_129__276__tn5 n_129__276__net0 rst_n vss vss nfet_05v0 w=3.6e-07 l=6e-07 nf=1 m=1
XM_129__276__tn4 n_129__276__net4 n_129__276__net8 n_129__276__net0 vss nfet_05v0 w=4e-07 l=6e-07 nf=1 m=1
XM_129__276__tn3 integ_1 n_129__276__net4 vss vss nfet_05v0 w=8.15e-07 l=6e-07 nf=1 m=1
XM_129__276__tp8 n_129__276__ncki clknet_1_0__leaf_clk_ref vdd vdd pfet_05v0 w=8.65e-07 l=5e-07 nf=1 m=1
XM_129__276__tp11 n_129__276__cki n_129__276__ncki vdd vdd pfet_05v0 w=8.65e-07 l=5e-07 nf=1 m=1
XM_129__276__tp9 vdd _147__1 n_129__276__net10 vdd pfet_05v0 w=7.8e-07 l=5e-07 nf=1 m=1
XM_129__276__tp15 n_129__276__net1 n_129__276__cki n_129__276__net10 vdd pfet_05v0 w=7.8e-07 l=5e-07 nf=1 m=1
XM_129__276__tp7 n_129__276__net9 n_129__276__ncki n_129__276__net1 vdd pfet_05v0 w=7.8e-07 l=5e-07 nf=1 m=1
XM_129__276__tp6 vdd n_129__276__net2 n_129__276__net9 vdd pfet_05v0 w=7.8e-07 l=5e-07 nf=1 m=1
XM_129__276__tp12 n_129__276__net9 rst_n vdd vdd pfet_05v0 w=7.8e-07 l=5e-07 nf=1 m=1
XM_129__276__tp18 vdd n_129__276__net1 n_129__276__net2 vdd pfet_05v0 w=5.05e-07 l=5e-07 nf=1 m=1
XM_129__276__tp2 n_129__276__net2 n_129__276__ncki n_129__276__net8 vdd pfet_05v0 w=5.05e-07 l=5e-07 nf=1 m=1
XM_129__276__tp3 n_129__276__net8 n_129__276__cki n_129__276__net11 vdd pfet_05v0 w=5.05e-07 l=5e-07 nf=1 m=1
XM_129__276__tp10 n_129__276__net11 n_129__276__net4 vdd vdd pfet_05v0 w=5.05e-07 l=5e-07 nf=1 m=1
XM_129__276__tp5 n_129__276__net4 rst_n vdd vdd pfet_05v0 w=1e-06 l=5e-07 nf=1 m=1
XM_129__276__tp4 vdd n_129__276__net8 n_129__276__net4 vdd pfet_05v0 w=1e-06 l=5e-07 nf=1 m=1
XM_129__276__tp1 integ_1 n_129__276__net4 vdd vdd pfet_05v0 w=1.215e-06 l=5e-07 nf=1 m=1
XM_130__277__tn10 n_130__277__ncki clknet_1_0__leaf_clk_ref vss vss nfet_05v0 w=4.05e-07 l=6e-07 nf=1 m=1
XM_130__277__tn13 n_130__277__cki n_130__277__ncki vss vss nfet_05v0 w=4.05e-07 l=6e-07 nf=1 m=1
XM_130__277__tn11 n_130__277__net10 _147__2 vss vss nfet_05v0 w=3.6e-07 l=6e-07 nf=1 m=1
XM_130__277__tn15 n_130__277__net10 n_130__277__ncki n_130__277__net1 vss nfet_05v0 w=3.6e-07 l=6e-07 nf=1 m=1
XM_130__277__tn14 n_130__277__net1 n_130__277__cki n_130__277__net15 vss nfet_05v0 w=3.6e-07 l=6e-07 nf=1 m=1
XM_130__277__tn8 n_130__277__net12 n_130__277__net2 n_130__277__net15 vss nfet_05v0 w=3.6e-07 l=6e-07 nf=1 m=1
XM_130__277__tn9 vss rst_n n_130__277__net12 vss nfet_05v0 w=3.6e-07 l=6e-07 nf=1 m=1
XM_130__277__tn18 vss n_130__277__net1 n_130__277__net2 vss nfet_05v0 w=3.6e-07 l=6e-07 nf=1 m=1
XM_130__277__tn0 n_130__277__net8 n_130__277__cki n_130__277__net2 vss nfet_05v0 w=3.6e-07 l=6e-07 nf=1 m=1
XM_130__277__tn1 n_130__277__net11 n_130__277__ncki n_130__277__net8 vss nfet_05v0 w=3.6e-07 l=6e-07 nf=1 m=1
XM_130__277__tn12 n_130__277__net11 n_130__277__net4 vss vss nfet_05v0 w=3.6e-07 l=6e-07 nf=1 m=1
XM_130__277__tn5 n_130__277__net0 rst_n vss vss nfet_05v0 w=3.6e-07 l=6e-07 nf=1 m=1
XM_130__277__tn4 n_130__277__net4 n_130__277__net8 n_130__277__net0 vss nfet_05v0 w=4e-07 l=6e-07 nf=1 m=1
XM_130__277__tn3 integ_2 n_130__277__net4 vss vss nfet_05v0 w=8.15e-07 l=6e-07 nf=1 m=1
XM_130__277__tp8 n_130__277__ncki clknet_1_0__leaf_clk_ref vdd vdd pfet_05v0 w=8.65e-07 l=5e-07 nf=1 m=1
XM_130__277__tp11 n_130__277__cki n_130__277__ncki vdd vdd pfet_05v0 w=8.65e-07 l=5e-07 nf=1 m=1
XM_130__277__tp9 vdd _147__2 n_130__277__net10 vdd pfet_05v0 w=7.8e-07 l=5e-07 nf=1 m=1
XM_130__277__tp15 n_130__277__net1 n_130__277__cki n_130__277__net10 vdd pfet_05v0 w=7.8e-07 l=5e-07 nf=1 m=1
XM_130__277__tp7 n_130__277__net9 n_130__277__ncki n_130__277__net1 vdd pfet_05v0 w=7.8e-07 l=5e-07 nf=1 m=1
XM_130__277__tp6 vdd n_130__277__net2 n_130__277__net9 vdd pfet_05v0 w=7.8e-07 l=5e-07 nf=1 m=1
XM_130__277__tp12 n_130__277__net9 rst_n vdd vdd pfet_05v0 w=7.8e-07 l=5e-07 nf=1 m=1
XM_130__277__tp18 vdd n_130__277__net1 n_130__277__net2 vdd pfet_05v0 w=5.05e-07 l=5e-07 nf=1 m=1
XM_130__277__tp2 n_130__277__net2 n_130__277__ncki n_130__277__net8 vdd pfet_05v0 w=5.05e-07 l=5e-07 nf=1 m=1
XM_130__277__tp3 n_130__277__net8 n_130__277__cki n_130__277__net11 vdd pfet_05v0 w=5.05e-07 l=5e-07 nf=1 m=1
XM_130__277__tp10 n_130__277__net11 n_130__277__net4 vdd vdd pfet_05v0 w=5.05e-07 l=5e-07 nf=1 m=1
XM_130__277__tp5 n_130__277__net4 rst_n vdd vdd pfet_05v0 w=1e-06 l=5e-07 nf=1 m=1
XM_130__277__tp4 vdd n_130__277__net8 n_130__277__net4 vdd pfet_05v0 w=1e-06 l=5e-07 nf=1 m=1
XM_130__277__tp1 integ_2 n_130__277__net4 vdd vdd pfet_05v0 w=1.215e-06 l=5e-07 nf=1 m=1
XM_131__278__tn10 n_131__278__ncki clknet_1_0__leaf_clk_ref vss vss nfet_05v0 w=4.05e-07 l=6e-07 nf=1 m=1
XM_131__278__tn13 n_131__278__cki n_131__278__ncki vss vss nfet_05v0 w=4.05e-07 l=6e-07 nf=1 m=1
XM_131__278__tn11 n_131__278__net10 _147__3 vss vss nfet_05v0 w=3.6e-07 l=6e-07 nf=1 m=1
XM_131__278__tn15 n_131__278__net10 n_131__278__ncki n_131__278__net1 vss nfet_05v0 w=3.6e-07 l=6e-07 nf=1 m=1
XM_131__278__tn14 n_131__278__net1 n_131__278__cki n_131__278__net15 vss nfet_05v0 w=3.6e-07 l=6e-07 nf=1 m=1
XM_131__278__tn8 n_131__278__net12 n_131__278__net2 n_131__278__net15 vss nfet_05v0 w=3.6e-07 l=6e-07 nf=1 m=1
XM_131__278__tn9 vss rst_n n_131__278__net12 vss nfet_05v0 w=3.6e-07 l=6e-07 nf=1 m=1
XM_131__278__tn18 vss n_131__278__net1 n_131__278__net2 vss nfet_05v0 w=3.6e-07 l=6e-07 nf=1 m=1
XM_131__278__tn0 n_131__278__net8 n_131__278__cki n_131__278__net2 vss nfet_05v0 w=3.6e-07 l=6e-07 nf=1 m=1
XM_131__278__tn1 n_131__278__net11 n_131__278__ncki n_131__278__net8 vss nfet_05v0 w=3.6e-07 l=6e-07 nf=1 m=1
XM_131__278__tn12 n_131__278__net11 n_131__278__net4 vss vss nfet_05v0 w=3.6e-07 l=6e-07 nf=1 m=1
XM_131__278__tn5 n_131__278__net0 rst_n vss vss nfet_05v0 w=3.6e-07 l=6e-07 nf=1 m=1
XM_131__278__tn4 n_131__278__net4 n_131__278__net8 n_131__278__net0 vss nfet_05v0 w=4e-07 l=6e-07 nf=1 m=1
XM_131__278__tn3 integ_3 n_131__278__net4 vss vss nfet_05v0 w=8.15e-07 l=6e-07 nf=1 m=1
XM_131__278__tp8 n_131__278__ncki clknet_1_0__leaf_clk_ref vdd vdd pfet_05v0 w=8.65e-07 l=5e-07 nf=1 m=1
XM_131__278__tp11 n_131__278__cki n_131__278__ncki vdd vdd pfet_05v0 w=8.65e-07 l=5e-07 nf=1 m=1
XM_131__278__tp9 vdd _147__3 n_131__278__net10 vdd pfet_05v0 w=7.8e-07 l=5e-07 nf=1 m=1
XM_131__278__tp15 n_131__278__net1 n_131__278__cki n_131__278__net10 vdd pfet_05v0 w=7.8e-07 l=5e-07 nf=1 m=1
XM_131__278__tp7 n_131__278__net9 n_131__278__ncki n_131__278__net1 vdd pfet_05v0 w=7.8e-07 l=5e-07 nf=1 m=1
XM_131__278__tp6 vdd n_131__278__net2 n_131__278__net9 vdd pfet_05v0 w=7.8e-07 l=5e-07 nf=1 m=1
XM_131__278__tp12 n_131__278__net9 rst_n vdd vdd pfet_05v0 w=7.8e-07 l=5e-07 nf=1 m=1
XM_131__278__tp18 vdd n_131__278__net1 n_131__278__net2 vdd pfet_05v0 w=5.05e-07 l=5e-07 nf=1 m=1
XM_131__278__tp2 n_131__278__net2 n_131__278__ncki n_131__278__net8 vdd pfet_05v0 w=5.05e-07 l=5e-07 nf=1 m=1
XM_131__278__tp3 n_131__278__net8 n_131__278__cki n_131__278__net11 vdd pfet_05v0 w=5.05e-07 l=5e-07 nf=1 m=1
XM_131__278__tp10 n_131__278__net11 n_131__278__net4 vdd vdd pfet_05v0 w=5.05e-07 l=5e-07 nf=1 m=1
XM_131__278__tp5 n_131__278__net4 rst_n vdd vdd pfet_05v0 w=1e-06 l=5e-07 nf=1 m=1
XM_131__278__tp4 vdd n_131__278__net8 n_131__278__net4 vdd pfet_05v0 w=1e-06 l=5e-07 nf=1 m=1
XM_131__278__tp1 integ_3 n_131__278__net4 vdd vdd pfet_05v0 w=1.215e-06 l=5e-07 nf=1 m=1
XM_132__279__tn10 n_132__279__ncki clknet_1_1__leaf_clk_ref vss vss nfet_05v0 w=4.05e-07 l=6e-07 nf=1 m=1
XM_132__279__tn13 n_132__279__cki n_132__279__ncki vss vss nfet_05v0 w=4.05e-07 l=6e-07 nf=1 m=1
XM_132__279__tn11 n_132__279__net10 _147__4 vss vss nfet_05v0 w=3.6e-07 l=6e-07 nf=1 m=1
XM_132__279__tn15 n_132__279__net10 n_132__279__ncki n_132__279__net1 vss nfet_05v0 w=3.6e-07 l=6e-07 nf=1 m=1
XM_132__279__tn14 n_132__279__net1 n_132__279__cki n_132__279__net15 vss nfet_05v0 w=3.6e-07 l=6e-07 nf=1 m=1
XM_132__279__tn8 n_132__279__net12 n_132__279__net2 n_132__279__net15 vss nfet_05v0 w=3.6e-07 l=6e-07 nf=1 m=1
XM_132__279__tn9 vss rst_n n_132__279__net12 vss nfet_05v0 w=3.6e-07 l=6e-07 nf=1 m=1
XM_132__279__tn18 vss n_132__279__net1 n_132__279__net2 vss nfet_05v0 w=3.6e-07 l=6e-07 nf=1 m=1
XM_132__279__tn0 n_132__279__net8 n_132__279__cki n_132__279__net2 vss nfet_05v0 w=3.6e-07 l=6e-07 nf=1 m=1
XM_132__279__tn1 n_132__279__net11 n_132__279__ncki n_132__279__net8 vss nfet_05v0 w=3.6e-07 l=6e-07 nf=1 m=1
XM_132__279__tn12 n_132__279__net11 n_132__279__net4 vss vss nfet_05v0 w=3.6e-07 l=6e-07 nf=1 m=1
XM_132__279__tn5 n_132__279__net0 rst_n vss vss nfet_05v0 w=3.6e-07 l=6e-07 nf=1 m=1
XM_132__279__tn4 n_132__279__net4 n_132__279__net8 n_132__279__net0 vss nfet_05v0 w=4e-07 l=6e-07 nf=1 m=1
XM_132__279__tn3 integ_4 n_132__279__net4 vss vss nfet_05v0 w=8.15e-07 l=6e-07 nf=1 m=1
XM_132__279__tp8 n_132__279__ncki clknet_1_1__leaf_clk_ref vdd vdd pfet_05v0 w=8.65e-07 l=5e-07 nf=1 m=1
XM_132__279__tp11 n_132__279__cki n_132__279__ncki vdd vdd pfet_05v0 w=8.65e-07 l=5e-07 nf=1 m=1
XM_132__279__tp9 vdd _147__4 n_132__279__net10 vdd pfet_05v0 w=7.8e-07 l=5e-07 nf=1 m=1
XM_132__279__tp15 n_132__279__net1 n_132__279__cki n_132__279__net10 vdd pfet_05v0 w=7.8e-07 l=5e-07 nf=1 m=1
XM_132__279__tp7 n_132__279__net9 n_132__279__ncki n_132__279__net1 vdd pfet_05v0 w=7.8e-07 l=5e-07 nf=1 m=1
XM_132__279__tp6 vdd n_132__279__net2 n_132__279__net9 vdd pfet_05v0 w=7.8e-07 l=5e-07 nf=1 m=1
XM_132__279__tp12 n_132__279__net9 rst_n vdd vdd pfet_05v0 w=7.8e-07 l=5e-07 nf=1 m=1
XM_132__279__tp18 vdd n_132__279__net1 n_132__279__net2 vdd pfet_05v0 w=5.05e-07 l=5e-07 nf=1 m=1
XM_132__279__tp2 n_132__279__net2 n_132__279__ncki n_132__279__net8 vdd pfet_05v0 w=5.05e-07 l=5e-07 nf=1 m=1
XM_132__279__tp3 n_132__279__net8 n_132__279__cki n_132__279__net11 vdd pfet_05v0 w=5.05e-07 l=5e-07 nf=1 m=1
XM_132__279__tp10 n_132__279__net11 n_132__279__net4 vdd vdd pfet_05v0 w=5.05e-07 l=5e-07 nf=1 m=1
XM_132__279__tp5 n_132__279__net4 rst_n vdd vdd pfet_05v0 w=1e-06 l=5e-07 nf=1 m=1
XM_132__279__tp4 vdd n_132__279__net8 n_132__279__net4 vdd pfet_05v0 w=1e-06 l=5e-07 nf=1 m=1
XM_132__279__tp1 integ_4 n_132__279__net4 vdd vdd pfet_05v0 w=1.215e-06 l=5e-07 nf=1 m=1
XM_133__280__tn10 n_133__280__ncki clknet_1_1__leaf_clk_ref vss vss nfet_05v0 w=4.05e-07 l=6e-07 nf=1 m=1
XM_133__280__tn13 n_133__280__cki n_133__280__ncki vss vss nfet_05v0 w=4.05e-07 l=6e-07 nf=1 m=1
XM_133__280__tn11 n_133__280__net10 _147__5 vss vss nfet_05v0 w=3.6e-07 l=6e-07 nf=1 m=1
XM_133__280__tn15 n_133__280__net10 n_133__280__ncki n_133__280__net1 vss nfet_05v0 w=3.6e-07 l=6e-07 nf=1 m=1
XM_133__280__tn14 n_133__280__net1 n_133__280__cki n_133__280__net15 vss nfet_05v0 w=3.6e-07 l=6e-07 nf=1 m=1
XM_133__280__tn8 n_133__280__net12 n_133__280__net2 n_133__280__net15 vss nfet_05v0 w=3.6e-07 l=6e-07 nf=1 m=1
XM_133__280__tn9 vss rst_n n_133__280__net12 vss nfet_05v0 w=3.6e-07 l=6e-07 nf=1 m=1
XM_133__280__tn18 vss n_133__280__net1 n_133__280__net2 vss nfet_05v0 w=3.6e-07 l=6e-07 nf=1 m=1
XM_133__280__tn0 n_133__280__net8 n_133__280__cki n_133__280__net2 vss nfet_05v0 w=3.6e-07 l=6e-07 nf=1 m=1
XM_133__280__tn1 n_133__280__net11 n_133__280__ncki n_133__280__net8 vss nfet_05v0 w=3.6e-07 l=6e-07 nf=1 m=1
XM_133__280__tn12 n_133__280__net11 n_133__280__net4 vss vss nfet_05v0 w=3.6e-07 l=6e-07 nf=1 m=1
XM_133__280__tn5 n_133__280__net0 rst_n vss vss nfet_05v0 w=3.6e-07 l=6e-07 nf=1 m=1
XM_133__280__tn4 n_133__280__net4 n_133__280__net8 n_133__280__net0 vss nfet_05v0 w=4e-07 l=6e-07 nf=1 m=1
XM_133__280__tn3 integ_5 n_133__280__net4 vss vss nfet_05v0 w=8.15e-07 l=6e-07 nf=1 m=1
XM_133__280__tp8 n_133__280__ncki clknet_1_1__leaf_clk_ref vdd vdd pfet_05v0 w=8.65e-07 l=5e-07 nf=1 m=1
XM_133__280__tp11 n_133__280__cki n_133__280__ncki vdd vdd pfet_05v0 w=8.65e-07 l=5e-07 nf=1 m=1
XM_133__280__tp9 vdd _147__5 n_133__280__net10 vdd pfet_05v0 w=7.8e-07 l=5e-07 nf=1 m=1
XM_133__280__tp15 n_133__280__net1 n_133__280__cki n_133__280__net10 vdd pfet_05v0 w=7.8e-07 l=5e-07 nf=1 m=1
XM_133__280__tp7 n_133__280__net9 n_133__280__ncki n_133__280__net1 vdd pfet_05v0 w=7.8e-07 l=5e-07 nf=1 m=1
XM_133__280__tp6 vdd n_133__280__net2 n_133__280__net9 vdd pfet_05v0 w=7.8e-07 l=5e-07 nf=1 m=1
XM_133__280__tp12 n_133__280__net9 rst_n vdd vdd pfet_05v0 w=7.8e-07 l=5e-07 nf=1 m=1
XM_133__280__tp18 vdd n_133__280__net1 n_133__280__net2 vdd pfet_05v0 w=5.05e-07 l=5e-07 nf=1 m=1
XM_133__280__tp2 n_133__280__net2 n_133__280__ncki n_133__280__net8 vdd pfet_05v0 w=5.05e-07 l=5e-07 nf=1 m=1
XM_133__280__tp3 n_133__280__net8 n_133__280__cki n_133__280__net11 vdd pfet_05v0 w=5.05e-07 l=5e-07 nf=1 m=1
XM_133__280__tp10 n_133__280__net11 n_133__280__net4 vdd vdd pfet_05v0 w=5.05e-07 l=5e-07 nf=1 m=1
XM_133__280__tp5 n_133__280__net4 rst_n vdd vdd pfet_05v0 w=1e-06 l=5e-07 nf=1 m=1
XM_133__280__tp4 vdd n_133__280__net8 n_133__280__net4 vdd pfet_05v0 w=1e-06 l=5e-07 nf=1 m=1
XM_133__280__tp1 integ_5 n_133__280__net4 vdd vdd pfet_05v0 w=1.215e-06 l=5e-07 nf=1 m=1
XM_134__281__tn10 n_134__281__ncki clknet_1_1__leaf_clk_ref vss vss nfet_05v0 w=4.05e-07 l=6e-07 nf=1 m=1
XM_134__281__tn13 n_134__281__cki n_134__281__ncki vss vss nfet_05v0 w=4.05e-07 l=6e-07 nf=1 m=1
XM_134__281__tn11 n_134__281__net10 _147__6 vss vss nfet_05v0 w=3.6e-07 l=6e-07 nf=1 m=1
XM_134__281__tn15 n_134__281__net10 n_134__281__ncki n_134__281__net1 vss nfet_05v0 w=3.6e-07 l=6e-07 nf=1 m=1
XM_134__281__tn14 n_134__281__net1 n_134__281__cki n_134__281__net15 vss nfet_05v0 w=3.6e-07 l=6e-07 nf=1 m=1
XM_134__281__tn8 n_134__281__net12 n_134__281__net2 n_134__281__net15 vss nfet_05v0 w=3.6e-07 l=6e-07 nf=1 m=1
XM_134__281__tn9 vss rst_n n_134__281__net12 vss nfet_05v0 w=3.6e-07 l=6e-07 nf=1 m=1
XM_134__281__tn18 vss n_134__281__net1 n_134__281__net2 vss nfet_05v0 w=3.6e-07 l=6e-07 nf=1 m=1
XM_134__281__tn0 n_134__281__net8 n_134__281__cki n_134__281__net2 vss nfet_05v0 w=3.6e-07 l=6e-07 nf=1 m=1
XM_134__281__tn1 n_134__281__net11 n_134__281__ncki n_134__281__net8 vss nfet_05v0 w=3.6e-07 l=6e-07 nf=1 m=1
XM_134__281__tn12 n_134__281__net11 n_134__281__net4 vss vss nfet_05v0 w=3.6e-07 l=6e-07 nf=1 m=1
XM_134__281__tn5 n_134__281__net0 rst_n vss vss nfet_05v0 w=3.6e-07 l=6e-07 nf=1 m=1
XM_134__281__tn4 n_134__281__net4 n_134__281__net8 n_134__281__net0 vss nfet_05v0 w=4e-07 l=6e-07 nf=1 m=1
XM_134__281__tn3 integ_6 n_134__281__net4 vss vss nfet_05v0 w=8.15e-07 l=6e-07 nf=1 m=1
XM_134__281__tp8 n_134__281__ncki clknet_1_1__leaf_clk_ref vdd vdd pfet_05v0 w=8.65e-07 l=5e-07 nf=1 m=1
XM_134__281__tp11 n_134__281__cki n_134__281__ncki vdd vdd pfet_05v0 w=8.65e-07 l=5e-07 nf=1 m=1
XM_134__281__tp9 vdd _147__6 n_134__281__net10 vdd pfet_05v0 w=7.8e-07 l=5e-07 nf=1 m=1
XM_134__281__tp15 n_134__281__net1 n_134__281__cki n_134__281__net10 vdd pfet_05v0 w=7.8e-07 l=5e-07 nf=1 m=1
XM_134__281__tp7 n_134__281__net9 n_134__281__ncki n_134__281__net1 vdd pfet_05v0 w=7.8e-07 l=5e-07 nf=1 m=1
XM_134__281__tp6 vdd n_134__281__net2 n_134__281__net9 vdd pfet_05v0 w=7.8e-07 l=5e-07 nf=1 m=1
XM_134__281__tp12 n_134__281__net9 rst_n vdd vdd pfet_05v0 w=7.8e-07 l=5e-07 nf=1 m=1
XM_134__281__tp18 vdd n_134__281__net1 n_134__281__net2 vdd pfet_05v0 w=5.05e-07 l=5e-07 nf=1 m=1
XM_134__281__tp2 n_134__281__net2 n_134__281__ncki n_134__281__net8 vdd pfet_05v0 w=5.05e-07 l=5e-07 nf=1 m=1
XM_134__281__tp3 n_134__281__net8 n_134__281__cki n_134__281__net11 vdd pfet_05v0 w=5.05e-07 l=5e-07 nf=1 m=1
XM_134__281__tp10 n_134__281__net11 n_134__281__net4 vdd vdd pfet_05v0 w=5.05e-07 l=5e-07 nf=1 m=1
XM_134__281__tp5 n_134__281__net4 rst_n vdd vdd pfet_05v0 w=1e-06 l=5e-07 nf=1 m=1
XM_134__281__tp4 vdd n_134__281__net8 n_134__281__net4 vdd pfet_05v0 w=1e-06 l=5e-07 nf=1 m=1
XM_134__281__tp1 integ_6 n_134__281__net4 vdd vdd pfet_05v0 w=1.215e-06 l=5e-07 nf=1 m=1
XM_135__282__tn10 n_135__282__ncki clknet_1_1__leaf_clk_ref vss vss nfet_05v0 w=4.05e-07 l=6e-07 nf=1 m=1
XM_135__282__tn13 n_135__282__cki n_135__282__ncki vss vss nfet_05v0 w=4.05e-07 l=6e-07 nf=1 m=1
XM_135__282__tn11 n_135__282__net10 _147__7 vss vss nfet_05v0 w=3.6e-07 l=6e-07 nf=1 m=1
XM_135__282__tn15 n_135__282__net10 n_135__282__ncki n_135__282__net1 vss nfet_05v0 w=3.6e-07 l=6e-07 nf=1 m=1
XM_135__282__tn14 n_135__282__net1 n_135__282__cki n_135__282__net15 vss nfet_05v0 w=3.6e-07 l=6e-07 nf=1 m=1
XM_135__282__tn8 n_135__282__net12 n_135__282__net2 n_135__282__net15 vss nfet_05v0 w=3.6e-07 l=6e-07 nf=1 m=1
XM_135__282__tn9 vss rst_n n_135__282__net12 vss nfet_05v0 w=3.6e-07 l=6e-07 nf=1 m=1
XM_135__282__tn18 vss n_135__282__net1 n_135__282__net2 vss nfet_05v0 w=3.6e-07 l=6e-07 nf=1 m=1
XM_135__282__tn0 n_135__282__net8 n_135__282__cki n_135__282__net2 vss nfet_05v0 w=3.6e-07 l=6e-07 nf=1 m=1
XM_135__282__tn1 n_135__282__net11 n_135__282__ncki n_135__282__net8 vss nfet_05v0 w=3.6e-07 l=6e-07 nf=1 m=1
XM_135__282__tn12 n_135__282__net11 n_135__282__net4 vss vss nfet_05v0 w=3.6e-07 l=6e-07 nf=1 m=1
XM_135__282__tn5 n_135__282__net0 rst_n vss vss nfet_05v0 w=3.6e-07 l=6e-07 nf=1 m=1
XM_135__282__tn4 n_135__282__net4 n_135__282__net8 n_135__282__net0 vss nfet_05v0 w=4e-07 l=6e-07 nf=1 m=1
XM_135__282__tn3 integ_7 n_135__282__net4 vss vss nfet_05v0 w=8.15e-07 l=6e-07 nf=1 m=1
XM_135__282__tp8 n_135__282__ncki clknet_1_1__leaf_clk_ref vdd vdd pfet_05v0 w=8.65e-07 l=5e-07 nf=1 m=1
XM_135__282__tp11 n_135__282__cki n_135__282__ncki vdd vdd pfet_05v0 w=8.65e-07 l=5e-07 nf=1 m=1
XM_135__282__tp9 vdd _147__7 n_135__282__net10 vdd pfet_05v0 w=7.8e-07 l=5e-07 nf=1 m=1
XM_135__282__tp15 n_135__282__net1 n_135__282__cki n_135__282__net10 vdd pfet_05v0 w=7.8e-07 l=5e-07 nf=1 m=1
XM_135__282__tp7 n_135__282__net9 n_135__282__ncki n_135__282__net1 vdd pfet_05v0 w=7.8e-07 l=5e-07 nf=1 m=1
XM_135__282__tp6 vdd n_135__282__net2 n_135__282__net9 vdd pfet_05v0 w=7.8e-07 l=5e-07 nf=1 m=1
XM_135__282__tp12 n_135__282__net9 rst_n vdd vdd pfet_05v0 w=7.8e-07 l=5e-07 nf=1 m=1
XM_135__282__tp18 vdd n_135__282__net1 n_135__282__net2 vdd pfet_05v0 w=5.05e-07 l=5e-07 nf=1 m=1
XM_135__282__tp2 n_135__282__net2 n_135__282__ncki n_135__282__net8 vdd pfet_05v0 w=5.05e-07 l=5e-07 nf=1 m=1
XM_135__282__tp3 n_135__282__net8 n_135__282__cki n_135__282__net11 vdd pfet_05v0 w=5.05e-07 l=5e-07 nf=1 m=1
XM_135__282__tp10 n_135__282__net11 n_135__282__net4 vdd vdd pfet_05v0 w=5.05e-07 l=5e-07 nf=1 m=1
XM_135__282__tp5 n_135__282__net4 rst_n vdd vdd pfet_05v0 w=1e-06 l=5e-07 nf=1 m=1
XM_135__282__tp4 vdd n_135__282__net8 n_135__282__net4 vdd pfet_05v0 w=1e-06 l=5e-07 nf=1 m=1
XM_135__282__tp1 integ_7 n_135__282__net4 vdd vdd pfet_05v0 w=1.215e-06 l=5e-07 nf=1 m=1
XM_136__283__tn10 n_136__283__ncki clknet_1_0__leaf_clk_ref vss vss nfet_05v0 w=4.05e-07 l=6e-07 nf=1 m=1
XM_136__283__tn13 n_136__283__cki n_136__283__ncki vss vss nfet_05v0 w=4.05e-07 l=6e-07 nf=1 m=1
XM_136__283__tn11 n_136__283__net10 _147__8 vss vss nfet_05v0 w=3.6e-07 l=6e-07 nf=1 m=1
XM_136__283__tn15 n_136__283__net10 n_136__283__ncki n_136__283__net1 vss nfet_05v0 w=3.6e-07 l=6e-07 nf=1 m=1
XM_136__283__tn14 n_136__283__net1 n_136__283__cki n_136__283__net15 vss nfet_05v0 w=3.6e-07 l=6e-07 nf=1 m=1
XM_136__283__tn8 n_136__283__net12 n_136__283__net2 n_136__283__net15 vss nfet_05v0 w=3.6e-07 l=6e-07 nf=1 m=1
XM_136__283__tn9 vss rst_n n_136__283__net12 vss nfet_05v0 w=3.6e-07 l=6e-07 nf=1 m=1
XM_136__283__tn18 vss n_136__283__net1 n_136__283__net2 vss nfet_05v0 w=3.6e-07 l=6e-07 nf=1 m=1
XM_136__283__tn0 n_136__283__net8 n_136__283__cki n_136__283__net2 vss nfet_05v0 w=3.6e-07 l=6e-07 nf=1 m=1
XM_136__283__tn1 n_136__283__net11 n_136__283__ncki n_136__283__net8 vss nfet_05v0 w=3.6e-07 l=6e-07 nf=1 m=1
XM_136__283__tn12 n_136__283__net11 n_136__283__net4 vss vss nfet_05v0 w=3.6e-07 l=6e-07 nf=1 m=1
XM_136__283__tn5 n_136__283__net0 rst_n vss vss nfet_05v0 w=3.6e-07 l=6e-07 nf=1 m=1
XM_136__283__tn4 n_136__283__net4 n_136__283__net8 n_136__283__net0 vss nfet_05v0 w=4e-07 l=6e-07 nf=1 m=1
XM_136__283__tn3 integ_8 n_136__283__net4 vss vss nfet_05v0 w=8.15e-07 l=6e-07 nf=1 m=1
XM_136__283__tp8 n_136__283__ncki clknet_1_0__leaf_clk_ref vdd vdd pfet_05v0 w=8.65e-07 l=5e-07 nf=1 m=1
XM_136__283__tp11 n_136__283__cki n_136__283__ncki vdd vdd pfet_05v0 w=8.65e-07 l=5e-07 nf=1 m=1
XM_136__283__tp9 vdd _147__8 n_136__283__net10 vdd pfet_05v0 w=7.8e-07 l=5e-07 nf=1 m=1
XM_136__283__tp15 n_136__283__net1 n_136__283__cki n_136__283__net10 vdd pfet_05v0 w=7.8e-07 l=5e-07 nf=1 m=1
XM_136__283__tp7 n_136__283__net9 n_136__283__ncki n_136__283__net1 vdd pfet_05v0 w=7.8e-07 l=5e-07 nf=1 m=1
XM_136__283__tp6 vdd n_136__283__net2 n_136__283__net9 vdd pfet_05v0 w=7.8e-07 l=5e-07 nf=1 m=1
XM_136__283__tp12 n_136__283__net9 rst_n vdd vdd pfet_05v0 w=7.8e-07 l=5e-07 nf=1 m=1
XM_136__283__tp18 vdd n_136__283__net1 n_136__283__net2 vdd pfet_05v0 w=5.05e-07 l=5e-07 nf=1 m=1
XM_136__283__tp2 n_136__283__net2 n_136__283__ncki n_136__283__net8 vdd pfet_05v0 w=5.05e-07 l=5e-07 nf=1 m=1
XM_136__283__tp3 n_136__283__net8 n_136__283__cki n_136__283__net11 vdd pfet_05v0 w=5.05e-07 l=5e-07 nf=1 m=1
XM_136__283__tp10 n_136__283__net11 n_136__283__net4 vdd vdd pfet_05v0 w=5.05e-07 l=5e-07 nf=1 m=1
XM_136__283__tp5 n_136__283__net4 rst_n vdd vdd pfet_05v0 w=1e-06 l=5e-07 nf=1 m=1
XM_136__283__tp4 vdd n_136__283__net8 n_136__283__net4 vdd pfet_05v0 w=1e-06 l=5e-07 nf=1 m=1
XM_136__283__tp1 integ_8 n_136__283__net4 vdd vdd pfet_05v0 w=1.215e-06 l=5e-07 nf=1 m=1
XM_137__284__tn3 n_137__284__ncki clknet_1_0__leaf_clk_ref vss vss nfet_05v0 w=4.05e-07 l=6e-07 nf=1 m=1
XM_137__284__tn0 n_137__284__cki n_137__284__ncki vss vss nfet_05v0 w=4.05e-07 l=6e-07 nf=1 m=1
XM_137__284__tn10 n_137__284__net13 _147__9 vss vss nfet_05v0 w=3.6e-07 l=6e-07 nf=1 m=1
XM_137__284__tn6 n_137__284__net13 n_137__284__ncki n_137__284__net3 vss nfet_05v0 w=3.6e-07 l=6e-07 nf=1 m=1
XM_137__284__tn4 n_137__284__net3 n_137__284__cki n_137__284__net14 vss nfet_05v0 w=3.6e-07 l=6e-07 nf=1 m=1
XM_137__284__tn5 vss n_137__284__net4 n_137__284__net14 vss nfet_05v0 w=3.6e-07 l=6e-07 nf=1 m=1
XM_137__284__tn2 n_137__284__net0 n_137__284__net3 vss vss nfet_05v0 w=3.6e-07 l=6e-07 nf=1 m=1
XM_137__284__tn1 n_137__284__net4 rst_n n_137__284__net0 vss nfet_05v0 w=3.6e-07 l=6e-07 nf=1 m=1
XM_137__284__tn13 n_137__284__net5 n_137__284__cki n_137__284__net4 vss nfet_05v0 w=3.6e-07 l=6e-07 nf=1 m=1
XM_137__284__tn12 n_137__284__net7 n_137__284__ncki n_137__284__net5 vss nfet_05v0 w=3.6e-07 l=6e-07 nf=1 m=1
XM_137__284__tn14 n_137__284__net1 rst_n n_137__284__net7 vss nfet_05v0 w=4.05e-07 l=6e-07 nf=1 m=1
XM_137__284__tn15 vss n_137__284__net6 n_137__284__net1 vss nfet_05v0 w=4.05e-07 l=6e-07 nf=1 m=1
XM_137__284__tn18 n_137__284__net6 n_137__284__net5 vss vss nfet_05v0 w=4.05e-07 l=6e-07 nf=1 m=1
XM_137__284__tn16 vss n_137__284__net6 integ_9 vss nfet_05v0 w=8.15e-07 l=6e-07 nf=1 m=1
XM_137__284__tp4 n_137__284__ncki clknet_1_0__leaf_clk_ref vdd vdd pfet_05v0 w=8.65e-07 l=5e-07 nf=1 m=1
XM_137__284__tp0 n_137__284__cki n_137__284__ncki vdd vdd pfet_05v0 w=8.65e-07 l=5e-07 nf=1 m=1
XM_137__284__tp8 vdd _147__9 n_137__284__net13 vdd pfet_05v0 w=5.05e-07 l=5e-07 nf=1 m=1
XM_137__284__tp9 n_137__284__net3 n_137__284__cki n_137__284__net13 vdd pfet_05v0 w=5.05e-07 l=5e-07 nf=1 m=1
XM_137__284__tp6 n_137__284__net10 n_137__284__ncki n_137__284__net3 vdd pfet_05v0 w=5.05e-07 l=5e-07 nf=1 m=1
XM_137__284__tp5 vdd n_137__284__net4 n_137__284__net10 vdd pfet_05v0 w=5.05e-07 l=5e-07 nf=1 m=1
XM_137__284__tp3 n_137__284__net4 n_137__284__net3 vdd vdd pfet_05v0 w=5.85e-07 l=5e-07 nf=1 m=1
XM_137__284__tp2 vdd rst_n n_137__284__net4 vdd pfet_05v0 w=5.85e-07 l=5e-07 nf=1 m=1
XM_137__284__tp18 n_137__284__net5 n_137__284__ncki n_137__284__net4 vdd pfet_05v0 w=4.15e-07 l=5e-07 nf=1 m=1
XM_137__284__tp17 n_137__284__net7 n_137__284__cki n_137__284__net5 vdd pfet_05v0 w=4.15e-07 l=5e-07 nf=1 m=1
XM_137__284__tp12 n_137__284__net7 rst_n vdd vdd pfet_05v0 w=7.8e-07 l=5e-07 nf=1 m=1
XM_137__284__tp13 vdd n_137__284__net6 n_137__284__net7 vdd pfet_05v0 w=7.8e-07 l=5e-07 nf=1 m=1
XM_137__284__tp16 n_137__284__net6 n_137__284__net5 vdd vdd pfet_05v0 w=7.8e-07 l=5e-07 nf=1 m=1
XM_137__284__tp14 vdd n_137__284__net6 integ_9 vdd pfet_05v0 w=1.215e-06 l=5e-07 nf=1 m=1
XM_138__285__tn10 n_138__285__ncki clknet_1_0__leaf_clk_ref vss vss nfet_05v0 w=4.05e-07 l=6e-07 nf=1 m=1
XM_138__285__tn13 n_138__285__cki n_138__285__ncki vss vss nfet_05v0 w=4.05e-07 l=6e-07 nf=1 m=1
XM_138__285__tn11 n_138__285__net10 _147__10 vss vss nfet_05v0 w=3.6e-07 l=6e-07 nf=1 m=1
XM_138__285__tn15 n_138__285__net10 n_138__285__ncki n_138__285__net1 vss nfet_05v0 w=3.6e-07 l=6e-07 nf=1 m=1
XM_138__285__tn14 n_138__285__net1 n_138__285__cki n_138__285__net15 vss nfet_05v0 w=3.6e-07 l=6e-07 nf=1 m=1
XM_138__285__tn8 n_138__285__net12 n_138__285__net2 n_138__285__net15 vss nfet_05v0 w=3.6e-07 l=6e-07 nf=1 m=1
XM_138__285__tn9 vss rst_n n_138__285__net12 vss nfet_05v0 w=3.6e-07 l=6e-07 nf=1 m=1
XM_138__285__tn18 vss n_138__285__net1 n_138__285__net2 vss nfet_05v0 w=3.6e-07 l=6e-07 nf=1 m=1
XM_138__285__tn0 n_138__285__net8 n_138__285__cki n_138__285__net2 vss nfet_05v0 w=3.6e-07 l=6e-07 nf=1 m=1
XM_138__285__tn1 n_138__285__net11 n_138__285__ncki n_138__285__net8 vss nfet_05v0 w=3.6e-07 l=6e-07 nf=1 m=1
XM_138__285__tn12 n_138__285__net11 n_138__285__net4 vss vss nfet_05v0 w=3.6e-07 l=6e-07 nf=1 m=1
XM_138__285__tn5 n_138__285__net0 rst_n vss vss nfet_05v0 w=3.6e-07 l=6e-07 nf=1 m=1
XM_138__285__tn4 n_138__285__net4 n_138__285__net8 n_138__285__net0 vss nfet_05v0 w=4e-07 l=6e-07 nf=1 m=1
XM_138__285__tn3 integ_10 n_138__285__net4 vss vss nfet_05v0 w=8.15e-07 l=6e-07 nf=1 m=1
XM_138__285__tp8 n_138__285__ncki clknet_1_0__leaf_clk_ref vdd vdd pfet_05v0 w=8.65e-07 l=5e-07 nf=1 m=1
XM_138__285__tp11 n_138__285__cki n_138__285__ncki vdd vdd pfet_05v0 w=8.65e-07 l=5e-07 nf=1 m=1
XM_138__285__tp9 vdd _147__10 n_138__285__net10 vdd pfet_05v0 w=7.8e-07 l=5e-07 nf=1 m=1
XM_138__285__tp15 n_138__285__net1 n_138__285__cki n_138__285__net10 vdd pfet_05v0 w=7.8e-07 l=5e-07 nf=1 m=1
XM_138__285__tp7 n_138__285__net9 n_138__285__ncki n_138__285__net1 vdd pfet_05v0 w=7.8e-07 l=5e-07 nf=1 m=1
XM_138__285__tp6 vdd n_138__285__net2 n_138__285__net9 vdd pfet_05v0 w=7.8e-07 l=5e-07 nf=1 m=1
XM_138__285__tp12 n_138__285__net9 rst_n vdd vdd pfet_05v0 w=7.8e-07 l=5e-07 nf=1 m=1
XM_138__285__tp18 vdd n_138__285__net1 n_138__285__net2 vdd pfet_05v0 w=5.05e-07 l=5e-07 nf=1 m=1
XM_138__285__tp2 n_138__285__net2 n_138__285__ncki n_138__285__net8 vdd pfet_05v0 w=5.05e-07 l=5e-07 nf=1 m=1
XM_138__285__tp3 n_138__285__net8 n_138__285__cki n_138__285__net11 vdd pfet_05v0 w=5.05e-07 l=5e-07 nf=1 m=1
XM_138__285__tp10 n_138__285__net11 n_138__285__net4 vdd vdd pfet_05v0 w=5.05e-07 l=5e-07 nf=1 m=1
XM_138__285__tp5 n_138__285__net4 rst_n vdd vdd pfet_05v0 w=1e-06 l=5e-07 nf=1 m=1
XM_138__285__tp4 vdd n_138__285__net8 n_138__285__net4 vdd pfet_05v0 w=1e-06 l=5e-07 nf=1 m=1
XM_138__285__tp1 integ_10 n_138__285__net4 vdd vdd pfet_05v0 w=1.215e-06 l=5e-07 nf=1 m=1
XM_139__286__tn10 n_139__286__ncki clknet_1_0__leaf_clk_ref vss vss nfet_05v0 w=4.05e-07 l=6e-07 nf=1 m=1
XM_139__286__tn13 n_139__286__cki n_139__286__ncki vss vss nfet_05v0 w=4.05e-07 l=6e-07 nf=1 m=1
XM_139__286__tn11 n_139__286__net10 _147__11 vss vss nfet_05v0 w=3.6e-07 l=6e-07 nf=1 m=1
XM_139__286__tn15 n_139__286__net10 n_139__286__ncki n_139__286__net1 vss nfet_05v0 w=3.6e-07 l=6e-07 nf=1 m=1
XM_139__286__tn14 n_139__286__net1 n_139__286__cki n_139__286__net15 vss nfet_05v0 w=3.6e-07 l=6e-07 nf=1 m=1
XM_139__286__tn8 n_139__286__net12 n_139__286__net2 n_139__286__net15 vss nfet_05v0 w=3.6e-07 l=6e-07 nf=1 m=1
XM_139__286__tn9 vss rst_n n_139__286__net12 vss nfet_05v0 w=3.6e-07 l=6e-07 nf=1 m=1
XM_139__286__tn18 vss n_139__286__net1 n_139__286__net2 vss nfet_05v0 w=3.6e-07 l=6e-07 nf=1 m=1
XM_139__286__tn0 n_139__286__net8 n_139__286__cki n_139__286__net2 vss nfet_05v0 w=3.6e-07 l=6e-07 nf=1 m=1
XM_139__286__tn1 n_139__286__net11 n_139__286__ncki n_139__286__net8 vss nfet_05v0 w=3.6e-07 l=6e-07 nf=1 m=1
XM_139__286__tn12 n_139__286__net11 n_139__286__net4 vss vss nfet_05v0 w=3.6e-07 l=6e-07 nf=1 m=1
XM_139__286__tn5 n_139__286__net0 rst_n vss vss nfet_05v0 w=3.6e-07 l=6e-07 nf=1 m=1
XM_139__286__tn4 n_139__286__net4 n_139__286__net8 n_139__286__net0 vss nfet_05v0 w=4e-07 l=6e-07 nf=1 m=1
XM_139__286__tn3 integ_11 n_139__286__net4 vss vss nfet_05v0 w=8.15e-07 l=6e-07 nf=1 m=1
XM_139__286__tp8 n_139__286__ncki clknet_1_0__leaf_clk_ref vdd vdd pfet_05v0 w=8.65e-07 l=5e-07 nf=1 m=1
XM_139__286__tp11 n_139__286__cki n_139__286__ncki vdd vdd pfet_05v0 w=8.65e-07 l=5e-07 nf=1 m=1
XM_139__286__tp9 vdd _147__11 n_139__286__net10 vdd pfet_05v0 w=7.8e-07 l=5e-07 nf=1 m=1
XM_139__286__tp15 n_139__286__net1 n_139__286__cki n_139__286__net10 vdd pfet_05v0 w=7.8e-07 l=5e-07 nf=1 m=1
XM_139__286__tp7 n_139__286__net9 n_139__286__ncki n_139__286__net1 vdd pfet_05v0 w=7.8e-07 l=5e-07 nf=1 m=1
XM_139__286__tp6 vdd n_139__286__net2 n_139__286__net9 vdd pfet_05v0 w=7.8e-07 l=5e-07 nf=1 m=1
XM_139__286__tp12 n_139__286__net9 rst_n vdd vdd pfet_05v0 w=7.8e-07 l=5e-07 nf=1 m=1
XM_139__286__tp18 vdd n_139__286__net1 n_139__286__net2 vdd pfet_05v0 w=5.05e-07 l=5e-07 nf=1 m=1
XM_139__286__tp2 n_139__286__net2 n_139__286__ncki n_139__286__net8 vdd pfet_05v0 w=5.05e-07 l=5e-07 nf=1 m=1
XM_139__286__tp3 n_139__286__net8 n_139__286__cki n_139__286__net11 vdd pfet_05v0 w=5.05e-07 l=5e-07 nf=1 m=1
XM_139__286__tp10 n_139__286__net11 n_139__286__net4 vdd vdd pfet_05v0 w=5.05e-07 l=5e-07 nf=1 m=1
XM_139__286__tp5 n_139__286__net4 rst_n vdd vdd pfet_05v0 w=1e-06 l=5e-07 nf=1 m=1
XM_139__286__tp4 vdd n_139__286__net8 n_139__286__net4 vdd pfet_05v0 w=1e-06 l=5e-07 nf=1 m=1
XM_139__286__tp1 integ_11 n_139__286__net4 vdd vdd pfet_05v0 w=1.215e-06 l=5e-07 nf=1 m=1
XM_140__287__i_2 vss dsm_acc1_9 n_140__287__Z_neg vss nfet_05v0 w=8.2e-07 l=6e-07 nf=1 m=1
XM_140__287__i_0_0 dsm_out n_140__287__Z_neg vss vss nfet_05v0 w=8.2e-07 l=6e-07 nf=1 m=1
XM_140__287__i_0_1 vss n_140__287__Z_neg dsm_out vss nfet_05v0 w=8.2e-07 l=6e-07 nf=1 m=1
XM_140__287__i_3 vdd dsm_acc1_9 n_140__287__Z_neg vdd pfet_05v0 w=1.22e-06 l=5e-07 nf=1 m=1
XM_140__287__i_1_0 dsm_out n_140__287__Z_neg vdd vdd pfet_05v0 w=1.22e-06 l=5e-07 nf=1 m=1
XM_140__287__i_1_1 vdd n_140__287__Z_neg dsm_out vdd pfet_05v0 w=1.22e-06 l=5e-07 nf=1 m=1
XM_141__288__i_2 vss phase_err_1 n_141__288__Z_neg vss nfet_05v0 w=8.2e-07 l=6e-07 nf=1 m=1
XM_141__288__i_0_0 _139_ n_141__288__Z_neg vss vss nfet_05v0 w=8.2e-07 l=6e-07 nf=1 m=1
XM_141__288__i_0_1 vss n_141__288__Z_neg _139_ vss nfet_05v0 w=8.2e-07 l=6e-07 nf=1 m=1
XM_141__288__i_3 vdd phase_err_1 n_141__288__Z_neg vdd pfet_05v0 w=1.22e-06 l=5e-07 nf=1 m=1
XM_141__288__i_1_0 _139_ n_141__288__Z_neg vdd vdd pfet_05v0 w=1.22e-06 l=5e-07 nf=1 m=1
XM_141__288__i_1_1 vdd n_141__288__Z_neg _139_ vdd pfet_05v0 w=1.22e-06 l=5e-07 nf=1 m=1
XM_142__289__i_2 vss integ_3 n_142__289__Z_neg vss nfet_05v0 w=8.2e-07 l=6e-07 nf=1 m=1
XM_142__289__i_0_0 _039_ n_142__289__Z_neg vss vss nfet_05v0 w=8.2e-07 l=6e-07 nf=1 m=1
XM_142__289__i_0_1 vss n_142__289__Z_neg _039_ vss nfet_05v0 w=8.2e-07 l=6e-07 nf=1 m=1
XM_142__289__i_3 vdd integ_3 n_142__289__Z_neg vdd pfet_05v0 w=1.22e-06 l=5e-07 nf=1 m=1
XM_142__289__i_1_0 _039_ n_142__289__Z_neg vdd vdd pfet_05v0 w=1.22e-06 l=5e-07 nf=1 m=1
XM_142__289__i_1_1 vdd n_142__289__Z_neg _039_ vdd pfet_05v0 w=1.22e-06 l=5e-07 nf=1 m=1
XM_143__290__i_2 vss dsm_acc1_3 n_143__290__Z_neg vss nfet_05v0 w=8.2e-07 l=6e-07 nf=1 m=1
XM_143__290__i_0_0 _028_ n_143__290__Z_neg vss vss nfet_05v0 w=8.2e-07 l=6e-07 nf=1 m=1
XM_143__290__i_0_1 vss n_143__290__Z_neg _028_ vss nfet_05v0 w=8.2e-07 l=6e-07 nf=1 m=1
XM_143__290__i_3 vdd dsm_acc1_3 n_143__290__Z_neg vdd pfet_05v0 w=1.22e-06 l=5e-07 nf=1 m=1
XM_143__290__i_1_0 _028_ n_143__290__Z_neg vdd vdd pfet_05v0 w=1.22e-06 l=5e-07 nf=1 m=1
XM_143__290__i_1_1 vdd n_143__290__Z_neg _028_ vdd pfet_05v0 w=1.22e-06 l=5e-07 nf=1 m=1
XM_144__291__i_2 vss phase_err_0 n_144__291__Z_neg vss nfet_05v0 w=8.2e-07 l=6e-07 nf=1 m=1
XM_144__291__i_0_0 _138_ n_144__291__Z_neg vss vss nfet_05v0 w=8.2e-07 l=6e-07 nf=1 m=1
XM_144__291__i_0_1 vss n_144__291__Z_neg _138_ vss nfet_05v0 w=8.2e-07 l=6e-07 nf=1 m=1
XM_144__291__i_3 vdd phase_err_0 n_144__291__Z_neg vdd pfet_05v0 w=1.22e-06 l=5e-07 nf=1 m=1
XM_144__291__i_1_0 _138_ n_144__291__Z_neg vdd vdd pfet_05v0 w=1.22e-06 l=5e-07 nf=1 m=1
XM_144__291__i_1_1 vdd n_144__291__Z_neg _138_ vdd pfet_05v0 w=1.22e-06 l=5e-07 nf=1 m=1
XM_145__292__i_2 vss integ_2 n_145__292__Z_neg vss nfet_05v0 w=8.2e-07 l=6e-07 nf=1 m=1
XM_145__292__i_0_0 _038_ n_145__292__Z_neg vss vss nfet_05v0 w=8.2e-07 l=6e-07 nf=1 m=1
XM_145__292__i_0_1 vss n_145__292__Z_neg _038_ vss nfet_05v0 w=8.2e-07 l=6e-07 nf=1 m=1
XM_145__292__i_3 vdd integ_2 n_145__292__Z_neg vdd pfet_05v0 w=1.22e-06 l=5e-07 nf=1 m=1
XM_145__292__i_1_0 _038_ n_145__292__Z_neg vdd vdd pfet_05v0 w=1.22e-06 l=5e-07 nf=1 m=1
XM_145__292__i_1_1 vdd n_145__292__Z_neg _038_ vdd pfet_05v0 w=1.22e-06 l=5e-07 nf=1 m=1
XM_146__293__i_2 vss dsm_acc1_2 n_146__293__Z_neg vss nfet_05v0 w=8.2e-07 l=6e-07 nf=1 m=1
XM_146__293__i_0_0 _027_ n_146__293__Z_neg vss vss nfet_05v0 w=8.2e-07 l=6e-07 nf=1 m=1
XM_146__293__i_0_1 vss n_146__293__Z_neg _027_ vss nfet_05v0 w=8.2e-07 l=6e-07 nf=1 m=1
XM_146__293__i_3 vdd dsm_acc1_2 n_146__293__Z_neg vdd pfet_05v0 w=1.22e-06 l=5e-07 nf=1 m=1
XM_146__293__i_1_0 _027_ n_146__293__Z_neg vdd vdd pfet_05v0 w=1.22e-06 l=5e-07 nf=1 m=1
XM_146__293__i_1_1 vdd n_146__293__Z_neg _027_ vdd pfet_05v0 w=1.22e-06 l=5e-07 nf=1 m=1
XM_147__294__i_2 vss integ_1 n_147__294__Z_neg vss nfet_05v0 w=8.2e-07 l=6e-07 nf=1 m=1
XM_147__294__i_0_0 _037_ n_147__294__Z_neg vss vss nfet_05v0 w=8.2e-07 l=6e-07 nf=1 m=1
XM_147__294__i_0_1 vss n_147__294__Z_neg _037_ vss nfet_05v0 w=8.2e-07 l=6e-07 nf=1 m=1
XM_147__294__i_3 vdd integ_1 n_147__294__Z_neg vdd pfet_05v0 w=1.22e-06 l=5e-07 nf=1 m=1
XM_147__294__i_1_0 _037_ n_147__294__Z_neg vdd vdd pfet_05v0 w=1.22e-06 l=5e-07 nf=1 m=1
XM_147__294__i_1_1 vdd n_147__294__Z_neg _037_ vdd pfet_05v0 w=1.22e-06 l=5e-07 nf=1 m=1
XM_148__295__i_2 vss dsm_acc1_1 n_148__295__Z_neg vss nfet_05v0 w=8.2e-07 l=6e-07 nf=1 m=1
XM_148__295__i_0_0 _026_ n_148__295__Z_neg vss vss nfet_05v0 w=8.2e-07 l=6e-07 nf=1 m=1
XM_148__295__i_0_1 vss n_148__295__Z_neg _026_ vss nfet_05v0 w=8.2e-07 l=6e-07 nf=1 m=1
XM_148__295__i_3 vdd dsm_acc1_1 n_148__295__Z_neg vdd pfet_05v0 w=1.22e-06 l=5e-07 nf=1 m=1
XM_148__295__i_1_0 _026_ n_148__295__Z_neg vdd vdd pfet_05v0 w=1.22e-06 l=5e-07 nf=1 m=1
XM_148__295__i_1_1 vdd n_148__295__Z_neg _026_ vdd pfet_05v0 w=1.22e-06 l=5e-07 nf=1 m=1
XM_149__296__i_2 vss integ_0 n_149__296__Z_neg vss nfet_05v0 w=8.2e-07 l=6e-07 nf=1 m=1
XM_149__296__i_0_0 _034_ n_149__296__Z_neg vss vss nfet_05v0 w=8.2e-07 l=6e-07 nf=1 m=1
XM_149__296__i_0_1 vss n_149__296__Z_neg _034_ vss nfet_05v0 w=8.2e-07 l=6e-07 nf=1 m=1
XM_149__296__i_3 vdd integ_0 n_149__296__Z_neg vdd pfet_05v0 w=1.22e-06 l=5e-07 nf=1 m=1
XM_149__296__i_1_0 _034_ n_149__296__Z_neg vdd vdd pfet_05v0 w=1.22e-06 l=5e-07 nf=1 m=1
XM_149__296__i_1_1 vdd n_149__296__Z_neg _034_ vdd pfet_05v0 w=1.22e-06 l=5e-07 nf=1 m=1
XM_150__297__i_2 vss dsm_acc1_0 n_150__297__Z_neg vss nfet_05v0 w=8.2e-07 l=6e-07 nf=1 m=1
XM_150__297__i_0_0 _025_ n_150__297__Z_neg vss vss nfet_05v0 w=8.2e-07 l=6e-07 nf=1 m=1
XM_150__297__i_0_1 vss n_150__297__Z_neg _025_ vss nfet_05v0 w=8.2e-07 l=6e-07 nf=1 m=1
XM_150__297__i_3 vdd dsm_acc1_0 n_150__297__Z_neg vdd pfet_05v0 w=1.22e-06 l=5e-07 nf=1 m=1
XM_150__297__i_1_0 _025_ n_150__297__Z_neg vdd vdd pfet_05v0 w=1.22e-06 l=5e-07 nf=1 m=1
XM_150__297__i_1_1 vdd n_150__297__Z_neg _025_ vdd pfet_05v0 w=1.22e-06 l=5e-07 nf=1 m=1
XM_151__298__i_2 vss phase_err_2 n_151__298__Z_neg vss nfet_05v0 w=8.2e-07 l=6e-07 nf=1 m=1
XM_151__298__i_0_0 _140_ n_151__298__Z_neg vss vss nfet_05v0 w=8.2e-07 l=6e-07 nf=1 m=1
XM_151__298__i_0_1 vss n_151__298__Z_neg _140_ vss nfet_05v0 w=8.2e-07 l=6e-07 nf=1 m=1
XM_151__298__i_3 vdd phase_err_2 n_151__298__Z_neg vdd pfet_05v0 w=1.22e-06 l=5e-07 nf=1 m=1
XM_151__298__i_1_0 _140_ n_151__298__Z_neg vdd vdd pfet_05v0 w=1.22e-06 l=5e-07 nf=1 m=1
XM_151__298__i_1_1 vdd n_151__298__Z_neg _140_ vdd pfet_05v0 w=1.22e-06 l=5e-07 nf=1 m=1
XM_152__299__i_2 vss integ_4 n_152__299__Z_neg vss nfet_05v0 w=8.2e-07 l=6e-07 nf=1 m=1
XM_152__299__i_0_0 _040_ n_152__299__Z_neg vss vss nfet_05v0 w=8.2e-07 l=6e-07 nf=1 m=1
XM_152__299__i_0_1 vss n_152__299__Z_neg _040_ vss nfet_05v0 w=8.2e-07 l=6e-07 nf=1 m=1
XM_152__299__i_3 vdd integ_4 n_152__299__Z_neg vdd pfet_05v0 w=1.22e-06 l=5e-07 nf=1 m=1
XM_152__299__i_1_0 _040_ n_152__299__Z_neg vdd vdd pfet_05v0 w=1.22e-06 l=5e-07 nf=1 m=1
XM_152__299__i_1_1 vdd n_152__299__Z_neg _040_ vdd pfet_05v0 w=1.22e-06 l=5e-07 nf=1 m=1
XM_153__300__i_2 vss dsm_acc1_4 n_153__300__Z_neg vss nfet_05v0 w=8.2e-07 l=6e-07 nf=1 m=1
XM_153__300__i_0_0 _029_ n_153__300__Z_neg vss vss nfet_05v0 w=8.2e-07 l=6e-07 nf=1 m=1
XM_153__300__i_0_1 vss n_153__300__Z_neg _029_ vss nfet_05v0 w=8.2e-07 l=6e-07 nf=1 m=1
XM_153__300__i_3 vdd dsm_acc1_4 n_153__300__Z_neg vdd pfet_05v0 w=1.22e-06 l=5e-07 nf=1 m=1
XM_153__300__i_1_0 _029_ n_153__300__Z_neg vdd vdd pfet_05v0 w=1.22e-06 l=5e-07 nf=1 m=1
XM_153__300__i_1_1 vdd n_153__300__Z_neg _029_ vdd pfet_05v0 w=1.22e-06 l=5e-07 nf=1 m=1
XM_154__301__i_2 vss _005_ n_154__301__Z_neg vss nfet_05v0 w=8.2e-07 l=6e-07 nf=1 m=1
XM_154__301__i_0_0 _145__4 n_154__301__Z_neg vss vss nfet_05v0 w=8.2e-07 l=6e-07 nf=1 m=1
XM_154__301__i_0_1 vss n_154__301__Z_neg _145__4 vss nfet_05v0 w=8.2e-07 l=6e-07 nf=1 m=1
XM_154__301__i_3 vdd _005_ n_154__301__Z_neg vdd pfet_05v0 w=1.22e-06 l=5e-07 nf=1 m=1
XM_154__301__i_1_0 _145__4 n_154__301__Z_neg vdd vdd pfet_05v0 w=1.22e-06 l=5e-07 nf=1 m=1
XM_154__301__i_1_1 vdd n_154__301__Z_neg _145__4 vdd pfet_05v0 w=1.22e-06 l=5e-07 nf=1 m=1
XM_155__302__i_2 vss _004_ n_155__302__Z_neg vss nfet_05v0 w=8.2e-07 l=6e-07 nf=1 m=1
XM_155__302__i_0_0 _145__3 n_155__302__Z_neg vss vss nfet_05v0 w=8.2e-07 l=6e-07 nf=1 m=1
XM_155__302__i_0_1 vss n_155__302__Z_neg _145__3 vss nfet_05v0 w=8.2e-07 l=6e-07 nf=1 m=1
XM_155__302__i_3 vdd _004_ n_155__302__Z_neg vdd pfet_05v0 w=1.22e-06 l=5e-07 nf=1 m=1
XM_155__302__i_1_0 _145__3 n_155__302__Z_neg vdd vdd pfet_05v0 w=1.22e-06 l=5e-07 nf=1 m=1
XM_155__302__i_1_1 vdd n_155__302__Z_neg _145__3 vdd pfet_05v0 w=1.22e-06 l=5e-07 nf=1 m=1
XM_156__303__i_2 vss _003_ n_156__303__Z_neg vss nfet_05v0 w=8.2e-07 l=6e-07 nf=1 m=1
XM_156__303__i_0_0 _145__2 n_156__303__Z_neg vss vss nfet_05v0 w=8.2e-07 l=6e-07 nf=1 m=1
XM_156__303__i_0_1 vss n_156__303__Z_neg _145__2 vss nfet_05v0 w=8.2e-07 l=6e-07 nf=1 m=1
XM_156__303__i_3 vdd _003_ n_156__303__Z_neg vdd pfet_05v0 w=1.22e-06 l=5e-07 nf=1 m=1
XM_156__303__i_1_0 _145__2 n_156__303__Z_neg vdd vdd pfet_05v0 w=1.22e-06 l=5e-07 nf=1 m=1
XM_156__303__i_1_1 vdd n_156__303__Z_neg _145__2 vdd pfet_05v0 w=1.22e-06 l=5e-07 nf=1 m=1
XM_157__304__i_2 vss _002_ n_157__304__Z_neg vss nfet_05v0 w=8.2e-07 l=6e-07 nf=1 m=1
XM_157__304__i_0_0 _145__1 n_157__304__Z_neg vss vss nfet_05v0 w=8.2e-07 l=6e-07 nf=1 m=1
XM_157__304__i_0_1 vss n_157__304__Z_neg _145__1 vss nfet_05v0 w=8.2e-07 l=6e-07 nf=1 m=1
XM_157__304__i_3 vdd _002_ n_157__304__Z_neg vdd pfet_05v0 w=1.22e-06 l=5e-07 nf=1 m=1
XM_157__304__i_1_0 _145__1 n_157__304__Z_neg vdd vdd pfet_05v0 w=1.22e-06 l=5e-07 nf=1 m=1
XM_157__304__i_1_1 vdd n_157__304__Z_neg _145__1 vdd pfet_05v0 w=1.22e-06 l=5e-07 nf=1 m=1
XM_158__305__i_2 vss phase_err_3 n_158__305__Z_neg vss nfet_05v0 w=8.2e-07 l=6e-07 nf=1 m=1
XM_158__305__i_0_0 _141_ n_158__305__Z_neg vss vss nfet_05v0 w=8.2e-07 l=6e-07 nf=1 m=1
XM_158__305__i_0_1 vss n_158__305__Z_neg _141_ vss nfet_05v0 w=8.2e-07 l=6e-07 nf=1 m=1
XM_158__305__i_3 vdd phase_err_3 n_158__305__Z_neg vdd pfet_05v0 w=1.22e-06 l=5e-07 nf=1 m=1
XM_158__305__i_1_0 _141_ n_158__305__Z_neg vdd vdd pfet_05v0 w=1.22e-06 l=5e-07 nf=1 m=1
XM_158__305__i_1_1 vdd n_158__305__Z_neg _141_ vdd pfet_05v0 w=1.22e-06 l=5e-07 nf=1 m=1
XM_159__306__i_2 vss integ_5 n_159__306__Z_neg vss nfet_05v0 w=8.2e-07 l=6e-07 nf=1 m=1
XM_159__306__i_0_0 _041_ n_159__306__Z_neg vss vss nfet_05v0 w=8.2e-07 l=6e-07 nf=1 m=1
XM_159__306__i_0_1 vss n_159__306__Z_neg _041_ vss nfet_05v0 w=8.2e-07 l=6e-07 nf=1 m=1
XM_159__306__i_3 vdd integ_5 n_159__306__Z_neg vdd pfet_05v0 w=1.22e-06 l=5e-07 nf=1 m=1
XM_159__306__i_1_0 _041_ n_159__306__Z_neg vdd vdd pfet_05v0 w=1.22e-06 l=5e-07 nf=1 m=1
XM_159__306__i_1_1 vdd n_159__306__Z_neg _041_ vdd pfet_05v0 w=1.22e-06 l=5e-07 nf=1 m=1
XM_160__307__i_2 vss phase_err_4 n_160__307__Z_neg vss nfet_05v0 w=8.2e-07 l=6e-07 nf=1 m=1
XM_160__307__i_0_0 _142_ n_160__307__Z_neg vss vss nfet_05v0 w=8.2e-07 l=6e-07 nf=1 m=1
XM_160__307__i_0_1 vss n_160__307__Z_neg _142_ vss nfet_05v0 w=8.2e-07 l=6e-07 nf=1 m=1
XM_160__307__i_3 vdd phase_err_4 n_160__307__Z_neg vdd pfet_05v0 w=1.22e-06 l=5e-07 nf=1 m=1
XM_160__307__i_1_0 _142_ n_160__307__Z_neg vdd vdd pfet_05v0 w=1.22e-06 l=5e-07 nf=1 m=1
XM_160__307__i_1_1 vdd n_160__307__Z_neg _142_ vdd pfet_05v0 w=1.22e-06 l=5e-07 nf=1 m=1
XM_161__308__i_2 vss integ_6 n_161__308__Z_neg vss nfet_05v0 w=8.2e-07 l=6e-07 nf=1 m=1
XM_161__308__i_0_0 _042_ n_161__308__Z_neg vss vss nfet_05v0 w=8.2e-07 l=6e-07 nf=1 m=1
XM_161__308__i_0_1 vss n_161__308__Z_neg _042_ vss nfet_05v0 w=8.2e-07 l=6e-07 nf=1 m=1
XM_161__308__i_3 vdd integ_6 n_161__308__Z_neg vdd pfet_05v0 w=1.22e-06 l=5e-07 nf=1 m=1
XM_161__308__i_1_0 _042_ n_161__308__Z_neg vdd vdd pfet_05v0 w=1.22e-06 l=5e-07 nf=1 m=1
XM_161__308__i_1_1 vdd n_161__308__Z_neg _042_ vdd pfet_05v0 w=1.22e-06 l=5e-07 nf=1 m=1
XM_162__309__i_2 vss dsm_acc1_6 n_162__309__Z_neg vss nfet_05v0 w=8.2e-07 l=6e-07 nf=1 m=1
XM_162__309__i_0_0 _031_ n_162__309__Z_neg vss vss nfet_05v0 w=8.2e-07 l=6e-07 nf=1 m=1
XM_162__309__i_0_1 vss n_162__309__Z_neg _031_ vss nfet_05v0 w=8.2e-07 l=6e-07 nf=1 m=1
XM_162__309__i_3 vdd dsm_acc1_6 n_162__309__Z_neg vdd pfet_05v0 w=1.22e-06 l=5e-07 nf=1 m=1
XM_162__309__i_1_0 _031_ n_162__309__Z_neg vdd vdd pfet_05v0 w=1.22e-06 l=5e-07 nf=1 m=1
XM_162__309__i_1_1 vdd n_162__309__Z_neg _031_ vdd pfet_05v0 w=1.22e-06 l=5e-07 nf=1 m=1
XM_163__310__i_2 vss dsm_acc1_5 n_163__310__Z_neg vss nfet_05v0 w=8.2e-07 l=6e-07 nf=1 m=1
XM_163__310__i_0_0 _030_ n_163__310__Z_neg vss vss nfet_05v0 w=8.2e-07 l=6e-07 nf=1 m=1
XM_163__310__i_0_1 vss n_163__310__Z_neg _030_ vss nfet_05v0 w=8.2e-07 l=6e-07 nf=1 m=1
XM_163__310__i_3 vdd dsm_acc1_5 n_163__310__Z_neg vdd pfet_05v0 w=1.22e-06 l=5e-07 nf=1 m=1
XM_163__310__i_1_0 _030_ n_163__310__Z_neg vdd vdd pfet_05v0 w=1.22e-06 l=5e-07 nf=1 m=1
XM_163__310__i_1_1 vdd n_163__310__Z_neg _030_ vdd pfet_05v0 w=1.22e-06 l=5e-07 nf=1 m=1
XM_164__311__i_2 vss integ_7 n_164__311__Z_neg vss nfet_05v0 w=8.2e-07 l=6e-07 nf=1 m=1
XM_164__311__i_0_0 _043_ n_164__311__Z_neg vss vss nfet_05v0 w=8.2e-07 l=6e-07 nf=1 m=1
XM_164__311__i_0_1 vss n_164__311__Z_neg _043_ vss nfet_05v0 w=8.2e-07 l=6e-07 nf=1 m=1
XM_164__311__i_3 vdd integ_7 n_164__311__Z_neg vdd pfet_05v0 w=1.22e-06 l=5e-07 nf=1 m=1
XM_164__311__i_1_0 _043_ n_164__311__Z_neg vdd vdd pfet_05v0 w=1.22e-06 l=5e-07 nf=1 m=1
XM_164__311__i_1_1 vdd n_164__311__Z_neg _043_ vdd pfet_05v0 w=1.22e-06 l=5e-07 nf=1 m=1
XM_165__312__i_2 vss dsm_acc1_7 n_165__312__Z_neg vss nfet_05v0 w=8.2e-07 l=6e-07 nf=1 m=1
XM_165__312__i_0_0 _032_ n_165__312__Z_neg vss vss nfet_05v0 w=8.2e-07 l=6e-07 nf=1 m=1
XM_165__312__i_0_1 vss n_165__312__Z_neg _032_ vss nfet_05v0 w=8.2e-07 l=6e-07 nf=1 m=1
XM_165__312__i_3 vdd dsm_acc1_7 n_165__312__Z_neg vdd pfet_05v0 w=1.22e-06 l=5e-07 nf=1 m=1
XM_165__312__i_1_0 _032_ n_165__312__Z_neg vdd vdd pfet_05v0 w=1.22e-06 l=5e-07 nf=1 m=1
XM_165__312__i_1_1 vdd n_165__312__Z_neg _032_ vdd pfet_05v0 w=1.22e-06 l=5e-07 nf=1 m=1
XM_166__313__i_2 vss _008_ n_166__313__Z_neg vss nfet_05v0 w=8.2e-07 l=6e-07 nf=1 m=1
XM_166__313__i_0_0 _145__7 n_166__313__Z_neg vss vss nfet_05v0 w=8.2e-07 l=6e-07 nf=1 m=1
XM_166__313__i_0_1 vss n_166__313__Z_neg _145__7 vss nfet_05v0 w=8.2e-07 l=6e-07 nf=1 m=1
XM_166__313__i_3 vdd _008_ n_166__313__Z_neg vdd pfet_05v0 w=1.22e-06 l=5e-07 nf=1 m=1
XM_166__313__i_1_0 _145__7 n_166__313__Z_neg vdd vdd pfet_05v0 w=1.22e-06 l=5e-07 nf=1 m=1
XM_166__313__i_1_1 vdd n_166__313__Z_neg _145__7 vdd pfet_05v0 w=1.22e-06 l=5e-07 nf=1 m=1
XM_167__314__i_2 vss _007_ n_167__314__Z_neg vss nfet_05v0 w=8.2e-07 l=6e-07 nf=1 m=1
XM_167__314__i_0_0 _145__6 n_167__314__Z_neg vss vss nfet_05v0 w=8.2e-07 l=6e-07 nf=1 m=1
XM_167__314__i_0_1 vss n_167__314__Z_neg _145__6 vss nfet_05v0 w=8.2e-07 l=6e-07 nf=1 m=1
XM_167__314__i_3 vdd _007_ n_167__314__Z_neg vdd pfet_05v0 w=1.22e-06 l=5e-07 nf=1 m=1
XM_167__314__i_1_0 _145__6 n_167__314__Z_neg vdd vdd pfet_05v0 w=1.22e-06 l=5e-07 nf=1 m=1
XM_167__314__i_1_1 vdd n_167__314__Z_neg _145__6 vdd pfet_05v0 w=1.22e-06 l=5e-07 nf=1 m=1
XM_168__315__i_2 vss _006_ n_168__315__Z_neg vss nfet_05v0 w=8.2e-07 l=6e-07 nf=1 m=1
XM_168__315__i_0_0 _145__5 n_168__315__Z_neg vss vss nfet_05v0 w=8.2e-07 l=6e-07 nf=1 m=1
XM_168__315__i_0_1 vss n_168__315__Z_neg _145__5 vss nfet_05v0 w=8.2e-07 l=6e-07 nf=1 m=1
XM_168__315__i_3 vdd _006_ n_168__315__Z_neg vdd pfet_05v0 w=1.22e-06 l=5e-07 nf=1 m=1
XM_168__315__i_1_0 _145__5 n_168__315__Z_neg vdd vdd pfet_05v0 w=1.22e-06 l=5e-07 nf=1 m=1
XM_168__315__i_1_1 vdd n_168__315__Z_neg _145__5 vdd pfet_05v0 w=1.22e-06 l=5e-07 nf=1 m=1
XM_169__316__i_2 vss integ_10 n_169__316__Z_neg vss nfet_05v0 w=8.2e-07 l=6e-07 nf=1 m=1
XM_169__316__i_0_0 _035_ n_169__316__Z_neg vss vss nfet_05v0 w=8.2e-07 l=6e-07 nf=1 m=1
XM_169__316__i_0_1 vss n_169__316__Z_neg _035_ vss nfet_05v0 w=8.2e-07 l=6e-07 nf=1 m=1
XM_169__316__i_3 vdd integ_10 n_169__316__Z_neg vdd pfet_05v0 w=1.22e-06 l=5e-07 nf=1 m=1
XM_169__316__i_1_0 _035_ n_169__316__Z_neg vdd vdd pfet_05v0 w=1.22e-06 l=5e-07 nf=1 m=1
XM_169__316__i_1_1 vdd n_169__316__Z_neg _035_ vdd pfet_05v0 w=1.22e-06 l=5e-07 nf=1 m=1
XM_170__317__i_2 vss integ_8 n_170__317__Z_neg vss nfet_05v0 w=8.2e-07 l=6e-07 nf=1 m=1
XM_170__317__i_0_0 _044_ n_170__317__Z_neg vss vss nfet_05v0 w=8.2e-07 l=6e-07 nf=1 m=1
XM_170__317__i_0_1 vss n_170__317__Z_neg _044_ vss nfet_05v0 w=8.2e-07 l=6e-07 nf=1 m=1
XM_170__317__i_3 vdd integ_8 n_170__317__Z_neg vdd pfet_05v0 w=1.22e-06 l=5e-07 nf=1 m=1
XM_170__317__i_1_0 _044_ n_170__317__Z_neg vdd vdd pfet_05v0 w=1.22e-06 l=5e-07 nf=1 m=1
XM_170__317__i_1_1 vdd n_170__317__Z_neg _044_ vdd pfet_05v0 w=1.22e-06 l=5e-07 nf=1 m=1
XM_171__318__i_2 vss integ_9 n_171__318__Z_neg vss nfet_05v0 w=8.2e-07 l=6e-07 nf=1 m=1
XM_171__318__i_0_0 _045_ n_171__318__Z_neg vss vss nfet_05v0 w=8.2e-07 l=6e-07 nf=1 m=1
XM_171__318__i_0_1 vss n_171__318__Z_neg _045_ vss nfet_05v0 w=8.2e-07 l=6e-07 nf=1 m=1
XM_171__318__i_3 vdd integ_9 n_171__318__Z_neg vdd pfet_05v0 w=1.22e-06 l=5e-07 nf=1 m=1
XM_171__318__i_1_0 _045_ n_171__318__Z_neg vdd vdd pfet_05v0 w=1.22e-06 l=5e-07 nf=1 m=1
XM_171__318__i_1_1 vdd n_171__318__Z_neg _045_ vdd pfet_05v0 w=1.22e-06 l=5e-07 nf=1 m=1
XM_172__319__i_2 vss integ_11 n_172__319__Z_neg vss nfet_05v0 w=8.2e-07 l=6e-07 nf=1 m=1
XM_172__319__i_0_0 _036_ n_172__319__Z_neg vss vss nfet_05v0 w=8.2e-07 l=6e-07 nf=1 m=1
XM_172__319__i_0_1 vss n_172__319__Z_neg _036_ vss nfet_05v0 w=8.2e-07 l=6e-07 nf=1 m=1
XM_172__319__i_3 vdd integ_11 n_172__319__Z_neg vdd pfet_05v0 w=1.22e-06 l=5e-07 nf=1 m=1
XM_172__319__i_1_0 _036_ n_172__319__Z_neg vdd vdd pfet_05v0 w=1.22e-06 l=5e-07 nf=1 m=1
XM_172__319__i_1_1 vdd n_172__319__Z_neg _036_ vdd pfet_05v0 w=1.22e-06 l=5e-07 nf=1 m=1
XM_173__320__i_2 vss _012_ n_173__320__Z_neg vss nfet_05v0 w=8.2e-07 l=6e-07 nf=1 m=1
XM_173__320__i_0_0 _147__11 n_173__320__Z_neg vss vss nfet_05v0 w=8.2e-07 l=6e-07 nf=1 m=1
XM_173__320__i_0_1 vss n_173__320__Z_neg _147__11 vss nfet_05v0 w=8.2e-07 l=6e-07 nf=1 m=1
XM_173__320__i_3 vdd _012_ n_173__320__Z_neg vdd pfet_05v0 w=1.22e-06 l=5e-07 nf=1 m=1
XM_173__320__i_1_0 _147__11 n_173__320__Z_neg vdd vdd pfet_05v0 w=1.22e-06 l=5e-07 nf=1 m=1
XM_173__320__i_1_1 vdd n_173__320__Z_neg _147__11 vdd pfet_05v0 w=1.22e-06 l=5e-07 nf=1 m=1
XM_174__321__i_2 vss _011_ n_174__321__Z_neg vss nfet_05v0 w=8.2e-07 l=6e-07 nf=1 m=1
XM_174__321__i_0_0 _147__10 n_174__321__Z_neg vss vss nfet_05v0 w=8.2e-07 l=6e-07 nf=1 m=1
XM_174__321__i_0_1 vss n_174__321__Z_neg _147__10 vss nfet_05v0 w=8.2e-07 l=6e-07 nf=1 m=1
XM_174__321__i_3 vdd _011_ n_174__321__Z_neg vdd pfet_05v0 w=1.22e-06 l=5e-07 nf=1 m=1
XM_174__321__i_1_0 _147__10 n_174__321__Z_neg vdd vdd pfet_05v0 w=1.22e-06 l=5e-07 nf=1 m=1
XM_174__321__i_1_1 vdd n_174__321__Z_neg _147__10 vdd pfet_05v0 w=1.22e-06 l=5e-07 nf=1 m=1
XM_175__322__i_2 vss _021_ n_175__322__Z_neg vss nfet_05v0 w=8.2e-07 l=6e-07 nf=1 m=1
XM_175__322__i_0_0 _147__9 n_175__322__Z_neg vss vss nfet_05v0 w=8.2e-07 l=6e-07 nf=1 m=1
XM_175__322__i_0_1 vss n_175__322__Z_neg _147__9 vss nfet_05v0 w=8.2e-07 l=6e-07 nf=1 m=1
XM_175__322__i_3 vdd _021_ n_175__322__Z_neg vdd pfet_05v0 w=1.22e-06 l=5e-07 nf=1 m=1
XM_175__322__i_1_0 _147__9 n_175__322__Z_neg vdd vdd pfet_05v0 w=1.22e-06 l=5e-07 nf=1 m=1
XM_175__322__i_1_1 vdd n_175__322__Z_neg _147__9 vdd pfet_05v0 w=1.22e-06 l=5e-07 nf=1 m=1
XM_176__323__i_2 vss _020_ n_176__323__Z_neg vss nfet_05v0 w=8.2e-07 l=6e-07 nf=1 m=1
XM_176__323__i_0_0 _147__8 n_176__323__Z_neg vss vss nfet_05v0 w=8.2e-07 l=6e-07 nf=1 m=1
XM_176__323__i_0_1 vss n_176__323__Z_neg _147__8 vss nfet_05v0 w=8.2e-07 l=6e-07 nf=1 m=1
XM_176__323__i_3 vdd _020_ n_176__323__Z_neg vdd pfet_05v0 w=1.22e-06 l=5e-07 nf=1 m=1
XM_176__323__i_1_0 _147__8 n_176__323__Z_neg vdd vdd pfet_05v0 w=1.22e-06 l=5e-07 nf=1 m=1
XM_176__323__i_1_1 vdd n_176__323__Z_neg _147__8 vdd pfet_05v0 w=1.22e-06 l=5e-07 nf=1 m=1
XM_177__324__i_2 vss _019_ n_177__324__Z_neg vss nfet_05v0 w=8.2e-07 l=6e-07 nf=1 m=1
XM_177__324__i_0_0 _147__7 n_177__324__Z_neg vss vss nfet_05v0 w=8.2e-07 l=6e-07 nf=1 m=1
XM_177__324__i_0_1 vss n_177__324__Z_neg _147__7 vss nfet_05v0 w=8.2e-07 l=6e-07 nf=1 m=1
XM_177__324__i_3 vdd _019_ n_177__324__Z_neg vdd pfet_05v0 w=1.22e-06 l=5e-07 nf=1 m=1
XM_177__324__i_1_0 _147__7 n_177__324__Z_neg vdd vdd pfet_05v0 w=1.22e-06 l=5e-07 nf=1 m=1
XM_177__324__i_1_1 vdd n_177__324__Z_neg _147__7 vdd pfet_05v0 w=1.22e-06 l=5e-07 nf=1 m=1
XM_178__325__i_2 vss _018_ n_178__325__Z_neg vss nfet_05v0 w=8.2e-07 l=6e-07 nf=1 m=1
XM_178__325__i_0_0 _147__6 n_178__325__Z_neg vss vss nfet_05v0 w=8.2e-07 l=6e-07 nf=1 m=1
XM_178__325__i_0_1 vss n_178__325__Z_neg _147__6 vss nfet_05v0 w=8.2e-07 l=6e-07 nf=1 m=1
XM_178__325__i_3 vdd _018_ n_178__325__Z_neg vdd pfet_05v0 w=1.22e-06 l=5e-07 nf=1 m=1
XM_178__325__i_1_0 _147__6 n_178__325__Z_neg vdd vdd pfet_05v0 w=1.22e-06 l=5e-07 nf=1 m=1
XM_178__325__i_1_1 vdd n_178__325__Z_neg _147__6 vdd pfet_05v0 w=1.22e-06 l=5e-07 nf=1 m=1
XM_179__326__i_2 vss _017_ n_179__326__Z_neg vss nfet_05v0 w=8.2e-07 l=6e-07 nf=1 m=1
XM_179__326__i_0_0 _147__5 n_179__326__Z_neg vss vss nfet_05v0 w=8.2e-07 l=6e-07 nf=1 m=1
XM_179__326__i_0_1 vss n_179__326__Z_neg _147__5 vss nfet_05v0 w=8.2e-07 l=6e-07 nf=1 m=1
XM_179__326__i_3 vdd _017_ n_179__326__Z_neg vdd pfet_05v0 w=1.22e-06 l=5e-07 nf=1 m=1
XM_179__326__i_1_0 _147__5 n_179__326__Z_neg vdd vdd pfet_05v0 w=1.22e-06 l=5e-07 nf=1 m=1
XM_179__326__i_1_1 vdd n_179__326__Z_neg _147__5 vdd pfet_05v0 w=1.22e-06 l=5e-07 nf=1 m=1
XM_180__327__i_2 vss _016_ n_180__327__Z_neg vss nfet_05v0 w=8.2e-07 l=6e-07 nf=1 m=1
XM_180__327__i_0_0 _147__4 n_180__327__Z_neg vss vss nfet_05v0 w=8.2e-07 l=6e-07 nf=1 m=1
XM_180__327__i_0_1 vss n_180__327__Z_neg _147__4 vss nfet_05v0 w=8.2e-07 l=6e-07 nf=1 m=1
XM_180__327__i_3 vdd _016_ n_180__327__Z_neg vdd pfet_05v0 w=1.22e-06 l=5e-07 nf=1 m=1
XM_180__327__i_1_0 _147__4 n_180__327__Z_neg vdd vdd pfet_05v0 w=1.22e-06 l=5e-07 nf=1 m=1
XM_180__327__i_1_1 vdd n_180__327__Z_neg _147__4 vdd pfet_05v0 w=1.22e-06 l=5e-07 nf=1 m=1
XM_181__328__i_2 vss _015_ n_181__328__Z_neg vss nfet_05v0 w=8.2e-07 l=6e-07 nf=1 m=1
XM_181__328__i_0_0 _147__3 n_181__328__Z_neg vss vss nfet_05v0 w=8.2e-07 l=6e-07 nf=1 m=1
XM_181__328__i_0_1 vss n_181__328__Z_neg _147__3 vss nfet_05v0 w=8.2e-07 l=6e-07 nf=1 m=1
XM_181__328__i_3 vdd _015_ n_181__328__Z_neg vdd pfet_05v0 w=1.22e-06 l=5e-07 nf=1 m=1
XM_181__328__i_1_0 _147__3 n_181__328__Z_neg vdd vdd pfet_05v0 w=1.22e-06 l=5e-07 nf=1 m=1
XM_181__328__i_1_1 vdd n_181__328__Z_neg _147__3 vdd pfet_05v0 w=1.22e-06 l=5e-07 nf=1 m=1
XM_182__329__i_2 vss _014_ n_182__329__Z_neg vss nfet_05v0 w=8.2e-07 l=6e-07 nf=1 m=1
XM_182__329__i_0_0 _147__2 n_182__329__Z_neg vss vss nfet_05v0 w=8.2e-07 l=6e-07 nf=1 m=1
XM_182__329__i_0_1 vss n_182__329__Z_neg _147__2 vss nfet_05v0 w=8.2e-07 l=6e-07 nf=1 m=1
XM_182__329__i_3 vdd _014_ n_182__329__Z_neg vdd pfet_05v0 w=1.22e-06 l=5e-07 nf=1 m=1
XM_182__329__i_1_0 _147__2 n_182__329__Z_neg vdd vdd pfet_05v0 w=1.22e-06 l=5e-07 nf=1 m=1
XM_182__329__i_1_1 vdd n_182__329__Z_neg _147__2 vdd pfet_05v0 w=1.22e-06 l=5e-07 nf=1 m=1
XM_183__330__i_2 vss _013_ n_183__330__Z_neg vss nfet_05v0 w=8.2e-07 l=6e-07 nf=1 m=1
XM_183__330__i_0_0 _147__1 n_183__330__Z_neg vss vss nfet_05v0 w=8.2e-07 l=6e-07 nf=1 m=1
XM_183__330__i_0_1 vss n_183__330__Z_neg _147__1 vss nfet_05v0 w=8.2e-07 l=6e-07 nf=1 m=1
XM_183__330__i_3 vdd _013_ n_183__330__Z_neg vdd pfet_05v0 w=1.22e-06 l=5e-07 nf=1 m=1
XM_183__330__i_1_0 _147__1 n_183__330__Z_neg vdd vdd pfet_05v0 w=1.22e-06 l=5e-07 nf=1 m=1
XM_183__330__i_1_1 vdd n_183__330__Z_neg _147__1 vdd pfet_05v0 w=1.22e-06 l=5e-07 nf=1 m=1
XM_184__331__i_2 vss _010_ n_184__331__Z_neg vss nfet_05v0 w=8.2e-07 l=6e-07 nf=1 m=1
XM_184__331__i_0_0 _146__0 n_184__331__Z_neg vss vss nfet_05v0 w=8.2e-07 l=6e-07 nf=1 m=1
XM_184__331__i_0_1 vss n_184__331__Z_neg _146__0 vss nfet_05v0 w=8.2e-07 l=6e-07 nf=1 m=1
XM_184__331__i_3 vdd _010_ n_184__331__Z_neg vdd pfet_05v0 w=1.22e-06 l=5e-07 nf=1 m=1
XM_184__331__i_1_0 _146__0 n_184__331__Z_neg vdd vdd pfet_05v0 w=1.22e-06 l=5e-07 nf=1 m=1
XM_184__331__i_1_1 vdd n_184__331__Z_neg _146__0 vdd pfet_05v0 w=1.22e-06 l=5e-07 nf=1 m=1
XM_185__332__i_2 vss dsm_acc1_8 n_185__332__Z_neg vss nfet_05v0 w=8.2e-07 l=6e-07 nf=1 m=1
XM_185__332__i_0_0 _033_ n_185__332__Z_neg vss vss nfet_05v0 w=8.2e-07 l=6e-07 nf=1 m=1
XM_185__332__i_0_1 vss n_185__332__Z_neg _033_ vss nfet_05v0 w=8.2e-07 l=6e-07 nf=1 m=1
XM_185__332__i_3 vdd dsm_acc1_8 n_185__332__Z_neg vdd pfet_05v0 w=1.22e-06 l=5e-07 nf=1 m=1
XM_185__332__i_1_0 _033_ n_185__332__Z_neg vdd vdd pfet_05v0 w=1.22e-06 l=5e-07 nf=1 m=1
XM_185__332__i_1_1 vdd n_185__332__Z_neg _033_ vdd pfet_05v0 w=1.22e-06 l=5e-07 nf=1 m=1
XM_186__333__i_2 vss _000_ n_186__333__Z_neg vss nfet_05v0 w=8.2e-07 l=6e-07 nf=1 m=1
XM_186__333__i_0_0 _143__8 n_186__333__Z_neg vss vss nfet_05v0 w=8.2e-07 l=6e-07 nf=1 m=1
XM_186__333__i_0_1 vss n_186__333__Z_neg _143__8 vss nfet_05v0 w=8.2e-07 l=6e-07 nf=1 m=1
XM_186__333__i_3 vdd _000_ n_186__333__Z_neg vdd pfet_05v0 w=1.22e-06 l=5e-07 nf=1 m=1
XM_186__333__i_1_0 _143__8 n_186__333__Z_neg vdd vdd pfet_05v0 w=1.22e-06 l=5e-07 nf=1 m=1
XM_186__333__i_1_1 vdd n_186__333__Z_neg _143__8 vdd pfet_05v0 w=1.22e-06 l=5e-07 nf=1 m=1
XM_187__334__i_2 vss _024_ n_187__334__Z_neg vss nfet_05v0 w=8.2e-07 l=6e-07 nf=1 m=1
XM_187__334__i_0_0 dco_coarse_2 n_187__334__Z_neg vss vss nfet_05v0 w=8.2e-07 l=6e-07 nf=1 m=1
XM_187__334__i_0_1 vss n_187__334__Z_neg dco_coarse_2 vss nfet_05v0 w=8.2e-07 l=6e-07 nf=1 m=1
XM_187__334__i_3 vdd _024_ n_187__334__Z_neg vdd pfet_05v0 w=1.22e-06 l=5e-07 nf=1 m=1
XM_187__334__i_1_0 dco_coarse_2 n_187__334__Z_neg vdd vdd pfet_05v0 w=1.22e-06 l=5e-07 nf=1 m=1
XM_187__334__i_1_1 vdd n_187__334__Z_neg dco_coarse_2 vdd pfet_05v0 w=1.22e-06 l=5e-07 nf=1 m=1
XM_188__335__i_2 vss _023_ n_188__335__Z_neg vss nfet_05v0 w=8.2e-07 l=6e-07 nf=1 m=1
XM_188__335__i_0_0 dco_coarse_1 n_188__335__Z_neg vss vss nfet_05v0 w=8.2e-07 l=6e-07 nf=1 m=1
XM_188__335__i_0_1 vss n_188__335__Z_neg dco_coarse_1 vss nfet_05v0 w=8.2e-07 l=6e-07 nf=1 m=1
XM_188__335__i_3 vdd _023_ n_188__335__Z_neg vdd pfet_05v0 w=1.22e-06 l=5e-07 nf=1 m=1
XM_188__335__i_1_0 dco_coarse_1 n_188__335__Z_neg vdd vdd pfet_05v0 w=1.22e-06 l=5e-07 nf=1 m=1
XM_188__335__i_1_1 vdd n_188__335__Z_neg dco_coarse_1 vdd pfet_05v0 w=1.22e-06 l=5e-07 nf=1 m=1
XM_189__336__i_2 vss _022_ n_189__336__Z_neg vss nfet_05v0 w=8.2e-07 l=6e-07 nf=1 m=1
XM_189__336__i_0_0 dco_coarse_0 n_189__336__Z_neg vss vss nfet_05v0 w=8.2e-07 l=6e-07 nf=1 m=1
XM_189__336__i_0_1 vss n_189__336__Z_neg dco_coarse_0 vss nfet_05v0 w=8.2e-07 l=6e-07 nf=1 m=1
XM_189__336__i_3 vdd _022_ n_189__336__Z_neg vdd pfet_05v0 w=1.22e-06 l=5e-07 nf=1 m=1
XM_189__336__i_1_0 dco_coarse_0 n_189__336__Z_neg vdd vdd pfet_05v0 w=1.22e-06 l=5e-07 nf=1 m=1
XM_189__336__i_1_1 vdd n_189__336__Z_neg dco_coarse_0 vdd pfet_05v0 w=1.22e-06 l=5e-07 nf=1 m=1
XM_190__337__i_2 vss _001_ n_190__337__Z_neg vss nfet_05v0 w=8.2e-07 l=6e-07 nf=1 m=1
XM_190__337__i_0_0 _144__0 n_190__337__Z_neg vss vss nfet_05v0 w=8.2e-07 l=6e-07 nf=1 m=1
XM_190__337__i_0_1 vss n_190__337__Z_neg _144__0 vss nfet_05v0 w=8.2e-07 l=6e-07 nf=1 m=1
XM_190__337__i_3 vdd _001_ n_190__337__Z_neg vdd pfet_05v0 w=1.22e-06 l=5e-07 nf=1 m=1
XM_190__337__i_1_0 _144__0 n_190__337__Z_neg vdd vdd pfet_05v0 w=1.22e-06 l=5e-07 nf=1 m=1
XM_190__337__i_1_1 vdd n_190__337__Z_neg _144__0 vdd pfet_05v0 w=1.22e-06 l=5e-07 nf=1 m=1
XM_191__338__i_2 vss _009_ n_191__338__Z_neg vss nfet_05v0 w=8.2e-07 l=6e-07 nf=1 m=1
XM_191__338__i_0_0 _145__8 n_191__338__Z_neg vss vss nfet_05v0 w=8.2e-07 l=6e-07 nf=1 m=1
XM_191__338__i_0_1 vss n_191__338__Z_neg _145__8 vss nfet_05v0 w=8.2e-07 l=6e-07 nf=1 m=1
XM_191__338__i_3 vdd _009_ n_191__338__Z_neg vdd pfet_05v0 w=1.22e-06 l=5e-07 nf=1 m=1
XM_191__338__i_1_0 _145__8 n_191__338__Z_neg vdd vdd pfet_05v0 w=1.22e-06 l=5e-07 nf=1 m=1
XM_191__338__i_1_1 vdd n_191__338__Z_neg _145__8 vdd pfet_05v0 w=1.22e-06 l=5e-07 nf=1 m=1
XM_192_clkbuf_0_clk_ref_i_2_1 vss clk_ref n_192_clkbuf_0_clk_ref_Z_neg vss nfet_05v0 w=6.05e-07 l=6e-07 nf=1 m=1
XM_192_clkbuf_0_clk_ref_i_0_0 clknet_0_clk_ref n_192_clkbuf_0_clk_ref_Z_neg vss vss nfet_05v0 w=4.55e-07 l=6e-07 nf=1 m=1
XM_192_clkbuf_0_clk_ref_i_0_1 vss n_192_clkbuf_0_clk_ref_Z_neg clknet_0_clk_ref vss nfet_05v0 w=4.55e-07 l=6e-07 nf=1 m=1
XM_192_clkbuf_0_clk_ref_i_0_2 clknet_0_clk_ref n_192_clkbuf_0_clk_ref_Z_neg vss vss nfet_05v0 w=4.55e-07 l=6e-07 nf=1 m=1
XM_192_clkbuf_0_clk_ref_i_0_3 vss n_192_clkbuf_0_clk_ref_Z_neg clknet_0_clk_ref vss nfet_05v0 w=4.55e-07 l=6e-07 nf=1 m=1
XM_192_clkbuf_0_clk_ref_i_3_0 n_192_clkbuf_0_clk_ref_Z_neg clk_ref vdd vdd pfet_05v0 w=0.82e-06 l=5e-07 nf=1 m=1
XM_192_clkbuf_0_clk_ref_i_3_1 vdd clk_ref n_192_clkbuf_0_clk_ref_Z_neg vdd pfet_05v0 w=0.82e-06 l=5e-07 nf=1 m=1
XM_192_clkbuf_0_clk_ref_i_1_0 clknet_0_clk_ref n_192_clkbuf_0_clk_ref_Z_neg vdd vdd pfet_05v0 w=1.22e-06 l=5e-07 nf=1 m=1
XM_192_clkbuf_0_clk_ref_i_1_1 vdd n_192_clkbuf_0_clk_ref_Z_neg clknet_0_clk_ref vdd pfet_05v0 w=1.22e-06 l=5e-07 nf=1 m=1
XM_192_clkbuf_0_clk_ref_i_1_2 clknet_0_clk_ref n_192_clkbuf_0_clk_ref_Z_neg vdd vdd pfet_05v0 w=1.22e-06 l=5e-07 nf=1 m=1
XM_192_clkbuf_0_clk_ref_i_1_3 vdd n_192_clkbuf_0_clk_ref_Z_neg clknet_0_clk_ref vdd pfet_05v0 w=1.22e-06 l=5e-07 nf=1 m=1
XM_193_clkbuf_1_0__f_clk_ref_i_2_1 vss clknet_0_clk_ref n_193_clkbuf_1_0__f_clk_ref_Z_neg vss nfet_05v0 w=6.05e-07 l=6e-07 nf=1 m=1
XM_193_clkbuf_1_0__f_clk_ref_i_0_0 clknet_1_0__leaf_clk_ref n_193_clkbuf_1_0__f_clk_ref_Z_neg vss vss nfet_05v0 w=4.55e-07 l=6e-07 nf=1 m=1
XM_193_clkbuf_1_0__f_clk_ref_i_0_1 vss n_193_clkbuf_1_0__f_clk_ref_Z_neg clknet_1_0__leaf_clk_ref vss nfet_05v0 w=4.55e-07 l=6e-07 nf=1 m=1
XM_193_clkbuf_1_0__f_clk_ref_i_0_2 clknet_1_0__leaf_clk_ref n_193_clkbuf_1_0__f_clk_ref_Z_neg vss vss nfet_05v0 w=4.55e-07 l=6e-07 nf=1 m=1
XM_193_clkbuf_1_0__f_clk_ref_i_0_3 vss n_193_clkbuf_1_0__f_clk_ref_Z_neg clknet_1_0__leaf_clk_ref vss nfet_05v0 w=4.55e-07 l=6e-07 nf=1 m=1
XM_193_clkbuf_1_0__f_clk_ref_i_3_0 n_193_clkbuf_1_0__f_clk_ref_Z_neg clknet_0_clk_ref vdd vdd pfet_05v0 w=0.82e-06 l=5e-07 nf=1 m=1
XM_193_clkbuf_1_0__f_clk_ref_i_3_1 vdd clknet_0_clk_ref n_193_clkbuf_1_0__f_clk_ref_Z_neg vdd pfet_05v0 w=0.82e-06 l=5e-07 nf=1 m=1
XM_193_clkbuf_1_0__f_clk_ref_i_1_0 clknet_1_0__leaf_clk_ref n_193_clkbuf_1_0__f_clk_ref_Z_neg vdd vdd pfet_05v0 w=1.22e-06 l=5e-07 nf=1 m=1
XM_193_clkbuf_1_0__f_clk_ref_i_1_1 vdd n_193_clkbuf_1_0__f_clk_ref_Z_neg clknet_1_0__leaf_clk_ref vdd pfet_05v0 w=1.22e-06 l=5e-07 nf=1 m=1
XM_193_clkbuf_1_0__f_clk_ref_i_1_2 clknet_1_0__leaf_clk_ref n_193_clkbuf_1_0__f_clk_ref_Z_neg vdd vdd pfet_05v0 w=1.22e-06 l=5e-07 nf=1 m=1
XM_193_clkbuf_1_0__f_clk_ref_i_1_3 vdd n_193_clkbuf_1_0__f_clk_ref_Z_neg clknet_1_0__leaf_clk_ref vdd pfet_05v0 w=1.22e-06 l=5e-07 nf=1 m=1
XM_194_clkbuf_1_1__f_clk_ref_i_2_1 vss clknet_0_clk_ref n_194_clkbuf_1_1__f_clk_ref_Z_neg vss nfet_05v0 w=6.05e-07 l=6e-07 nf=1 m=1
XM_194_clkbuf_1_1__f_clk_ref_i_0_0 clknet_1_1__leaf_clk_ref n_194_clkbuf_1_1__f_clk_ref_Z_neg vss vss nfet_05v0 w=4.55e-07 l=6e-07 nf=1 m=1
XM_194_clkbuf_1_1__f_clk_ref_i_0_1 vss n_194_clkbuf_1_1__f_clk_ref_Z_neg clknet_1_1__leaf_clk_ref vss nfet_05v0 w=4.55e-07 l=6e-07 nf=1 m=1
XM_194_clkbuf_1_1__f_clk_ref_i_0_2 clknet_1_1__leaf_clk_ref n_194_clkbuf_1_1__f_clk_ref_Z_neg vss vss nfet_05v0 w=4.55e-07 l=6e-07 nf=1 m=1
XM_194_clkbuf_1_1__f_clk_ref_i_0_3 vss n_194_clkbuf_1_1__f_clk_ref_Z_neg clknet_1_1__leaf_clk_ref vss nfet_05v0 w=4.55e-07 l=6e-07 nf=1 m=1
XM_194_clkbuf_1_1__f_clk_ref_i_3_0 n_194_clkbuf_1_1__f_clk_ref_Z_neg clknet_0_clk_ref vdd vdd pfet_05v0 w=0.82e-06 l=5e-07 nf=1 m=1
XM_194_clkbuf_1_1__f_clk_ref_i_3_1 vdd clknet_0_clk_ref n_194_clkbuf_1_1__f_clk_ref_Z_neg vdd pfet_05v0 w=0.82e-06 l=5e-07 nf=1 m=1
XM_194_clkbuf_1_1__f_clk_ref_i_1_0 clknet_1_1__leaf_clk_ref n_194_clkbuf_1_1__f_clk_ref_Z_neg vdd vdd pfet_05v0 w=1.22e-06 l=5e-07 nf=1 m=1
XM_194_clkbuf_1_1__f_clk_ref_i_1_1 vdd n_194_clkbuf_1_1__f_clk_ref_Z_neg clknet_1_1__leaf_clk_ref vdd pfet_05v0 w=1.22e-06 l=5e-07 nf=1 m=1
XM_194_clkbuf_1_1__f_clk_ref_i_1_2 clknet_1_1__leaf_clk_ref n_194_clkbuf_1_1__f_clk_ref_Z_neg vdd vdd pfet_05v0 w=1.22e-06 l=5e-07 nf=1 m=1
XM_194_clkbuf_1_1__f_clk_ref_i_1_3 vdd n_194_clkbuf_1_1__f_clk_ref_Z_neg clknet_1_1__leaf_clk_ref vdd pfet_05v0 w=1.22e-06 l=5e-07 nf=1 m=1
.ends dlf_pi_dsm

* Magic 8.3 RC post-PEX extracted core subcircuit for ad_pll_1v8_1p2g
.subckt pll_core_ad_pll_1v8_1p2g vdd vss fref fb_div vctrl b0 b1 b2 out outn
X0 outn a_4377_5390# a_935_3763# vss nfet_03v3 ad=1.344p pd=5.36u as=1.344p ps=5.36u w=4.8u l=0.44u nf=1
X1 vdd vss out vdd pfet_03v3 ad=1.176p pd=4.76u as=2.52p ps=9.6u w=4.2u l=0.44u nf=1
X2 a_1589_855# fref cap_mim_2f0fF c_width=5.84u c_length=5.84u
X3 outn a_4377_5390# a_935_3763# vss nfet_03v3 ad=1.344p pd=5.36u as=1.344p ps=5.36u w=4.8u l=0.44u nf=1
X4 vss vdd a_935_3763# vss nfet_03v3 ad=1.176p pd=4.76u as=1.176p ps=4.76u w=4.2u l=0.7u nf=1
X5 vdd vss a_3977_5610# vdd pfet_03v3 ad=1.176p pd=4.76u as=2.52p ps=9.6u w=4.2u l=0.44u nf=1
X6 a_1504_8640# out a_935_3763# vss nfet_03v3 ad=1.344p pd=5.36u as=1.344p ps=5.36u w=4.8u l=0.44u nf=1
X7 vss vctrl a_935_3763# vss nfet_03v3 ad=2.52p pd=9.6u as=1.176p ps=4.76u w=4.2u l=0.7u nf=1
X8 a_3977_5610# a_1504_8640# a_935_3763# vss nfet_03v3 ad=1.344p pd=5.36u as=2.88p ps=10.8u w=4.8u l=0.44u nf=1
X9 a_935_3763# a_1504_10245# a_4377_5390# vss nfet_03v3 ad=1.344p pd=5.36u as=1.344p ps=5.36u w=4.8u l=0.44u nf=1
X10 vctrl fb_div a_1589_855# vss nfet_03v3 ad=2.52p pd=9.6u as=2.52p ps=9.6u w=4.2u l=0.7u nf=1
X11 a_935_3763# out a_1504_8640# vss nfet_03v3 ad=1.344p pd=5.36u as=1.344p ps=5.36u w=4.8u l=0.44u nf=1
X12 a_1589_855# fref cap_mim_2f0fF c_width=5.84u c_length=5.84u
X13 a_935_3763# outn a_1504_10245# vss nfet_03v3 ad=1.344p pd=5.36u as=1.344p ps=5.36u w=4.8u l=0.44u nf=1
X14 a_935_3763# outn a_1504_10245# vss nfet_03v3 ad=1.344p pd=5.36u as=1.344p ps=5.36u w=4.8u l=0.44u nf=1
X15 a_4377_5390# a_1504_10245# a_935_3763# vss nfet_03v3 ad=1.344p pd=5.36u as=1.344p ps=5.36u w=4.8u l=0.44u nf=1
X16 a_935_3763# b2 vss vss nfet_03v3 ad=2.52p pd=9.6u as=2.52p ps=9.6u w=4.2u l=0.7u nf=1
X17 a_1504_8640# out a_935_3763# vss nfet_03v3 ad=1.344p pd=5.36u as=2.88p ps=10.8u w=4.8u l=0.44u nf=1
X18 a_935_3763# b1 vss vss nfet_03v3 ad=2.52p pd=9.6u as=1.176p ps=4.76u w=4.2u l=0.7u nf=1
X19 vdd a_1504_8640# vss ppolyf_u_1k r_width=1.5u r_length=3.14u
X20 out a_3977_5610# a_935_3763# vss nfet_03v3 ad=1.344p pd=5.36u as=1.344p ps=5.36u w=4.8u l=0.44u nf=1
X21 outn vss vdd vdd pfet_03v3 ad=2.52p pd=9.6u as=1.176p ps=4.76u w=4.2u l=0.44u nf=1
X22 a_1589_855# fref cap_mim_2f0fF c_width=5.84u c_length=5.84u
X23 vss b2 a_935_3763# vss nfet_03v3 ad=2.52p pd=9.6u as=1.176p ps=4.76u w=4.2u l=0.7u nf=1
X24 a_935_3763# a_3977_5610# out vss nfet_03v3 ad=1.344p pd=5.36u as=1.344p ps=5.36u w=4.8u l=0.44u nf=1
X25 vdd a_1504_10245# vss ppolyf_u_1k r_width=1.5u r_length=3.14u
X26 a_935_3763# a_4377_5390# outn vss nfet_03v3 ad=1.344p pd=5.36u as=1.344p ps=5.36u w=4.8u l=0.44u nf=1
X27 a_935_3763# a_4377_5390# outn vss nfet_03v3 ad=1.344p pd=5.36u as=1.344p ps=5.36u w=4.8u l=0.44u nf=1
X28 a_935_3763# a_1504_10245# a_4377_5390# vss nfet_03v3 ad=1.344p pd=5.36u as=1.344p ps=5.36u w=4.8u l=0.44u nf=1
X29 a_935_3763# b1 vss vss nfet_03v3 ad=1.176p pd=4.76u as=2.52p ps=9.6u w=4.2u l=0.7u nf=1
X30 a_935_3763# vctrl vss vss nfet_03v3 ad=1.176p pd=4.76u as=1.176p ps=4.76u w=4.2u l=0.7u nf=1
X31 a_935_3763# out a_1504_8640# vss nfet_03v3 ad=2.88p pd=10.8u as=1.344p ps=5.36u w=4.8u l=0.44u nf=1
X32 out a_3977_5610# a_935_3763# vss nfet_03v3 ad=1.344p pd=5.36u as=2.88p ps=10.8u w=4.8u l=0.44u nf=1
X33 a_1589_855# fref cap_mim_2f0fF c_width=5.84u c_length=5.84u
X34 a_1504_10245# outn a_935_3763# vss nfet_03v3 ad=1.344p pd=5.36u as=1.344p ps=5.36u w=4.8u l=0.44u nf=1
X35 a_935_3763# a_1504_8640# a_3977_5610# vss nfet_03v3 ad=2.88p pd=10.8u as=1.344p ps=5.36u w=4.8u l=0.44u nf=1
X36 a_1504_10245# outn a_935_3763# vss nfet_03v3 ad=1.344p pd=5.36u as=1.344p ps=5.36u w=4.8u l=0.44u nf=1
X37 a_4377_5390# a_1504_10245# a_935_3763# vss nfet_03v3 ad=1.344p pd=5.36u as=1.344p ps=5.36u w=4.8u l=0.44u nf=1
X38 vss b0 a_935_3763# vss nfet_03v3 ad=1.176p pd=4.76u as=1.176p ps=4.76u w=4.2u l=0.7u nf=1
X39 a_935_3763# vctrl vss vss nfet_03v3 ad=1.176p pd=4.76u as=2.52p ps=9.6u w=4.2u l=0.7u nf=1
X40 a_3977_5610# a_1504_8640# a_935_3763# vss nfet_03v3 ad=1.344p pd=5.36u as=1.344p ps=5.36u w=4.8u l=0.44u nf=1
X41 a_935_3763# a_3977_5610# out vss nfet_03v3 ad=2.88p pd=10.8u as=1.344p ps=5.36u w=4.8u l=0.44u nf=1
X42 a_4377_5390# vss vdd vdd pfet_03v3 ad=2.52p pd=9.6u as=1.176p ps=4.76u w=4.2u l=0.44u nf=1
X43 a_935_3763# a_1504_8640# a_3977_5610# vss nfet_03v3 ad=1.344p pd=5.36u as=1.344p ps=5.36u w=4.8u l=0.44u nf=1
X44 a_935_3763# b2 vss vss nfet_03v3 ad=1.176p pd=4.76u as=2.52p ps=9.6u w=4.2u l=0.7u nf=1
C0 a_1504_10245# vdd 0.43763f
C1 a_1504_10245# a_4377_5390# 0.37141f
C2 outn a_1504_10245# 0.35504f
C3 b2 fb_div 0.55351f
C4 out vdd 2.02899f
C5 a_3977_5610# vdd 1.88788f
C6 a_1589_855# a_935_3763# 1.16387f
C7 out a_4377_5390# 0.86826f
C8 a_3977_5610# a_4377_5390# 6.65512f
C9 a_935_3763# b0 0.11235f
C10 out outn 5.46006f
C11 outn a_3977_5610# 0.71502f
C12 a_1589_855# vctrl 0.58795f
C13 a_1589_855# vdd 0.20756f
C14 a_1504_8640# a_935_3763# 5.90653f
C15 outn a_1589_855# 0.01584f
C16 fref vdd 0.02131f
C17 b2 a_1589_855# 0.05393f
C18 a_1504_8640# vdd 0.6859f
C19 a_1504_8640# a_4377_5390# 0.08718f
C20 fref outn 0.2006f
C21 a_935_3763# vctrl 1.28667f
C22 a_935_3763# vdd 1.79054f
C23 a_935_3763# a_4377_5390# 3.84517f
C24 out a_1504_10245# 0.07093f
C25 outn a_935_3763# 3.8512f
C26 fb_div a_1589_855# 0.12293f
C27 out a_3977_5610# 1.85479f
C28 b2 a_935_3763# 0.41514f
C29 vctrl vdd 1.06327f
C30 vdd a_4377_5390# 2.11082f
C31 b1 b0 0.37417f
C32 outn vdd 2.16089f
C33 outn a_4377_5390# 0.47829f
C34 b2 vctrl 0.03604f
C35 out a_1589_855# 0.03226f
C36 a_1504_8640# a_1504_10245# 2.94311f
C37 out fref 0.11703f
C38 out a_1504_8640# 0.4856f
C39 b1 a_935_3763# 0.28911f
C40 a_1504_8640# a_3977_5610# 0.48798f
C41 a_1504_10245# a_935_3763# 4.35035f
C42 fb_div vctrl 0.10849f
C43 out a_935_3763# 4.86641f
C44 a_935_3763# a_3977_5610# 4.85361f
C45 fref a_1589_855# 3.04517f
C46 fref vss 3.75194f
C47 fb_div vss 1.52033f
C48 b2 vss 1.81746f
C49 vctrl vss 4.53977f
C50 b0 vss 1.24275f
C51 b1 vss 1.19694f
C52 outn vss 6.62384f
C53 out vss 4.22919f
C54 vdd vss 28.6746f
C55 a_1589_855# vss 8.09884f
C56 a_4377_5390# vss 6.13582f
C57 a_3977_5610# vss 4.22826f
C58 a_935_3763# vss 22.194f
C59 a_1504_10245# vss 6.34426f
C60 a_1504_8640# vss 4.29118f
.ends pll_core_ad_pll_1v8_1p2g

* Full hierarchical PLL macro netlist (pll_ad_pll_1v8_1p2g, POST-PEX)
.subckt pll_ad_pll_1v8_1p2g vdd vss fref fb_div vctrl b0 b1 b2 out outn
Xcore vdd vss fref fb_div vctrl b0 b1 b2 out outn pll_core_ad_pll_1v8_1p2g
Xdig fref net_dig_en net_sa_outp_0 net_sa_outp_1 net_sa_outp_2 net_sa_outp_3 net_sa_outp_4 net_dco_c0 net_dco_c1 net_dco_c2 net_dsm_out vdd vss dlf_pi_dsm
Xvco vdd vss net_aux_vco_p net_aux_vco_n net_dco_c0 net_dco_c1 net_dco_c2 cml_dco_idac_n3_1v8_1p2g
Xdiv_0 vdd vss net_ls_out net_aux_vco_n net_div_out_p net_div_out_n net_div_ibias div_cml_div2_1v8_1p5g
Xiref vdd vss net_iref net_vbias b0 b1 b2 bm_lv_cascode_1v8_10u
Xidac_0 vdd vss net_iref net_div_ibias cm_cascode_1v8_8u
Xtcap_0 vdd vss net_lf_aux net_dco_c0 net_dco_c1 net_dco_c2 tcap_var_sw_cap_gnd_1v8_1p6p
Xtcap_1 vdd vss net_lf_aux net_dco_c0 net_dco_c1 net_dco_c2 tcap_var_sw_cap_gnd_1v8_1p6p
Xtcap_2 vdd vss net_sw_out_0 net_dco_c0 net_dco_c1 net_dco_c2 tcap_var_sw_cap_gnd_1v8_1p6p
Xtcap_3 vdd vss net_sw_out_1 net_dco_c0 net_dco_c1 net_dco_c2 tcap_var_sw_cap_gnd_1v8_1p6p
Xdl_0 vdd vss fref dl_out_0 dl_tap1_0 net_dig_en dl_cmos_tap_1v8_1p0n
Xsw_0 vctrl net_sw_out_0 net_dsm_out vdd vss nmos__1p8v__10u_100u
Xsw_1 net_vbias net_sw_out_1 net_dsm_out vdd vss nmos__1p8v__10u_100u
Xsa_0 net_div_out_p net_div_out_n fb_div dl_out_0 net_sa_outp_0 net_sa_chain_0 vdd vdd vss comp
Xsa_1 dl_tap1_0 net_div_out_n fb_div dl_out_0 net_sa_outp_1 net_sa_chain_1 vdd vdd vss comp
Xsa_2 net_div_out_p net_div_out_n fb_div dl_out_0 net_sa_outp_2 net_sa_chain_2 vdd vdd vss comp
Xsa_3 dl_tap1_0 net_div_out_n fb_div dl_out_0 net_sa_outp_3 net_sa_chain_3 vdd vdd vss comp
Xsa_4 net_div_out_p net_div_out_n fb_div dl_out_0 net_sa_outp_4 net_sa_chain_4 vdd vdd vss comp
Xsa_5 net_sa_chain_0 net_div_out_n fb_div dl_out_0 net_sa_chain_5 net_sa_outn_5 vdd vdd vss comp
Xsa_6 net_sa_chain_1 net_div_out_n fb_div dl_out_0 net_sa_chain_6 net_sa_outn_6 vdd vdd vss comp
Xsa_7 net_sa_chain_2 net_div_out_n fb_div dl_out_0 net_sa_chain_7 net_sa_outn_7 vdd vdd vss comp
Xsa_8 net_sa_chain_3 net_div_out_n fb_div dl_out_0 net_sa_chain_8 net_sa_outn_8 vdd vdd vss comp
Xsa_9 net_sa_chain_4 net_div_out_n fb_div dl_out_0 net_sa_chain_9 net_sa_outn_9 vdd vdd vss comp
Xsa_10 net_sa_chain_5 net_div_out_n fb_div dl_out_0 net_sa_last_in net_sa_outn_10 vdd vdd vss comp
Xsa_11 net_sa_chain_6 net_div_out_n fb_div dl_out_0 net_sa_outp_11 net_sa_outn_11 vdd vdd vss comp
Xsa_12 net_sa_chain_7 net_div_out_n fb_div dl_out_0 net_sa_outp_12 net_sa_outn_12 vdd vdd vss comp
Xsa_13 net_sa_chain_8 net_div_out_n fb_div dl_out_0 net_sa_outp_13 net_sa_outn_13 vdd vdd vss comp
Xsa_14 net_sa_chain_9 net_div_out_n fb_div dl_out_0 net_sa_outp_14 net_sa_outn_14 vdd vdd vss comp
Xsa_15 net_sa_last_in net_div_out_n fb_div dl_out_0 net_sa_outp_15 net_sa_outn_15 vdd vdd vss comp
Xls net_aux_vco_p net_ls_out vdd vss vdd vss TOP1_DCVS
* On-chip VDD-VSS CMOS decoupling capacitor whitespace fill
Xdecap_0 vdd vss pll_decap_lg
Xdecap_1 vdd vss pll_decap_lg
Xdecap_2 vdd vss pll_decap_lg
Xdecap_3 vdd vss pll_decap_lg
Xdecap_4 vdd vss pll_decap_lg
Xdecap_5 vdd vss pll_decap_lg
Xdecap_6 vdd vss pll_decap_lg
Xdecap_7 vdd vss pll_decap_lg
Xdecap_8 vdd vss pll_decap_lg
Xdecap_9 vdd vss pll_decap_lg
Xdecap_10 vdd vss pll_decap_sm
Xdecap_11 vdd vss pll_decap_sm
Xdecap_12 vdd vss pll_decap_sm
Xdecap_13 vdd vss pll_decap_sm
Xdecap_14 vdd vss pll_decap_sm
Xdecap_15 vdd vss pll_decap_sm
Xdecap_16 vdd vss pll_decap_sm
Xdecap_17 vdd vss pll_decap_sm
Xdecap_18 vdd vss pll_decap_sm
Xdecap_19 vdd vss pll_decap_sm
Xdecap_20 vdd vss pll_decap_sm
Xdecap_21 vdd vss pll_decap_sm
Xdecap_22 vdd vss pll_decap_sm
Xdecap_23 vdd vss pll_decap_sm
Xdecap_24 vdd vss pll_decap_sm
Xdecap_25 vdd vss pll_decap_sm
Xdecap_26 vdd vss pll_decap_sm
Xdecap_27 vdd vss pll_decap_sm
Xdecap_28 vdd vss pll_decap_sm
Xdecap_29 vdd vss pll_decap_sm
Xdecap_30 vdd vss pll_decap_sm
Xdecap_31 vdd vss pll_decap_sm
Xdecap_32 vdd vss pll_decap_sm
Xdecap_33 vdd vss pll_decap_sm
Xdecap_34 vdd vss pll_decap_sm
Xdecap_35 vdd vss pll_decap_sm
Xdecap_36 vdd vss pll_decap_sm
Xdecap_37 vdd vss pll_decap_sm
* Top-level inter-macro routing RC parasitics
Ctop_rt_0 b0 vss 14.5870f
Ctop_rt_1 b1 vss 14.9275f
Ctop_rt_2 b2 vss 6.7893f
Ctop_rt_3 dl_out_0 vss 64.5332f
Ctop_rt_4 dl_tap1_0 vss 34.7110f
Ctop_rt_5 fb_div vss 42.9663f
Ctop_rt_6 fref vss 35.7044f
Ctop_rt_7 net_aux_vco_p vss 2.9464f
Ctop_rt_8 net_dco_c0 vss 7.3262f
Ctop_rt_9 net_dco_c1 vss 5.5846f
Ctop_rt_10 net_dco_c2 vss 6.2242f
Ctop_rt_11 net_dig_en vss 0.2918f
Ctop_rt_12 net_div_ibias vss 11.1890f
Ctop_rt_13 net_div_out_n vss 58.4508f
Ctop_rt_14 net_div_out_p vss 23.1549f
Ctop_rt_15 net_dsm_out vss 9.4017f
Ctop_rt_16 net_ls_out vss 4.2969f
Ctop_rt_17 net_sa_chain_0 vss 21.4768f
Ctop_rt_18 net_sa_chain_1 vss 1.5280f
Ctop_rt_19 net_sa_chain_2 vss 12.0845f
Ctop_rt_20 net_sa_chain_3 vss 14.9580f
Ctop_rt_21 net_sa_chain_4 vss 10.4011f
Ctop_rt_22 net_sa_chain_5 vss 20.7782f
Ctop_rt_23 net_sa_chain_6 vss 16.4689f
Ctop_rt_24 net_sa_chain_7 vss 25.9155f
Ctop_rt_25 net_sa_chain_8 vss 9.7323f
Ctop_rt_26 net_sa_chain_9 vss 21.5123f
Ctop_rt_27 net_sa_last_in vss 10.0732f
Ctop_rt_28 net_sa_outp_0 vss 31.8957f
Ctop_rt_29 net_sa_outp_1 vss 26.7897f
Ctop_rt_30 net_sa_outp_2 vss 13.6772f
Ctop_rt_31 net_sa_outp_3 vss 31.7277f
Ctop_rt_32 net_sa_outp_4 vss 10.0699f
Ctop_rt_33 net_sw_out_0 vss 8.0564f
Ctop_rt_34 net_sw_out_1 vss 0.0671f
Ctop_rt_35 net_vbias vss 0.4562f
Ctop_rt_36 out vss 0.9933f
Ctop_rt_37 outn vss 0.8446f
Ctop_rt_38 vctrl vss 17.7726f
.ends pll_ad_pll_1v8_1p2g
