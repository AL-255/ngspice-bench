* opa1000[0485]: 2p/nmos_miller_3v3_i1u_weak (nmos_miller, VDD=3.3V, CL=2.0pF, Iref=0.15uA)
.include "pdk_opa.inc"
.temp 27
.option gmin=1e-12 rshunt=1e12 reltol=1e-3 abstol=1e-12 vntol=1e-5 method=gear
* Post-PEX R+C extracted netlist for nmos_miller_3v3_i1u_weak
.subckt opamp_dut vdd vss inp inn out ib
XMpar0 a_6626_4634.t0 ib.t0 vss.t2 vss.t1 nfet_03v3 w=0.4u l=3.5u ad=2.4000e-13 pd=2.0000e-06 as=1.1200e-13 ps=9.6000e-07 nf=1 m=4 par=4
XMpar1 out.t2 ib.t0 vss.t2 vss.t1 nfet_03v3 w=0.4u l=3.5u ad=1.8880e-13 pd=1.5840e-06 as=1.6320e-13 ps=1.3760e-06 nf=1 m=10 par=10
XMpar2 out.t0 a_1236_8756.t5 vdd.t1 vdd.t0 pfet_03v3 w=0.85u l=1.8u ad=2.9240e-13 pd=1.7080e-06 as=3.4680e-13 ps=2.0060e-06 nf=1 m=10 par=10
XMpar3 a_6852_6756.t1 a_6852_6756.t0 vdd.t1 vdd.t0 pfet_03v3 w=0.85u l=1.8u ad=2.3800e-13 pd=1.4100e-06 as=2.3800e-13 ps=1.4100e-06 nf=1 m=2 par=2
XMpar4 a_1236_8756.t1 a_6852_6756.t0 vdd.t1 vdd.t0 pfet_03v3 w=0.85u l=1.8u ad=5.1000e-13 pd=2.9000e-06 as=2.3800e-13 ps=1.4100e-06 nf=1 m=2 par=2
XMpar5 ib.t1 ib.t0 vss.t2 vss.t1 nfet_03v3 w=0.4u l=3.5u ad=2.4000e-13 pd=2.0000e-06 as=1.1200e-13 ps=9.6000e-07 nf=1 m=2 par=2
XMpar6 a_1236_8756.t3 inp.t0 a_6626_4634.t4 vss.t27 nfet_03v3 w=0.62u l=3.2u ad=3.7200e-13 pd=2.4400e-06 as=3.7200e-13 ps=2.4400e-06 nf=1 m=2 par=2
XMpar7 a_6626_4634.t4 inn.t0 a_6852_6756.t4 vss.t27 nfet_03v3 w=0.62u l=3.2u ad=3.7200e-13 pd=2.4400e-06 as=3.7200e-13 ps=2.4400e-06 nf=1 m=2 par=2
X2 a_1236_11356.t1 out.t14 cap_mim_2f0fF c_width=15.29u c_length=15.29u
X3 a_1236_9276.t0 a_5200_9796.t0 vss.t0 ppolyf_u_1k r_width=1u r_length=19.16u
X6 a_1236_11356.t0 a_5200_10836.t0 vss.t0 ppolyf_u_1k r_width=1u r_length=19.16u
X9 a_1236_9276.t0 a_5200_8756.t0 vss.t0 ppolyf_u_1k r_width=1u r_length=19.16u
X14 a_1236_10316.t0 a_5200_10836.t0 vss.t0 ppolyf_u_1k r_width=1u r_length=19.16u
X15 a_1236_8756.t0 a_5200_8756.t0 vss.t0 ppolyf_u_1k r_width=1u r_length=19.16u
X22 a_1236_10316.t0 a_5200_9796.t0 vss.t0 ppolyf_u_1k r_width=1u r_length=19.16u
X40 a_1236_11356.t1 out.t14 cap_mim_2f0fF c_width=15.29u c_length=15.29u
Rpar0 a_1236_11356.t0 a_1236_11356.t1 71.2399
Rpar1 a_1236_8756.t0 a_1236_8756.t1 76.7895
Rpar2 a_1236_8756.t0 a_1236_8756.t5 291.4243
Rpar3 a_1236_8756.t0 a_1236_8756.t3 168.4572
Rpar4 a_1236_8756.t1 a_1236_8756.t5 138.0538
Rpar5 a_1236_8756.t1 a_1236_8756.t3 79.8017
Rpar6 a_1236_8756.t5 a_1236_8756.t3 81.4134
Rpar7 a_6626_4634.t0 a_6626_4634.t4 52.1951
Rpar8 a_6852_6756.t0 a_6852_6756.t1 28.6194
Rpar9 a_6852_6756.t0 a_6852_6756.t4 101.1417
Rpar10 a_6852_6756.t1 a_6852_6756.t4 85.9026
Rpar11 ib ib.t0 14.4639
Rpar12 ib ib.t1 14.6953
Rpar13 ib.t0 ib.t1 34.2160
Rpar14 inn inn.t0 4.8759
Rpar15 inp inp.t0 4.8755
Rpar16 out out.t0 136.0138
Rpar17 out out.t2 142.5482
Rpar18 out out.t14 21.8003
Rpar19 out.t0 out.t2 61.2397
Rpar20 out.t0 out.t14 867.7003
Rpar21 out.t2 out.t14 909.3864
Rpar22 vdd vdd.t0 44.5948
Rpar23 vdd vdd.t1 319.0477
Rpar24 vdd.t0 vdd.t1 5.6336
Rpar25 vss vss.t0 992.3077
Rpar26 vss vss.t1 98.7485
Rpar27 vss vss.t2 55.2788
Rpar28 vss vss.t27 404.0746
Rpar29 vss.t0 vss.t1 108.6833
Rpar30 vss.t0 vss.t2 583.4842
Rpar31 vss.t0 vss.t27 411.6181
Rpar32 vss.t1 vss.t2 13.9856
Rpar33 vss.t1 vss.t27 4.6022
Rpar34 vss.t2 vss.t27 64.6792
Cpar0 a_1236_10316.t0 vss 3.92800e-17
Cpar1 a_1236_11356.t0 vss 1.03297e-16
Cpar2 a_1236_11356.t1 vss 4.70266e-15
Cpar3 a_1236_8756.t0 vss 2.75682e-15
Cpar4 a_1236_8756.t1 vss 3.11629e-15
Cpar5 a_1236_8756.t3 vss 3.36979e-15
Cpar6 a_1236_8756.t5 vss 1.35798e-14
Cpar7 a_1236_9276.t0 vss 3.92800e-17
Cpar8 a_5200_10836.t0 vss 3.00000e-17
Cpar9 a_5200_8756.t0 vss 3.42200e-17
Cpar10 a_5200_9796.t0 vss 3.43800e-17
Cpar11 a_6626_4634.t0 vss 1.30595e-14
Cpar12 a_6626_4634.t4 vss 7.46290e-15
Cpar13 a_6852_6756.t0 vss 5.88641e-15
Cpar14 a_6852_6756.t1 vss 1.90861e-15
Cpar15 a_6852_6756.t4 vss 3.39824e-15
Cpar16 ib out 2.20926e-15
Cpar17 ib vss 4.41094e-14
Cpar18 ib.t0 vss 7.34799e-15
Cpar19 ib.t1 vss 6.06381e-16
Cpar20 inn inp 1.03090e-16
Cpar21 inn vss 4.57658e-15
Cpar22 inn.t0 vss 8.84610e-16
Cpar23 inp vss 4.60738e-15
Cpar24 inp.t0 vss 8.95490e-16
Cpar25 out vdd 1.16223e-14
Cpar26 out vss 2.51278e-14
Cpar27 out.t0 vss 4.46760e-15
Cpar28 out.t14 vss 1.40302e-14
Cpar29 out.t2 vss 6.40938e-15
Cpar30 vdd vss 6.76415e-14
Cpar31 vdd.t0 vss 2.24132e-14
Cpar32 vdd.t1 vss 4.48431e-15
.ends opamp_dut

Vdd vdd 0 3.300000
Vss vss 0 0
Ibias vdd ib 1.500000e-07
Vinp inp 0 DC 1.645000 AC 1 PWL(0 1.645000 2.660786e-07 1.645000 2.926865e-07 1.655000)
Rfb out inn 1m
Cload out 0 2.000000e-12
Xdut vdd vss inp inn out ib opamp_dut
.end
