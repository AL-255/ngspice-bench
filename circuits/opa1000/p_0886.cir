* opa1000[0886]: 2p/telescopic_nmos_1v8_1u_10u_subth (telescopic_nmos, VDD=1.8V, CL=2.0pF, Iref=1.625uA)
.include "pdk_opa.inc"
.temp 27
.option gmin=1e-12 rshunt=1e12 reltol=1e-3 abstol=1e-12 vntol=1e-5 method=gear
* Post-PEX R+C extracted netlist for telescopic_nmos_1v8_1u_10u_subth
.subckt opamp_dut vdd vss inp inn out ib
XMpar0 a_2490_11475.t1 a_1589_11267.t210 vdd.t3 vdd.t2 pfet_03v3 w=2.01u l=2u ad=5.6280e-13 pd=2.5700e-06 as=5.6280e-13 ps=2.5700e-06 nf=1 m=30 par=30
XMpar1 a_2490_11475.t0 a_1589_11267.t0 out.t0 vdd.t0 pfet_03v3 w=3.98u l=1.3u ad=1.5124e-12 pd=5.9838e-06 as=1.4328e-12 ps=5.6950e-06 nf=1 m=64 par=64
XMpar2 a_1469_11475.t0 a_1589_11267.t0 a_1589_11267.t1 vdd.t0 pfet_03v3 w=3.98u l=1.3u ad=1.5124e-12 pd=5.9838e-06 as=1.3930e-12 ps=5.5506e-06 nf=1 m=64 par=64
XMpar3 a_11374_1204.t18 inn.t0 a_1892_1204.t8 vss.t15 nfet_03v3 w=2.14u l=1.3u ad=6.4200e-13 pd=2.8737e-06 as=6.6340e-13 ps=2.9606e-06 nf=1 m=64 par=64
XMpar4 a_1469_11475.t1 a_1589_11267.t210 vdd.t3 vdd.t2 pfet_03v3 w=2.01u l=2u ad=6.9144e-13 pd=3.1000e-06 as=5.6280e-13 ps=2.5700e-06 nf=1 m=30 par=30
XMpar5 a_1892_1204.t0 ib.t0 vss.t1 vss.t0 nfet_03v3 w=3.51u l=1.6u ad=9.8280e-13 pd=4.0700e-06 as=1.8252e-12 ps=7.1825e-06 nf=1 m=8 par=8
XMpar6 a_1892_1204.t8 inp.t0 a_4362_7501.t0 vss.t15 nfet_03v3 w=2.14u l=1.3u ad=6.6340e-13 pd=2.9606e-06 as=6.4200e-13 ps=2.8737e-06 nf=1 m=64 par=64
XMpar7 a_1589_11267.t128 vdd.t166 a_4362_7501.t64 vss.t15 nfet_03v3 w=2.04u l=1.3u ad=5.7120e-13 pd=2.6000e-06 as=6.4373e-13 ps=2.8978e-06 nf=1 m=18 par=18
XMpar8 a_11374_1204.t0 vdd.t166 out.t1 vss.t15 nfet_03v3 w=2.04u l=1.3u ad=6.4373e-13 pd=2.8978e-06 as=5.7120e-13 ps=2.6000e-06 nf=1 m=18 par=18
XMpar9 ib.t1 ib.t0 vss.t1 vss.t0 nfet_03v3 w=3.51u l=1.6u ad=2.1060e-12 pd=8.2200e-06 as=9.8280e-13 ps=4.0700e-06 nf=1 m=2 par=2
Rpar0 a_11374_1204.t0 a_11374_1204.t18 45.8226
Rpar1 a_1469_11475.t0 a_1469_11475.t1 61.0633
Rpar2 a_1589_11267.t0 a_1589_11267.t1 5.6815
Rpar3 a_1589_11267.t0 a_1589_11267.t128 247.0566
Rpar4 a_1589_11267.t0 a_1589_11267.t210 249.6172
Rpar5 a_1589_11267.t1 a_1589_11267.t128 64.8183
Rpar6 a_1589_11267.t1 a_1589_11267.t210 65.4901
Rpar7 a_1589_11267.t128 a_1589_11267.t210 125.0765
Rpar8 a_1892_1204.t0 a_1892_1204.t8 43.8517
Rpar9 a_2490_11475.t0 a_2490_11475.t1 39.5115
Rpar10 a_4362_7501.t0 a_4362_7501.t64 45.8226
Rpar11 ib ib.t0 13.4689
Rpar12 ib ib.t1 8.1286
Rpar13 ib.t0 ib.t1 22.5664
Rpar14 inn inn.t0 1.4488
Rpar15 inp inp.t0 1.4488
Rpar16 out out.t0 3.0095
Rpar17 out out.t1 37.4996
Rpar18 vdd vdd.t0 83.9987
Rpar19 vdd vdd.t3 37.6398
Rpar20 vdd vdd.t2 311.3015
Rpar21 vdd vdd.t166 196.4719
Rpar22 vdd.t0 vdd.t3 76.8950
Rpar23 vdd.t0 vdd.t2 635.9627
Rpar24 vdd.t0 vdd.t166 172.1371
Rpar25 vdd.t3 vdd.t2 9.9660
Rpar26 vdd.t3 vdd.t166 179.8564
Rpar27 vdd.t2 vdd.t166 1487.5083
Rpar28 vss vss.t0 1094.5645
Rpar29 vss vss.t1 98.0854
Rpar30 vss vss.t15 30.9378
Rpar31 vss.t0 vss.t1 16.4133
Rpar32 vss.t0 vss.t15 8.4661
Rpar33 vss.t1 vss.t15 26.9857
Cpar0 a_11374_1204.t0 vss 1.15837e-14
Cpar1 a_11374_1204.t18 vss 4.28372e-14
Cpar2 a_1469_11475.t0 vss 1.04591e-13
Cpar3 a_1469_11475.t1 vss 4.07605e-14
Cpar4 a_1589_11267.t0 vss 1.73947e-13
Cpar5 a_1589_11267.t1 vss 7.70719e-14
Cpar6 a_1589_11267.t128 vss 1.09364e-14
Cpar7 a_1589_11267.t210 vss 8.54791e-14
Cpar8 a_1892_1204.t0 vss 9.29880e-15
Cpar9 a_1892_1204.t8 vss 7.28276e-14
Cpar10 a_2490_11475.t0 vss 1.10408e-13
Cpar11 a_2490_11475.t1 vss 4.02412e-14
Cpar12 a_4362_7501.t0 vss 4.34665e-14
Cpar13 a_4362_7501.t64 vss 1.17540e-14
Cpar14 ib vss 2.07737e-14
Cpar15 ib.t0 vss 3.34570e-15
Cpar16 ib.t1 vss 9.01647e-16
Cpar17 inn inp 2.27990e-16
Cpar18 inn vdd 3.24800e-17
Cpar19 inn vss 4.13356e-14
Cpar20 inn.t0 vss 2.61329e-14
Cpar21 inp vdd 1.62400e-17
Cpar22 inp vss 4.12047e-14
Cpar23 inp.t0 vss 2.61342e-14
Cpar24 out vdd 3.55100e-14
Cpar25 out vss 1.56319e-14
Cpar26 out.t0 vss 1.02993e-13
Cpar27 out.t1 vss 1.39076e-14
Cpar28 vdd vss 6.40035e-13
Cpar29 vdd.t0 vss 2.04479e-13
Cpar30 vdd.t166 vss 1.08290e-14
Cpar31 vdd.t2 vss 8.67225e-14
Cpar32 vdd.t3 vss 1.01522e-14
.ends opamp_dut

Vdd vdd 0 1.800000
Vss vss 0 0
Ibias vdd ib 1.625000e-06
Vinp inp 0 DC 0.931000 AC 1 PWL(0 0.931000 2.736867e-08 0.931000 3.010553e-08 0.941000)
Rfb out inn 1m
Cload out 0 2.000000e-12
Xdut vdd vss inp inn out ib opamp_dut
.end
