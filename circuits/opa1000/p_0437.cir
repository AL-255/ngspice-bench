* opa1000[0437]: 200f/nmos_miller_1v8_i500u_weak (nmos_miller, VDD=1.8V, CL=0.2pF, Iref=60.7143uA)
.include "pdk_opa.inc"
.temp 27
.option gmin=1e-12 rshunt=1e12 reltol=1e-3 abstol=1e-12 vntol=1e-5 method=gear
* Post-PEX R+C extracted netlist for nmos_miller_1v8_i500u_weak
.subckt opamp_dut vdd vss inp inn out ib
XMpar0 a_2720_6317.t0 inp.t0 a_958_13905.t1 vss.t1 nfet_03v3 w=1.99u l=0.45u ad=7.6947e-13 pd=3.4267e-06 as=5.5720e-13 ps=2.5500e-06 nf=1 m=18 par=18
XMpar1 out.t9 ib.t0 vss.t8 vss.t7 nfet_03v3 w=1.74u l=0.56u ad=5.7072e-13 pd=2.6570e-06 as=4.8720e-13 ps=2.3000e-06 nf=1 m=80 par=80
XMpar2 a_2720_6317.t18 ib.t0 vss.t8 vss.t7 nfet_03v3 w=1.74u l=0.56u ad=5.2200e-13 pd=2.4487e-06 as=5.5680e-13 ps=2.5975e-06 nf=1 m=32 par=32
XMpar3 a_2720_6317.t0 inn.t0 a_7348_10250.t0 vss.t1 nfet_03v3 w=1.99u l=0.45u ad=7.6947e-13 pd=3.4267e-06 as=5.5720e-13 ps=2.5500e-06 nf=1 m=18 par=18
XMpar4 a_7348_10250.t19 a_7348_10250.t18 vdd.t1 vdd.t0 pfet_03v3 w=9.4u l=0.48u ad=2.6320e-12 pd=9.9600e-06 as=2.6320e-12 ps=9.9600e-06 nf=1 m=16 par=16
XMpar5 ib.t1 ib.t0 vss.t8 vss.t7 nfet_03v3 w=1.74u l=0.56u ad=4.8720e-13 pd=2.3000e-06 as=5.5680e-13 ps=2.5975e-06 nf=1 m=16 par=16
XMpar6 out.t0 a_958_13905.t35 vdd.t1 vdd.t0 pfet_03v3 w=9.4u l=0.48u ad=2.7072e-12 pd=1.0211e-05 as=2.7824e-12 ps=1.0462e-05 nf=1 m=80 par=80
XMpar7 a_958_13905.t19 a_7348_10250.t18 vdd.t1 vdd.t0 pfet_03v3 w=9.4u l=0.48u ad=2.6320e-12 pd=9.9600e-06 as=3.0080e-12 ps=1.1215e-05 nf=1 m=16 par=16
X37 a_1290_13905.t1 out.t160 cap_mim_2f0fF c_width=19.63u c_length=19.62u
X135 a_958_13905.t0 a_1290_13905.t0 vss.t0 ppolyf_u_1k r_width=1u r_length=1u
Rpar0 a_1290_13905.t0 a_1290_13905.t1 47.7358
Rpar1 a_2720_6317.t0 a_2720_6317.t18 83.1662
Rpar2 a_7348_10250.t0 a_7348_10250.t18 2970.1673
Rpar3 a_7348_10250.t0 a_7348_10250.t19 46.8851
Rpar4 a_7348_10250.t18 a_7348_10250.t19 17.2403
Rpar5 a_958_13905.t0 a_958_13905.t1 151.2913
Rpar6 a_958_13905.t0 a_958_13905.t35 281.8316
Rpar7 a_958_13905.t0 a_958_13905.t19 116.0322
Rpar8 a_958_13905.t1 a_958_13905.t35 278.7526
Rpar9 a_958_13905.t1 a_958_13905.t19 114.7646
Rpar10 a_958_13905.t35 a_958_13905.t19 119.9991
Rpar11 ib ib.t0 1.7268
Rpar12 ib ib.t1 1239.5951
Rpar13 ib.t0 ib.t1 11.2682
Rpar14 inn inn.t0 4.5587
Rpar15 inp inp.t0 4.5587
Rpar16 out out.t0 165.9083
Rpar17 out out.t9 94.1807
Rpar18 out out.t160 20.5302
Rpar19 out.t0 out.t9 38.4866
Rpar20 out.t0 out.t160 1641.7024
Rpar21 out.t9 out.t160 931.9404
Rpar22 vdd vdd.t0 31.7371
Rpar23 vdd vdd.t1 685.1585
Rpar24 vdd.t0 vdd.t1 3.0220
Rpar25 vss vss.t1 2017.5714
Rpar26 vss vss.t8 576.7527
Rpar27 vss vss.t7 39.7770
Rpar28 vss.t0 vss.t1 81.4776
Rpar29 vss.t0 vss.t8 5864.7111
Rpar30 vss.t0 vss.t7 159.8672
Rpar31 vss.t1 vss.t8 1076.9717
Rpar32 vss.t1 vss.t7 33.6795
Rpar33 vss.t8 vss.t7 2.4832
Cpar0 a_1290_13905.t0 vss 3.29800e-17
Cpar1 a_1290_13905.t1 vss 2.46732e-15
Cpar2 a_2720_6317.t0 vss 2.31072e-14
Cpar3 a_2720_6317.t18 vss 2.34134e-14
Cpar4 a_7348_10250.t0 vss 1.03817e-14
Cpar5 a_7348_10250.t18 vss 3.24756e-14
Cpar6 a_7348_10250.t19 vss 2.93847e-14
Cpar7 a_958_13905.t0 vss 3.22938e-15
Cpar8 a_958_13905.t1 vss 1.11437e-14
Cpar9 a_958_13905.t19 vss 2.61921e-14
Cpar10 a_958_13905.t35 vss 8.28641e-14
Cpar11 ib out 7.33416e-15
Cpar12 ib vdd 4.62500e-17
Cpar13 ib vss 8.91230e-14
Cpar14 ib.t0 vss 8.08960e-15
Cpar15 ib.t1 vss 6.29457e-16
Cpar16 inn inp 1.55160e-16
Cpar17 inn vdd 3.25000e-17
Cpar18 inn vss 9.96141e-15
Cpar19 inn.t0 vss 3.62175e-15
Cpar20 inp vdd 3.28100e-17
Cpar21 inp vss 1.00428e-14
Cpar22 inp.t0 vss 3.61854e-15
Cpar23 out vdd 1.45510e-13
Cpar24 out vss 6.45752e-14
Cpar25 out.t0 vss 1.37449e-13
Cpar26 out.t160 vss 1.59114e-14
Cpar27 out.t9 vss 3.03058e-14
Cpar28 vdd vss 2.71449e-13
Cpar29 vdd.t0 vss 1.86093e-13
Cpar30 vdd.t1 vss 7.65502e-14
.ends opamp_dut

Vdd vdd 0 1.800000
Vss vss 0 0
Ibias vdd ib 6.071430e-05
Vinp inp 0 DC 0.895000 AC 1 PWL(0 0.895000 3.000000e-09 0.895000 3.300000e-09 0.905000)
Rfb out inn 1m
Cload out 0 2.000000e-13
Xdut vdd vss inp inn out ib opamp_dut
.end
