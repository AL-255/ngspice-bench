* opa1000[0967]: 2p/telescopic_pmos_1v8_i1u_weak (telescopic_pmos, VDD=1.8V, CL=2.0pF, Iref=0.23uA)
.include "pdk_opa.inc"
.temp 27
.option gmin=1e-12 rshunt=1e12 reltol=1e-3 abstol=1e-12 vntol=1e-5 method=gear
* Post-PEX R+C extracted netlist for telescopic_pmos_1v8_i1u_weak
.subckt opamp_dut vdd vss inp inn out ib
XMpar0 a_1506_9607.t0 inn.t0 a_8494_5797.t0 vdd.t0 pfet_03v3 w=2.05u l=5u ad=7.5291e-13 pd=3.3436e-06 as=6.3364e-13 ps=2.8545e-06 nf=1 m=22 par=22
XMpar1 ib.t1 ib.t0 vss.t14 vss.t13 nfet_03v3 w=0.62u l=5.25u ad=3.7200e-13 pd=2.4400e-06 as=1.7360e-13 ps=1.1800e-06 nf=1 m=2 par=2
XMpar2 a_8494_5797.t22 vss.t19 out.t1 vdd.t21 pfet_03v3 w=2.49u l=1.36u ad=1.4940e-12 pd=6.1800e-06 as=6.9720e-13 ps=3.0500e-06 nf=1 m=2 par=2
XMpar3 a_1506_9607.t0 inp.t0 a_2626_9607.t0 vdd.t0 pfet_03v3 w=2.05u l=5u ad=7.5291e-13 pd=3.3436e-06 as=6.3364e-13 ps=2.8545e-06 nf=1 m=22 par=22
XMpar4 a_1506_9607.t44 a_3886_2777.t0 vdd.t12 vdd.t11 pfet_03v3 w=2.45u l=5.25u ad=6.8600e-13 pd=3.0100e-06 as=8.8200e-13 ps=3.7825e-06 nf=1 m=8 par=8
XMpar5 a_8092_2777.t0 a_7152_996.t0 out.t0 vss.t2 nfet_03v3 w=0.53u l=1.36u ad=3.1800e-13 pd=2.2600e-06 as=1.4840e-13 ps=1.0900e-06 nf=1 m=2 par=2
XMpar6 a_7032_1204.t0 a_7152_996.t6 vss.t1 vss.t0 nfet_03v3 w=0.41u l=2.7u ad=2.4600e-13 pd=2.0200e-06 as=1.1480e-13 ps=9.7000e-07 nf=1 m=2 par=2
XMpar7 a_3886_2777.t4 ib.t0 vss.t14 vss.t13 nfet_03v3 w=0.62u l=5.25u ad=3.7200e-13 pd=2.4400e-06 as=1.7360e-13 ps=1.1800e-06 nf=1 m=2 par=2
XMpar8 a_8092_2777.t1 a_7152_996.t6 vss.t1 vss.t0 nfet_03v3 w=0.41u l=2.7u ad=1.1480e-13 pd=9.7000e-07 as=1.1480e-13 ps=9.7000e-07 nf=1 m=2 par=2
XMpar9 a_7032_1204.t1 a_7152_996.t0 a_7152_996.t1 vss.t2 nfet_03v3 w=0.53u l=1.36u ad=3.1800e-13 pd=2.2600e-06 as=3.1800e-13 ps=2.2600e-06 nf=1 m=2 par=2
XMpar10 a_2626_9607.t22 vss.t19 a_7152_996.t4 vdd.t21 pfet_03v3 w=2.49u l=1.36u ad=1.4940e-12 pd=6.1800e-06 as=6.9720e-13 ps=3.0500e-06 nf=1 m=2 par=2
XMpar11 a_3886_2777.t1 a_3886_2777.t0 vdd.t12 vdd.t11 pfet_03v3 w=2.45u l=5.25u ad=6.8600e-13 pd=3.0100e-06 as=6.8600e-13 ps=3.0100e-06 nf=1 m=2 par=2
X66 out.t4 vss.t3 cap_mim_2f0fF c_width=10.25u c_length=10.25u
Rpar0 a_1506_9607.t0 a_1506_9607.t44 48.6803
Rpar1 a_2626_9607.t0 a_2626_9607.t22 67.6568
Rpar2 a_3886_2777.t0 a_3886_2777.t1 25.6186
Rpar3 a_3886_2777.t0 a_3886_2777.t4 300.7759
Rpar4 a_3886_2777.t1 a_3886_2777.t4 130.8098
Rpar5 a_7032_1204.t0 a_7032_1204.t1 55.3851
Rpar6 a_7152_996.t0 a_7152_996.t1 27.7525
Rpar7 a_7152_996.t0 a_7152_996.t4 160.6825
Rpar8 a_7152_996.t0 a_7152_996.t6 172.9073
Rpar9 a_7152_996.t1 a_7152_996.t4 91.9980
Rpar10 a_7152_996.t1 a_7152_996.t6 98.9972
Rpar11 a_7152_996.t4 a_7152_996.t6 124.3980
Rpar12 a_8092_2777.t0 a_8092_2777.t1 71.4338
Rpar13 a_8494_5797.t0 a_8494_5797.t22 67.6568
Rpar14 ib ib.t0 9.8009
Rpar15 ib ib.t1 10.7688
Rpar16 ib.t0 ib.t1 40.7895
Rpar17 inn inn.t0 1.9763
Rpar18 inp inp.t0 1.9763
Rpar19 out out.t0 61.9626
Rpar20 out out.t1 7.6935
Rpar21 out out.t4 179.7838
Rpar22 out.t0 out.t4 298.7018
Rpar23 vdd vdd.t0 20.8456
Rpar24 vdd vdd.t11 271.6380
Rpar25 vdd vdd.t12 785.4420
Rpar26 vdd vdd.t21 903.0344
Rpar27 vdd.t0 vdd.t11 102.3237
Rpar28 vdd.t0 vdd.t12 295.8691
Rpar29 vdd.t0 vdd.t21 340.1651
Rpar30 vdd.t11 vdd.t12 5.8505
Rpar31 vdd.t11 vdd.t21 217.9794
Rpar32 vdd.t12 vdd.t21 630.2880
Rpar33 vss vss.t0 87.6216
Rpar34 vss vss.t1 322.2942
Rpar35 vss vss.t2 132.7776
Rpar36 vss vss.t13 549.0031
Rpar37 vss vss.t14 219.8387
Rpar38 vss vss.t19 174.4443
Rpar39 vss vss.t3 258.9340
Rpar40 vss.t0 vss.t1 15.4829
Rpar41 vss.t0 vss.t2 1.9424
Rpar42 vss.t0 vss.t13 745.4246
Rpar43 vss.t0 vss.t14 350.6904
Rpar44 vss.t0 vss.t19 290.5273
Rpar45 vss.t0 vss.t3 431.2403
Rpar46 vss.t1 vss.t2 35.4679
Rpar47 vss.t1 vss.t13 2679.2598
Rpar48 vss.t1 vss.t14 1282.9726
Rpar49 vss.t1 vss.t19 1068.5109
Rpar50 vss.t1 vss.t3 1586.0298
Rpar51 vss.t2 vss.t13 1194.8690
Rpar52 vss.t2 vss.t14 538.2423
Rpar53 vss.t2 vss.t19 440.3677
Rpar54 vss.t2 vss.t3 653.6539
Rpar55 vss.t13 vss.t14 26.7665
Rpar56 vss.t13 vss.t19 675.4950
Rpar57 vss.t13 vss.t3 1002.6620
Rpar58 vss.t14 vss.t19 268.3649
Rpar59 vss.t14 vss.t3 398.3438
Rpar60 vss.t19 vss.t3 155.7141
Cpar0 a_1506_9607.t0 vss 6.22254e-14
Cpar1 a_1506_9607.t44 vss 1.25597e-14
Cpar2 a_2626_9607.t0 vss 3.53185e-14
Cpar3 a_2626_9607.t22 vss 8.04805e-15
Cpar4 a_3886_2777.t0 vss 3.63766e-14
Cpar5 a_3886_2777.t1 vss 6.46130e-15
Cpar6 a_3886_2777.t4 vss 7.85811e-15
Cpar7 a_7032_1204.t0 vss 2.47281e-15
Cpar8 a_7032_1204.t1 vss 2.36255e-15
Cpar9 a_7152_996.t0 vss 1.87481e-15
Cpar10 a_7152_996.t1 vss 1.34198e-15
Cpar11 a_7152_996.t4 vss 1.26124e-15
Cpar12 a_7152_996.t6 vss 3.08717e-15
Cpar13 a_8092_2777.t0 vss 3.49746e-15
Cpar14 a_8092_2777.t1 vss 2.81063e-15
Cpar15 a_8494_5797.t0 vss 3.42422e-14
Cpar16 a_8494_5797.t22 vss 7.80282e-15
Cpar17 ib out 1.30980e-16
Cpar18 ib vss 1.82739e-14
Cpar19 ib.t0 vss 2.81592e-15
Cpar20 ib.t1 vss 3.63950e-16
Cpar21 inn inp 1.14960e-16
Cpar22 inn vdd 4.00824e-14
Cpar23 inn vss 4.84993e-15
Cpar24 inn.t0 vss 5.57344e-14
Cpar25 inp out 4.18000e-17
Cpar26 inp vdd 4.04827e-14
Cpar27 inp vss 4.99701e-15
Cpar28 inp.t0 vss 5.60964e-14
Cpar29 out vdd 4.49859e-15
Cpar30 out vss 1.39509e-14
Cpar31 out.t0 vss 9.03816e-16
Cpar32 out.t1 vss 1.32197e-16
Cpar33 out.t4 vss 9.81783e-15
Cpar34 vdd vss 3.40145e-13
Cpar35 vdd.t0 vss 1.03579e-13
Cpar36 vdd.t11 vss 2.76930e-14
Cpar37 vdd.t12 vss 1.13636e-14
Cpar38 vdd.t21 vss 8.06299e-15
.ends opamp_dut

Vdd vdd 0 1.800000
Vss vss 0 0
Ibias vdd ib 2.300000e-07
Vinp inp 0 DC 0.805000 AC 1 PWL(0 0.805000 1.633392e-07 0.805000 1.796731e-07 0.815000)
Rfb out inn 1m
Cload out 0 2.000000e-12
Xdut vdd vss inp inn out ib opamp_dut
.end
