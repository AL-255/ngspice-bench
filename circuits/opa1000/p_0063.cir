* opa1000[0063]: 2p/cherry_hooper_3v3_i50n_subth (cherry_hooper, VDD=3.3V, CL=2.0pF, Iref=0.0022uA)
.include "pdk_opa.inc"
.temp 27
.option gmin=1e-12 rshunt=1e12 reltol=1e-3 abstol=1e-12 vntol=1e-5 method=gear
* Post-PEX R+C extracted netlist for cherry_hooper_3v3_i50n_subth
.subckt opamp_dut vdd vss inp inn out ib
XMpar0 a_4299_3063.t2 ib.t0 vss.t5 vss.t4 nfet_03v3 w=0.4u l=7.5u ad=1.5467e-13 pd=1.3067e-06 as=1.9733e-13 ps=1.6533e-06 nf=1 m=6 par=6
XMpar1 a_1110_3019.t2 a_1110_3019.t1 vdd.t3 vdd.t2 pfet_03v3 w=0.4u l=5u ad=2.4000e-13 pd=2.0000e-06 as=2.4000e-13 ps=2.0000e-06 nf=1 m=1
XMpar2 a_1038_6262.t1 a_1230_2811.t3 a_9614_6218.t0 vdd.t11 pfet_03v3 w=0.4u l=16u ad=2.4000e-13 pd=2.0000e-06 as=2.4000e-13 ps=2.0000e-06 nf=1 m=1
XMpar3 a_6260_12881.t2 a_6260_12881.t1 vdd.t3 vdd.t2 pfet_03v3 w=0.4u l=5u ad=1.5467e-13 pd=1.3067e-06 as=1.1200e-13 ps=9.6000e-07 nf=1 m=3 par=3
XMpar4 ib.t1 ib.t0 vss.t5 vss.t4 nfet_03v3 w=0.4u l=7.5u ad=2.4000e-13 pd=2.0000e-06 as=1.1200e-13 ps=9.6000e-07 nf=1 m=1
XMpar5 a_2853_1384.t2 ib.t0 vss.t5 vss.t4 nfet_03v3 w=0.4u l=7.5u ad=1.1200e-13 pd=9.6000e-07 as=1.5467e-13 ps=1.3067e-06 nf=1 m=6 par=6
XMpar6 out.t1 a_6260_12881.t1 vdd.t3 vdd.t2 pfet_03v3 w=0.4u l=5u ad=1.5467e-13 pd=1.3067e-06 as=1.1200e-13 ps=9.6000e-07 nf=1 m=3 par=3
XMpar7 a_2853_1384.t0 a_5986_14542.t8 a_6260_12881.t0 vss.t0 nfet_03v3 w=0.54u l=4.4u ad=3.2400e-13 pd=2.2800e-06 as=3.2400e-13 ps=2.2800e-06 nf=1 m=1
XMpar8 a_1038_6262.t0 a_9614_6218.t4 a_4299_3063.t0 vss.t0 nfet_03v3 w=0.54u l=4.4u ad=3.2400e-13 pd=2.2800e-06 as=3.2400e-13 ps=2.2800e-06 nf=1 m=1
XMpar9 a_7314_11426.t4 ib.t0 vss.t5 vss.t4 nfet_03v3 w=0.4u l=7.5u ad=2.4000e-13 pd=2.0000e-06 as=1.1200e-13 ps=9.6000e-07 nf=1 m=2 par=2
XMpar10 a_7314_11426.t0 inn.t0 a_9614_6218.t1 vss.t1 nfet_03v3 w=0.4u l=4.4u ad=2.4000e-13 pd=2.0000e-06 as=1.1200e-13 ps=9.6000e-07 nf=1 m=1
XMpar11 a_1079_12674.t0 ib.t0 vss.t5 vss.t4 nfet_03v3 w=0.4u l=7.5u ad=2.4000e-13 pd=2.0000e-06 as=1.1200e-13 ps=9.6000e-07 nf=1 m=1
XMpar12 a_1079_12674.t2 a_1079_12674.t1 vdd.t1 vdd.t0 pfet_03v3 w=0.4u l=7.5u ad=2.4000e-13 pd=2.0000e-06 as=2.4000e-13 ps=2.0000e-06 nf=1 m=1
XMpar13 a_1038_6262.t3 a_1038_6262.t2 vdd.t3 vdd.t2 pfet_03v3 w=0.4u l=5u ad=1.5467e-13 pd=1.3067e-06 as=1.5467e-13 ps=1.3067e-06 nf=1 m=3 par=3
XMpar14 a_7314_11426.t0 inp.t0 a_8314_11426.t0 vss.t0 nfet_03v3 w=0.4u l=4.4u ad=2.4000e-13 pd=2.0000e-06 as=1.1200e-13 ps=9.6000e-07 nf=1 m=1
XMpar15 a_9614_6218.t3 a_1079_12674.t1 vdd.t1 vdd.t0 pfet_03v3 w=0.4u l=7.5u ad=2.4000e-13 pd=2.0000e-06 as=2.4000e-13 ps=2.0000e-06 nf=1 m=1
XMpar16 a_1110_3019.t0 a_1230_2811.t1 a_1230_2811.t2 vdd.t10 pfet_03v3 w=0.47u l=1u ad=2.8200e-13 pd=2.1400e-06 as=2.8200e-13 ps=2.1400e-06 nf=1 m=1
XMpar17 a_7314_11426.t0 inn.t0 a_9614_6218.t1 vss.t0 nfet_03v3 w=0.4u l=4.4u ad=2.4000e-13 pd=2.0000e-06 as=1.1200e-13 ps=9.6000e-07 nf=1 m=1
XMpar18 a_2853_1384.t0 a_1038_6262.t8 out.t0 vss.t0 nfet_03v3 w=0.54u l=4.4u ad=3.2400e-13 pd=2.2800e-06 as=3.2400e-13 ps=2.2800e-06 nf=1 m=1
XMpar19 a_8314_11426.t3 a_1079_12674.t1 vdd.t1 vdd.t0 pfet_03v3 w=0.4u l=7.5u ad=2.4000e-13 pd=2.0000e-06 as=2.4000e-13 ps=2.0000e-06 nf=1 m=1
XMpar20 a_7314_11426.t0 inp.t0 a_8314_11426.t0 vss.t1 nfet_03v3 w=0.4u l=4.4u ad=2.4000e-13 pd=2.0000e-06 as=1.1200e-13 ps=9.6000e-07 nf=1 m=1
XMpar21 a_5986_14542.t3 a_5986_14542.t2 vdd.t3 vdd.t2 pfet_03v3 w=0.4u l=5u ad=1.5467e-13 pd=1.3067e-06 as=1.5467e-13 ps=1.3067e-06 nf=1 m=3 par=3
XMpar22 a_5986_14542.t0 a_1230_2811.t3 a_8314_11426.t2 vdd.t11 pfet_03v3 w=0.4u l=16u ad=2.4000e-13 pd=2.0000e-06 as=2.4000e-13 ps=2.0000e-06 nf=1 m=1
XMpar23 a_4299_3063.t0 a_8314_11426.t4 a_5986_14542.t1 vss.t0 nfet_03v3 w=0.54u l=4.4u ad=3.2400e-13 pd=2.2800e-06 as=3.2400e-13 ps=2.2800e-06 nf=1 m=1
XMpar24 a_1230_2811.t0 ib.t0 vss.t5 vss.t4 nfet_03v3 w=0.4u l=7.5u ad=2.4000e-13 pd=2.0000e-06 as=2.4000e-13 ps=2.0000e-06 nf=1 m=1
Rpar0 a_1038_6262.t0 a_1038_6262.t1 264.3762
Rpar1 a_1038_6262.t0 a_1038_6262.t2 646.5358
Rpar2 a_1038_6262.t0 a_1038_6262.t3 471.1510
Rpar3 a_1038_6262.t0 a_1038_6262.t8 81.7562
Rpar4 a_1038_6262.t1 a_1038_6262.t2 1562.1941
Rpar5 a_1038_6262.t1 a_1038_6262.t3 1138.4200
Rpar6 a_1038_6262.t1 a_1038_6262.t8 123.6905
Rpar7 a_1038_6262.t2 a_1038_6262.t3 21.2160
Rpar8 a_1038_6262.t2 a_1038_6262.t8 483.0959
Rpar9 a_1038_6262.t3 a_1038_6262.t8 352.0472
Rpar10 a_1079_12674.t0 a_1079_12674.t1 72.0517
Rpar11 a_1079_12674.t0 a_1079_12674.t2 206.2928
Rpar12 a_1079_12674.t1 a_1079_12674.t2 32.2949
Rpar13 a_1110_3019.t0 a_1110_3019.t1 81.0720
Rpar14 a_1110_3019.t0 a_1110_3019.t2 89.1236
Rpar15 a_1110_3019.t1 a_1110_3019.t2 37.9563
Rpar16 a_1230_2811.t0 a_1230_2811.t1 395.3163
Rpar17 a_1230_2811.t0 a_1230_2811.t2 184.1456
Rpar18 a_1230_2811.t0 a_1230_2811.t3 93.8871
Rpar19 a_1230_2811.t1 a_1230_2811.t2 51.7297
Rpar20 a_1230_2811.t1 a_1230_2811.t3 529.6934
Rpar21 a_1230_2811.t2 a_1230_2811.t3 246.7409
Rpar22 a_2853_1384.t0 a_2853_1384.t2 79.4354
Rpar23 a_4299_3063.t0 a_4299_3063.t2 65.4740
Rpar24 a_5986_14542.t0 a_5986_14542.t1 272.4049
Rpar25 a_5986_14542.t0 a_5986_14542.t2 1015.5893
Rpar26 a_5986_14542.t0 a_5986_14542.t3 740.0899
Rpar27 a_5986_14542.t0 a_5986_14542.t8 148.1941
Rpar28 a_5986_14542.t1 a_5986_14542.t2 335.0476
Rpar29 a_5986_14542.t1 a_5986_14542.t3 244.1591
Rpar30 a_5986_14542.t1 a_5986_14542.t8 55.7672
Rpar31 a_5986_14542.t2 a_5986_14542.t3 22.4627
Rpar32 a_5986_14542.t2 a_5986_14542.t8 207.9132
Rpar33 a_5986_14542.t3 a_5986_14542.t8 151.5125
Rpar34 a_6260_12881.t0 a_6260_12881.t1 171.6875
Rpar35 a_6260_12881.t0 a_6260_12881.t2 123.4597
Rpar36 a_6260_12881.t1 a_6260_12881.t2 20.0178
Rpar37 a_7314_11426.t0 a_7314_11426.t4 53.1982
Rpar38 a_8314_11426.t0 a_8314_11426.t2 132.4872
Rpar39 a_8314_11426.t0 a_8314_11426.t3 375.4044
Rpar40 a_8314_11426.t0 a_8314_11426.t4 148.3351
Rpar41 a_8314_11426.t2 a_8314_11426.t3 449.5208
Rpar42 a_8314_11426.t2 a_8314_11426.t4 177.6210
Rpar43 a_8314_11426.t3 a_8314_11426.t4 62.2941
Rpar44 a_9614_6218.t0 a_9614_6218.t1 135.3056
Rpar45 a_9614_6218.t0 a_9614_6218.t3 271.4637
Rpar46 a_9614_6218.t0 a_9614_6218.t4 254.1192
Rpar47 a_9614_6218.t1 a_9614_6218.t3 185.0271
Rpar48 a_9614_6218.t1 a_9614_6218.t4 173.2053
Rpar49 a_9614_6218.t3 a_9614_6218.t4 83.7813
Rpar50 ib ib.t0 2.2221
Rpar51 ib ib.t1 169.6305
Rpar52 ib.t0 ib.t1 29.8194
Rpar53 inn inn.t0 3.1426
Rpar54 inp inp.t0 3.1912
Rpar55 out out.t0 57.0987
Rpar56 out out.t1 7.9205
Rpar57 vdd vdd.t0 536.2903
Rpar58 vdd vdd.t1 469.2473
Rpar59 vdd vdd.t10 4979.2977
Rpar60 vdd vdd.t11 69.1288
Rpar61 vdd vdd.t2 143.1950
Rpar62 vdd vdd.t3 405.8423
Rpar63 vdd.t0 vdd.t1 12.0321
Rpar64 vdd.t0 vdd.t10 961.4856
Rpar65 vdd.t0 vdd.t11 594.6052
Rpar66 vdd.t0 vdd.t2 109.0803
Rpar67 vdd.t0 vdd.t3 162.0956
Rpar68 vdd.t1 vdd.t10 895.0087
Rpar69 vdd.t1 vdd.t11 520.2722
Rpar70 vdd.t1 vdd.t2 101.6644
Rpar71 vdd.t1 vdd.t3 152.4688
Rpar72 vdd.t10 vdd.t11 5520.7347
Rpar73 vdd.t10 vdd.t2 207.6091
Rpar74 vdd.t10 vdd.t3 225.3297
Rpar75 vdd.t11 vdd.t2 158.7657
Rpar76 vdd.t11 vdd.t3 449.9726
Rpar77 vdd.t2 vdd.t3 3.8975
Rpar78 vss vss.t0 1857.1524
Rpar79 vss vss.t1 4683.6121
Rpar80 vss vss.t4 57.7394
Rpar81 vss vss.t5 410.1623
Rpar82 vss.t0 vss.t1 17.5202
Rpar83 vss.t0 vss.t4 32.0812
Rpar84 vss.t0 vss.t5 92.7302
Rpar85 vss.t1 vss.t4 77.4207
Rpar86 vss.t1 vss.t5 210.9272
Rpar87 vss.t4 vss.t5 3.9685
Cpar0 a_1038_6262.t0 vss 3.72274e-15
Cpar1 a_1038_6262.t1 vss 4.22303e-15
Cpar2 a_1038_6262.t2 vss 8.83797e-15
Cpar3 a_1038_6262.t3 vss 4.97637e-15
Cpar4 a_1038_6262.t8 vss 6.55449e-15
Cpar5 a_1079_12674.t0 vss 5.68696e-15
Cpar6 a_1079_12674.t1 vss 1.66303e-14
Cpar7 a_1079_12674.t2 vss 3.30067e-15
Cpar8 a_1110_3019.t0 vss 1.45013e-15
Cpar9 a_1110_3019.t1 vss 3.44691e-15
Cpar10 a_1110_3019.t2 vss 1.37397e-15
Cpar11 a_1230_2811.t0 vss 6.27097e-15
Cpar12 a_1230_2811.t1 vss 2.26585e-15
Cpar13 a_1230_2811.t2 vss 3.94667e-15
Cpar14 a_1230_2811.t3 vss 1.93211e-14
Cpar15 a_2853_1384.t0 vss 2.59595e-15
Cpar16 a_2853_1384.t2 vss 4.59254e-15
Cpar17 a_4299_3063.t0 vss 3.32512e-15
Cpar18 a_4299_3063.t2 vss 9.51636e-15
Cpar19 a_5986_14542.t0 vss 5.19422e-15
Cpar20 a_5986_14542.t1 vss 3.14201e-15
Cpar21 a_5986_14542.t2 vss 8.65357e-15
Cpar22 a_5986_14542.t3 vss 3.71184e-15
Cpar23 a_5986_14542.t8 vss 6.35991e-15
Cpar24 a_6260_12881.t0 vss 3.54329e-15
Cpar25 a_6260_12881.t1 vss 1.93663e-14
Cpar26 a_6260_12881.t2 vss 5.64813e-15
Cpar27 a_7314_11426.t0 vss 6.12640e-15
Cpar28 a_7314_11426.t4 vss 9.02200e-15
Cpar29 a_8314_11426.t0 vss 3.59957e-15
Cpar30 a_8314_11426.t2 vss 3.95444e-15
Cpar31 a_8314_11426.t3 vss 2.41514e-15
Cpar32 a_8314_11426.t4 vss 5.18968e-15
Cpar33 a_9614_6218.t0 vss 4.27210e-15
Cpar34 a_9614_6218.t1 vss 4.04480e-15
Cpar35 a_9614_6218.t3 vss 3.21123e-15
Cpar36 a_9614_6218.t4 vss 4.96894e-15
Cpar37 ib vdd 1.88741e-15
Cpar38 ib vss 7.72495e-14
Cpar39 ib.t0 vss 8.16940e-15
Cpar40 ib.t1 vss 3.74574e-16
Cpar41 inn inp 5.19700e-17
Cpar42 inn out 2.15200e-17
Cpar43 inn vss 4.84800e-15
Cpar44 inn.t0 vss 4.08634e-16
Cpar45 inp vss 4.90747e-15
Cpar46 inp.t0 vss 4.06204e-16
Cpar47 out vdd 4.44343e-15
Cpar48 out vss 1.00482e-14
Cpar49 out.t0 vss 2.64202e-15
Cpar50 out.t1 vss 1.17898e-15
Cpar51 vdd vss 1.70391e-13
Cpar52 vdd.t0 vss 1.30454e-14
Cpar53 vdd.t1 vss 8.43639e-15
Cpar54 vdd.t10 vss 2.98067e-15
Cpar55 vdd.t11 vss 1.49398e-14
Cpar56 vdd.t2 vss 3.80640e-14
Cpar57 vdd.t3 vss 1.93518e-14
.ends opamp_dut

Vdd vdd 0 3.300000
Vss vss 0 0
Ibias vdd ib 2.200000e-09
Vinp inp 0 DC 2.021700 AC 1 PWL(0 2.021700 1.569970e-06 2.021700 1.726967e-06 2.031700)
Rfb out inn 1m
Cload out 0 2.000000e-12
Xdut vdd vss inp inn out ib opamp_dut
.end
