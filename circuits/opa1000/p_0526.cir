* opa1000[0526]: 200f/pmos_5t_3v3_0p1u_1u_weak (pmos_5t, VDD=3.3V, CL=0.2pF, Iref=0.115uA)
.include "pdk_opa.inc"
.temp 27
.option gmin=1e-12 rshunt=1e12 reltol=1e-3 abstol=1e-12 vntol=1e-5 method=gear
* Post-PEX R+C extracted netlist for pmos_5t_3v3_0p1u_1u_weak
.subckt opamp_dut vdd vss inp inn out ib
XMpar0 a_1792_2612.t3 a_1792_2612.t2 vdd.t1 vdd.t0 pfet_03v3 w=1.53u l=6.25u ad=9.1800e-13 pd=4.2600e-06 as=4.2840e-13 ps=2.0900e-06 nf=1 m=2 par=2
XMpar1 a_1792_2612.t0 ib.t0 vss.t9 vss.t8 nfet_03v3 w=0.4u l=6.25u ad=1.1200e-13 pd=9.6000e-07 as=1.1200e-13 ps=9.6000e-07 nf=1 m=2 par=2
XMpar2 a_1490_7856.t0 inp.t0 a_2012_6249.t4 vdd.t6 pfet_03v3 w=1.79u l=4u ad=7.3032e-13 pd=3.3220e-06 as=6.1576e-13 ps=2.8360e-06 nf=1 m=10 par=10
XMpar3 a_1490_7856.t0 inn.t0 out.t0 vdd.t6 pfet_03v3 w=1.79u l=4u ad=7.3032e-13 pd=3.3220e-06 as=6.1576e-13 ps=2.8360e-06 nf=1 m=10 par=10
XMpar4 a_1490_7856.t20 a_1792_2612.t2 vdd.t1 vdd.t0 pfet_03v3 w=1.53u l=6.25u ad=4.2840e-13 pd=2.0900e-06 as=7.9560e-13 ps=3.7175e-06 nf=1 m=8 par=8
XMpar5 a_2012_6249.t1 a_2012_6249.t0 vss.t1 vss.t0 nfet_03v3 w=0.58u l=8u ad=3.4800e-13 pd=2.3600e-06 as=1.6240e-13 ps=1.1400e-06 nf=1 m=2 par=2
XMpar6 ib.t1 ib.t0 vss.t9 vss.t8 nfet_03v3 w=0.4u l=6.25u ad=2.4000e-13 pd=2.0000e-06 as=1.1200e-13 ps=9.6000e-07 nf=1 m=2 par=2
XMpar7 out.t7 a_2012_6249.t0 vss.t1 vss.t0 nfet_03v3 w=0.58u l=8u ad=1.6240e-13 pd=1.1400e-06 as=1.6240e-13 ps=1.1400e-06 nf=1 m=2 par=2
Rpar0 a_1490_7856.t0 a_1490_7856.t20 49.6789
Rpar1 a_1792_2612.t0 a_1792_2612.t2 119.8492
Rpar2 a_1792_2612.t0 a_1792_2612.t3 132.7472
Rpar3 a_1792_2612.t2 a_1792_2612.t3 12.9810
Rpar4 a_2012_6249.t0 a_2012_6249.t1 21.5827
Rpar5 a_2012_6249.t0 a_2012_6249.t4 141.4860
Rpar6 a_2012_6249.t1 a_2012_6249.t4 103.2607
Rpar7 ib ib.t0 11.5933
Rpar8 ib ib.t1 8.8363
Rpar9 inn inn.t0 2.4954
Rpar10 inp inp.t0 2.4954
Rpar11 out out.t0 51.2622
Rpar12 out out.t7 17.0388
Rpar13 out.t0 out.t7 208.8607
Rpar14 vdd vdd.t0 161.8615
Rpar15 vdd vdd.t1 1727.6284
Rpar16 vdd vdd.t6 21.8656
Rpar17 vdd.t0 vdd.t1 12.1202
Rpar18 vdd.t0 vdd.t6 63.9542
Rpar19 vdd.t1 vdd.t6 682.6150
Rpar20 vss vss.t0 228.6057
Rpar21 vss vss.t1 214.9066
Rpar22 vss vss.t8 96.1142
Rpar23 vss vss.t9 104.8941
Rpar24 vss.t0 vss.t1 21.7804
Rpar25 vss.t0 vss.t8 211.4454
Rpar26 vss.t0 vss.t9 230.6898
Rpar27 vss.t1 vss.t8 198.8116
Rpar28 vss.t1 vss.t9 216.9086
Rpar29 vss.t8 vss.t9 21.7407
Cpar0 a_1490_7856.t0 vss 3.15877e-14
Cpar1 a_1490_7856.t20 vss 1.78848e-14
Cpar2 a_1792_2612.t0 vss 4.20512e-15
Cpar3 a_1792_2612.t2 vss 4.31343e-14
Cpar4 a_1792_2612.t3 vss 7.58631e-15
Cpar5 a_2012_6249.t0 vss 1.17803e-14
Cpar6 a_2012_6249.t1 vss 3.09190e-15
Cpar7 a_2012_6249.t4 vss 7.70273e-15
Cpar8 ib vdd 2.02100e-17
Cpar9 ib vss 1.81271e-14
Cpar10 ib.t0 vss 1.98388e-15
Cpar11 ib.t1 vss 1.06620e-16
Cpar12 inn inp 7.18000e-17
Cpar13 inn out 4.65991e-15
Cpar14 inn vdd 1.69783e-14
Cpar15 inn vss 4.03902e-15
Cpar16 inn.t0 vss 2.14524e-14
Cpar17 inp vdd 1.70221e-14
Cpar18 inp vss 4.05147e-15
Cpar19 inp.t0 vss 2.15077e-14
Cpar20 out vdd 4.47672e-15
Cpar21 out vss 1.06432e-14
Cpar22 out.t0 vss 1.32405e-14
Cpar23 out.t7 vss 1.21947e-15
Cpar24 vdd vss 2.02510e-13
Cpar25 vdd.t0 vss 4.12228e-14
Cpar26 vdd.t1 vss 6.31272e-15
Cpar27 vdd.t6 vss 5.12575e-14
.ends opamp_dut

Vdd vdd 0 3.300000
Vss vss 0 0
Ibias vdd ib 1.150000e-07
Vinp inp 0 DC 1.480000 AC 1 PWL(0 1.480000 3.684843e-08 1.480000 4.053328e-08 1.490000)
Rfb out inn 1m
Cload out 0 2.000000e-13
Xdut vdd vss inp inn out ib opamp_dut
.end
