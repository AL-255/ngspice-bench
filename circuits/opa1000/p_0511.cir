* opa1000[0511]: 200f/pmos_5t_1v8_1u_10u_weak (pmos_5t, VDD=1.8V, CL=0.2pF, Iref=1.0uA)
.include "pdk_opa.inc"
.temp 27
.option gmin=1e-12 rshunt=1e12 reltol=1e-3 abstol=1e-12 vntol=1e-5 method=gear
* Post-PEX R+C extracted netlist for pmos_5t_1v8_1u_10u_weak
.subckt opamp_dut vdd vss inp inn out ib
XMpar0 a_1554_2946.t0 inn.t0 out.t0 vdd.t8 pfet_03v3 w=1.88u l=1.6u ad=7.2693e-13 pd=3.2800e-06 as=5.2640e-13 ps=2.4400e-06 nf=1 m=18 par=18
XMpar1 a_1554_2946.t0 inp.t0 a_2346_5053.t4 vdd.t8 pfet_03v3 w=1.88u l=1.6u ad=7.2693e-13 pd=3.2800e-06 as=5.2640e-13 ps=2.4400e-06 nf=1 m=18 par=18
XMpar2 a_1234_2738.t0 ib.t0 vss.t3 vss.t2 nfet_03v3 w=0.71u l=1.6u ad=1.9880e-13 pd=1.2700e-06 as=1.9880e-13 ps=1.2700e-06 nf=1 m=2 par=2
XMpar3 out.t5 a_2346_5053.t0 vss.t1 vss.t0 nfet_03v3 w=1.26u l=1.6u ad=3.5280e-13 pd=1.8200e-06 as=3.5280e-13 ps=1.8200e-06 nf=1 m=2 par=2
XMpar4 a_1554_2946.t36 a_1234_2738.t2 vdd.t1 vdd.t0 pfet_03v3 w=3.08u l=1.6u ad=8.6240e-13 pd=3.6400e-06 as=1.1088e-12 ps=4.5700e-06 nf=1 m=8 par=8
XMpar5 ib.t1 ib.t0 vss.t3 vss.t2 nfet_03v3 w=0.71u l=1.6u ad=4.2600e-13 pd=2.6200e-06 as=1.9880e-13 ps=1.2700e-06 nf=1 m=2 par=2
XMpar6 a_1234_2738.t3 a_1234_2738.t2 vdd.t1 vdd.t0 pfet_03v3 w=3.08u l=1.6u ad=8.6240e-13 pd=3.6400e-06 as=8.6240e-13 ps=3.6400e-06 nf=1 m=2 par=2
XMpar7 a_2346_5053.t1 a_2346_5053.t0 vss.t1 vss.t0 nfet_03v3 w=1.26u l=1.6u ad=7.5600e-13 pd=3.7200e-06 as=3.5280e-13 ps=1.8200e-06 nf=1 m=2 par=2
Rpar0 a_1234_2738.t0 a_1234_2738.t2 123.8704
Rpar1 a_1234_2738.t0 a_1234_2738.t3 57.8100
Rpar2 a_1234_2738.t2 a_1234_2738.t3 23.4532
Rpar3 a_1554_2946.t0 a_1554_2946.t36 35.7307
Rpar4 a_2346_5053.t0 a_2346_5053.t1 20.8373
Rpar5 a_2346_5053.t0 a_2346_5053.t4 179.5759
Rpar6 a_2346_5053.t1 a_2346_5053.t4 94.5792
Rpar7 ib ib.t0 15.5633
Rpar8 ib ib.t1 7.5551
Rpar9 ib.t0 ib.t1 136.6527
Rpar10 inn inn.t0 1.9940
Rpar11 inp inp.t0 1.9940
Rpar12 out out.t0 56.5597
Rpar13 out out.t5 12.9245
Rpar14 vdd vdd.t0 288.1480
Rpar15 vdd vdd.t1 477.5896
Rpar16 vdd vdd.t8 23.3675
Rpar17 vdd.t0 vdd.t1 5.0500
Rpar18 vdd.t0 vdd.t8 138.9621
Rpar19 vdd.t1 vdd.t8 230.3221
Rpar20 vss vss.t0 75.2934
Rpar21 vss vss.t1 73.7086
Rpar22 vss vss.t2 112.5212
Rpar23 vss vss.t3 184.5958
Rpar24 vss.t0 vss.t1 18.1066
Rpar25 vss.t0 vss.t2 324.6296
Rpar26 vss.t0 vss.t3 532.7265
Rpar27 vss.t1 vss.t2 317.9493
Rpar28 vss.t1 vss.t3 521.7637
Rpar29 vss.t2 vss.t3 13.5635
Cpar0 a_1234_2738.t0 vss 1.53556e-15
Cpar1 a_1234_2738.t2 vss 1.51440e-14
Cpar2 a_1234_2738.t3 vss 3.11455e-15
Cpar3 a_1554_2946.t0 vss 3.00288e-14
Cpar4 a_1554_2946.t36 vss 8.02665e-15
Cpar5 a_2346_5053.t0 vss 5.26624e-15
Cpar6 a_2346_5053.t1 vss 3.19999e-15
Cpar7 a_2346_5053.t4 vss 1.42859e-14
Cpar8 ib out 8.26000e-17
Cpar9 ib vdd 4.05000e-17
Cpar10 ib vss 6.98519e-15
Cpar11 ib.t0 vss 8.44552e-16
Cpar12 ib.t1 vss 8.66436e-17
Cpar13 inn inp 1.56820e-16
Cpar14 inn out 5.01941e-15
Cpar15 inn vdd 1.43409e-14
Cpar16 inn vss 4.08734e-15
Cpar17 inn.t0 vss 1.93031e-14
Cpar18 inp vdd 1.44152e-14
Cpar19 inp vss 4.05973e-15
Cpar20 inp.t0 vss 1.93983e-14
Cpar21 out vdd 3.97417e-15
Cpar22 out vss 9.09115e-15
Cpar23 out.t0 vss 1.40815e-14
Cpar24 out.t5 vss 2.48779e-16
Cpar25 vdd vss 1.27984e-13
Cpar26 vdd.t0 vss 1.29014e-14
Cpar27 vdd.t1 vss 6.47770e-15
Cpar28 vdd.t8 vss 4.06703e-14
.ends opamp_dut

Vdd vdd 0 1.800000
Vss vss 0 0
Ibias vdd ib 1.000000e-06
Vinp inp 0 DC 0.805000 AC 1 PWL(0 0.805000 5.157784e-09 0.805000 5.673563e-09 0.815000)
Rfb out inn 1m
Cload out 0 2.000000e-13
Xdut vdd vss inp inn out ib opamp_dut
.end
