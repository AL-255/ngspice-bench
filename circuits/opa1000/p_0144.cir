* opa1000[0144]: 2p/current_reuse_1v8_i150u_weak (current_reuse, VDD=1.8V, CL=2.0pF, Iref=24.6429uA)
.include "pdk_opa.inc"
.temp 27
.option gmin=1e-12 rshunt=1e12 reltol=1e-3 abstol=1e-12 vntol=1e-5 method=gear
* Post-PEX R+C extracted netlist for current_reuse_1v8_i150u_weak
.subckt opamp_dut vdd vss inp inn out ib
XMpar0 a_1000_3264.t0 inn.t12 a_1676_1294.t0 vss.t0 nfet_03v3 w=2u l=0.28u ad=8.6000e-13 pd=2.8600e-06 as=1.0200e-12 ps=3.5200e-06 nf=1 m=8 par=8
XMpar1 a_1000_3264.t8 inn.t0 a_1100_3472.t2 vdd.t14 pfet_03v3 w=1.97u l=0.28u ad=8.4710e-13 pd=2.8300e-06 as=1.0572e-12 ps=3.7000e-06 nf=1 m=12 par=12
XMpar2 out a_928_8248.t24 vdd.t1 vdd.t0 pfet_03v3 w=10u l=0.5u ad=2.8000e-12 pd=1.0560e-05 as=3.0133e-12 ps=1.1269e-05 nf=1 m=30 par=30
XMpar3 out.t24 ib vss.t18 vss.t17 nfet_03v3 w=2.76u l=0.81u ad=8.3168e-13 pd=3.5467e-06 as=7.7280e-13 ps=3.3200e-06 nf=1 m=30 par=30
XMpar4 a_928_8248.t20 a_1000_3264.t20 vdd.t1 vdd.t0 pfet_03v3 w=10u l=0.5u ad=3.8667e-12 pd=1.4107e-05 as=2.8000e-12 ps=1.0560e-05 nf=1 m=3 par=3
XMpar5 a_1000_3264.t21 a_1000_3264.t20 vdd.t1 vdd.t0 pfet_03v3 w=10u l=0.5u ad=3.8667e-12 pd=1.4107e-05 as=2.8000e-12 ps=1.0560e-05 nf=1 m=3 par=3
XMpar6 a_1100_3472.t0 a_1000_3264.t20 vdd.t1 vdd.t0 pfet_03v3 w=10u l=0.5u ad=2.8000e-12 pd=1.0560e-05 as=3.8667e-12 ps=1.4107e-05 nf=1 m=6 par=6
XMpar7 ib.t1 ib vss.t18 vss.t17 nfet_03v3 w=2.76u l=0.81u ad=7.7280e-13 pd=3.3200e-06 as=1.0672e-12 ps=4.4533e-06 nf=1 m=6 par=6
XMpar8 a_1676_1294.t0 inp.t12 a_928_8248.t0 vss.t0 nfet_03v3 w=2u l=0.28u ad=1.0200e-12 pd=3.5200e-06 as=8.6000e-13 ps=2.8600e-06 nf=1 m=8 par=8
XMpar9 a_1676_1294.t16 ib vss.t18 vss.t17 nfet_03v3 w=2.76u l=0.81u ad=7.7280e-13 pd=3.3200e-06 as=7.7280e-13 ps=3.3200e-06 nf=1 m=12 par=12
XMpar10 a_1100_3472.t2 inp.t0 a_928_8248.t8 vdd.t14 pfet_03v3 w=1.97u l=0.28u ad=1.0572e-12 pd=3.7000e-06 as=8.4710e-13 ps=2.8300e-06 nf=1 m=12 par=12
X36 a_1260_8248.t1 out.t7 cap_mim_2f0fF c_width=18.91u c_length=18.91u
X60 a_1260_8248.t1 out.t7 cap_mim_2f0fF c_width=18.91u c_length=18.91u
X74 a_1260_8248.t1 out.t7 cap_mim_2f0fF c_width=18.91u c_length=18.91u
X86 a_928_8248.t22 a_1260_8248.t0 vss.t16 ppolyf_u_1k r_width=1u r_length=1u
X134 a_1260_8248.t1 out.t7 cap_mim_2f0fF c_width=18.91u c_length=18.91u
Rpar0 a_1000_3264.t0 a_1000_3264.t8 44.1582
Rpar1 a_1000_3264.t0 a_1000_3264.t20 216.6565
Rpar2 a_1000_3264.t0 a_1000_3264.t21 196.5098
Rpar3 a_1000_3264.t8 a_1000_3264.t20 120.2266
Rpar4 a_1000_3264.t8 a_1000_3264.t21 232.5441
Rpar5 a_1000_3264.t20 a_1000_3264.t21 32.7304
Rpar6 a_1100_3472.t0 a_1100_3472.t2 45.9898
Rpar7 a_1260_8248.t0 a_1260_8248.t1 80.9823
Rpar8 a_1676_1294.t0 a_1676_1294.t16 48.0113
Rpar9 a_928_8248.t0 a_928_8248.t8 60.7888
Rpar10 a_928_8248.t0 a_928_8248.t20 298.1758
Rpar11 a_928_8248.t0 a_928_8248.t22 194.4671
Rpar12 a_928_8248.t0 a_928_8248.t24 138.3527
Rpar13 a_928_8248.t8 a_928_8248.t20 485.4050
Rpar14 a_928_8248.t8 a_928_8248.t22 316.5760
Rpar15 a_928_8248.t8 a_928_8248.t24 225.2266
Rpar16 a_928_8248.t20 a_928_8248.t22 197.4370
Rpar17 a_928_8248.t20 a_928_8248.t24 140.4657
Rpar18 a_928_8248.t22 a_928_8248.t24 91.6102
Rpar19 ib ib.t1 14.5473
Rpar20 inn inn.t0 55.0961
Rpar21 inn inn.t12 6.9834
Rpar22 inp inp.t0 45.6551
Rpar23 inp inp.t12 7.0320
Rpar24 out out.t24 90.7127
Rpar25 out out.t7 72.3349
Rpar26 out.t24 out.t7 120.4252
Rpar27 vdd vdd.t0 23.1554
Rpar28 vdd vdd.t1 122.6576
Rpar29 vdd vdd.t14 508.1834
Rpar30 vdd.t0 vdd.t1 1.9722
Rpar31 vdd.t0 vdd.t14 35.4661
Rpar32 vdd.t1 vdd.t14 173.1287
Rpar33 vss vss.t0 235.2830
Rpar34 vss vss.t18 712.2477
Rpar35 vss vss.t17 115.0996
Rpar36 vss vss.t16 490.0533
Rpar37 vss.t0 vss.t18 440.3757
Rpar38 vss.t0 vss.t17 65.5805
Rpar39 vss.t0 vss.t16 144.2551
Rpar40 vss.t18 vss.t17 2.0003
Rpar41 vss.t18 vss.t16 938.7550
Rpar42 vss.t17 vss.t16 147.2101
Cpar0 a_1000_3264.t0 vss 8.81198e-15
Cpar1 a_1000_3264.t20 vss 1.43173e-14
Cpar2 a_1000_3264.t21 vss 1.15728e-14
Cpar3 a_1000_3264.t8 vss 1.17776e-14
Cpar4 a_1100_3472.t0 vss 1.28241e-14
Cpar5 a_1100_3472.t2 vss 1.96098e-14
Cpar6 a_1260_8248.t0 vss 1.69593e-16
Cpar7 a_1260_8248.t1 vss 1.40249e-14
Cpar8 a_1676_1294.t0 vss 8.34046e-15
Cpar9 a_1676_1294.t16 vss 1.03334e-14
Cpar10 a_928_8248.t0 vss 6.26218e-15
Cpar11 a_928_8248.t20 vss 9.45753e-15
Cpar12 a_928_8248.t22 vss 3.16157e-15
Cpar13 a_928_8248.t24 vss 3.30264e-14
Cpar14 a_928_8248.t8 vss 8.00187e-15
Cpar15 ib out 3.41018e-15
Cpar16 ib vdd 8.25610e-16
Cpar17 ib vss 5.06149e-14
Cpar18 ib.t1 vss 1.15607e-15
Cpar19 inn inp 1.51670e-16
Cpar20 inn out 2.74700e-17
Cpar21 inn vdd 5.85582e-15
Cpar22 inn vss 8.50669e-15
Cpar23 inn.t0 vss 6.39213e-15
Cpar24 inn.t12 vss 1.01076e-15
Cpar25 inp vdd 6.37301e-15
Cpar26 inp vss 8.53356e-15
Cpar27 inp.t0 vss 6.38970e-15
Cpar28 inp.t12 vss 1.05920e-15
Cpar29 out vdd 5.34221e-14
Cpar30 out vss 6.35356e-14
Cpar31 out.t24 vss 1.47394e-14
Cpar32 out.t7 vss 3.64528e-14
Cpar33 vdd vss 1.81311e-13
Cpar34 vdd.t0 vss 6.38406e-14
Cpar35 vdd.t1 vss 3.19867e-14
Cpar36 vdd.t14 vss 2.58165e-14
.ends opamp_dut

Vdd vdd 0 1.800000
Vss vss 0 0
Ibias vdd ib 2.464290e-05
Vinp inp 0 DC 0.895000 AC 1 PWL(0 0.895000 3.098015e-09 0.895000 3.407817e-09 0.905000)
Rfb out inn 1m
Cload out 0 2.000000e-12
Xdut vdd vss inp inn out ib opamp_dut
.end
