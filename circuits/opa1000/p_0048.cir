* opa1000[0048]: 2p/cherry_hooper_1v8_i1u_weak (cherry_hooper, VDD=1.8V, CL=2.0pF, Iref=0.05uA)
.include "pdk_opa.inc"
.temp 27
.option gmin=1e-12 rshunt=1e12 reltol=1e-3 abstol=1e-12 vntol=1e-5 method=gear
* Post-PEX R+C extracted netlist for cherry_hooper_1v8_i1u_weak
.subckt opamp_dut vdd vss inp inn out ib
XMpar0 a_2019_9931.t0 ib vss.t2 vss.t1 nfet_03v3 w=0.4u l=3.5u ad=1.1200e-13 pd=9.6000e-07 as=1.5467e-13 ps=1.3067e-06 nf=1 m=6 par=6
XMpar1 a_12134_9060.t4 a_1297_2755.t1 vdd.t8 vdd.t7 pfet_03v3 w=0.57u l=3.5u ad=1.5960e-13 pd=1.1300e-06 as=3.4200e-13 ps=2.3400e-06 nf=1 m=2 par=2
XMpar2 a_10894_1339.t2 inp.t0 a_3643_9931.t4 vss.t44 nfet_03v3 w=0.4u l=2.4u ad=1.1200e-13 pd=9.6000e-07 as=2.4000e-13 ps=2.0000e-06 nf=1 m=2 par=2
XMpar3 out.t1 a_11358_15323.t1 vdd.t2 vdd.t1 pfet_03v3 w=0.86u l=1.3u ad=2.4080e-13 pd=1.4200e-06 as=2.4080e-13 ps=1.4200e-06 nf=1 m=4 par=4
XMpar4 a_3613_8294.t0 a_12014_6554.t9 out.t0 vss.t0 nfet_03v3 w=9.44u l=2.4u ad=5.6640e-12 pd=2.0080e-05 as=5.6640e-12 ps=2.0080e-05 nf=1 m=1
XMpar5 a_11358_15323.t2 a_11358_15323.t1 vdd.t2 vdd.t1 pfet_03v3 w=0.86u l=1.3u ad=5.1600e-13 pd=2.9200e-06 as=2.4080e-13 ps=1.4200e-06 nf=1 m=4 par=4
XMpar6 a_3613_8294.t1 ib vss.t2 vss.t1 nfet_03v3 w=0.4u l=3.5u ad=1.1200e-13 pd=9.6000e-07 as=1.4400e-13 ps=1.2200e-06 nf=1 m=8 par=8
XMpar7 a_1238_4874.t0 a_1358_4666.t0 a_1358_4666.t1 vdd.t0 pfet_03v3 w=10u l=1u ad=3.2000e-12 pd=1.1890e-05 as=2.8000e-12 ps=1.0560e-05 nf=1 m=16 par=16
XMpar8 a_3643_9931.t0 ib vss.t2 vss.t1 nfet_03v3 w=0.4u l=3.5u ad=1.1200e-13 pd=9.6000e-07 as=1.1200e-13 ps=9.6000e-07 nf=1 m=4 par=4
XMpar9 a_10089_2845.t0 a_1358_4666.t33 a_10894_1339.t0 vdd.t11 pfet_03v3 w=6.47u l=1u ad=3.8820e-12 pd=1.4140e-05 as=1.8116e-12 ps=7.0300e-06 nf=1 m=2 par=2
XMpar10 a_12014_6554.t0 a_1358_4666.t33 a_12134_9060.t0 vdd.t11 pfet_03v3 w=6.47u l=1u ad=3.8820e-12 pd=1.4140e-05 as=1.8116e-12 ps=7.0300e-06 nf=1 m=2 par=2
XMpar11 a_12014_6554.t4 a_12014_6554.t3 vdd.t2 vdd.t1 pfet_03v3 w=0.86u l=1.3u ad=3.3253e-13 pd=1.9200e-06 as=3.3253e-13 ps=1.9200e-06 nf=1 m=3 par=3
XMpar12 a_10089_2845.t2 a_10894_1339.t6 a_2019_9931.t6 vss.t0 nfet_03v3 w=7.08u l=2.4u ad=4.2480e-12 pd=1.5360e-05 as=4.2480e-12 ps=1.5360e-05 nf=1 m=1
XMpar13 a_10894_1339.t4 a_1297_2755.t1 vdd.t8 vdd.t7 pfet_03v3 w=0.57u l=3.5u ad=1.5960e-13 pd=1.1300e-06 as=3.4200e-13 ps=2.3400e-06 nf=1 m=2 par=2
XMpar14 a_12134_9060.t2 inn.t0 a_3643_9931.t4 vss.t44 nfet_03v3 w=0.4u l=2.4u ad=1.1200e-13 pd=9.6000e-07 as=2.4000e-13 ps=2.0000e-06 nf=1 m=2 par=2
XMpar15 a_1297_2755.t0 ib vss.t2 vss.t1 nfet_03v3 w=0.4u l=3.5u ad=2.4000e-13 pd=2.0000e-06 as=1.1200e-13 ps=9.6000e-07 nf=1 m=1
XMpar16 a_10089_2845.t4 a_10089_2845.t3 vdd.t2 vdd.t1 pfet_03v3 w=0.86u l=1.3u ad=3.3253e-13 pd=1.9200e-06 as=3.3253e-13 ps=1.9200e-06 nf=1 m=3 par=3
XMpar17 a_11358_15323.t0 a_10089_2845.t9 a_3613_8294.t0 vss.t0 nfet_03v3 w=9.44u l=2.4u ad=5.6640e-12 pd=2.0080e-05 as=5.6640e-12 ps=2.0080e-05 nf=1 m=1
XMpar18 a_12014_6554.t2 a_12134_9060.t6 a_2019_9931.t6 vss.t0 nfet_03v3 w=7.08u l=2.4u ad=4.2480e-12 pd=1.5360e-05 as=4.2480e-12 ps=1.5360e-05 nf=1 m=1
XMpar19 ib.t1 ib vss.t2 vss.t1 nfet_03v3 w=0.4u l=3.5u ad=2.4000e-13 pd=2.0000e-06 as=1.1200e-13 ps=9.6000e-07 nf=1 m=1
XMpar20 a_1297_2755.t2 a_1297_2755.t1 vdd.t8 vdd.t7 pfet_03v3 w=0.57u l=3.5u ad=3.4200e-13 pd=2.3400e-06 as=3.4200e-13 ps=2.3400e-06 nf=1 m=1
XMpar21 a_1238_4874.t17 a_1238_4874.t16 vdd.t2 vdd.t1 pfet_03v3 w=0.86u l=1.3u ad=5.1600e-13 pd=2.9200e-06 as=5.1600e-13 ps=2.9200e-06 nf=1 m=1
XMpar22 a_1358_4666.t32 ib vss.t2 vss.t1 nfet_03v3 w=0.4u l=3.5u ad=2.4000e-13 pd=2.0000e-06 as=2.4000e-13 ps=2.0000e-06 nf=1 m=1
X12 out.t5 vss.t46 cap_mim_2f0fF c_width=18.71u c_length=18.71u
X22 out.t5 vss.t46 cap_mim_2f0fF c_width=18.71u c_length=18.71u
X23 out.t5 vss.t46 cap_mim_2f0fF c_width=18.71u c_length=18.71u
X63 out.t5 vss.t46 cap_mim_2f0fF c_width=18.71u c_length=18.71u
Rpar0 a_10089_2845.t0 a_10089_2845.t2 84.9017
Rpar1 a_10089_2845.t0 a_10089_2845.t3 204.2656
Rpar2 a_10089_2845.t0 a_10089_2845.t4 94.4539
Rpar3 a_10089_2845.t0 a_10089_2845.t9 167.0593
Rpar4 a_10089_2845.t2 a_10089_2845.t3 778.1008
Rpar5 a_10089_2845.t2 a_10089_2845.t4 359.7993
Rpar6 a_10089_2845.t2 a_10089_2845.t9 65.7794
Rpar7 a_10089_2845.t3 a_10089_2845.t4 23.4193
Rpar8 a_10089_2845.t3 a_10089_2845.t9 1531.0532
Rpar9 a_10089_2845.t4 a_10089_2845.t9 707.9698
Rpar10 a_10894_1339.t0 a_10894_1339.t2 89.2454
Rpar11 a_10894_1339.t0 a_10894_1339.t4 169.0923
Rpar12 a_10894_1339.t0 a_10894_1339.t6 61.0464
Rpar13 a_10894_1339.t2 a_10894_1339.t4 116.4202
Rpar14 a_10894_1339.t2 a_10894_1339.t6 162.6747
Rpar15 a_10894_1339.t4 a_10894_1339.t6 308.2179
Rpar16 a_11358_15323.t0 a_11358_15323.t1 119.3355
Rpar17 a_11358_15323.t0 a_11358_15323.t2 60.0706
Rpar18 a_11358_15323.t1 a_11358_15323.t2 10.2650
Rpar19 a_12014_6554.t0 a_12014_6554.t2 84.9017
Rpar20 a_12014_6554.t0 a_12014_6554.t3 204.2656
Rpar21 a_12014_6554.t0 a_12014_6554.t4 94.4539
Rpar22 a_12014_6554.t0 a_12014_6554.t9 167.0593
Rpar23 a_12014_6554.t2 a_12014_6554.t3 778.1008
Rpar24 a_12014_6554.t2 a_12014_6554.t4 359.7993
Rpar25 a_12014_6554.t2 a_12014_6554.t9 65.7794
Rpar26 a_12014_6554.t3 a_12014_6554.t4 23.4193
Rpar27 a_12014_6554.t3 a_12014_6554.t9 1531.0532
Rpar28 a_12014_6554.t4 a_12014_6554.t9 707.9698
Rpar29 a_12134_9060.t0 a_12134_9060.t2 89.2454
Rpar30 a_12134_9060.t0 a_12134_9060.t4 169.0923
Rpar31 a_12134_9060.t0 a_12134_9060.t6 61.0464
Rpar32 a_12134_9060.t2 a_12134_9060.t4 116.4202
Rpar33 a_12134_9060.t2 a_12134_9060.t6 162.6747
Rpar34 a_12134_9060.t4 a_12134_9060.t6 308.2179
Rpar35 a_1238_4874.t0 a_1238_4874.t16 131.7890
Rpar36 a_1238_4874.t0 a_1238_4874.t17 58.2983
Rpar37 a_1238_4874.t16 a_1238_4874.t17 54.6049
Rpar38 a_1297_2755.t0 a_1297_2755.t1 68.9684
Rpar39 a_1297_2755.t0 a_1297_2755.t2 123.7581
Rpar40 a_1297_2755.t1 a_1297_2755.t2 31.3731
Rpar41 a_1358_4666.t0 a_1358_4666.t1 16.8167
Rpar42 a_1358_4666.t0 a_1358_4666.t32 3401.4749
Rpar43 a_1358_4666.t0 a_1358_4666.t33 5122.4790
Rpar44 a_1358_4666.t1 a_1358_4666.t32 65.1875
Rpar45 a_1358_4666.t1 a_1358_4666.t33 98.1696
Rpar46 a_1358_4666.t32 a_1358_4666.t33 123.8101
Rpar47 a_2019_9931.t0 a_2019_9931.t6 48.4761
Rpar48 a_3613_8294.t0 a_3613_8294.t1 50.9578
Rpar49 a_3643_9931.t0 a_3643_9931.t4 75.0756
Rpar50 ib ib.t1 25.6871
Rpar51 inn inn.t0 3.8284
Rpar52 inp inp.t0 3.8769
Rpar53 out out.t0 82.3015
Rpar54 out out.t1 88.5245
Rpar55 out out.t5 18.6208
Rpar56 out.t0 out.t1 169.2918
Rpar57 out.t0 out.t5 334.7002
Rpar58 out.t1 out.t5 360.0078
Rpar59 vdd vdd.t1 319.4778
Rpar60 vdd vdd.t2 92.2500
Rpar61 vdd vdd.t11 247.1437
Rpar62 vdd vdd.t8 6413.4909
Rpar63 vdd.t0 vdd.t1 192.1082
Rpar64 vdd.t0 vdd.t2 164.6030
Rpar65 vdd.t0 vdd.t11 1007.9346
Rpar66 vdd.t0 vdd.t7 429.0406
Rpar67 vdd.t0 vdd.t8 138.4141
Rpar68 vdd.t1 vdd.t2 4.8063
Rpar69 vdd.t1 vdd.t11 178.6124
Rpar70 vdd.t1 vdd.t7 320.2215
Rpar71 vdd.t1 vdd.t8 100.7288
Rpar72 vdd.t2 vdd.t11 90.6399
Rpar73 vdd.t2 vdd.t7 270.4370
Rpar74 vdd.t2 vdd.t8 85.6327
Rpar75 vdd.t11 vdd.t7 1760.2793
Rpar76 vdd.t11 vdd.t8 525.2751
Rpar77 vdd.t7 vdd.t8 13.6746
Rpar78 vss vss.t0 507.8735
Rpar79 vss vss.t1 73.2645
Rpar80 vss vss.t2 195.8042
Rpar81 vss vss.t44 107.5511
Rpar82 vss vss.t46 475.5628
Rpar83 vss.t0 vss.t1 75.4747
Rpar84 vss.t0 vss.t2 174.9475
Rpar85 vss.t0 vss.t44 80.1593
Rpar86 vss.t0 vss.t46 630.8941
Rpar87 vss.t1 vss.t2 3.0945
Rpar88 vss.t1 vss.t44 88.9527
Rpar89 vss.t1 vss.t46 433.8184
Rpar90 vss.t2 vss.t44 192.4412
Rpar91 vss.t2 vss.t46 944.8050
Rpar92 vss.t44 vss.t46 113.2743
Cpar0 a_10089_2845.t0 vss 5.43935e-15
Cpar1 a_10089_2845.t2 vss 3.54889e-15
Cpar2 a_10089_2845.t3 vss 2.42322e-15
Cpar3 a_10089_2845.t4 vss 2.03019e-15
Cpar4 a_10089_2845.t9 vss 4.07507e-15
Cpar5 a_10894_1339.t0 vss 3.53867e-15
Cpar6 a_10894_1339.t2 vss 2.06809e-15
Cpar7 a_10894_1339.t4 vss 2.23707e-15
Cpar8 a_10894_1339.t6 vss 3.58347e-15
Cpar9 a_11358_15323.t0 vss 4.86356e-15
Cpar10 a_11358_15323.t1 vss 8.82673e-15
Cpar11 a_11358_15323.t2 vss 5.10127e-15
Cpar12 a_12014_6554.t0 vss 4.88731e-15
Cpar13 a_12014_6554.t2 vss 3.18871e-15
Cpar14 a_12014_6554.t3 vss 2.17727e-15
Cpar15 a_12014_6554.t4 vss 1.82413e-15
Cpar16 a_12014_6554.t9 vss 3.66149e-15
Cpar17 a_12134_9060.t0 vss 3.31382e-15
Cpar18 a_12134_9060.t2 vss 1.93669e-15
Cpar19 a_12134_9060.t4 vss 2.09493e-15
Cpar20 a_12134_9060.t6 vss 3.35578e-15
Cpar21 a_1238_4874.t0 vss 2.72443e-14
Cpar22 a_1238_4874.t16 vss 9.74456e-16
Cpar23 a_1238_4874.t17 vss 1.16893e-15
Cpar24 a_1297_2755.t0 vss 3.16136e-15
Cpar25 a_1297_2755.t1 vss 1.30160e-14
Cpar26 a_1297_2755.t2 vss 2.09384e-15
Cpar27 a_1358_4666.t0 vss 2.10220e-14
Cpar28 a_1358_4666.t1 vss 1.88614e-14
Cpar29 a_1358_4666.t32 vss 1.68958e-15
Cpar30 a_1358_4666.t33 vss 4.68552e-15
Cpar31 a_2019_9931.t0 vss 3.47675e-15
Cpar32 a_2019_9931.t6 vss 4.49573e-15
Cpar33 a_3613_8294.t0 vss 3.69847e-15
Cpar34 a_3613_8294.t1 vss 2.35273e-15
Cpar35 a_3643_9931.t0 vss 6.07490e-15
Cpar36 a_3643_9931.t4 vss 4.56451e-15
Cpar37 ib vdd 4.03759e-15
Cpar38 ib vss 5.56060e-14
Cpar39 ib.t1 vss 4.99000e-16
Cpar40 inn inp 5.19700e-17
Cpar41 inn vdd 7.19200e-17
Cpar42 inn vss 3.04965e-15
Cpar43 inn.t0 vss 3.06957e-16
Cpar44 inp vdd 1.52800e-17
Cpar45 inp vss 3.02718e-15
Cpar46 inp.t0 vss 2.92431e-16
Cpar47 out vdd 5.58728e-15
Cpar48 out vss 3.09320e-14
Cpar49 out.t0 vss 9.86039e-17
Cpar50 out.t1 vss 9.63407e-17
Cpar51 out.t5 vss 1.11112e-14
Cpar52 vdd vss 1.87330e-13
Cpar53 vdd.t0 vss 2.49265e-14
Cpar54 vdd.t1 vss 1.67683e-14
Cpar55 vdd.t11 vss 9.07221e-15
Cpar56 vdd.t2 vss 1.02582e-14
Cpar57 vdd.t7 vss 5.24787e-15
Cpar58 vdd.t8 vss 8.23481e-15
.ends opamp_dut

Vdd vdd 0 1.800000
Vss vss 0 0
Ibias vdd ib 5.000000e-08
Vinp inp 0 DC 1.193700 AC 1 PWL(0 1.193700 1.397065e-07 1.193700 1.536771e-07 1.203700)
Rfb out inn 1m
Cload out 0 2.000000e-12
Xdut vdd vss inp inn out ib opamp_dut
.end
