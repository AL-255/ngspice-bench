* opa1000[0052]: 2p/cherry_hooper_1v8_1u_10u_weak (cherry_hooper, VDD=1.8V, CL=2.0pF, Iref=0.25uA)
.include "pdk_opa.inc"
.temp 27
.option gmin=1e-12 rshunt=1e12 reltol=1e-3 abstol=1e-12 vntol=1e-5 method=gear
* Post-PEX R+C extracted netlist for cherry_hooper_1v8_1u_10u_weak
.subckt opamp_dut vdd vss inp inn out ib
XMpar0 a_1284_3015.t0 a_5052_4717.t1 a_5052_4717.t2 vdd.t1 pfet_03v3 w=10u l=0.6u ad=3.2000e-12 pd=1.1890e-05 as=2.8000e-12 ps=1.0560e-05 nf=1 m=16 par=16
XMpar1 a_11082_3224.t0 a_5052_4717.t33 a_11402_3224.t3 vdd.t0 pfet_03v3 w=6.85u l=1u ad=2.6487e-12 pd=9.9067e-06 as=2.6487e-12 ps=9.9067e-06 nf=1 m=3 par=3
XMpar2 a_6360_8524.t0 ib.t0 vss.t1 vss.t0 nfet_03v3 w=0.73u l=3u ad=4.3800e-13 pd=2.6600e-06 as=3.2120e-13 ps=1.9750e-06 nf=1 m=4 par=4
XMpar3 a_7792_8524.t0 ib.t0 vss.t1 vss.t0 nfet_03v3 w=0.73u l=3u ad=4.3800e-13 pd=2.6600e-06 as=2.0440e-13 ps=1.2900e-06 nf=1 m=2 par=2
XMpar4 a_11620_16950.t2 a_11620_16950.t1 vdd.t6 vdd.t5 pfet_03v3 w=1.89u l=0.6u ad=7.3080e-13 pd=3.2933e-06 as=5.2920e-13 ps=2.4500e-06 nf=1 m=3 par=3
XMpar5 a_4812_1086.t2 a_4812_1086.t1 vdd.t17 vdd.t16 pfet_03v3 w=2.1u l=3u ad=1.2600e-12 pd=5.4000e-06 as=1.2600e-12 ps=5.4000e-06 nf=1 m=1
XMpar6 out.t0 a_11620_16950.t1 vdd.t6 vdd.t5 pfet_03v3 w=1.89u l=0.6u ad=7.3080e-13 pd=3.2933e-06 as=5.2920e-13 ps=2.4500e-06 nf=1 m=3 par=3
XMpar7 a_11082_3224.t4 a_11082_3224.t3 vdd.t6 vdd.t5 pfet_03v3 w=1.89u l=0.6u ad=5.2920e-13 pd=2.4500e-06 as=1.1340e-12 ps=4.9800e-06 nf=1 m=2 par=2
XMpar8 a_5237_3224.t0 ib.t0 vss.t1 vss.t0 nfet_03v3 w=0.73u l=3u ad=2.0440e-13 pd=1.2900e-06 as=2.8227e-13 ps=1.7467e-06 nf=1 m=6 par=6
XMpar9 a_5237_3224.t6 a_12334_8480.t8 out.t3 vss.t28 nfet_03v3 w=7.83u l=0.5u ad=4.6980e-12 pd=1.6860e-05 as=4.6980e-12 ps=1.6860e-05 nf=1 m=1
XMpar10 a_4812_1086.t0 ib.t0 vss.t1 vss.t0 nfet_03v3 w=0.73u l=3u ad=4.3800e-13 pd=2.6600e-06 as=2.0440e-13 ps=1.2900e-06 nf=1 m=1
XMpar11 a_1284_3015.t16 a_1284_3015.t15 vdd.t6 vdd.t5 pfet_03v3 w=1.89u l=0.6u ad=1.1340e-12 pd=4.9800e-06 as=1.1340e-12 ps=4.9800e-06 nf=1 m=1
XMpar12 a_12334_8480.t5 a_12334_8480.t4 vdd.t6 vdd.t5 pfet_03v3 w=1.89u l=0.6u ad=5.2920e-13 pd=2.4500e-06 as=1.1340e-12 ps=4.9800e-06 nf=1 m=2 par=2
XMpar13 a_12334_1294.t3 a_4812_1086.t1 vdd.t17 vdd.t16 pfet_03v3 w=2.1u l=3u ad=1.2600e-12 pd=5.4000e-06 as=1.2600e-12 ps=5.4000e-06 nf=1 m=1
XMpar14 a_12334_8480.t0 a_12334_1294.t6 a_6360_8524.t4 vss.t27 nfet_03v3 w=5.22u l=0.5u ad=3.1320e-12 pd=1.1640e-05 as=3.1320e-12 ps=1.1640e-05 nf=1 m=1
XMpar15 a_12334_1294.t0 a_5052_4717.t33 a_12334_8480.t1 vdd.t0 pfet_03v3 w=6.85u l=1u ad=2.6487e-12 pd=9.9067e-06 as=2.6487e-12 ps=9.9067e-06 nf=1 m=3 par=3
XMpar16 a_11082_3224.t7 a_11402_3224.t6 a_6360_8524.t4 vss.t27 nfet_03v3 w=5.22u l=0.5u ad=3.1320e-12 pd=1.1640e-05 as=3.1320e-12 ps=1.1640e-05 nf=1 m=1
XMpar17 a_12334_1294.t1 inn.t0 a_7792_8524.t2 vss.t30 nfet_03v3 w=0.46u l=2u ad=1.2880e-13 pd=1.0200e-06 as=2.7600e-13 ps=2.1200e-06 nf=1 m=2 par=2
XMpar18 a_5052_4717.t0 ib.t0 vss.t1 vss.t0 nfet_03v3 w=0.73u l=3u ad=4.3800e-13 pd=2.6600e-06 as=4.3800e-13 ps=2.6600e-06 nf=1 m=1
XMpar19 a_11402_3224.t1 inp.t0 a_7792_8524.t2 vss.t30 nfet_03v3 w=0.46u l=2u ad=1.2880e-13 pd=1.0200e-06 as=2.7600e-13 ps=2.1200e-06 nf=1 m=2 par=2
XMpar20 ib.t1 ib.t0 vss.t1 vss.t0 nfet_03v3 w=0.73u l=3u ad=4.3800e-13 pd=2.6600e-06 as=2.0440e-13 ps=1.2900e-06 nf=1 m=1
XMpar21 a_11620_16950.t0 a_11082_3224.t8 a_5237_3224.t6 vss.t28 nfet_03v3 w=7.83u l=0.5u ad=4.6980e-12 pd=1.6860e-05 as=4.6980e-12 ps=1.6860e-05 nf=1 m=1
XMpar22 a_11402_3224.t0 a_4812_1086.t1 vdd.t17 vdd.t16 pfet_03v3 w=2.1u l=3u ad=1.2600e-12 pd=5.4000e-06 as=1.2600e-12 ps=5.4000e-06 nf=1 m=1
X11 out.t4 vss.t35 cap_mim_2f0fF c_width=17.8u c_length=17.8u
X39 out.t4 vss.t35 cap_mim_2f0fF c_width=17.8u c_length=17.8u
X50 out.t4 vss.t35 cap_mim_2f0fF c_width=17.8u c_length=17.8u
Rpar0 a_11082_3224.t0 a_11082_3224.t3 490.9284
Rpar1 a_11082_3224.t0 a_11082_3224.t4 119.4662
Rpar2 a_11082_3224.t0 a_11082_3224.t7 86.7847
Rpar3 a_11082_3224.t0 a_11082_3224.t8 599.0534
Rpar4 a_11082_3224.t3 a_11082_3224.t4 55.8841
Rpar5 a_11082_3224.t3 a_11082_3224.t7 334.7263
Rpar6 a_11082_3224.t3 a_11082_3224.t8 1038.6387
Rpar7 a_11082_3224.t4 a_11082_3224.t7 81.4548
Rpar8 a_11082_3224.t4 a_11082_3224.t8 252.7502
Rpar9 a_11082_3224.t7 a_11082_3224.t8 408.4484
Rpar10 a_11402_3224.t0 a_11402_3224.t1 151.7859
Rpar11 a_11402_3224.t0 a_11402_3224.t3 69.7645
Rpar12 a_11402_3224.t0 a_11402_3224.t6 540.5879
Rpar13 a_11402_3224.t1 a_11402_3224.t3 113.9768
Rpar14 a_11402_3224.t1 a_11402_3224.t6 165.1400
Rpar15 a_11402_3224.t3 a_11402_3224.t6 405.9304
Rpar16 a_11620_16950.t0 a_11620_16950.t1 226.4690
Rpar17 a_11620_16950.t0 a_11620_16950.t2 62.9543
Rpar18 a_11620_16950.t1 a_11620_16950.t2 21.6885
Rpar19 a_12334_1294.t0 a_12334_1294.t1 113.9768
Rpar20 a_12334_1294.t0 a_12334_1294.t3 69.7645
Rpar21 a_12334_1294.t0 a_12334_1294.t6 405.9304
Rpar22 a_12334_1294.t1 a_12334_1294.t3 151.7859
Rpar23 a_12334_1294.t1 a_12334_1294.t6 165.1400
Rpar24 a_12334_1294.t3 a_12334_1294.t6 540.5879
Rpar25 a_12334_8480.t0 a_12334_8480.t1 86.7847
Rpar26 a_12334_8480.t0 a_12334_8480.t4 334.7263
Rpar27 a_12334_8480.t0 a_12334_8480.t5 81.4548
Rpar28 a_12334_8480.t0 a_12334_8480.t8 408.4484
Rpar29 a_12334_8480.t1 a_12334_8480.t4 490.9284
Rpar30 a_12334_8480.t1 a_12334_8480.t5 119.4662
Rpar31 a_12334_8480.t1 a_12334_8480.t8 599.0534
Rpar32 a_12334_8480.t4 a_12334_8480.t5 55.8841
Rpar33 a_12334_8480.t4 a_12334_8480.t8 1038.6387
Rpar34 a_12334_8480.t5 a_12334_8480.t8 252.7502
Rpar35 a_1284_3015.t0 a_1284_3015.t15 312.9825
Rpar36 a_1284_3015.t0 a_1284_3015.t16 60.8218
Rpar37 a_1284_3015.t15 a_1284_3015.t16 61.7410
Rpar38 a_4812_1086.t0 a_4812_1086.t1 183.1750
Rpar39 a_4812_1086.t0 a_4812_1086.t2 194.0600
Rpar40 a_4812_1086.t1 a_4812_1086.t2 23.3632
Rpar41 a_5052_4717.t0 a_5052_4717.t1 7060.1276
Rpar42 a_5052_4717.t0 a_5052_4717.t2 147.2517
Rpar43 a_5052_4717.t0 a_5052_4717.t33 303.2476
Rpar44 a_5052_4717.t1 a_5052_4717.t2 18.8008
Rpar45 a_5052_4717.t1 a_5052_4717.t33 2780.4672
Rpar46 a_5052_4717.t2 a_5052_4717.t33 57.9917
Rpar47 a_5237_3224.t0 a_5237_3224.t6 105.0199
Rpar48 a_6360_8524.t0 a_6360_8524.t4 47.7491
Rpar49 a_7792_8524.t0 a_7792_8524.t2 76.8114
Rpar50 ib ib.t0 9.3488
Rpar51 ib ib.t1 13.7034
Rpar52 inn inn.t0 4.3060
Rpar53 inp inp.t0 4.3546
Rpar54 out out.t0 73.2648
Rpar55 out out.t3 124.5188
Rpar56 out out.t4 18.0120
Rpar57 out.t0 out.t3 54.9259
Rpar58 out.t0 out.t4 305.7637
Rpar59 out.t3 out.t4 519.6675
Rpar60 vdd vdd.t0 1793.6941
Rpar61 vdd vdd.t1 3092.7907
Rpar62 vdd vdd.t5 75.0531
Rpar63 vdd vdd.t6 62.7698
Rpar64 vdd vdd.t17 3516.3299
Rpar65 vdd.t0 vdd.t1 77.0076
Rpar66 vdd.t0 vdd.t5 260.8691
Rpar67 vdd.t0 vdd.t6 112.5415
Rpar68 vdd.t0 vdd.t16 260.8233
Rpar69 vdd.t0 vdd.t17 80.9456
Rpar70 vdd.t1 vdd.t5 457.3580
Rpar71 vdd.t1 vdd.t6 197.7488
Rpar72 vdd.t1 vdd.t16 486.4385
Rpar73 vdd.t1 vdd.t17 150.9645
Rpar74 vdd.t5 vdd.t6 4.0356
Rpar75 vdd.t5 vdd.t16 618.0175
Rpar76 vdd.t5 vdd.t17 241.2147
Rpar77 vdd.t6 vdd.t16 246.2274
Rpar78 vdd.t6 vdd.t17 97.2535
Rpar79 vdd.t16 vdd.t17 12.5554
Rpar80 vss vss.t0 59.0468
Rpar81 vss vss.t1 93.0701
Rpar82 vss vss.t27 195.1435
Rpar83 vss vss.t28 1604.9616
Rpar84 vss vss.t30 113.8459
Rpar85 vss vss.t35 526.1912
Rpar86 vss.t0 vss.t1 3.6832
Rpar87 vss.t0 vss.t27 46.6766
Rpar88 vss.t0 vss.t28 74.4657
Rpar89 vss.t0 vss.t30 37.5595
Rpar90 vss.t0 vss.t35 363.4448
Rpar91 vss.t1 vss.t27 252.5322
Rpar92 vss.t1 vss.t28 766.9356
Rpar93 vss.t1 vss.t30 179.4725
Rpar94 vss.t1 vss.t35 1192.2082
Rpar95 vss.t27 vss.t28 353.6383
Rpar96 vss.t27 vss.t30 11.1612
Rpar97 vss.t27 vss.t35 217.8995
Rpar98 vss.t28 vss.t30 297.6902
Rpar99 vss.t28 vss.t35 3426.0517
Rpar100 vss.t30 vss.t35 115.4949
Cpar0 a_11082_3224.t0 vss 6.92843e-15
Cpar1 a_11082_3224.t3 vss 1.49533e-15
Cpar2 a_11082_3224.t4 vss 3.49311e-15
Cpar3 a_11082_3224.t7 vss 4.04199e-15
Cpar4 a_11082_3224.t8 vss 1.25293e-15
Cpar5 a_11402_3224.t0 vss 2.57398e-15
Cpar6 a_11402_3224.t1 vss 2.39188e-15
Cpar7 a_11402_3224.t3 vss 6.44724e-15
Cpar8 a_11402_3224.t6 vss 1.20498e-15
Cpar9 a_11620_16950.t0 vss 3.97460e-15
Cpar10 a_11620_16950.t1 vss 3.63613e-15
Cpar11 a_11620_16950.t2 vss 3.60727e-15
Cpar12 a_12334_1294.t0 vss 5.27116e-15
Cpar13 a_12334_1294.t1 vss 1.93671e-15
Cpar14 a_12334_1294.t3 vss 2.10445e-15
Cpar15 a_12334_1294.t6 vss 9.85173e-16
Cpar16 a_12334_8480.t0 vss 2.86089e-15
Cpar17 a_12334_8480.t1 vss 4.90389e-15
Cpar18 a_12334_8480.t4 vss 1.05838e-15
Cpar19 a_12334_8480.t5 vss 2.47240e-15
Cpar20 a_12334_8480.t8 vss 8.86809e-16
Cpar21 a_1284_3015.t0 vss 3.08153e-14
Cpar22 a_1284_3015.t15 vss 7.81513e-16
Cpar23 a_1284_3015.t16 vss 2.44601e-15
Cpar24 a_4812_1086.t0 vss 4.60501e-15
Cpar25 a_4812_1086.t1 vss 1.01069e-14
Cpar26 a_4812_1086.t2 vss 4.49927e-15
Cpar27 a_5052_4717.t0 vss 3.96098e-15
Cpar28 a_5052_4717.t1 vss 1.65591e-14
Cpar29 a_5052_4717.t2 vss 2.56698e-14
Cpar30 a_5052_4717.t33 vss 9.74060e-15
Cpar31 a_5237_3224.t0 vss 3.68960e-15
Cpar32 a_5237_3224.t6 vss 5.64763e-15
Cpar33 a_6360_8524.t0 vss 4.39532e-15
Cpar34 a_6360_8524.t4 vss 3.81679e-15
Cpar35 a_7792_8524.t0 vss 6.46799e-15
Cpar36 a_7792_8524.t2 vss 4.82774e-15
Cpar37 ib vdd 2.25240e-16
Cpar38 ib vss 3.44179e-14
Cpar39 ib.t0 vss 6.72490e-15
Cpar40 ib.t1 vss 3.04600e-17
Cpar41 inn inp 5.19700e-17
Cpar42 inn vdd 1.06300e-17
Cpar43 inn vss 2.68751e-15
Cpar44 inn.t0 vss 2.76957e-16
Cpar45 inp vdd 2.46600e-17
Cpar46 inp vss 2.70580e-15
Cpar47 inp.t0 vss 2.95016e-16
Cpar48 out vdd 2.91995e-15
Cpar49 out vss 2.57718e-14
Cpar50 out.t0 vss 4.46742e-17
Cpar51 out.t3 vss 6.51831e-17
Cpar52 out.t4 vss 6.21840e-15
Cpar53 vdd vss 1.60902e-13
Cpar54 vdd.t0 vss 8.95054e-15
Cpar55 vdd.t1 vss 1.74020e-14
Cpar56 vdd.t16 vss 3.72289e-15
Cpar57 vdd.t17 vss 6.53945e-15
Cpar58 vdd.t5 vss 7.49697e-15
Cpar59 vdd.t6 vss 9.57375e-15
.ends opamp_dut

Vdd vdd 0 1.800000
Vss vss 0 0
Ibias vdd ib 2.500000e-07
Vinp inp 0 DC 1.212300 AC 1 PWL(0 1.212300 3.723591e-08 1.212300 4.095950e-08 1.222300)
Rfb out inn 1m
Cload out 0 2.000000e-12
Xdut vdd vss inp inn out ib opamp_dut
.end
