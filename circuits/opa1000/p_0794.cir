* opa1000[0794]: 2p/symmetrical_ota_1v8_i50n_subth (symmetrical_ota, VDD=1.8V, CL=2.0pF, Iref=0.0096uA)
.include "pdk_opa.inc"
.temp 27
.option gmin=1e-12 rshunt=1e12 reltol=1e-3 abstol=1e-12 vntol=1e-5 method=gear
* Post-PEX R+C extracted netlist for symmetrical_ota_1v8_i50n_subth
.subckt opamp_dut vdd vss inp inn out ib
XMpar0 a_5218_996.t0 a_9914_7243.t2 vdd.t1 vdd.t0 pfet_03v3 w=0.51u l=9.75u ad=3.0600e-13 pd=2.2200e-06 as=2.2440e-13 ps=1.6450e-06 nf=1 m=4 par=4
XMpar1 a_1719_3971.t0 inp.t0 a_7274_7243.t0 vss.t2 nfet_03v3 w=1.49u l=3.3u ad=4.1720e-13 pd=2.0500e-06 as=8.9400e-13 ps=4.1800e-06 nf=1 m=2 par=2
XMpar2 a_1719_3971.t3 a_1719_3971.t2 vdd.t1 vdd.t0 pfet_03v3 w=0.51u l=9.75u ad=3.0600e-13 pd=2.2200e-06 as=1.4280e-13 ps=1.0700e-06 nf=1 m=2 par=2
XMpar3 a_7274_7243.t4 ib.t0 vss.t13 vss.t12 nfet_03v3 w=0.4u l=3u ad=2.4000e-13 pd=2.0000e-06 as=1.7600e-13 ps=1.4800e-06 nf=1 m=4 par=4
XMpar4 a_9914_7243.t3 a_9914_7243.t2 vdd.t1 vdd.t0 pfet_03v3 w=0.51u l=9.75u ad=3.0600e-13 pd=2.2200e-06 as=1.4280e-13 ps=1.0700e-06 nf=1 m=2 par=2
XMpar5 a_5218_996.t5 a_5218_996.t4 vss.t1 vss.t0 nfet_03v3 w=0.4u l=9.75u ad=1.1200e-13 pd=9.6000e-07 as=1.1200e-13 ps=9.6000e-07 nf=1 m=4 par=4
XMpar6 out.t0 a_1719_3971.t2 vdd.t1 vdd.t0 pfet_03v3 w=0.51u l=9.75u ad=3.0600e-13 pd=2.2200e-06 as=2.2440e-13 ps=1.6450e-06 nf=1 m=4 par=4
XMpar7 ib.t1 ib.t0 vss.t13 vss.t12 nfet_03v3 w=0.4u l=3u ad=2.4000e-13 pd=2.0000e-06 as=1.1200e-13 ps=9.6000e-07 nf=1 m=2 par=2
XMpar8 a_7274_7243.t0 inn.t0 a_9914_7243.t0 vss.t2 nfet_03v3 w=1.49u l=3.3u ad=8.9400e-13 pd=4.1800e-06 as=4.1720e-13 ps=2.0500e-06 nf=1 m=2 par=2
XMpar9 out.t1 a_5218_996.t4 vss.t1 vss.t0 nfet_03v3 w=0.4u l=9.75u ad=2.4000e-13 pd=2.0000e-06 as=1.1200e-13 ps=9.6000e-07 nf=1 m=4 par=4
Rpar0 a_1719_3971.t0 a_1719_3971.t2 89.8061
Rpar1 a_1719_3971.t0 a_1719_3971.t3 132.5101
Rpar2 a_1719_3971.t2 a_1719_3971.t3 16.2711
Rpar3 a_5218_996.t0 a_5218_996.t4 119.1430
Rpar4 a_5218_996.t0 a_5218_996.t5 101.7145
Rpar5 a_5218_996.t4 a_5218_996.t5 15.7072
Rpar6 a_7274_7243.t0 a_7274_7243.t4 60.7739
Rpar7 a_9914_7243.t0 a_9914_7243.t2 89.8057
Rpar8 a_9914_7243.t0 a_9914_7243.t3 132.5108
Rpar9 a_9914_7243.t2 a_9914_7243.t3 16.2711
Rpar10 ib ib.t0 11.2059
Rpar11 ib ib.t1 12.7782
Rpar12 ib.t0 ib.t1 38.2757
Rpar13 inn inn.t0 3.9095
Rpar14 inp inp.t0 3.9581
Rpar15 out out.t0 6.1789
Rpar16 out out.t1 38.8712
Rpar17 vdd vdd.t0 162.9476
Rpar18 vdd vdd.t1 70.0106
Rpar19 vdd.t0 vdd.t1 7.6122
Rpar20 vss vss.t0 63.3986
Rpar21 vss vss.t1 258.6310
Rpar22 vss vss.t2 430.8948
Rpar23 vss vss.t12 849.4758
Rpar24 vss vss.t13 862.6900
Rpar25 vss.t0 vss.t1 18.6921
Rpar26 vss.t0 vss.t2 115.7374
Rpar27 vss.t0 vss.t12 227.8768
Rpar28 vss.t0 vss.t13 232.7476
Rpar29 vss.t1 vss.t2 472.0224
Rpar30 vss.t1 vss.t12 929.3227
Rpar31 vss.t1 vss.t13 949.3609
Rpar32 vss.t2 vss.t12 10.0217
Rpar33 vss.t2 vss.t13 24.9581
Rpar34 vss.t12 vss.t13 28.3932
Cpar0 a_1719_3971.t0 vss 4.22014e-15
Cpar1 a_1719_3971.t2 vss 3.57751e-14
Cpar2 a_1719_3971.t3 vss 7.49317e-15
Cpar3 a_5218_996.t0 vss 5.31157e-15
Cpar4 a_5218_996.t4 vss 1.75650e-14
Cpar5 a_5218_996.t5 vss 3.37442e-15
Cpar6 a_7274_7243.t0 vss 2.92198e-15
Cpar7 a_7274_7243.t4 vss 4.23324e-15
Cpar8 a_9914_7243.t0 vss 4.22083e-15
Cpar9 a_9914_7243.t2 vss 3.57809e-14
Cpar10 a_9914_7243.t3 vss 7.49439e-15
Cpar11 ib vdd 2.13480e-16
Cpar12 ib vss 1.77576e-14
Cpar13 ib.t0 vss 2.51647e-15
Cpar14 ib.t1 vss 3.36006e-16
Cpar15 inn inp 5.16000e-17
Cpar16 inn vdd 9.53100e-17
Cpar17 inn vss 3.85229e-15
Cpar18 inn.t0 vss 5.45074e-16
Cpar19 inp vdd 1.86500e-17
Cpar20 inp vss 3.94654e-15
Cpar21 inp.t0 vss 5.12578e-16
Cpar22 out vdd 9.43402e-15
Cpar23 out vss 2.42847e-14
Cpar24 out.t0 vss 4.65543e-15
Cpar25 out.t1 vss 1.25186e-14
Cpar26 vdd vss 1.56059e-13
Cpar27 vdd.t0 vss 6.98472e-14
Cpar28 vdd.t1 vss 1.42188e-14
.ends opamp_dut

Vdd vdd 0 1.800000
Vss vss 0 0
Ibias vdd ib 9.600000e-09
Vinp inp 0 DC 0.895000 AC 1 PWL(0 0.895000 2.661528e-06 0.895000 2.927681e-06 0.905000)
Rfb out inn 1m
Cload out 0 2.000000e-12
Xdut vdd vss inp inn out ib opamp_dut
.end
