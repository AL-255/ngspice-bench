* opa1000[0603]: 200f/pmos_miller_1v8_i150u_subth (pmos_miller, VDD=1.8V, CL=0.2pF, Iref=24.375uA)
.include "pdk_opa.inc"
.temp 27
.option gmin=1e-12 rshunt=1e12 reltol=1e-3 abstol=1e-12 vntol=1e-5 method=gear
* Post-PEX R+C extracted netlist for pmos_miller_1v8_i150u_subth
.subckt opamp_dut vdd vss inp inn out ib
XMpar0 a_1367_1249.t0 inn.t0 a_8084_10240.t0 vdd.t18 pfet_03v3 w=5.07u l=0.28u ad=2.2815e-12 pd=6.2869e-06 as=2.2308e-12 ps=6.1084e-06 nf=1 m=64 par=64
XMpar1 a_1367_1249.t0 inp.t0 a_4008_14118.t7 vdd.t18 pfet_03v3 w=5.07u l=0.28u ad=2.2815e-12 pd=6.2869e-06 as=2.2308e-12 ps=6.1084e-06 nf=1 m=64 par=64
XMpar2 a_1367_1249.t128 a_1047_1041.t6 vdd.t1 vdd.t0 pfet_03v3 w=10u l=0.52u ad=2.8000e-12 pd=1.0560e-05 as=2.8000e-12 ps=1.0560e-05 nf=1 m=12 par=12
XMpar3 a_4008_14118.t0 a_8084_10240.t64 vss.t1 vss.t0 nfet_03v3 w=10u l=0.4u ad=3.8667e-12 pd=1.4107e-05 as=2.8000e-12 ps=1.0560e-05 nf=1 m=6 par=6
XMpar4 ib.t1 ib.t0 vss.t54 vss.t53 nfet_03v3 w=4.7u l=0.52u ad=1.8173e-12 pd=7.0400e-06 as=1.3160e-12 ps=5.2600e-06 nf=1 m=6 par=6
XMpar5 out a_4008_14118.t71 vss.t1 vss.t0 nfet_03v3 w=10u l=0.4u ad=2.8000e-12 pd=1.0560e-05 as=3.0133e-12 ps=1.1269e-05 nf=1 m=30 par=30
XMpar6 out.t0 a_1047_1041.t6 vdd.t1 vdd.t0 pfet_03v3 w=10u l=0.52u ad=3.0133e-12 pd=1.1269e-05 as=2.8000e-12 ps=1.0560e-05 nf=1 m=30 par=30
XMpar7 a_8084_10240.t65 a_8084_10240.t64 vss.t1 vss.t0 nfet_03v3 w=10u l=0.4u ad=2.8000e-12 pd=1.0560e-05 as=2.8000e-12 ps=1.0560e-05 nf=1 m=6 par=6
XMpar8 a_1047_1041.t7 a_1047_1041.t6 vdd.t1 vdd.t0 pfet_03v3 w=10u l=0.52u ad=2.8000e-12 pd=1.0560e-05 as=3.8667e-12 ps=1.4107e-05 nf=1 m=6 par=6
XMpar9 a_1047_1041.t0 ib.t0 vss.t54 vss.t53 nfet_03v3 w=4.7u l=0.52u ad=1.3160e-12 pd=5.2600e-06 as=1.3160e-12 ps=5.2600e-06 nf=1 m=6 par=6
X201 a_4008_14118.t6 a_14940_4870.t0 vss.t26 ppolyf_u_1k r_width=1u r_length=1u
X229 a_14940_4870.t1 out.t38 cap_mim_2f0fF c_width=19.63u c_length=19.62u
Rpar0 a_1047_1041.t0 a_1047_1041.t6 52.9606
Rpar1 a_1047_1041.t0 a_1047_1041.t7 66.3298
Rpar2 a_1047_1041.t6 a_1047_1041.t7 26.6981
Rpar3 a_1367_1249.t0 a_1367_1249.t128 55.6512
Rpar4 a_14940_4870.t0 a_14940_4870.t1 76.4692
Rpar5 a_4008_14118.t0 a_4008_14118.t7 73.7661
Rpar6 a_4008_14118.t0 a_4008_14118.t71 107.4480
Rpar7 a_4008_14118.t0 a_4008_14118.t6 462.6289
Rpar8 a_4008_14118.t7 a_4008_14118.t71 281.2599
Rpar9 a_4008_14118.t7 a_4008_14118.t6 1210.9945
Rpar10 a_4008_14118.t71 a_4008_14118.t6 85.6407
Rpar11 a_8084_10240.t0 a_8084_10240.t64 565.3045
Rpar12 a_8084_10240.t0 a_8084_10240.t65 43.4900
Rpar13 a_8084_10240.t64 a_8084_10240.t65 25.5372
Rpar14 ib ib.t0 31.1483
Rpar15 ib ib.t1 2.2231
Rpar16 ib.t0 ib.t1 37.9819
Rpar17 inn inn.t0 3.5130
Rpar18 inp inp.t0 3.5130
Rpar19 out out.t0 161.1778
Rpar20 out out.t38 58.1568
Rpar21 out.t0 out.t38 227.6740
Rpar22 vdd vdd.t0 311.5749
Rpar23 vdd vdd.t1 907.2570
Rpar24 vdd vdd.t18 20.1788
Rpar25 vdd.t0 vdd.t1 2.6976
Rpar26 vdd.t0 vdd.t18 109.5346
Rpar27 vdd.t1 vdd.t18 318.9474
Rpar28 vss vss.t0 163.3094
Rpar29 vss vss.t1 978.3318
Rpar30 vss vss.t26 237.1345
Rpar31 vss vss.t53 106.1302
Rpar32 vss vss.t54 217.9731
Rpar33 vss.t0 vss.t1 1.9871
Rpar34 vss.t0 vss.t26 153.8107
Rpar35 vss.t0 vss.t53 84.6834
Rpar36 vss.t0 vss.t54 173.8930
Rpar37 vss.t1 vss.t26 925.5237
Rpar38 vss.t1 vss.t53 507.3332
Rpar39 vss.t1 vss.t54 1041.7941
Rpar40 vss.t26 vss.t53 122.7866
Rpar41 vss.t26 vss.t54 252.2236
Rpar42 vss.t53 vss.t54 5.8893
Cpar0 a_1047_1041.t0 vss 7.17169e-15
Cpar1 a_1047_1041.t6 vss 4.20061e-14
Cpar2 a_1047_1041.t7 vss 9.74870e-15
Cpar3 a_1367_1249.t0 vss 1.48286e-13
Cpar4 a_1367_1249.t128 vss 2.80246e-14
Cpar5 a_14940_4870.t0 vss 1.27020e-16
Cpar6 a_14940_4870.t1 vss 3.68615e-15
Cpar7 a_4008_14118.t0 vss 1.31479e-14
Cpar8 a_4008_14118.t6 vss 2.61121e-15
Cpar9 a_4008_14118.t7 vss 5.22365e-14
Cpar10 a_4008_14118.t71 vss 2.40277e-14
Cpar11 a_8084_10240.t0 vss 6.12973e-14
Cpar12 a_8084_10240.t64 vss 9.15515e-15
Cpar13 a_8084_10240.t65 vss 1.26142e-14
Cpar14 ib vdd 1.63600e-16
Cpar15 ib vss 1.58113e-14
Cpar16 ib.t0 vss 1.27056e-15
Cpar17 ib.t1 vss 9.73464e-16
Cpar18 inn inp 9.81600e-17
Cpar19 inn vdd 2.46418e-14
Cpar20 inn vss 1.21926e-14
Cpar21 inn.t0 vss 3.16925e-14
Cpar22 inp vdd 2.45887e-14
Cpar23 inp vss 1.21501e-14
Cpar24 inp.t0 vss 3.15634e-14
Cpar25 out vdd 5.30065e-14
Cpar26 out vss 1.01814e-13
Cpar27 out.t0 vss 3.54521e-14
Cpar28 out.t38 vss 1.13659e-14
Cpar29 vdd vss 3.55850e-13
Cpar30 vdd.t0 vss 5.97285e-14
Cpar31 vdd.t1 vss 2.77393e-14
Cpar32 vdd.t18 vss 1.04530e-13
.ends opamp_dut

Vdd vdd 0 1.800000
Vss vss 0 0
Ibias vdd ib 2.437500e-05
Vinp inp 0 DC 0.805000 AC 1 PWL(0 0.805000 3.000000e-09 0.805000 3.300000e-09 0.815000)
Rfb out inn 1m
Cload out 0 2.000000e-13
Xdut vdd vss inp inn out ib opamp_dut
.end
