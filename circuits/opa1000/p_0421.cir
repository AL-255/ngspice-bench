* opa1000[0421]: 200f/nmos_miller_1v8_i200n_subth (nmos_miller, VDD=1.8V, CL=0.2pF, Iref=0.0329uA)
.include "pdk_opa.inc"
.temp 27
.option gmin=1e-12 rshunt=1e12 reltol=1e-3 abstol=1e-12 vntol=1e-5 method=gear
* Post-PEX R+C extracted netlist for nmos_miller_1v8_i200n_subth
.subckt opamp_dut vdd vss inp inn out ib
XMpar0 out.t9 ib.t0 vss.t17 vss.t16 nfet_03v3 w=0.4u l=7.5u ad=1.8880e-13 pd=1.5840e-06 as=1.6320e-13 ps=1.3760e-06 nf=1 m=10 par=10
XMpar1 out.t0 a_987_8262.t5 vdd.t1 vdd.t0 pfet_03v3 w=0.92u l=1.92u ad=2.5760e-13 pd=1.4800e-06 as=3.1648e-13 ps=1.7920e-06 nf=1 m=10 par=10
XMpar2 a_987_8262.t0 a_7924_6249.t0 vdd.t1 vdd.t0 pfet_03v3 w=0.92u l=1.92u ad=5.5200e-13 pd=3.0400e-06 as=2.5760e-13 ps=1.4800e-06 nf=1 m=2 par=2
XMpar3 a_5166_1294.t4 ib.t0 vss.t17 vss.t16 nfet_03v3 w=0.4u l=7.5u ad=2.4000e-13 pd=2.0000e-06 as=1.1200e-13 ps=9.6000e-07 nf=1 m=4 par=4
XMpar4 a_5166_1294.t0 inp.t0 a_987_8262.t2 vss.t0 nfet_03v3 w=1.79u l=7.2u ad=1.0740e-12 pd=4.7800e-06 as=5.0120e-13 ps=2.3500e-06 nf=1 m=2 par=2
XMpar5 a_5166_1294.t0 inn.t0 a_7924_6249.t4 vss.t0 nfet_03v3 w=1.79u l=7.2u ad=1.0740e-12 pd=4.7800e-06 as=5.0120e-13 ps=2.3500e-06 nf=1 m=2 par=2
XMpar6 a_7924_6249.t1 a_7924_6249.t0 vdd.t1 vdd.t0 pfet_03v3 w=0.92u l=1.92u ad=2.5760e-13 pd=1.4800e-06 as=2.5760e-13 ps=1.4800e-06 nf=1 m=2 par=2
XMpar7 ib.t1 ib.t0 vss.t17 vss.t16 nfet_03v3 w=0.4u l=7.5u ad=2.4000e-13 pd=2.0000e-06 as=1.1200e-13 ps=9.6000e-07 nf=1 m=2 par=2
X0 a_987_8262.t4 a_4965_8262.t0 vss.t2 ppolyf_u_1k r_width=1u r_length=19.23u
X2 a_987_10862.t0 a_4965_11382.t0 vss.t2 ppolyf_u_1k r_width=1u r_length=19.23u
X6 a_987_13982.t0 a_4965_13462.t0 vss.t2 ppolyf_u_1k r_width=1u r_length=19.23u
X9 a_987_10862.t0 a_4965_10342.t0 vss.t2 ppolyf_u_1k r_width=1u r_length=19.23u
X19 a_987_12942.t0 a_4965_13462.t0 vss.t2 ppolyf_u_1k r_width=1u r_length=19.23u
X21 a_987_9822.t0 a_4965_10342.t0 vss.t2 ppolyf_u_1k r_width=1u r_length=19.23u
X25 a_987_9822.t0 a_4965_9302.t0 vss.t2 ppolyf_u_1k r_width=1u r_length=19.23u
X27 a_987_12942.t0 a_4965_12422.t0 vss.t2 ppolyf_u_1k r_width=1u r_length=19.23u
X30 a_987_8782.t0 a_4965_9302.t0 vss.t2 ppolyf_u_1k r_width=1u r_length=19.23u
X32 a_987_11902.t0 a_4965_12422.t0 vss.t2 ppolyf_u_1k r_width=1u r_length=19.23u
X36 a_987_11902.t0 a_4965_11382.t0 vss.t2 ppolyf_u_1k r_width=1u r_length=19.23u
X39 a_4965_14502.t1 out.t5 cap_mim_2f0fF c_width=11.46u c_length=11.46u
X40 a_987_13982.t0 a_4965_14502.t0 vss.t2 ppolyf_u_1k r_width=1u r_length=19.23u
X42 a_987_8782.t0 a_4965_8262.t0 vss.t2 ppolyf_u_1k r_width=1u r_length=19.23u
Rpar0 a_4965_14502.t0 a_4965_14502.t1 56.5582
Rpar1 a_5166_1294.t0 a_5166_1294.t4 54.8797
Rpar2 a_7924_6249.t0 a_7924_6249.t1 28.3804
Rpar3 a_7924_6249.t0 a_7924_6249.t4 106.4695
Rpar4 a_7924_6249.t1 a_7924_6249.t4 89.4455
Rpar5 a_987_8262.t0 a_987_8262.t5 77.8268
Rpar6 a_987_8262.t0 a_987_8262.t2 121.4067
Rpar7 a_987_8262.t0 a_987_8262.t4 261.3927
Rpar8 a_987_8262.t5 a_987_8262.t2 66.6128
Rpar9 a_987_8262.t5 a_987_8262.t4 63.4714
Rpar10 a_987_8262.t2 a_987_8262.t4 223.7288
Rpar11 ib ib.t0 19.8243
Rpar12 ib ib.t1 16.2333
Rpar13 ib.t0 ib.t1 34.4702
Rpar14 inn inn.t0 3.7640
Rpar15 inp inp.t0 3.8126
Rpar16 out out.t0 42.1313
Rpar17 out out.t9 102.9014
Rpar18 out out.t5 19.9125
Rpar19 out.t0 out.t9 176.7751
Rpar20 out.t0 out.t5 692.0686
Rpar21 out.t9 out.t5 1690.3062
Rpar22 vdd vdd.t0 52.7148
Rpar23 vdd vdd.t1 96.9499
Rpar24 vdd.t0 vdd.t1 4.4574
Rpar25 vss vss.t0 104.2818
Rpar26 vss vss.t2 248.0824
Rpar27 vss vss.t16 148.5854
Rpar28 vss vss.t17 795.1466
Rpar29 vss.t0 vss.t2 10.4533
Rpar30 vss.t0 vss.t16 3.8878
Rpar31 vss.t0 vss.t17 25.9337
Rpar32 vss.t2 vss.t16 14.2332
Rpar33 vss.t2 vss.t17 76.5858
Rpar34 vss.t16 vss.t17 36.9089
Cpar0 a_4965_10342.t0 vss 3.70000e-17
Cpar1 a_4965_11382.t0 vss 3.70000e-17
Cpar2 a_4965_12422.t0 vss 3.62000e-17
Cpar3 a_4965_13462.t0 vss 3.88200e-17
Cpar4 a_4965_14502.t0 vss 9.54500e-17
Cpar5 a_4965_14502.t1 vss 1.44267e-15
Cpar6 a_4965_8262.t0 vss 4.27600e-17
Cpar7 a_4965_9302.t0 vss 3.53800e-17
Cpar8 a_5166_1294.t0 vss 9.10549e-15
Cpar9 a_5166_1294.t4 vss 2.18953e-14
Cpar10 a_7924_6249.t0 vss 5.73281e-15
Cpar11 a_7924_6249.t1 vss 1.96185e-15
Cpar12 a_7924_6249.t4 vss 2.93293e-15
Cpar13 a_987_10862.t0 vss 2.93600e-17
Cpar14 a_987_11902.t0 vss 2.93600e-17
Cpar15 a_987_12942.t0 vss 3.00800e-17
Cpar16 a_987_13982.t0 vss 2.81600e-17
Cpar17 a_987_8262.t0 vss 2.65279e-15
Cpar18 a_987_8262.t2 vss 2.78588e-15
Cpar19 a_987_8262.t4 vss 2.65419e-15
Cpar20 a_987_8262.t5 vss 1.26079e-14
Cpar21 a_987_8782.t0 vss 3.34600e-17
Cpar22 a_987_9822.t0 vss 2.93600e-17
Cpar23 ib inn 2.32900e-17
Cpar24 ib inp 2.45500e-17
Cpar25 ib out 2.37764e-15
Cpar26 ib vss 8.07107e-14
Cpar27 ib.t0 vss 1.24753e-14
Cpar28 ib.t1 vss 9.06499e-16
Cpar29 inn inp 5.19700e-17
Cpar30 inn vss 7.30737e-15
Cpar31 inn.t0 vss 8.57407e-16
Cpar32 inp vss 7.52545e-15
Cpar33 inp.t0 vss 8.41034e-16
Cpar34 out vdd 7.69178e-15
Cpar35 out vss 2.93225e-14
Cpar36 out.t0 vss 3.64926e-15
Cpar37 out.t5 vss 6.43222e-15
Cpar38 out.t9 vss 1.31715e-14
Cpar39 vdd vss 6.02893e-14
Cpar40 vdd.t0 vss 1.31153e-14
Cpar41 vdd.t1 vss 7.77387e-15
.ends opamp_dut

Vdd vdd 0 1.800000
Vss vss 0 0
Ibias vdd ib 3.290000e-08
Vinp inp 0 DC 0.895000 AC 1 PWL(0 0.895000 2.501349e-07 0.895000 2.751484e-07 0.905000)
Rfb out inn 1m
Cload out 0 2.000000e-13
Xdut vdd vss inp inn out ib opamp_dut
.end
