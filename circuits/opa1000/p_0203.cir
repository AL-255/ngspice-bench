* opa1000[0203]: 200f/folded_cascode_nmos_3v3_10u_100u_weak (folded_cascode_nmos, VDD=3.3V, CL=0.2pF, Iref=11.1111uA)
.include "pdk_opa.inc"
.temp 27
.option gmin=1e-12 rshunt=1e12 reltol=1e-3 abstol=1e-12 vntol=1e-5 method=gear
* Post-PEX R+C extracted netlist for folded_cascode_nmos_3v3_10u_100u_weak
.subckt opamp_dut vdd vss inp inn out ib
XMpar0 a_2150_3531.t14 a_1134_8022.t2 vdd.t1 vdd.t0 pfet_03v3 w=8.46u l=0.8u ad=2.3688e-12 pd=9.0200e-06 as=3.7224e-12 ps=1.3570e-05 nf=1 m=4 par=4
XMpar1 a_2360_3531.t15 a_2360_3531.t14 vss.t1 vss.t0 nfet_03v3 w=2.71u l=0.6u ad=1.6260e-12 pd=6.6200e-06 as=7.5880e-13 ps=3.2700e-06 nf=1 m=2 par=2
XMpar2 a_1698_1249.t4 inn.t0 a_5294_3531.t18 vss.t20 nfet_03v3 w=1.97u l=0.8u ad=7.0920e-13 pd=3.1825e-06 as=5.5160e-13 ps=2.5300e-06 nf=1 m=16 par=16
XMpar3 a_1698_1249.t4 inp.t0 a_2150_3531.t15 vss.t20 nfet_03v3 w=1.97u l=0.8u ad=7.0920e-13 pd=3.1825e-06 as=5.5160e-13 ps=2.5300e-06 nf=1 m=16 par=16
XMpar4 a_1698_1249.t0 ib.t0 vss.t1 vss.t0 nfet_03v3 w=2.71u l=0.6u ad=7.5880e-13 pd=3.2700e-06 as=7.5880e-13 ps=3.2700e-06 nf=1 m=4 par=4
XMpar5 a_5294_3531.t2 ib.t10 out.t0 vdd.t4 pfet_03v3 w=2.04u l=0.45u ad=6.6446e-13 pd=2.9829e-06 as=5.7120e-13 ps=2.6000e-06 nf=1 m=14 par=14
XMpar6 a_1134_8022.t3 a_1134_8022.t2 vdd.t1 vdd.t0 pfet_03v3 w=8.46u l=0.8u ad=2.3688e-12 pd=9.0200e-06 as=5.0760e-12 ps=1.8120e-05 nf=1 m=2 par=2
XMpar7 a_2150_3531.t0 ib.t10 a_2360_3531.t0 vdd.t4 pfet_03v3 w=2.04u l=0.45u ad=6.6446e-13 pd=2.9829e-06 as=5.7120e-13 ps=2.6000e-06 nf=1 m=14 par=14
XMpar8 a_5294_3531.t0 a_1134_8022.t2 vdd.t1 vdd.t0 pfet_03v3 w=8.46u l=0.8u ad=2.3688e-12 pd=9.0200e-06 as=3.7224e-12 ps=1.3570e-05 nf=1 m=4 par=4
XMpar9 out.t2 a_2360_3531.t14 vss.t1 vss.t0 nfet_03v3 w=2.71u l=0.6u ad=7.5880e-13 pd=3.2700e-06 as=7.5880e-13 ps=3.2700e-06 nf=1 m=2 par=2
XMpar10 a_1134_8022.t0 ib.t0 vss.t1 vss.t0 nfet_03v3 w=2.71u l=0.6u ad=7.5880e-13 pd=3.2700e-06 as=7.5880e-13 ps=3.2700e-06 nf=1 m=2 par=2
XMpar11 ib.t1 ib.t0 vss.t1 vss.t0 nfet_03v3 w=2.71u l=0.6u ad=1.6260e-12 pd=6.6200e-06 as=7.5880e-13 ps=3.2700e-06 nf=1 m=2 par=2
Rpar0 a_1134_8022.t0 a_1134_8022.t2 105.9516
Rpar1 a_1134_8022.t0 a_1134_8022.t3 353.2250
Rpar2 a_1134_8022.t2 a_1134_8022.t3 31.8753
Rpar3 a_1698_1249.t0 a_1698_1249.t4 48.4639
Rpar4 a_2150_3531.t0 a_2150_3531.t14 160.4333
Rpar5 a_2150_3531.t0 a_2150_3531.t15 56.6096
Rpar6 a_2150_3531.t14 a_2150_3531.t15 61.1940
Rpar7 a_2360_3531.t0 a_2360_3531.t14 503.6695
Rpar8 a_2360_3531.t0 a_2360_3531.t15 94.1743
Rpar9 a_2360_3531.t14 a_2360_3531.t15 25.4076
Rpar10 a_5294_3531.t0 a_5294_3531.t2 160.4333
Rpar11 a_5294_3531.t0 a_5294_3531.t18 61.1940
Rpar12 a_5294_3531.t2 a_5294_3531.t18 56.6096
Rpar13 ib ib.t0 15.0489
Rpar14 ib ib.t1 4.0163
Rpar15 ib ib.t10 51.0691
Rpar16 inn inn.t0 2.6369
Rpar17 inp inp.t0 2.6369
Rpar18 out out.t0 53.9221
Rpar19 out out.t2 7.5934
Rpar20 vdd vdd.t0 145.2466
Rpar21 vdd vdd.t1 54.3940
Rpar22 vdd vdd.t4 84.7244
Rpar23 vdd.t0 vdd.t1 4.5188
Rpar24 vdd.t0 vdd.t4 360.4841
Rpar25 vdd.t1 vdd.t4 134.9991
Rpar26 vss vss.t0 60.2330
Rpar27 vss vss.t1 72.0149
Rpar28 vss vss.t20 397.2028
Rpar29 vss.t0 vss.t1 4.3750
Rpar30 vss.t0 vss.t20 115.4721
Rpar31 vss.t1 vss.t20 104.1489
Cpar0 a_1134_8022.t0 vss 4.73663e-15
Cpar1 a_1134_8022.t2 vss 1.44508e-14
Cpar2 a_1134_8022.t3 vss 4.88132e-15
Cpar3 a_1698_1249.t0 vss 4.74488e-15
Cpar4 a_1698_1249.t4 vss 2.07768e-14
Cpar5 a_2150_3531.t0 vss 9.75351e-15
Cpar6 a_2150_3531.t14 vss 9.01458e-15
Cpar7 a_2150_3531.t15 vss 1.27817e-14
Cpar8 a_2360_3531.t0 vss 7.36742e-15
Cpar9 a_2360_3531.t14 vss 2.25911e-15
Cpar10 a_2360_3531.t15 vss 4.65839e-15
Cpar11 a_5294_3531.t0 vss 8.36721e-15
Cpar12 a_5294_3531.t18 vss 1.18638e-14
Cpar13 a_5294_3531.t2 vss 9.05307e-15
Cpar14 ib out 1.01162e-15
Cpar15 ib vdd 1.23536e-14
Cpar16 ib vss 1.36761e-14
Cpar17 ib.t0 vss 3.89629e-15
Cpar18 ib.t1 vss 1.33414e-15
Cpar19 ib.t10 vss 1.19424e-14
Cpar20 inn inp 1.03380e-16
Cpar21 inn vdd 3.88200e-17
Cpar22 inn vss 1.03574e-14
Cpar23 inn.t0 vss 3.60976e-15
Cpar24 inp vdd 4.03100e-17
Cpar25 inp vss 1.02554e-14
Cpar26 inp.t0 vss 3.60370e-15
Cpar27 out vdd 2.55902e-15
Cpar28 out vss 7.84339e-15
Cpar29 out.t0 vss 9.55095e-15
Cpar30 out.t2 vss 9.33894e-16
Cpar31 vdd vss 8.92086e-14
Cpar32 vdd.t0 vss 1.47560e-14
Cpar33 vdd.t1 vss 1.27433e-14
Cpar34 vdd.t4 vss 1.79326e-14
.ends opamp_dut

Vdd vdd 0 3.300000
Vss vss 0 0
Ibias vdd ib 1.111110e-05
Vinp inp 0 DC 1.810000 AC 1 PWL(0 1.810000 3.000000e-09 1.810000 3.300000e-09 1.820000)
Rfb out inn 1m
Cload out 0 2.000000e-13
Xdut vdd vss inp inn out ib opamp_dut
.end
