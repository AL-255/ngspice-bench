* opa1000[0976]: 2p/telescopic_pmos_1v8_10u_100u_subth (telescopic_pmos, VDD=1.8V, CL=2.0pF, Iref=13.0uA)
.include "pdk_opa.inc"
.temp 27
.option gmin=1e-12 rshunt=1e12 reltol=1e-3 abstol=1e-12 vntol=1e-5 method=gear
* Post-PEX R+C extracted netlist for telescopic_pmos_1v8_10u_100u_subth
.subckt opamp_dut vdd vss inp inn out ib
XMpar0 a_10574_4919.t64 vss.t130 out vdd.t0 pfet_03v3 w=5.29u l=0.35u ad=1.5870e-12 pd=6.2206e-06 as=1.4812e-12 ps=5.8500e-06 nf=1 m=64 par=64
XMpar1 a_4085_1294.t0 inp.t0 a_4434_4919.t0 vdd.t37 pfet_03v3 w=8u l=0.45u ad=2.4000e-12 pd=9.1000e-06 as=2.3200e-12 ps=8.8300e-06 nf=1 m=64 par=64
XMpar2 a_1737_8954.t80 vss.t130 a_4434_4919.t64 vdd.t0 pfet_03v3 w=5.29u l=0.35u ad=1.4812e-12 pd=5.8500e-06 as=1.5870e-12 ps=6.2206e-06 nf=1 m=64 par=64
XMpar3 a_4085_1294.t128 a_1640_1250.t2 vdd.t2 vdd.t1 pfet_03v3 w=10u l=0.65u ad=2.8000e-12 pd=1.0560e-05 as=3.6000e-12 ps=1.3220e-05 nf=1 m=8 par=8
XMpar4 a_2257_9162.t0 a_1737_8954.t0 out.t16 vss.t0 nfet_03v3 w=1.94u l=0.35u ad=6.6736e-13 pd=3.0160e-06 as=6.0528e-13 ps=2.7580e-06 nf=1 m=40 par=40
XMpar5 a_10574_4919.t0 inn.t0 a_4085_1294.t0 vdd.t37 pfet_03v3 w=8u l=0.45u ad=2.3200e-12 pd=8.8300e-06 as=2.4000e-12 ps=9.1000e-06 nf=1 m=64 par=64
XMpar6 a_2257_9162.t3 a_1737_8954.t144 vss.t14 vss.t13 nfet_03v3 w=1.85u l=0.6u ad=6.0257e-13 pd=2.7657e-06 as=6.0257e-13 ps=2.7657e-06 nf=1 m=14 par=14
XMpar7 a_1617_9162.t0 a_1737_8954.t0 a_1737_8954.t1 vss.t0 nfet_03v3 w=1.94u l=0.35u ad=6.9840e-13 pd=3.1450e-06 as=6.0528e-13 ps=2.7580e-06 nf=1 m=40 par=40
XMpar8 ib.t1 ib.t0 vss.t3 vss.t2 nfet_03v3 w=8.8u l=0.65u ad=5.2800e-12 pd=1.8800e-05 as=2.4640e-12 ps=9.3600e-06 nf=1 m=2 par=2
XMpar9 a_1617_9162.t5 a_1737_8954.t144 vss.t14 vss.t13 nfet_03v3 w=1.85u l=0.6u ad=6.0257e-13 pd=2.7657e-06 as=6.0257e-13 ps=2.7657e-06 nf=1 m=14 par=14
XMpar10 a_1640_1250.t0 ib.t0 vss.t3 vss.t2 nfet_03v3 w=8.8u l=0.65u ad=2.4640e-12 pd=9.3600e-06 as=2.4640e-12 ps=9.3600e-06 nf=1 m=2 par=2
XMpar11 a_1640_1250.t3 a_1640_1250.t2 vdd.t2 vdd.t1 pfet_03v3 w=10u l=0.65u ad=2.8000e-12 pd=1.0560e-05 as=2.8000e-12 ps=1.0560e-05 nf=1 m=2 par=2
Rpar0 a_10574_4919.t0 a_10574_4919.t64 53.4034
Rpar1 a_1617_9162.t0 a_1617_9162.t5 116.2869
Rpar2 a_1640_1250.t0 a_1640_1250.t2 147.3675
Rpar3 a_1640_1250.t0 a_1640_1250.t3 56.6592
Rpar4 a_1640_1250.t2 a_1640_1250.t3 30.7100
Rpar5 a_1737_8954.t0 a_1737_8954.t1 16.2832
Rpar6 a_1737_8954.t0 a_1737_8954.t80 434.8921
Rpar7 a_1737_8954.t0 a_1737_8954.t144 797.3118
Rpar8 a_1737_8954.t1 a_1737_8954.t80 89.5344
Rpar9 a_1737_8954.t1 a_1737_8954.t144 164.1483
Rpar10 a_1737_8954.t80 a_1737_8954.t144 82.2514
Rpar11 a_2257_9162.t0 a_2257_9162.t3 108.3562
Rpar12 a_4085_1294.t0 a_4085_1294.t128 113.0322
Rpar13 a_4434_4919.t0 a_4434_4919.t64 53.4034
Rpar14 ib ib.t0 28.8773
Rpar15 ib ib.t1 3.2691
Rpar16 inn inn.t0 3.3899
Rpar17 inp inp.t0 3.3899
Rpar18 out out.t16 43.7139
Rpar19 vdd vdd.t0 168.0422
Rpar20 vdd vdd.t1 1089.6906
Rpar21 vdd vdd.t37 23.6406
Rpar22 vdd vdd.t2 3502.9406
Rpar23 vdd.t0 vdd.t1 151.5634
Rpar24 vdd.t0 vdd.t37 295.1780
Rpar25 vdd.t0 vdd.t2 487.2187
Rpar26 vdd.t1 vdd.t37 1914.1185
Rpar27 vdd.t1 vdd.t2 5.6470
Rpar28 vss vss.t0 220.0753
Rpar29 vss vss.t14 83.2636
Rpar30 vss vss.t13 723.3135
Rpar31 vss vss.t130 151.7944
Rpar32 vss vss.t2 135.7265
Rpar33 vss vss.t3 131.2400
Rpar34 vss.t0 vss.t14 276.9999
Rpar35 vss.t0 vss.t13 1918.1314
Rpar36 vss.t0 vss.t130 1425.0477
Rpar37 vss.t0 vss.t2 1030.2384
Rpar38 vss.t0 vss.t3 1168.1644
Rpar39 vss.t14 vss.t13 11.3954
Rpar40 vss.t14 vss.t130 540.7141
Rpar41 vss.t14 vss.t2 482.3540
Rpar42 vss.t14 vss.t3 466.8658
Rpar43 vss.t13 vss.t130 4641.5087
Rpar44 vss.t130 vss.t2 221.7480
Rpar45 vss.t130 vss.t3 214.4158
Rpar46 vss.t2 vss.t3 13.2598
Cpar0 a_10574_4919.t0 vss 1.19729e-13
Cpar1 a_10574_4919.t64 vss 8.30674e-14
Cpar2 a_1617_9162.t0 vss 3.47331e-14
Cpar3 a_1617_9162.t5 vss 1.89239e-14
Cpar4 a_1640_1250.t0 vss 3.06987e-15
Cpar5 a_1640_1250.t2 vss 1.06423e-14
Cpar6 a_1640_1250.t3 vss 4.56500e-15
Cpar7 a_1737_8954.t0 vss 3.09070e-14
Cpar8 a_1737_8954.t1 vss 2.89417e-14
Cpar9 a_1737_8954.t144 vss 1.97316e-14
Cpar10 a_1737_8954.t80 vss 6.40020e-14
Cpar11 a_2257_9162.t0 vss 4.03981e-14
Cpar12 a_2257_9162.t3 vss 2.23090e-14
Cpar13 a_4085_1294.t0 vss 2.19972e-13
Cpar14 a_4085_1294.t128 vss 2.17386e-14
Cpar15 a_4434_4919.t0 vss 1.21243e-13
Cpar16 a_4434_4919.t64 vss 8.41172e-14
Cpar17 ib vss 9.65546e-15
Cpar18 ib.t0 vss 4.64566e-16
Cpar19 ib.t1 vss 4.95570e-16
Cpar20 inn inp 1.04570e-16
Cpar21 inn vdd 2.40763e-14
Cpar22 inn vss 1.09127e-14
Cpar23 inn.t0 vss 4.26223e-14
Cpar24 inp vdd 2.39796e-14
Cpar25 inp vss 1.07147e-14
Cpar26 inp.t0 vss 4.25938e-14
Cpar27 out vdd 1.05636e-14
Cpar28 out vss 1.10050e-13
Cpar29 out.t16 vss 3.91822e-14
Cpar30 vdd vss 5.34204e-13
Cpar31 vdd.t0 vss 4.45717e-14
Cpar32 vdd.t1 vss 8.69822e-15
Cpar33 vdd.t2 vss 4.53105e-15
Cpar34 vdd.t37 vss 6.29317e-14
.ends opamp_dut

Vdd vdd 0 1.800000
Vss vss 0 0
Ibias vdd ib 1.300000e-05
Vinp inp 0 DC 0.805000 AC 1 PWL(0 0.805000 3.124280e-09 0.805000 3.436708e-09 0.815000)
Rfb out inn 1m
Cload out 0 2.000000e-12
Xdut vdd vss inp inn out ib opamp_dut
.end
