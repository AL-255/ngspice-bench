* opa1000[0946]: 200f/telescopic_pmos_3v3_i2u_subth (telescopic_pmos, VDD=3.3V, CL=0.2pF, Iref=0.28uA)
.include "pdk_opa.inc"
.temp 27
.option gmin=1e-12 rshunt=1e12 reltol=1e-3 abstol=1e-12 vntol=1e-5 method=gear
* Post-PEX R+C extracted netlist for telescopic_pmos_3v3_i2u_subth
.subckt opamp_dut vdd vss inp inn out ib
XMpar0 a_1892_13603.t7 inp.t0 a_2766_1249.t6 vdd.t30 pfet_03v3 w=3.49u l=1.14u ad=1.1168e-12 pd=4.5662e-06 as=9.7720e-13 ps=4.0500e-06 nf=1 m=64 par=64
XMpar1 a_2766_1249.t0 a_4783_7373.t0 a_4783_7373.t1 vdd.t0 pfet_03v3 w=1.79u l=0.78u ad=6.9213e-13 pd=3.1600e-06 as=5.0120e-13 ps=2.3500e-06 nf=1 m=12 par=12
XMpar2 a_1892_13603.t7 inn.t0 a_6548_7581.t7 vdd.t30 pfet_03v3 w=3.49u l=1.14u ad=1.1168e-12 pd=4.5662e-06 as=9.7720e-13 ps=4.0500e-06 nf=1 m=64 par=64
XMpar3 ib.t1 ib.t0 vss.t4 vss.t3 nfet_03v3 w=0.8u l=2.08u ad=4.8000e-13 pd=2.8000e-06 as=2.2400e-13 ps=1.3600e-06 nf=1 m=2 par=2
XMpar4 a_6548_7581.t0 a_4783_7373.t0 out.t0 vdd.t0 pfet_03v3 w=1.79u l=0.78u ad=5.9667e-13 pd=2.7550e-06 as=5.0120e-13 ps=2.3500e-06 nf=1 m=12 par=12
XMpar5 a_4783_7373.t25 a_4783_7373.t24 a_6976_11790.t0 vss.t2 nfet_03v3 w=1.85u l=0.78u ad=1.1100e-12 pd=4.9000e-06 as=1.1100e-12 ps=4.9000e-06 nf=1 m=2 par=2
XMpar6 a_1892_13603.t0 a_1476_13395.t2 vdd.t5 vdd.t4 pfet_03v3 w=3.7u l=2.08u ad=1.0360e-12 pd=4.2600e-06 as=1.3320e-12 ps=5.3450e-06 nf=1 m=8 par=8
XMpar7 a_1476_13395.t3 a_1476_13395.t2 vdd.t5 vdd.t4 pfet_03v3 w=3.7u l=2.08u ad=1.0360e-12 pd=4.2600e-06 as=1.0360e-12 ps=4.2600e-06 nf=1 m=2 par=2
XMpar8 a_7888_9680.t2 a_4783_7373.t42 vss.t14 vss.t13 nfet_03v3 w=0.94u l=2.04u ad=2.6320e-13 pd=1.5000e-06 as=2.6320e-13 ps=1.5000e-06 nf=1 m=2 par=2
XMpar9 a_6976_11790.t2 a_4783_7373.t42 vss.t14 vss.t13 nfet_03v3 w=0.94u l=2.04u ad=5.6400e-13 pd=3.0800e-06 as=2.6320e-13 ps=1.5000e-06 nf=1 m=2 par=2
XMpar10 a_1476_13395.t0 ib.t0 vss.t4 vss.t3 nfet_03v3 w=0.8u l=2.08u ad=2.2400e-13 pd=1.3600e-06 as=2.2400e-13 ps=1.3600e-06 nf=1 m=2 par=2
XMpar11 a_7888_9680.t0 a_4783_7373.t24 out.t8 vss.t2 nfet_03v3 w=1.85u l=0.78u ad=1.1100e-12 pd=4.9000e-06 as=5.1800e-13 ps=2.4100e-06 nf=1 m=2 par=2
X11 out.t14 vss.t0 cap_mim_2f0fF c_width=17.39u c_length=17.4u
X85 out.t14 vss.t0 cap_mim_2f0fF c_width=17.39u c_length=17.4u
Rpar0 a_1476_13395.t0 a_1476_13395.t2 114.2516
Rpar1 a_1476_13395.t0 a_1476_13395.t3 87.5589
Rpar2 a_1476_13395.t2 a_1476_13395.t3 23.4466
Rpar3 a_1892_13603.t0 a_1892_13603.t7 70.1484
Rpar4 a_2766_1249.t0 a_2766_1249.t6 37.2453
Rpar5 a_4783_7373.t0 a_4783_7373.t1 15.4677
Rpar6 a_4783_7373.t0 a_4783_7373.t24 1454.5758
Rpar7 a_4783_7373.t0 a_4783_7373.t25 445.6380
Rpar8 a_4783_7373.t0 a_4783_7373.t42 489.0351
Rpar9 a_4783_7373.t1 a_4783_7373.t24 361.8937
Rpar10 a_4783_7373.t1 a_4783_7373.t25 110.8733
Rpar11 a_4783_7373.t1 a_4783_7373.t42 121.6703
Rpar12 a_4783_7373.t24 a_4783_7373.t25 26.6941
Rpar13 a_4783_7373.t24 a_4783_7373.t42 264.5172
Rpar14 a_4783_7373.t25 a_4783_7373.t42 81.0401
Rpar15 a_6548_7581.t0 a_6548_7581.t7 57.6211
Rpar16 a_6976_11790.t0 a_6976_11790.t2 51.8855
Rpar17 a_7888_9680.t0 a_7888_9680.t2 58.1040
Rpar18 ib ib.t0 12.0643
Rpar19 ib ib.t1 7.1382
Rpar20 inn inn.t0 1.5718
Rpar21 inp inp.t0 1.5718
Rpar22 out out.t0 46.8222
Rpar23 out out.t8 9.9384
Rpar24 out out.t14 169.4933
Rpar25 out.t0 out.t8 521.7310
Rpar26 out.t0 out.t14 152.2967
Rpar27 out.t8 out.t14 1888.6305
Rpar28 vdd vdd.t0 201.6308
Rpar29 vdd vdd.t4 73.5114
Rpar30 vdd vdd.t5 168.8545
Rpar31 vdd vdd.t30 255.0019
Rpar32 vdd.t0 vdd.t4 216.7247
Rpar33 vdd.t0 vdd.t5 497.8128
Rpar34 vdd.t0 vdd.t30 48.5702
Rpar35 vdd.t4 vdd.t5 5.2105
Rpar36 vdd.t4 vdd.t30 274.0910
Rpar37 vdd.t5 vdd.t30 629.5823
Rpar38 vss vss.t0 980.4217
Rpar39 vss vss.t4 285.2509
Rpar40 vss vss.t2 590.0214
Rpar41 vss vss.t13 617.1350
Rpar42 vss vss.t14 2087.0181
Rpar43 vss vss.t3 150.4291
Rpar44 vss.t0 vss.t4 1017.1126
Rpar45 vss.t0 vss.t2 179.5855
Rpar46 vss.t0 vss.t13 177.2152
Rpar47 vss.t0 vss.t14 519.6535
Rpar48 vss.t0 vss.t3 536.3675
Rpar49 vss.t4 vss.t2 596.6773
Rpar50 vss.t4 vss.t13 621.7963
Rpar51 vss.t4 vss.t14 2084.4006
Rpar52 vss.t4 vss.t3 12.7960
Rpar53 vss.t2 vss.t13 2.0959
Rpar54 vss.t2 vss.t14 20.4916
Rpar55 vss.t2 vss.t3 314.5412
Rpar56 vss.t13 vss.t14 18.6039
Rpar57 vss.t13 vss.t3 327.7688
Rpar58 vss.t14 vss.t3 1098.6258
Cpar0 a_1476_13395.t0 vss 2.08734e-15
Cpar1 a_1476_13395.t2 vss 1.94749e-14
Cpar2 a_1476_13395.t3 vss 3.59250e-15
Cpar3 a_1892_13603.t0 vss 1.02008e-14
Cpar4 a_1892_13603.t7 vss 1.04817e-13
Cpar5 a_2766_1249.t0 vss 8.08173e-15
Cpar6 a_2766_1249.t6 vss 6.40437e-14
Cpar7 a_4783_7373.t0 vss 1.56636e-14
Cpar8 a_4783_7373.t1 vss 6.96459e-15
Cpar9 a_4783_7373.t24 vss 3.09462e-15
Cpar10 a_4783_7373.t25 vss 3.78450e-15
Cpar11 a_4783_7373.t42 vss 5.72844e-15
Cpar12 a_6548_7581.t0 vss 8.62376e-15
Cpar13 a_6548_7581.t7 vss 6.43515e-14
Cpar14 a_6976_11790.t0 vss 3.17318e-15
Cpar15 a_6976_11790.t2 vss 2.63472e-15
Cpar16 a_7888_9680.t0 vss 3.88813e-15
Cpar17 a_7888_9680.t2 vss 2.28119e-15
Cpar18 ib vss 8.27756e-15
Cpar19 ib.t0 vss 9.48691e-16
Cpar20 ib.t1 vss 7.41800e-17
Cpar21 inn inp 2.10380e-16
Cpar22 inn vdd 3.57171e-14
Cpar23 inn vss 6.84814e-15
Cpar24 inn.t0 vss 6.10060e-14
Cpar25 inp vdd 3.58427e-14
Cpar26 inp vss 7.00046e-15
Cpar27 inp.t0 vss 6.11520e-14
Cpar28 out vdd 7.72098e-15
Cpar29 out vss 2.35619e-14
Cpar30 out.t0 vss 7.06118e-16
Cpar31 out.t14 vss 1.79239e-14
Cpar32 out.t8 vss 6.81330e-17
Cpar33 vdd vss 3.50715e-13
Cpar34 vdd.t0 vss 2.16976e-14
Cpar35 vdd.t30 vss 1.01769e-13
Cpar36 vdd.t4 vss 1.40991e-14
Cpar37 vdd.t5 vss 6.70654e-15
.ends opamp_dut

Vdd vdd 0 3.300000
Vss vss 0 0
Ibias vdd ib 2.800000e-07
Vinp inp 0 DC 1.480000 AC 1 PWL(0 1.480000 6.281622e-08 1.480000 6.909784e-08 1.490000)
Rfb out inn 1m
Cload out 0 2.000000e-13
Xdut vdd vss inp inn out ib opamp_dut
.end
