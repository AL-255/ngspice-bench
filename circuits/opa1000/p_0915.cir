* opa1000[0915]: 2p/telescopic_nmos_3v3_i500u_subth (telescopic_nmos, VDD=3.3V, CL=2.0pF, Iref=125.0uA)
.include "pdk_opa.inc"
.temp 27
.option gmin=1e-12 rshunt=1e12 reltol=1e-3 abstol=1e-12 vntol=1e-5 method=gear
* Post-PEX R+C extracted netlist for telescopic_nmos_3v3_i500u_subth
.subckt opamp_dut vdd vss inp inn out ib
XMpar0 a_11777_9790.t0 a_5518_23466.t320 a_5518_23466.t321 vss.t0 nfet_03v3 w=4.6u l=0.3u ad=1.6560e-12 pd=6.4700e-06 as=1.4352e-12 ps=5.6840e-06 nf=1 m=160 par=160
XMpar1 a_6018_23674.t37 a_5518_23466.t0 out.t0 vdd.t70 pfet_03v3 w=14u l=0.3u ad=5.9360e-12 pd=2.1148e-05 as=4.9280e-12 ps=1.7854e-05 nf=1 m=160 par=160
XMpar2 a_5398_23674.t0 a_5518_23466.t960 vdd.t1 vdd.t0 pfet_03v3 w=7.11u l=0.75u ad=2.2183e-12 pd=8.4450e-06 as=1.9908e-12 ps=7.6700e-06 nf=1 m=160 par=160
XMpar3 a_12398_9790.t0 a_5518_23466.t320 out.t7 vss.t0 nfet_03v3 w=4.6u l=0.3u ad=1.5899e-12 pd=6.2349e-06 as=1.4390e-12 ps=5.6974e-06 nf=1 m=156 par=156
XMpar4 a_12398_9790.t90 inn.t0 a_1740_1205.t64 vss.t0 nfet_03v3 w=6.42u l=0.38u ad=1.7976e-12 pd=6.9800e-06 as=1.9003e-12 ps=7.3330e-06 nf=1 m=160 par=160
XMpar5 a_6018_23674.t0 a_5518_23466.t960 vdd.t1 vdd.t0 pfet_03v3 w=7.11u l=0.75u ad=2.2183e-12 pd=8.4450e-06 as=2.1046e-12 ps=8.0575e-06 nf=1 m=160 par=160
XMpar6 a_5398_23674.t19 a_5518_23466.t0 a_5518_23466.t1 vdd.t70 pfet_03v3 w=14u l=0.3u ad=6.2160e-12 pd=2.2063e-05 as=4.8160e-12 ps=1.7488e-05 nf=1 m=160 par=160
XMpar7 a_11777_9790.t65 inp.t0 a_1740_1205.t64 vss.t0 nfet_03v3 w=6.42u l=0.38u ad=1.7976e-12 pd=6.9800e-06 as=1.9030e-12 ps=7.3421e-06 nf=1 m=156 par=156
XMpar8 a_1740_1205.t0 ib.t0 vss.t9 vss.t8 nfet_03v3 w=6.77u l=0.35u ad=1.8956e-12 pd=7.3300e-06 as=2.0310e-12 ps=7.7931e-06 nf=1 m=64 par=64
XMpar9 ib.t1 ib.t0 vss.t9 vss.t8 nfet_03v3 w=6.77u l=0.35u ad=1.8956e-12 pd=7.3300e-06 as=1.8956e-12 ps=7.3300e-06 nf=1 m=16 par=16
XMpar10 a_11777_9790.t65 inp.t0 a_1740_1205.t64 vss.t171 nfet_03v3 w=6.42u l=0.38u ad=1.7976e-12 pd=6.9800e-06 as=1.7976e-12 ps=6.9800e-06 nf=1 m=4 par=4
XMpar11 a_12398_9790.t0 a_5518_23466.t320 out.t7 vss.t171 nfet_03v3 w=4.6u l=0.3u ad=1.2880e-12 pd=5.1600e-06 as=1.2880e-12 ps=5.1600e-06 nf=1 m=4 par=4
X968 out.t320 vss.t228 cap_mim_2f0fF c_width=15.74u c_length=15.73u
X1302 out.t320 vss.t228 cap_mim_2f0fF c_width=15.74u c_length=15.73u
Rpar0 a_11777_9790.t0 a_11777_9790.t65 39.3736
Rpar1 a_12398_9790.t0 a_12398_9790.t90 35.1409
Rpar2 a_1740_1205.t0 a_1740_1205.t64 41.8613
Rpar3 a_5398_23674.t0 a_5398_23674.t19 42.4735
Rpar4 a_5518_23466.t0 a_5518_23466.t1 6.8853
Rpar5 a_5518_23466.t1 a_5518_23466.t960 73.2337
Rpar6 a_5518_23466.t1 a_5518_23466.t321 56.7276
Rpar7 a_5518_23466.t960 a_5518_23466.t321 233.6028
Rpar8 a_5518_23466.t320 a_5518_23466.t321 4.0736
Rpar9 a_6018_23674.t0 a_6018_23674.t37 47.0816
Rpar10 ib ib.t0 16.7613
Rpar11 ib ib.t1 4.4347
Rpar12 ib.t0 ib.t1 14.5933
Rpar13 inn inn.t0 2.2023
Rpar14 inp inp.t0 2.2023
Rpar15 out out.t0 4.0624
Rpar16 out out.t7 101.6752
Rpar17 out out.t320 78.4697
Rpar18 out.t7 out.t320 89.7848
Rpar19 vdd vdd.t0 20.2627
Rpar20 vdd vdd.t70 190.8094
Rpar21 vdd.t0 vdd.t1 9.9012
Rpar22 vdd.t0 vdd.t70 66.4153
Rpar23 vss vss.t0 107.0841
Rpar24 vss vss.t8 5825.3709
Rpar25 vss vss.t9 64.9789
Rpar26 vss vss.t228 397.0193
Rpar27 vss.t0 vss.t8 376.8106
Rpar28 vss.t0 vss.t9 248.1898
Rpar29 vss.t0 vss.t171 7.1647
Rpar30 vss.t0 vss.t228 1532.8519
Rpar31 vss.t8 vss.t9 10.4027
Rpar32 vss.t8 vss.t228 8387.3503
Rpar33 vss.t9 vss.t228 93.1809
Cpar0 a_11777_9790.t0 vss 2.53823e-13
Cpar1 a_11777_9790.t65 vss 2.51784e-13
Cpar2 a_12398_9790.t0 vss 2.72633e-13
Cpar3 a_12398_9790.t90 vss 2.69755e-13
Cpar4 a_1740_1205.t0 vss 8.90270e-14
Cpar5 a_1740_1205.t64 vss 4.05244e-13
Cpar6 a_5398_23674.t0 vss 3.11007e-13
Cpar7 a_5398_23674.t19 vss 7.04788e-13
Cpar8 a_5518_23466.t0 vss 3.10114e-13
Cpar9 a_5518_23466.t1 vss 4.63666e-13
Cpar10 a_5518_23466.t320 vss 1.49162e-13
Cpar11 a_5518_23466.t321 vss 1.73834e-13
Cpar12 a_5518_23466.t960 vss 4.29811e-13
Cpar13 a_6018_23674.t0 vss 3.19028e-13
Cpar14 a_6018_23674.t37 vss 7.23686e-13
Cpar15 ib vss 7.77646e-14
Cpar16 ib.t0 vss 1.03461e-14
Cpar17 ib.t1 vss 5.24070e-15
Cpar18 inn inp 2.04490e-16
Cpar19 inn vss 5.74222e-14
Cpar20 inn.t0 vss 4.86156e-14
Cpar21 inp vss 5.73127e-14
Cpar22 inp.t0 vss 4.86230e-14
Cpar23 out vdd 7.00141e-14
Cpar24 out vss 8.86639e-14
Cpar25 out.t0 vss 5.35240e-13
Cpar26 out.t320 vss 2.21450e-13
Cpar27 out.t7 vss 2.03053e-13
Cpar28 vdd vss 1.92186e-12
Cpar29 vdd.t0 vss 3.30953e-13
Cpar30 vdd.t1 vss 9.24354e-14
Cpar31 vdd.t70 vss 4.91779e-13
.ends opamp_dut

Vdd vdd 0 3.300000
Vss vss 0 0
Ibias vdd ib 1.250000e-04
Vinp inp 0 DC 1.711000 AC 1 PWL(0 1.711000 3.000000e-09 1.711000 3.300000e-09 1.721000)
Rfb out inn 1m
Cload out 0 2.000000e-12
Xdut vdd vss inp inn out ib opamp_dut
.end
