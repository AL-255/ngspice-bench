* opa1000[0299]: 2p/folded_cascode_pmos_1v8_i1u_subth (folded_cascode_pmos, VDD=1.8V, CL=2.0pF, Iref=0.2889uA)
.include "pdk_opa.inc"
.temp 27
.option gmin=1e-12 rshunt=1e12 reltol=1e-3 abstol=1e-12 vntol=1e-5 method=gear
* Post-PEX R+C extracted netlist for folded_cascode_pmos_1v8_i1u_subth
.subckt opamp_dut vdd vss inp inn out ib
XMpar0 a_1410_12539.t0 inp.t0 a_1842_12539.t4 vdd.t7 pfet_03v3 w=8u l=1.56u ad=2.4000e-12 pd=9.1000e-06 as=2.3200e-12 ps=8.8300e-06 nf=1 m=64 par=64
XMpar1 a_11054_4205.t4 inn.t0 a_1410_12539.t0 vdd.t7 pfet_03v3 w=8u l=1.56u ad=2.3200e-12 pd=8.8300e-06 as=2.4000e-12 ps=9.1000e-06 nf=1 m=64 par=64
XMpar2 ib.t1 ib.t0 vss.t1 vss.t0 nfet_03v3 w=0.84u l=2.1u ad=5.0400e-13 pd=2.8800e-06 as=2.3520e-13 ps=1.4000e-06 nf=1 m=2 par=2
XMpar3 a_11054_4205.t0 ib.t0 vss.t1 vss.t0 nfet_03v3 w=0.84u l=2.1u ad=3.6960e-13 pd=2.1400e-06 as=5.0400e-13 ps=2.8800e-06 nf=1 m=4 par=4
XMpar4 a_1410_12539.t128 a_1578_6541.t2 vdd.t1 vdd.t0 pfet_03v3 w=7.55u l=5.63u ad=4.5300e-12 pd=1.6300e-05 as=3.3220e-12 ps=1.2205e-05 nf=1 m=4 par=4
XMpar5 a_1842_12539.t68 a_1578_6541.t6 a_8560_1204.t0 vss.t0 nfet_03v3 w=1.51u l=2.13u ad=6.6440e-13 pd=3.1450e-06 as=4.2280e-13 ps=2.0700e-06 nf=1 m=4 par=4
XMpar6 a_1578_6541.t3 a_1578_6541.t2 vdd.t1 vdd.t0 pfet_03v3 w=7.55u l=5.63u ad=4.5300e-12 pd=1.6300e-05 as=2.1140e-12 ps=8.1100e-06 nf=1 m=2 par=2
XMpar7 a_8560_1204.t4 a_8560_1204.t3 vdd.t1 vdd.t0 pfet_03v3 w=7.55u l=5.63u ad=4.5300e-12 pd=1.6300e-05 as=2.1140e-12 ps=8.1100e-06 nf=1 m=2 par=2
XMpar8 a_1842_12539.t0 ib.t0 vss.t1 vss.t0 nfet_03v3 w=0.84u l=2.1u ad=3.6960e-13 pd=2.1400e-06 as=5.0400e-13 ps=2.8800e-06 nf=1 m=4 par=4
XMpar9 a_11054_4205.t68 a_1578_6541.t6 out.t1 vss.t0 nfet_03v3 w=1.51u l=2.13u ad=6.6440e-13 pd=3.1450e-06 as=4.2280e-13 ps=2.0700e-06 nf=1 m=4 par=4
XMpar10 out.t0 a_8560_1204.t3 vdd.t1 vdd.t0 pfet_03v3 w=7.55u l=5.63u ad=2.1140e-12 pd=8.1100e-06 as=2.1140e-12 ps=8.1100e-06 nf=1 m=2 par=2
XMpar11 a_1578_6541.t0 ib.t0 vss.t1 vss.t0 nfet_03v3 w=0.84u l=2.1u ad=2.3520e-13 pd=1.4000e-06 as=2.3520e-13 ps=1.4000e-06 nf=1 m=2 par=2
X5 out.t6 vss.t28 cap_mim_2f0fF c_width=11.18u c_length=11.18u
Rpar0 a_11054_4205.t0 a_11054_4205.t4 107.7745
Rpar1 a_11054_4205.t0 a_11054_4205.t68 81.6673
Rpar2 a_11054_4205.t4 a_11054_4205.t68 137.7806
Rpar3 a_1410_12539.t0 a_1410_12539.t128 29.2270
Rpar4 a_1578_6541.t0 a_1578_6541.t6 93.7179
Rpar5 a_1578_6541.t0 a_1578_6541.t2 615.5914
Rpar6 a_1578_6541.t0 a_1578_6541.t3 220.4022
Rpar7 a_1578_6541.t6 a_1578_6541.t2 285.6454
Rpar8 a_1578_6541.t6 a_1578_6541.t3 102.2705
Rpar9 a_1578_6541.t2 a_1578_6541.t3 12.3547
Rpar10 a_1842_12539.t0 a_1842_12539.t4 124.9085
Rpar11 a_1842_12539.t0 a_1842_12539.t68 63.1806
Rpar12 a_1842_12539.t4 a_1842_12539.t68 168.8430
Rpar13 a_8560_1204.t0 a_8560_1204.t3 222.2709
Rpar14 a_8560_1204.t0 a_8560_1204.t4 61.7694
Rpar15 a_8560_1204.t3 a_8560_1204.t4 18.8741
Rpar16 ib ib.t0 3.3268
Rpar17 ib ib.t1 161.7600
Rpar18 ib.t0 ib.t1 18.8897
Rpar19 inn inn.t0 1.7895
Rpar20 inp inp.t0 1.7895
Rpar21 out out.t0 98.5392
Rpar22 out out.t1 100.2565
Rpar23 out out.t6 15.1125
Rpar24 out.t0 out.t1 112.5766
Rpar25 out.t0 out.t6 1167.7819
Rpar26 out.t1 out.t6 1188.1336
Rpar27 vdd vdd.t0 233.1848
Rpar28 vdd vdd.t1 166.6312
Rpar29 vdd vdd.t7 20.3836
Rpar30 vdd.t0 vdd.t1 5.4519
Rpar31 vdd.t0 vdd.t7 675.5853
Rpar32 vdd.t1 vdd.t7 482.7655
Rpar33 vss vss.t0 50.8058
Rpar34 vss vss.t1 151.9343
Rpar35 vss vss.t28 158.5802
Rpar36 vss.t0 vss.t1 4.7755
Rpar37 vss.t0 vss.t28 105.5621
Rpar38 vss.t1 vss.t28 424.9918
Cpar0 a_11054_4205.t0 vss 5.89992e-15
Cpar1 a_11054_4205.t4 vss 8.86329e-14
Cpar2 a_11054_4205.t68 vss 4.13313e-15
Cpar3 a_1410_12539.t0 vss 1.66154e-13
Cpar4 a_1410_12539.t128 vss 1.46590e-14
Cpar5 a_1578_6541.t0 vss 1.47196e-15
Cpar6 a_1578_6541.t2 vss 2.81996e-14
Cpar7 a_1578_6541.t3 vss 6.49318e-15
Cpar8 a_1578_6541.t6 vss 6.70578e-15
Cpar9 a_1842_12539.t0 vss 6.42575e-15
Cpar10 a_1842_12539.t4 vss 8.99631e-14
Cpar11 a_1842_12539.t68 vss 4.51421e-15
Cpar12 a_8560_1204.t0 vss 1.48428e-15
Cpar13 a_8560_1204.t3 vss 1.95237e-14
Cpar14 a_8560_1204.t4 vss 4.81865e-15
Cpar15 ib out 1.64342e-15
Cpar16 ib vdd 1.37770e-16
Cpar17 ib vss 2.69117e-14
Cpar18 ib.t0 vss 5.77470e-15
Cpar19 ib.t1 vss 1.30778e-15
Cpar20 inn inp 8.73800e-17
Cpar21 inn vdd 4.60202e-14
Cpar22 inn vss 1.12404e-14
Cpar23 inn.t0 vss 9.65477e-14
Cpar24 inp vdd 4.58468e-14
Cpar25 inp vss 1.11475e-14
Cpar26 inp.t0 vss 9.67486e-14
Cpar27 out vdd 3.81521e-15
Cpar28 out vss 1.14844e-14
Cpar29 out.t0 vss 1.52682e-15
Cpar30 out.t1 vss 9.85201e-16
Cpar31 out.t6 vss 1.02117e-14
Cpar32 vdd vss 6.30231e-13
Cpar33 vdd.t0 vss 3.76700e-14
Cpar34 vdd.t1 vss 1.19089e-14
Cpar35 vdd.t7 vss 1.35522e-13
.ends opamp_dut

Vdd vdd 0 1.800000
Vss vss 0 0
Ibias vdd ib 2.889000e-07
Vinp inp 0 DC 0.751000 AC 1 PWL(0 0.751000 1.923965e-07 0.751000 2.116361e-07 0.761000)
Rfb out inn 1m
Cload out 0 2.000000e-12
Xdut vdd vss inp inn out ib opamp_dut
.end
