* opa1000[0653]: 2p/pmos_miller_3v3_i1u_subth (pmos_miller, VDD=3.3V, CL=2.0pF, Iref=0.1312uA)
.include "pdk_opa.inc"
.temp 27
.option gmin=1e-12 rshunt=1e12 reltol=1e-3 abstol=1e-12 vntol=1e-5 method=gear
* Post-PEX R+C extracted netlist for pmos_miller_3v3_i1u_subth
.subckt opamp_dut vdd vss inp inn out ib
XMpar0 a_1178_3322.t2 inp.t0 a_4226_10068.t0 vdd.t2 pfet_03v3 w=1.95u l=2.08u ad=5.7096e-13 pd=2.6136e-06 as=6.7080e-13 ps=3.0280e-06 nf=1 m=50 par=50
XMpar1 a_4226_10068.t0 inn.t0 a_8452_3322.t4 vdd.t2 pfet_03v3 w=1.95u l=2.08u ad=6.7080e-13 pd=3.0280e-06 as=5.7096e-13 ps=2.6136e-06 nf=1 m=50 par=50
XMpar2 out.t0 a_1178_3322.t53 vss.t1 vss.t0 nfet_03v3 w=0.8u l=1.8u ad=2.2400e-13 pd=1.3600e-06 as=2.7520e-13 ps=1.6480e-06 nf=1 m=10 par=10
XMpar3 a_1205_996.t0 ib.t0 vss.t19 vss.t18 nfet_03v3 w=0.67u l=3.5u ad=1.8760e-13 pd=1.2300e-06 as=1.8760e-13 ps=1.2300e-06 nf=1 m=2 par=2
XMpar4 out.t2 a_1205_996.t2 vdd.t1 vdd.t0 pfet_03v3 w=2.93u l=3.5u ad=1.0079e-12 pd=4.2040e-06 as=8.2040e-13 ps=3.4900e-06 nf=1 m=10 par=10
XMpar5 a_1178_3322.t0 a_8452_3322.t0 vss.t1 vss.t0 nfet_03v3 w=0.8u l=1.8u ad=4.8000e-13 pd=2.8000e-06 as=2.2400e-13 ps=1.3600e-06 nf=1 m=2 par=2
XMpar6 a_8452_3322.t1 a_8452_3322.t0 vss.t1 vss.t0 nfet_03v3 w=0.8u l=1.8u ad=2.2400e-13 pd=1.3600e-06 as=2.2400e-13 ps=1.3600e-06 nf=1 m=2 par=2
XMpar7 a_4226_10068.t50 a_1205_996.t2 vdd.t1 vdd.t0 pfet_03v3 w=2.93u l=3.5u ad=8.2040e-13 pd=3.4900e-06 as=8.2040e-13 ps=3.4900e-06 nf=1 m=4 par=4
XMpar8 a_1205_996.t3 a_1205_996.t2 vdd.t1 vdd.t0 pfet_03v3 w=2.93u l=3.5u ad=8.2040e-13 pd=3.4900e-06 as=8.2040e-13 ps=3.4900e-06 nf=1 m=2 par=2
XMpar9 ib.t1 ib.t0 vss.t19 vss.t18 nfet_03v3 w=0.67u l=3.5u ad=4.0200e-13 pd=2.5400e-06 as=1.8760e-13 ps=1.2300e-06 nf=1 m=2 par=2
X15 a_9343_7436.t1 out.t16 cap_mim_2f0fF c_width=15.29u c_length=15.29u
X17 a_1178_3322.t52 a_9343_5356.t0 vss.t34 ppolyf_u_1k r_width=1u r_length=19.05u
X48 a_5401_6916.t0 a_9343_7436.t0 vss.t34 ppolyf_u_1k r_width=1u r_length=19.05u
X62 a_5401_6916.t0 a_9343_6396.t0 vss.t34 ppolyf_u_1k r_width=1u r_length=19.05u
X92 a_9343_7436.t1 out.t16 cap_mim_2f0fF c_width=15.29u c_length=15.29u
X106 a_5401_5876.t0 a_9343_6396.t0 vss.t34 ppolyf_u_1k r_width=1u r_length=19.05u
X117 a_5401_5876.t0 a_9343_5356.t0 vss.t34 ppolyf_u_1k r_width=1u r_length=19.05u
Rpar0 a_1178_3322.t0 a_1178_3322.t2 498.5384
Rpar1 a_1178_3322.t0 a_1178_3322.t52 1019.5315
Rpar2 a_1178_3322.t0 a_1178_3322.t53 87.0836
Rpar3 a_1178_3322.t2 a_1178_3322.t52 188.8019
Rpar4 a_1178_3322.t2 a_1178_3322.t53 87.6176
Rpar5 a_1178_3322.t52 a_1178_3322.t53 179.1816
Rpar6 a_1205_996.t0 a_1205_996.t2 78.2757
Rpar7 a_1205_996.t0 a_1205_996.t3 91.4605
Rpar8 a_1205_996.t2 a_1205_996.t3 28.5758
Rpar9 a_4226_10068.t0 a_4226_10068.t50 71.5560
Rpar10 a_8452_3322.t0 a_8452_3322.t1 28.2640
Rpar11 a_8452_3322.t0 a_8452_3322.t4 155.4076
Rpar12 a_8452_3322.t1 a_8452_3322.t4 144.4607
Rpar13 a_9343_7436.t0 a_9343_7436.t1 58.0331
Rpar14 ib ib.t0 11.7469
Rpar15 ib ib.t1 7.5629
Rpar16 inn inn.t0 1.6493
Rpar17 inp inp.t0 1.6493
Rpar18 out out.t0 109.3202
Rpar19 out out.t2 118.3091
Rpar20 out out.t16 22.0117
Rpar21 out.t0 out.t2 143.1402
Rpar22 out.t0 out.t16 697.2087
Rpar23 out.t2 out.t16 754.5372
Rpar24 vdd vdd.t0 334.2949
Rpar25 vdd vdd.t1 1692.2607
Rpar26 vdd vdd.t2 20.3556
Rpar27 vdd.t0 vdd.t1 5.4136
Rpar28 vdd.t0 vdd.t2 123.7185
Rpar29 vdd.t1 vdd.t2 626.2850
Rpar30 vss vss.t0 52.5092
Rpar31 vss vss.t1 346.3846
Rpar32 vss vss.t18 984.2386
Rpar33 vss vss.t19 1156.1883
Rpar34 vss vss.t34 1333.1348
Rpar35 vss.t0 vss.t1 3.7022
Rpar36 vss.t0 vss.t18 5.1384
Rpar37 vss.t0 vss.t19 11.0567
Rpar38 vss.t0 vss.t34 27.0166
Rpar39 vss.t1 vss.t18 53.2696
Rpar40 vss.t1 vss.t19 106.6583
Rpar41 vss.t1 vss.t34 166.5641
Rpar42 vss.t18 vss.t19 102.1566
Rpar43 vss.t18 vss.t34 943.4767
Rpar44 vss.t19 vss.t34 1710.3020
Cpar0 a_1178_3322.t0 vss 3.27708e-15
Cpar1 a_1178_3322.t2 vss 3.27633e-14
Cpar2 a_1178_3322.t52 vss 5.49569e-15
Cpar3 a_1178_3322.t53 vss 1.36548e-14
Cpar4 a_1205_996.t0 vss 2.52072e-15
Cpar5 a_1205_996.t2 vss 4.34083e-14
Cpar6 a_1205_996.t3 vss 5.08820e-15
Cpar7 a_4226_10068.t0 vss 9.07929e-14
Cpar8 a_4226_10068.t50 vss 1.38588e-14
Cpar9 a_5401_5876.t0 vss 3.34000e-17
Cpar10 a_5401_6916.t0 vss 3.83600e-17
Cpar11 a_8452_3322.t0 vss 8.65712e-15
Cpar12 a_8452_3322.t1 vss 4.68098e-15
Cpar13 a_8452_3322.t4 vss 4.68841e-14
Cpar14 a_9343_5356.t0 vss 4.17000e-17
Cpar15 a_9343_6396.t0 vss 4.62800e-17
Cpar16 a_9343_7436.t0 vss 1.20528e-16
Cpar17 a_9343_7436.t1 vss 5.58807e-15
Cpar18 ib vss 1.15404e-14
Cpar19 ib.t0 vss 1.38603e-15
Cpar20 ib.t1 vss 8.49700e-17
Cpar21 inn inp 1.64260e-16
Cpar22 inn out 6.68500e-17
Cpar23 inn vdd 4.24745e-14
Cpar24 inn vss 4.93733e-15
Cpar25 inn.t0 vss 6.72478e-14
Cpar26 inp vdd 4.23843e-14
Cpar27 inp vss 4.91432e-15
Cpar28 inp.t0 vss 6.68935e-14
Cpar29 out vdd 1.19646e-14
Cpar30 out vss 1.96453e-14
Cpar31 out.t0 vss 2.93403e-15
Cpar32 out.t16 vss 1.34426e-14
Cpar33 out.t2 vss 7.83017e-15
Cpar34 vdd vss 3.66643e-13
Cpar35 vdd.t0 vss 4.06061e-14
Cpar36 vdd.t1 vss 1.09422e-14
Cpar37 vdd.t2 vss 1.19277e-13
.ends opamp_dut

Vdd vdd 0 3.300000
Vss vss 0 0
Ibias vdd ib 1.312000e-07
Vinp inp 0 DC 1.480000 AC 1 PWL(0 1.480000 1.976719e-07 1.480000 2.174391e-07 1.490000)
Rfb out inn 1m
Cload out 0 2.000000e-12
Xdut vdd vss inp inn out ib opamp_dut
.end
