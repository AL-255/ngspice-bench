* opa1000[0790]: 200f/symmetrical_ota_3v3_i150u_weak (symmetrical_ota, VDD=3.3V, CL=0.2pF, Iref=23.75uA)
.include "pdk_opa.inc"
.temp 27
.option gmin=1e-12 rshunt=1e12 reltol=1e-3 abstol=1e-12 vntol=1e-5 method=gear
* Post-PEX R+C extracted netlist for symmetrical_ota_3v3_i150u_weak
.subckt opamp_dut vdd vss inp inn out ib
XMpar0 ib.t1 ib.t0 vss.t43 vss.t42 nfet_03v3 w=2.06u l=0.65u ad=5.7680e-13 pd=2.6200e-06 as=5.7680e-13 ps=2.6200e-06 nf=1 m=6 par=6
XMpar1 a_1436_996.t12 inp.t0 a_3994_3907.t0 vss.t0 nfet_03v3 w=1.78u l=0.45u ad=4.9840e-13 pd=2.3400e-06 as=5.9333e-13 ps=2.7433e-06 nf=1 m=12 par=12
XMpar2 a_3812_5386.t1 a_3812_5386.t0 vss.t1 vss.t0 nfet_03v3 w=1.56u l=0.7u ad=4.3680e-13 pd=2.1200e-06 as=4.3680e-13 ps=2.1200e-06 nf=1 m=12 par=12
XMpar3 out.t2 a_3812_5386.t0 vss.t1 vss.t0 nfet_03v3 w=1.56u l=0.7u ad=4.3680e-13 pd=2.1200e-06 as=5.2000e-13 ps=2.4867e-06 nf=1 m=12 par=12
XMpar4 a_3812_5386.t24 a_6944_3907.t12 vdd.t1 vdd.t0 pfet_03v3 w=6.06u l=0.7u ad=1.6968e-12 pd=6.6200e-06 as=2.0200e-12 ps=7.7367e-06 nf=1 m=12 par=12
XMpar5 a_3994_3907.t0 inn.t0 a_6944_3907.t0 vss.t0 nfet_03v3 w=1.78u l=0.45u ad=5.9333e-13 pd=2.7433e-06 as=4.9840e-13 ps=2.3400e-06 nf=1 m=12 par=12
XMpar6 out.t0 a_1436_996.t0 vdd.t1 vdd.t0 pfet_03v3 w=6.06u l=0.7u ad=1.6968e-12 pd=6.6200e-06 as=2.0200e-12 ps=7.7367e-06 nf=1 m=12 par=12
XMpar7 a_1436_996.t1 a_1436_996.t0 vdd.t1 vdd.t0 pfet_03v3 w=6.06u l=0.7u ad=1.6968e-12 pd=6.6200e-06 as=1.6968e-12 ps=6.6200e-06 nf=1 m=6 par=6
XMpar8 a_6944_3907.t13 a_6944_3907.t12 vdd.t1 vdd.t0 pfet_03v3 w=6.06u l=0.7u ad=1.6968e-12 pd=6.6200e-06 as=1.6968e-12 ps=6.6200e-06 nf=1 m=6 par=6
XMpar9 a_3994_3907.t24 ib.t0 vss.t43 vss.t42 nfet_03v3 w=2.06u l=0.65u ad=5.7680e-13 pd=2.6200e-06 as=9.0640e-13 ps=3.9700e-06 nf=1 m=12 par=12
X31 out.t24 vss.t2 cap_mim_2f0fF c_width=19.56u c_length=19.56u
X93 out.t24 vss.t2 cap_mim_2f0fF c_width=19.56u c_length=19.56u
Rpar0 a_1436_996.t0 a_1436_996.t1 18.8746
Rpar1 a_1436_996.t0 a_1436_996.t12 182.2547
Rpar2 a_1436_996.t1 a_1436_996.t12 47.3786
Rpar3 a_3812_5386.t0 a_3812_5386.t1 15.0079
Rpar4 a_3812_5386.t0 a_3812_5386.t24 813.4860
Rpar5 a_3812_5386.t1 a_3812_5386.t24 51.4839
Rpar6 a_3994_3907.t0 a_3994_3907.t24 68.0458
Rpar7 a_6944_3907.t0 a_6944_3907.t12 182.2547
Rpar8 a_6944_3907.t0 a_6944_3907.t13 47.3786
Rpar9 a_6944_3907.t12 a_6944_3907.t13 18.8746
Rpar10 ib ib.t0 12.9859
Rpar11 ib ib.t1 6.0812
Rpar12 ib.t0 ib.t1 13.8838
Rpar13 inn inn.t0 3.0314
Rpar14 inp inp.t0 3.4126
Rpar15 out out.t0 69.8472
Rpar16 out out.t2 84.8767
Rpar17 out out.t24 17.3248
Rpar18 out.t0 out.t2 70.5646
Rpar19 vdd vdd.t0 61.9222
Rpar20 vdd vdd.t1 245.1362
Rpar21 vdd.t0 vdd.t1 2.0956
Rpar22 vss vss.t0 40.9270
Rpar23 vss vss.t1 1810.3312
Rpar24 vss vss.t2 1647.3025
Rpar25 vss vss.t42 4922.4646
Rpar26 vss vss.t43 742.9997
Rpar27 vss.t0 vss.t1 3.2014
Rpar28 vss.t0 vss.t2 73.4435
Rpar29 vss.t0 vss.t42 68.1091
Rpar30 vss.t0 vss.t43 31.5417
Rpar31 vss.t1 vss.t2 1422.7129
Rpar32 vss.t1 vss.t42 648.4901
Rpar33 vss.t1 vss.t43 570.1102
Rpar34 vss.t2 vss.t42 665.6589
Rpar35 vss.t2 vss.t43 90.6569
Rpar36 vss.t42 vss.t43 12.3653
Cpar0 a_1436_996.t0 vss 1.96475e-14
Cpar1 a_1436_996.t1 vss 1.02452e-14
Cpar2 a_1436_996.t12 vss 4.15300e-15
Cpar3 a_3812_5386.t0 vss 8.93678e-15
Cpar4 a_3812_5386.t1 vss 4.81518e-15
Cpar5 a_3812_5386.t24 vss 1.00192e-14
Cpar6 a_3994_3907.t0 vss 9.05715e-15
Cpar7 a_3994_3907.t24 vss 1.46775e-14
Cpar8 a_6944_3907.t0 vss 4.21428e-15
Cpar9 a_6944_3907.t12 vss 1.99374e-14
Cpar10 a_6944_3907.t13 vss 1.03964e-14
Cpar11 ib out 2.50300e-17
Cpar12 ib vdd 1.48550e-16
Cpar13 ib vss 2.25337e-14
Cpar14 ib.t0 vss 2.74253e-15
Cpar15 ib.t1 vss 1.22470e-15
Cpar16 inn inp 5.23500e-17
Cpar17 inn vdd 1.28080e-16
Cpar18 inn vss 6.48604e-15
Cpar19 inn.t0 vss 8.01034e-16
Cpar20 inp vdd 4.53300e-17
Cpar21 inp vss 6.39810e-15
Cpar22 inp.t0 vss 8.88720e-16
Cpar23 out vdd 1.33649e-14
Cpar24 out vss 2.97431e-14
Cpar25 out.t0 vss 1.18328e-15
Cpar26 out.t2 vss 4.51090e-16
Cpar27 out.t24 vss 2.18992e-14
Cpar28 vdd vss 1.05555e-13
Cpar29 vdd.t0 vss 4.51298e-14
Cpar30 vdd.t1 vss 1.93294e-14
.ends opamp_dut

Vdd vdd 0 3.300000
Vss vss 0 0
Ibias vdd ib 2.375000e-05
Vinp inp 0 DC 1.645000 AC 1 PWL(0 1.645000 3.000000e-09 1.645000 3.300000e-09 1.655000)
Rfb out inn 1m
Cload out 0 2.000000e-13
Xdut vdd vss inp inn out ib opamp_dut
.end
