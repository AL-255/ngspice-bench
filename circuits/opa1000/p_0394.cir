* opa1000[0394]: 2p/nmos_5t_1v8_i150u_weak (nmos_5t, VDD=1.8V, CL=2.0pF, Iref=43.125uA)
.include "pdk_opa.inc"
.temp 27
.option gmin=1e-12 rshunt=1e12 reltol=1e-3 abstol=1e-12 vntol=1e-5 method=gear
* Post-PEX R+C extracted netlist for nmos_5t_1v8_i150u_weak
.subckt opamp_dut vdd vss inp inn out ib
XMpar0 a_1286_1205.t0 inn.t0 out.t14 vss.t0 nfet_03v3 w=1.98u l=0.68u ad=6.0409e-13 pd=2.7455e-06 as=5.6682e-13 ps=2.5914e-06 nf=1 m=102 par=102
XMpar1 a_1598_10582.t103 a_1598_10582.t102 vdd.t1 vdd.t0 pfet_03v3 w=1.96u l=0.56u ad=5.4880e-13 pd=2.5200e-06 as=5.4880e-13 ps=2.5200e-06 nf=1 m=52 par=52
XMpar2 out.t0 a_1598_10582.t102 vdd.t1 vdd.t0 pfet_03v3 w=1.96u l=0.56u ad=5.9705e-13 pd=2.7200e-06 as=5.4880e-13 ps=2.5200e-06 nf=1 m=52 par=52
XMpar3 a_1286_1205.t0 inp.t0 a_1598_10582.t0 vss.t0 nfet_03v3 w=1.98u l=0.68u ad=6.0409e-13 pd=2.7455e-06 as=5.6682e-13 ps=2.5914e-06 nf=1 m=102 par=102
XMpar4 ib.t1 ib.t0 vss.t83 vss.t0 nfet_03v3 w=4.82u l=0.81u ad=1.3496e-12 pd=5.3800e-06 as=1.3496e-12 ps=5.3800e-06 nf=1 m=6 par=6
XMpar5 a_1286_1205.t204 ib.t0 vss.t83 vss.t0 nfet_03v3 w=4.82u l=0.81u ad=1.3496e-12 pd=5.3800e-06 as=1.4781e-12 ps=5.8350e-06 nf=1 m=24 par=24
X49 out.t154 vss.t142 cap_mim_2f0fF c_width=9u c_length=9u
Rpar0 a_1286_1205.t0 a_1286_1205.t204 36.8159
Rpar1 a_1598_10582.t0 a_1598_10582.t102 181.2067
Rpar2 a_1598_10582.t0 a_1598_10582.t103 45.0543
Rpar3 a_1598_10582.t102 a_1598_10582.t103 7.1270
Rpar4 ib ib.t0 12.1420
Rpar5 ib ib.t1 4.4764
Rpar6 inn inn.t0 1.7243
Rpar7 inp inp.t0 1.7243
Rpar8 out out.t0 2.6699
Rpar9 out.t0 out.t14 46.3362
Rpar10 out.t0 out.t154 149.7090
Rpar11 out.t14 out.t154 64.7340
Rpar12 vdd vdd.t0 19.2549
Rpar13 vdd vdd.t1 1533.4219
Rpar14 vdd.t0 vdd.t1 9.7020
Rpar15 vss vss.t0 40.1086
Rpar16 vss vss.t83 1202.3717
Rpar17 vss vss.t142 107.6972
Rpar18 vss.t0 vss.t83 3.3118
Rpar19 vss.t0 vss.t142 53.6420
Rpar20 vss.t83 vss.t142 1608.0744
Cpar0 a_1286_1205.t0 vss 1.01391e-13
Cpar1 a_1286_1205.t204 vss 2.32894e-14
Cpar2 a_1598_10582.t0 vss 6.63481e-14
Cpar3 a_1598_10582.t102 vss 6.81554e-14
Cpar4 a_1598_10582.t103 vss 4.29918e-14
Cpar5 ib out 1.30700e-17
Cpar6 ib vss 3.31945e-14
Cpar7 ib.t0 vss 6.23907e-15
Cpar8 ib.t1 vss 1.20174e-15
Cpar9 inn inp 1.76270e-16
Cpar10 inn out 1.83721e-14
Cpar11 inn vdd 1.74600e-17
Cpar12 inn vss 4.37574e-14
Cpar13 inn.t0 vss 2.78169e-14
Cpar14 inp vdd 1.90800e-17
Cpar15 inp vss 4.37000e-14
Cpar16 inp.t0 vss 2.77513e-14
Cpar17 out vdd 3.53283e-14
Cpar18 out vss 2.19881e-14
Cpar19 out.t0 vss 3.05095e-14
Cpar20 out.t14 vss 5.25780e-14
Cpar21 out.t154 vss 3.24697e-14
Cpar22 vdd vss 1.44672e-13
Cpar23 vdd.t0 vss 1.02036e-13
Cpar24 vdd.t1 vss 1.75198e-14
.ends opamp_dut

Vdd vdd 0 1.800000
Vss vss 0 0
Ibias vdd ib 4.312500e-05
Vinp inp 0 DC 0.895000 AC 1 PWL(0 0.895000 3.000000e-09 0.895000 3.300000e-09 0.905000)
Rfb out inn 1m
Cload out 0 2.000000e-12
Xdut vdd vss inp inn out ib opamp_dut
.end
