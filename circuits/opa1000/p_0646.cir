* opa1000[0646]: 2p/pmos_miller_1v8_i500u_weak (pmos_miller, VDD=1.8V, CL=2.0pF, Iref=81.25uA)
.include "pdk_opa.inc"
.temp 27
.option gmin=1e-12 rshunt=1e12 reltol=1e-3 abstol=1e-12 vntol=1e-5 method=gear
* Post-PEX R+C extracted netlist for pmos_miller_1v8_i500u_weak
.subckt opamp_dut vdd vss inp inn out ib
XMpar0 a_1705_1086.t0 inp.t0 a_5266_14920.t0 vdd.t0 pfet_03v3 w=1.99u l=0.36u ad=5.7273e-13 pd=2.6141e-06 as=5.8826e-13 ps=2.6783e-06 nf=1 m=82 par=82
XMpar1 out.t28 a_1405_10209.t0 vdd.t56 vdd.t55 pfet_03v3 w=8.72u l=0.56u ad=2.4416e-12 pd=9.2800e-06 as=2.4416e-12 ps=9.2800e-06 nf=1 m=80 par=80
XMpar2 a_5266_14920.t0 inn.t0 a_7764_6214.t0 vdd.t0 pfet_03v3 w=1.99u l=0.36u ad=5.8826e-13 pd=2.6783e-06 as=5.7273e-13 ps=2.6141e-06 nf=1 m=82 par=82
XMpar3 a_5266_14920.t82 a_1405_10209.t0 vdd.t56 vdd.t55 pfet_03v3 w=8.72u l=0.56u ad=2.4416e-12 pd=9.2800e-06 as=2.7904e-12 ps=1.0450e-05 nf=1 m=32 par=32
XMpar4 ib.t1 ib.t0 vss.t157 vss.t0 nfet_03v3 w=2.33u l=0.56u ad=8.3880e-13 pd=3.6325e-06 as=6.5240e-13 ps=2.8900e-06 nf=1 m=16 par=16
XMpar5 a_1405_10209.t1 a_1405_10209.t0 vdd.t56 vdd.t55 pfet_03v3 w=8.72u l=0.56u ad=2.4416e-12 pd=9.2800e-06 as=2.7904e-12 ps=1.0450e-05 nf=1 m=16 par=16
XMpar6 out a_1705_1086.t99 vss.t1 vss.t0 nfet_03v3 w=2.4u l=0.4u ad=6.7200e-13 pd=2.9600e-06 as=7.1040e-13 ps=3.1120e-06 nf=1 m=80 par=80
XMpar7 a_1705_1086.t82 a_7764_6214.t82 vss.t1 vss.t0 nfet_03v3 w=2.4u l=0.4u ad=6.7200e-13 pd=2.9600e-06 as=7.6800e-13 ps=3.3400e-06 nf=1 m=16 par=16
XMpar8 a_7764_6214.t83 a_7764_6214.t82 vss.t1 vss.t0 nfet_03v3 w=2.4u l=0.4u ad=6.7200e-13 pd=2.9600e-06 as=6.7200e-13 ps=2.9600e-06 nf=1 m=16 par=16
XMpar9 a_1405_10209.t32 ib.t0 vss.t157 vss.t0 nfet_03v3 w=2.33u l=0.56u ad=7.4560e-13 pd=3.2612e-06 as=6.5240e-13 ps=2.8900e-06 nf=1 m=16 par=16
X142 a_6582_4878.t1 out.t150 cap_mim_2f0fF c_width=16.58u c_length=16.59u
X146 a_6582_4878.t1 out.t150 cap_mim_2f0fF c_width=16.58u c_length=16.59u
X329 a_1705_1086.t98 a_6582_4878.t0 vss.t155 ppolyf_u_1k r_width=1u r_length=1u
Rpar0 a_1405_10209.t0 a_1405_10209.t1 12.9287
Rpar1 a_1405_10209.t0 a_1405_10209.t32 50.0366
Rpar2 a_1405_10209.t1 a_1405_10209.t32 98.2381
Rpar3 a_1705_1086.t0 a_1705_1086.t99 402.9347
Rpar4 a_1705_1086.t0 a_1705_1086.t82 187.2061
Rpar5 a_1705_1086.t0 a_1705_1086.t98 173.8803
Rpar6 a_1705_1086.t99 a_1705_1086.t82 99.6328
Rpar7 a_1705_1086.t99 a_1705_1086.t98 227.9960
Rpar8 a_1705_1086.t82 a_1705_1086.t98 105.9284
Rpar9 a_5266_14920.t0 a_5266_14920.t82 35.9844
Rpar10 a_6582_4878.t0 a_6582_4878.t1 59.9968
Rpar11 a_7764_6214.t0 a_7764_6214.t82 1696.1698
Rpar12 a_7764_6214.t0 a_7764_6214.t83 60.7832
Rpar13 a_7764_6214.t82 a_7764_6214.t83 14.4557
Rpar14 ib ib.t0 13.5359
Rpar15 ib ib.t1 2.8579
Rpar16 ib.t0 ib.t1 8.2948
Rpar17 inn inn.t0 1.9574
Rpar18 inp inp.t0 1.9574
Rpar19 out out.t28 181.0974
Rpar20 out out.t150 85.7834
Rpar21 out.t28 out.t150 232.2675
Rpar22 vdd vdd.t0 24.6358
Rpar23 vdd vdd.t55 387.7841
Rpar24 vdd vdd.t56 248.7792
Rpar25 vdd.t0 vdd.t55 190.3927
Rpar26 vdd.t0 vdd.t56 122.1447
Rpar27 vdd.t55 vdd.t56 3.2044
Rpar28 vss vss.t0 59.1100
Rpar29 vss vss.t1 3421.7589
Rpar30 vss vss.t155 5880.6645
Rpar31 vss vss.t157 545.7373
Rpar32 vss.t0 vss.t1 1.6521
Rpar33 vss.t0 vss.t155 9.6617
Rpar34 vss.t0 vss.t157 7.0980
Rpar35 vss.t1 vss.t155 821.1655
Rpar36 vss.t1 vss.t157 336.3203
Cpar0 a_1405_10209.t0 vss 1.17362e-13
Cpar1 a_1405_10209.t1 vss 2.04728e-14
Cpar2 a_1405_10209.t32 vss 1.21697e-14
Cpar3 a_1705_1086.t0 vss 3.66255e-14
Cpar4 a_1705_1086.t82 vss 1.16827e-14
Cpar5 a_1705_1086.t98 vss 3.58163e-15
Cpar6 a_1705_1086.t99 vss 3.48002e-14
Cpar7 a_5266_14920.t0 vss 1.12099e-13
Cpar8 a_5266_14920.t82 vss 8.82343e-14
Cpar9 a_6582_4878.t0 vss 7.12760e-17
Cpar10 a_6582_4878.t1 vss 5.19597e-15
Cpar11 a_7764_6214.t0 vss 4.32565e-14
Cpar12 a_7764_6214.t82 vss 1.42214e-14
Cpar13 a_7764_6214.t83 vss 1.57244e-14
Cpar14 ib out 8.70800e-17
Cpar15 ib vss 3.66518e-14
Cpar16 ib.t0 vss 4.51718e-15
Cpar17 ib.t1 vss 3.36994e-15
Cpar18 inn inp 1.08260e-16
Cpar19 inn vdd 2.56264e-14
Cpar20 inn vss 8.45694e-15
Cpar21 inn.t0 vss 3.46605e-14
Cpar22 inp out 4.99200e-17
Cpar23 inp vdd 2.56544e-14
Cpar24 inp vss 8.52021e-15
Cpar25 inp.t0 vss 3.47425e-14
Cpar26 out vdd 1.17860e-13
Cpar27 out vss 1.20693e-13
Cpar28 out.t150 vss 2.64787e-14
Cpar29 out.t28 vss 1.00933e-13
Cpar30 vdd vss 4.42756e-13
Cpar31 vdd.t0 vss 9.40547e-14
Cpar32 vdd.t55 vss 1.88317e-13
Cpar33 vdd.t56 vss 7.29837e-14
.ends opamp_dut

Vdd vdd 0 1.800000
Vss vss 0 0
Ibias vdd ib 8.125000e-05
Vinp inp 0 DC 0.805000 AC 1 PWL(0 0.805000 3.000000e-09 0.805000 3.300000e-09 0.815000)
Rfb out inn 1m
Cload out 0 2.000000e-12
Xdut vdd vss inp inn out ib opamp_dut
.end
