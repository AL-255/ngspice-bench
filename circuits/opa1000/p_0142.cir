* opa1000[0142]: 2p/current_reuse_1v8_10u_100u_subth (current_reuse, VDD=1.8V, CL=2.0pF, Iref=9.2857uA)
.include "pdk_opa.inc"
.temp 27
.option gmin=1e-12 rshunt=1e12 reltol=1e-3 abstol=1e-12 vntol=1e-5 method=gear
* Post-PEX R+C extracted netlist for current_reuse_1v8_10u_100u_subth
.subckt opamp_dut vdd vss inp inn out ib
XMpar0 a_4514_17706.t0 a_7040_10806.t0 vdd.t44 vdd.t43 pfet_03v3 w=10u l=0.35u ad=2.8000e-12 pd=1.0560e-05 as=6.0000e-12 ps=2.1200e-05 nf=1 m=2 par=2
XMpar1 a_4514_17706.t2 inn.t28 a_7040_10806.t30 vdd.t0 pfet_03v3 w=2.52u l=0.6u ad=7.5600e-13 pd=3.2775e-06 as=7.3080e-13 ps=3.1787e-06 nf=1 m=64 par=64
XMpar2 a_1178_11054.t30 inp.t28 a_4514_17706.t2 vdd.t0 pfet_03v3 w=2.52u l=0.6u ad=7.3080e-13 pd=3.1787e-06 as=7.5600e-13 ps=3.2775e-06 nf=1 m=64 par=64
XMpar3 a_2298_1249.t56 ib.t0 vss.t30 vss.t29 nfet_03v3 w=8.64u l=0.8u ad=2.4192e-12 pd=9.2000e-06 as=2.4192e-12 ps=9.2000e-06 nf=1 m=4 par=4
XMpar4 out.t0 a_1178_11054.t94 vdd.t44 vdd.t43 pfet_03v3 w=10u l=0.35u ad=2.8000e-12 pd=1.0560e-05 as=3.4400e-12 ps=1.2688e-05 nf=1 m=10 par=10
XMpar5 a_2298_1249.t0 inn.t0 a_7040_10806.t2 vss.t0 nfet_03v3 w=2.02u l=0.6u ad=6.5794e-13 pd=2.9600e-06 as=5.6560e-13 ps=2.5800e-06 nf=1 m=28 par=28
XMpar6 a_1178_11054.t2 inp.t0 a_2298_1249.t0 vss.t0 nfet_03v3 w=2.02u l=0.6u ad=5.6560e-13 pd=2.5800e-06 as=6.5794e-13 ps=2.9600e-06 nf=1 m=28 par=28
XMpar7 out.t11 ib.t0 vss.t30 vss.t29 nfet_03v3 w=8.64u l=0.8u ad=2.9722e-12 pd=1.1056e-05 as=2.4192e-12 ps=9.2000e-06 nf=1 m=10 par=10
XMpar8 ib.t1 ib.t0 vss.t30 vss.t29 nfet_03v3 w=8.64u l=0.8u ad=2.4192e-12 pd=9.2000e-06 as=2.4192e-12 ps=9.2000e-06 nf=1 m=2 par=2
XMpar9 a_7040_10806.t1 a_7040_10806.t0 vdd.t44 vdd.t43 pfet_03v3 w=10u l=0.35u ad=6.0000e-12 pd=2.1200e-05 as=2.8000e-12 ps=1.0560e-05 nf=1 m=1
XMpar10 a_1178_11054.t0 a_7040_10806.t0 vdd.t44 vdd.t43 pfet_03v3 w=10u l=0.35u ad=6.0000e-12 pd=2.1200e-05 as=2.8000e-12 ps=1.0560e-05 nf=1 m=1
X0 a_1556_11054.t1 out.t5 cap_mim_2f0fF c_width=19.47u c_length=19.48u
X19 a_1178_11054.t1 a_1556_11054.t0 vss.t14 ppolyf_u_1k r_width=1u r_length=1.23u
X192 a_1556_11054.t1 out.t5 cap_mim_2f0fF c_width=19.47u c_length=19.48u
X214 a_1556_11054.t1 out.t5 cap_mim_2f0fF c_width=19.47u c_length=19.48u
Rpar0 a_1178_11054.t0 a_1178_11054.t1 500.9527
Rpar1 a_1178_11054.t0 a_1178_11054.t2 159.1987
Rpar2 a_1178_11054.t0 a_1178_11054.t94 521.8906
Rpar3 a_1178_11054.t0 a_1178_11054.t30 238.1415
Rpar4 a_1178_11054.t1 a_1178_11054.t2 208.1943
Rpar5 a_1178_11054.t1 a_1178_11054.t94 93.8183
Rpar6 a_1178_11054.t1 a_1178_11054.t30 311.4329
Rpar7 a_1178_11054.t2 a_1178_11054.t94 216.8961
Rpar8 a_1178_11054.t2 a_1178_11054.t30 86.9279
Rpar9 a_1178_11054.t94 a_1178_11054.t30 324.4497
Rpar10 a_1556_11054.t0 a_1556_11054.t1 80.8242
Rpar11 a_2298_1249.t0 a_2298_1249.t56 98.2734
Rpar12 a_4514_17706.t0 a_4514_17706.t2 73.6913
Rpar13 a_7040_10806.t0 a_7040_10806.t1 67.3926
Rpar14 a_7040_10806.t0 a_7040_10806.t2 678.4266
Rpar15 a_7040_10806.t0 a_7040_10806.t30 1362.9592
Rpar16 a_7040_10806.t1 a_7040_10806.t2 203.4794
Rpar17 a_7040_10806.t1 a_7040_10806.t30 408.7901
Rpar18 a_7040_10806.t2 a_7040_10806.t30 77.9729
Rpar19 ib ib.t0 24.6246
Rpar20 ib ib.t1 8.9856
Rpar21 ib.t0 ib.t1 75.9219
Rpar22 inn inn.t0 2.4997
Rpar23 inn inn.t28 34.0335
Rpar24 inp inp.t0 2.4997
Rpar25 inp inp.t28 33.9849
Rpar26 out out.t0 210.1253
Rpar27 out out.t11 1.8151
Rpar28 out out.t5 279.3819
Rpar29 out.t0 out.t11 81.1446
Rpar30 out.t0 out.t5 266.7009
Rpar31 out.t11 out.t5 107.8896
Rpar32 vdd vdd.t0 28.0219
Rpar33 vdd vdd.t43 347.7311
Rpar34 vdd vdd.t44 524.1377
Rpar35 vdd.t0 vdd.t43 220.3317
Rpar36 vdd.t0 vdd.t44 332.1076
Rpar37 vdd.t43 vdd.t44 3.2351
Rpar38 vss vss.t0 582.3639
Rpar39 vss vss.t14 340.8401
Rpar40 vss vss.t29 64.1734
Rpar41 vss vss.t30 553.6832
Rpar42 vss.t0 vss.t14 471.8206
Rpar43 vss.t0 vss.t29 273.2222
Rpar44 vss.t0 vss.t30 2261.2532
Rpar45 vss.t14 vss.t29 175.0175
Rpar46 vss.t14 vss.t30 1510.4458
Rpar47 vss.t29 vss.t30 4.8439
Cpar0 a_1178_11054.t0 vss 7.99082e-15
Cpar1 a_1178_11054.t1 vss 3.77877e-15
Cpar2 a_1178_11054.t2 vss 2.15122e-14
Cpar3 a_1178_11054.t30 vss 4.63998e-14
Cpar4 a_1178_11054.t94 vss 1.21196e-14
Cpar5 a_1556_11054.t0 vss 8.30700e-17
Cpar6 a_1556_11054.t1 vss 1.03676e-14
Cpar7 a_2298_1249.t0 vss 3.16700e-14
Cpar8 a_2298_1249.t56 vss 1.16946e-14
Cpar9 a_4514_17706.t0 vss 7.94941e-15
Cpar10 a_4514_17706.t2 vss 9.34385e-14
Cpar11 a_7040_10806.t0 vss 6.12108e-15
Cpar12 a_7040_10806.t1 vss 1.24680e-14
Cpar13 a_7040_10806.t2 vss 2.28425e-14
Cpar14 a_7040_10806.t30 vss 4.56859e-14
Cpar15 ib out 3.01169e-15
Cpar16 ib vss 2.03532e-14
Cpar17 ib.t0 vss 4.89497e-15
Cpar18 ib.t1 vss 6.59166e-16
Cpar19 inn inp 2.05280e-16
Cpar20 inn vdd 2.62528e-14
Cpar21 inn vss 1.97554e-14
Cpar22 inn.t0 vss 1.05238e-14
Cpar23 inn.t28 vss 3.67130e-14
Cpar24 inp vdd 2.55575e-14
Cpar25 inp vss 2.01378e-14
Cpar26 inp.t0 vss 1.05144e-14
Cpar27 inp.t28 vss 3.66786e-14
Cpar28 out vdd 2.28890e-14
Cpar29 out vss 2.83798e-14
Cpar30 out.t0 vss 8.99898e-15
Cpar31 out.t11 vss 8.37515e-15
Cpar32 out.t5 vss 2.09182e-14
Cpar33 vdd vss 2.35281e-13
Cpar34 vdd.t0 vss 7.80389e-14
Cpar35 vdd.t43 vss 2.07980e-14
Cpar36 vdd.t44 vss 1.71828e-14
.ends opamp_dut

Vdd vdd 0 1.800000
Vss vss 0 0
Ibias vdd ib 9.285700e-06
Vinp inp 0 DC 0.895000 AC 1 PWL(0 0.895000 5.588734e-09 0.895000 6.147608e-09 0.905000)
Rfb out inn 1m
Cload out 0 2.000000e-12
Xdut vdd vss inp inn out ib opamp_dut
.end
