* opa1000[0291]: 200f/folded_cascode_pmos_3v3_i500u_weak (folded_cascode_pmos, VDD=3.3V, CL=0.2pF, Iref=111.1111uA)
.include "pdk_opa.inc"
.temp 27
.option gmin=1e-12 rshunt=1e12 reltol=1e-3 abstol=1e-12 vntol=1e-5 method=gear
* Post-PEX R+C extracted netlist for folded_cascode_pmos_3v3_i500u_weak
.subckt opamp_dut vdd vss inp inn out ib
XMpar0 a_12494_12085.t118 a_1604_3900.t80 out.t0 vss.t2 nfet_03v3 w=1.99u l=0.45u ad=6.2088e-13 pd=2.8130e-06 as=5.8904e-13 ps=2.6815e-06 nf=1 m=40 par=40
XMpar1 a_5242_10130.t118 a_1604_3900.t80 a_9204_6228.t0 vss.t2 nfet_03v3 w=1.99u l=0.45u ad=6.2088e-13 pd=2.8130e-06 as=5.8904e-13 ps=2.6815e-06 nf=1 m=40 par=40
XMpar2 a_12494_12085.t0 inn.t0 a_1484_4108.t0 vdd.t0 pfet_03v3 w=1.98u l=0.45u ad=5.6514e-13 pd=2.5844e-06 as=6.0809e-13 ps=2.7620e-06 nf=1 m=118 par=118
XMpar3 a_1604_3900.t1 a_1604_3900.t0 vdd.t40 vdd.t39 pfet_03v3 w=8.13u l=0.5u ad=3.2520e-12 pd=1.1979e-05 as=2.6016e-12 ps=9.7862e-06 nf=1 m=16 par=16
XMpar4 a_1484_4108.t236 a_1604_3900.t0 vdd.t40 vdd.t39 pfet_03v3 w=8.13u l=0.5u ad=2.7642e-12 pd=1.0334e-05 as=2.7642e-12 ps=1.0334e-05 nf=1 m=32 par=32
XMpar5 a_12494_12085.t158 ib vss.t53 vss.t2 nfet_03v3 w=3.12u l=0.56u ad=8.7360e-13 pd=3.6800e-06 as=9.3600e-13 ps=3.9150e-06 nf=1 m=32 par=32
XMpar6 a_1484_4108.t0 inp.t0 a_5242_10130.t0 vdd.t0 pfet_03v3 w=1.98u l=0.45u ad=6.0809e-13 pd=2.7620e-06 as=5.6514e-13 ps=2.5844e-06 nf=1 m=118 par=118
XMpar7 a_5242_10130.t158 ib vss.t53 vss.t2 nfet_03v3 w=3.12u l=0.56u ad=8.7360e-13 pd=3.6800e-06 as=9.3600e-13 ps=3.9150e-06 nf=1 m=32 par=32
XMpar8 out.t8 a_9204_6228.t40 vdd.t40 vdd.t39 pfet_03v3 w=8.13u l=0.5u ad=2.2764e-12 pd=8.6900e-06 as=2.2764e-12 ps=8.6900e-06 nf=1 m=16 par=16
XMpar9 a_9204_6228.t41 a_9204_6228.t40 vdd.t40 vdd.t39 pfet_03v3 w=8.13u l=0.5u ad=2.2764e-12 pd=8.6900e-06 as=2.6016e-12 ps=9.7862e-06 nf=1 m=16 par=16
XMpar10 a_1604_3900.t32 ib vss.t53 vss.t2 nfet_03v3 w=3.12u l=0.56u ad=8.7360e-13 pd=3.6800e-06 as=8.7360e-13 ps=3.6800e-06 nf=1 m=16 par=16
XMpar11 ib.t1 ib vss.t53 vss.t2 nfet_03v3 w=3.12u l=0.56u ad=8.7360e-13 pd=3.6800e-06 as=9.9840e-13 ps=4.1500e-06 nf=1 m=16 par=16
X21 out.t56 vss.t0 cap_mim_2f0fF c_width=17.91u c_length=17.91u
X35 out.t56 vss.t0 cap_mim_2f0fF c_width=17.91u c_length=17.91u
Rpar0 a_12494_12085.t0 a_12494_12085.t118 83.8289
Rpar1 a_12494_12085.t0 a_12494_12085.t158 138.1179
Rpar2 a_12494_12085.t118 a_12494_12085.t158 58.5524
Rpar3 a_1484_4108.t0 a_1484_4108.t236 140.9699
Rpar4 a_1604_3900.t0 a_1604_3900.t1 6.8019
Rpar5 a_1604_3900.t0 a_1604_3900.t80 5617.2058
Rpar6 a_1604_3900.t0 a_1604_3900.t32 914.1459
Rpar7 a_1604_3900.t1 a_1604_3900.t80 331.9241
Rpar8 a_1604_3900.t1 a_1604_3900.t32 54.0174
Rpar9 a_1604_3900.t80 a_1604_3900.t32 311.8140
Rpar10 a_5242_10130.t0 a_5242_10130.t118 91.8392
Rpar11 a_5242_10130.t0 a_5242_10130.t158 105.4509
Rpar12 a_5242_10130.t118 a_5242_10130.t158 60.5487
Rpar13 a_9204_6228.t0 a_9204_6228.t40 491.5259
Rpar14 a_9204_6228.t0 a_9204_6228.t41 85.9505
Rpar15 a_9204_6228.t40 a_9204_6228.t41 16.7433
Rpar16 ib ib.t1 12.6059
Rpar17 inn inn.t0 1.9234
Rpar18 inp inp.t0 1.9234
Rpar19 out out.t0 113.7421
Rpar20 out out.t8 2.2776
Rpar21 out out.t56 69.7312
Rpar22 out.t0 out.t56 216.7635
Rpar23 vdd vdd.t0 28.9585
Rpar24 vdd vdd.t40 3460.2618
Rpar25 vdd vdd.t39 115.9388
Rpar26 vdd.t0 vdd.t40 4269.5123
Rpar27 vdd.t0 vdd.t39 209.0250
Rpar28 vdd.t40 vdd.t39 2.9160
Rpar29 vss vss.t0 103.7657
Rpar30 vss vss.t2 33.3250
Rpar31 vss vss.t53 229.4309
Rpar32 vss.t0 vss.t2 140.7383
Rpar33 vss.t0 vss.t53 968.9347
Rpar34 vss.t2 vss.t53 1.8874
Cpar0 a_12494_12085.t0 vss 7.23462e-14
Cpar1 a_12494_12085.t118 vss 2.68562e-14
Cpar2 a_12494_12085.t158 vss 2.64320e-14
Cpar3 a_1484_4108.t0 vss 1.56563e-13
Cpar4 a_1484_4108.t236 vss 9.07115e-14
Cpar5 a_1604_3900.t0 vss 3.41289e-14
Cpar6 a_1604_3900.t1 vss 3.69930e-14
Cpar7 a_1604_3900.t32 vss 1.47736e-14
Cpar8 a_1604_3900.t80 vss 3.50254e-14
Cpar9 a_5242_10130.t0 vss 7.25929e-14
Cpar10 a_5242_10130.t118 vss 2.68393e-14
Cpar11 a_5242_10130.t158 vss 2.68427e-14
Cpar12 a_9204_6228.t0 vss 2.34635e-14
Cpar13 a_9204_6228.t40 vss 3.16389e-14
Cpar14 a_9204_6228.t41 vss 2.76390e-14
Cpar15 ib vdd 1.54171e-15
Cpar16 ib vss 9.20868e-14
Cpar17 ib.t1 vss 4.55717e-15
Cpar18 inn inp 2.61430e-16
Cpar19 inn vdd 3.83367e-14
Cpar20 inn vss 8.11181e-15
Cpar21 inn.t0 vss 6.11324e-14
Cpar22 inp vdd 3.82559e-14
Cpar23 inp vss 7.96272e-15
Cpar24 inp.t0 vss 6.10766e-14
Cpar25 out vdd 2.64122e-14
Cpar26 out vss 2.85415e-14
Cpar27 out.t0 vss 5.10097e-15
Cpar28 out.t56 vss 5.16025e-14
Cpar29 out.t8 vss 4.46016e-15
Cpar30 vdd vss 4.74476e-13
Cpar31 vdd.t0 vss 1.28562e-13
Cpar32 vdd.t39 vss 1.31953e-13
Cpar33 vdd.t40 vss 4.33846e-14
.ends opamp_dut

Vdd vdd 0 3.300000
Vss vss 0 0
Ibias vdd ib 1.111111e-04
Vinp inp 0 DC 1.381000 AC 1 PWL(0 1.381000 3.000000e-09 1.381000 3.300000e-09 1.391000)
Rfb out inn 1m
Cload out 0 2.000000e-13
Xdut vdd vss inp inn out ib opamp_dut
.end
