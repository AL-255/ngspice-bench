* opa1000[0515]: 200f/pmos_5t_1v8_i20u_weak (pmos_5t, VDD=1.8V, CL=0.2pF, Iref=4.0uA)
.include "pdk_opa.inc"
.temp 27
.option gmin=1e-12 rshunt=1e12 reltol=1e-3 abstol=1e-12 vntol=1e-5 method=gear
* Post-PEX R+C extracted netlist for pmos_5t_1v8_i20u_weak
.subckt opamp_dut vdd vss inp inn out ib
XMpar0 a_1540_5769.t2 inp.t0 a_2746_1205.t0 vdd.t6 pfet_03v3 w=1.84u l=0.54u ad=5.8062e-13 pd=2.6756e-06 as=5.8062e-13 ps=2.6756e-06 nf=1 m=18 par=18
XMpar1 a_1540_5769.t2 inn.t0 out.t3 vdd.t6 pfet_03v3 w=1.84u l=0.54u ad=5.8062e-13 pd=2.6756e-06 as=5.8062e-13 ps=2.6756e-06 nf=1 m=18 par=18
XMpar2 a_2746_1205.t19 a_2746_1205.t18 vss.t1 vss.t0 nfet_03v3 w=1.28u l=1.08u ad=3.5840e-13 pd=1.8400e-06 as=5.6320e-13 ps=2.8000e-06 nf=1 m=4 par=4
XMpar3 a_1240_5561.t0 ib.t0 vss.t13 vss.t12 nfet_03v3 w=2.59u l=1.5u ad=7.2520e-13 pd=3.1500e-06 as=7.2520e-13 ps=3.1500e-06 nf=1 m=2 par=2
XMpar4 a_1540_5769.t0 a_1240_5561.t2 vdd.t1 vdd.t0 pfet_03v3 w=10u l=1.5u ad=2.8000e-12 pd=1.0560e-05 as=3.6000e-12 ps=1.3220e-05 nf=1 m=8 par=8
XMpar5 ib.t1 ib.t0 vss.t13 vss.t12 nfet_03v3 w=2.59u l=1.5u ad=1.5540e-12 pd=6.3800e-06 as=7.2520e-13 ps=3.1500e-06 nf=1 m=2 par=2
XMpar6 a_1240_5561.t3 a_1240_5561.t2 vdd.t1 vdd.t0 pfet_03v3 w=10u l=1.5u ad=2.8000e-12 pd=1.0560e-05 as=2.8000e-12 ps=1.0560e-05 nf=1 m=2 par=2
XMpar7 out.t0 a_2746_1205.t18 vss.t1 vss.t0 nfet_03v3 w=1.28u l=1.08u ad=3.5840e-13 pd=1.8400e-06 as=3.5840e-13 ps=1.8400e-06 nf=1 m=4 par=4
Rpar0 a_1240_5561.t0 a_1240_5561.t2 171.6055
Rpar1 a_1240_5561.t0 a_1240_5561.t3 60.0749
Rpar2 a_1240_5561.t2 a_1240_5561.t3 25.7949
Rpar3 a_1540_5769.t0 a_1540_5769.t2 47.3914
Rpar4 a_2746_1205.t0 a_2746_1205.t18 100.1896
Rpar5 a_2746_1205.t0 a_2746_1205.t19 59.5390
Rpar6 a_2746_1205.t18 a_2746_1205.t19 21.1917
Rpar7 ib ib.t0 18.3517
Rpar8 ib ib.t1 4.1435
Rpar9 ib.t0 ib.t1 90.4087
Rpar10 inn inn.t0 3.5169
Rpar11 inp inp.t0 3.5169
Rpar12 out out.t0 7.3060
Rpar13 out out.t3 54.0953
Rpar14 out.t0 out.t3 256.3518
Rpar15 vdd vdd.t0 58.0730
Rpar16 vdd vdd.t1 231.7434
Rpar17 vdd vdd.t6 129.2861
Rpar18 vdd.t0 vdd.t1 5.7033
Rpar19 vdd.t0 vdd.t6 132.4183
Rpar20 vdd.t1 vdd.t6 528.4224
Rpar21 vss vss.t0 132.2700
Rpar22 vss vss.t1 292.3014
Rpar23 vss vss.t12 79.0032
Rpar24 vss vss.t13 119.0926
Rpar25 vss.t0 vss.t1 6.5619
Rpar26 vss.t0 vss.t12 46.4397
Rpar27 vss.t0 vss.t13 83.9334
Rpar28 vss.t1 vss.t12 105.3249
Rpar29 vss.t1 vss.t13 190.0970
Rpar30 vss.t12 vss.t13 9.5886
Cpar0 a_1240_5561.t0 vss 1.83708e-15
Cpar1 a_1240_5561.t2 vss 2.00960e-14
Cpar2 a_1240_5561.t3 vss 4.15330e-15
Cpar3 a_1540_5769.t0 vss 1.81474e-14
Cpar4 a_1540_5769.t2 vss 2.12463e-14
Cpar5 a_2746_1205.t0 vss 9.59626e-15
Cpar6 a_2746_1205.t18 vss 5.96597e-15
Cpar7 a_2746_1205.t19 vss 2.09880e-15
Cpar8 ib vdd 1.71820e-16
Cpar9 ib vss 7.63949e-15
Cpar10 ib.t0 vss 8.99572e-16
Cpar11 ib.t1 vss 2.63037e-16
Cpar12 inn inp 1.04040e-16
Cpar13 inn out 2.37836e-15
Cpar14 inn vdd 8.15404e-15
Cpar15 inn vss 4.60469e-15
Cpar16 inn.t0 vss 8.18400e-15
Cpar17 inp vdd 8.04474e-15
Cpar18 inp vss 4.60274e-15
Cpar19 inp.t0 vss 8.11707e-15
Cpar20 out vdd 4.66412e-15
Cpar21 out vss 6.90113e-15
Cpar22 out.t0 vss 1.01420e-15
Cpar23 out.t3 vss 1.44874e-14
Cpar24 vdd vss 1.16891e-13
Cpar25 vdd.t0 vss 1.90562e-14
Cpar26 vdd.t1 vss 7.86716e-15
Cpar27 vdd.t6 vss 2.26296e-14
.ends opamp_dut

Vdd vdd 0 1.800000
Vss vss 0 0
Ibias vdd ib 4.000000e-06
Vinp inp 0 DC 0.805000 AC 1 PWL(0 0.805000 3.000000e-09 0.805000 3.300000e-09 0.815000)
Rfb out inn 1m
Cload out 0 2.000000e-13
Xdut vdd vss inp inn out ib opamp_dut
.end
