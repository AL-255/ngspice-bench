* opa1000[0676]: 200f/rail_to_rail_1v8_i2u_weak (rail_to_rail, VDD=1.8V, CL=0.2pF, Iref=0.2125uA)
.include "pdk_opa.inc"
.temp 27
.option gmin=1e-12 rshunt=1e12 reltol=1e-3 abstol=1e-12 vntol=1e-5 method=gear
* Post-PEX R+C extracted netlist for rail_to_rail_1v8_i2u_weak
.subckt opamp_dut vdd vss inp inn out ib
XMpar0 a_6634_8866.t0 inp.t0 a_906_1290.t5 vss.t0 nfet_03v3 w=1.17u l=4.5u ad=7.0200e-13 pd=3.5400e-06 as=3.2760e-13 ps=1.7300e-06 nf=1 m=2 par=2
XMpar1 a_6634_10700.t0 inn.t2 a_7764_4861.t0 vdd.t6 pfet_03v3 w=1.54u l=4.5u ad=9.2400e-13 pd=4.2800e-06 as=5.9547e-13 ps=2.8267e-06 nf=1 m=6 par=6
XMpar2 a_906_1290.t2 a_8176_6696.t2 vdd.t1 vdd.t0 pfet_03v3 w=1.14u l=1.69u ad=6.8400e-13 pd=3.4800e-06 as=3.1920e-13 ps=1.7000e-06 nf=1 m=2 par=2
XMpar3 ib.t1 ib.t0 vss.t18 vss.t17 nfet_03v3 w=0.4u l=1.56u ad=2.4000e-13 pd=2.0000e-06 as=1.1200e-13 ps=9.6000e-07 nf=1 m=2 par=2
XMpar4 a_10180_3044.t3 a_10180_3044.t2 vdd.t3 vdd.t2 pfet_03v3 w=0.64u l=1.56u ad=1.7920e-13 pd=1.2000e-06 as=1.7920e-13 ps=1.2000e-06 nf=1 m=2 par=2
XMpar5 a_7644_1294.t1 a_7644_1294.t0 vss.t3 vss.t2 nfet_03v3 w=0.4u l=2.72u ad=2.4000e-13 pd=2.0000e-06 as=1.1200e-13 ps=9.6000e-07 nf=1 m=2 par=2
XMpar6 out.t8 ib.t0 vss.t18 vss.t17 nfet_03v3 w=0.4u l=1.56u ad=1.1200e-13 pd=9.6000e-07 as=1.4400e-13 ps=1.2200e-06 nf=1 m=8 par=8
XMpar7 out.t0 a_906_1290.t7 vdd.t1 vdd.t0 pfet_03v3 w=1.14u l=1.69u ad=3.1920e-13 pd=1.7000e-06 as=4.1040e-13 ps=2.1450e-06 nf=1 m=8 par=8
XMpar8 a_906_1290.t0 a_7764_4861.t6 vss.t3 vss.t2 nfet_03v3 w=0.4u l=2.72u ad=2.4000e-13 pd=2.0000e-06 as=1.1200e-13 ps=9.6000e-07 nf=1 m=2 par=2
XMpar9 a_6634_8866.t0 inn.t0 a_8176_6696.t0 vss.t0 nfet_03v3 w=1.17u l=4.5u ad=7.0200e-13 pd=3.5400e-06 as=3.2760e-13 ps=1.7300e-06 nf=1 m=2 par=2
XMpar10 a_6634_10700.t0 inp.t2 a_7644_1294.t4 vdd.t6 pfet_03v3 w=1.54u l=4.5u ad=9.2400e-13 pd=4.2800e-06 as=5.9547e-13 ps=2.8267e-06 nf=1 m=6 par=6
XMpar11 a_8176_6696.t3 a_8176_6696.t2 vdd.t1 vdd.t0 pfet_03v3 w=1.14u l=1.69u ad=3.1920e-13 pd=1.7000e-06 as=3.1920e-13 ps=1.7000e-06 nf=1 m=2 par=2
XMpar12 a_6634_10700.t12 a_10180_3044.t2 vdd.t3 vdd.t2 pfet_03v3 w=0.64u l=1.56u ad=3.8400e-13 pd=2.4800e-06 as=1.7920e-13 ps=1.2000e-06 nf=1 m=2 par=2
XMpar13 a_6634_8866.t4 ib.t0 vss.t18 vss.t17 nfet_03v3 w=0.4u l=1.56u ad=2.4000e-13 pd=2.0000e-06 as=1.1200e-13 ps=9.6000e-07 nf=1 m=2 par=2
XMpar14 a_10180_3044.t0 ib.t0 vss.t18 vss.t17 nfet_03v3 w=0.4u l=1.56u ad=1.1200e-13 pd=9.6000e-07 as=1.1200e-13 ps=9.6000e-07 nf=1 m=2 par=2
XMpar15 a_8176_6696.t6 a_7644_1294.t0 vss.t3 vss.t2 nfet_03v3 w=0.4u l=2.72u ad=1.1200e-13 pd=9.6000e-07 as=1.1200e-13 ps=9.6000e-07 nf=1 m=2 par=2
XMpar16 a_7764_4861.t7 a_7764_4861.t6 vss.t3 vss.t2 nfet_03v3 w=0.4u l=2.72u ad=1.1200e-13 pd=9.6000e-07 as=1.1200e-13 ps=9.6000e-07 nf=1 m=2 par=2
X1 a_906_4930.t0 a_4690_5450.t0 vss.t7 ppolyf_u_1k r_width=1u r_length=18.26u
X5 a_906_1810.t0 a_4690_2330.t0 vss.t7 ppolyf_u_1k r_width=1u r_length=18.26u
X10 a_4690_5450.t1 out.t16 cap_mim_2f0fF c_width=12.99u c_length=12.99u
X15 a_906_4930.t0 a_4690_4410.t0 vss.t7 ppolyf_u_1k r_width=1u r_length=18.26u
X18 a_906_1810.t0 a_4690_1290.t0 vss.t7 ppolyf_u_1k r_width=1u r_length=18.26u
X26 a_906_3890.t0 a_4690_4410.t0 vss.t7 ppolyf_u_1k r_width=1u r_length=18.26u
X38 a_906_1290.t1 a_4690_1290.t0 vss.t7 ppolyf_u_1k r_width=1u r_length=18.26u
X41 a_906_3890.t0 a_4690_3370.t0 vss.t7 ppolyf_u_1k r_width=1u r_length=18.26u
X52 a_906_2850.t0 a_4690_3370.t0 vss.t7 ppolyf_u_1k r_width=1u r_length=18.26u
X57 a_906_2850.t0 a_4690_2330.t0 vss.t7 ppolyf_u_1k r_width=1u r_length=18.26u
Rpar0 a_10180_3044.t0 a_10180_3044.t2 102.3981
Rpar1 a_10180_3044.t0 a_10180_3044.t3 106.5988
Rpar2 a_10180_3044.t2 a_10180_3044.t3 28.5848
Rpar3 a_4690_5450.t0 a_4690_5450.t1 54.4343
Rpar4 a_6634_10700.t0 a_6634_10700.t12 58.8783
Rpar5 a_6634_8866.t0 a_6634_8866.t4 132.6799
Rpar6 a_7644_1294.t0 a_7644_1294.t1 21.1813
Rpar7 a_7644_1294.t0 a_7644_1294.t4 162.9289
Rpar8 a_7644_1294.t1 a_7644_1294.t4 119.2463
Rpar9 a_7764_4861.t0 a_7764_4861.t6 151.3028
Rpar10 a_7764_4861.t0 a_7764_4861.t7 157.1149
Rpar11 a_7764_4861.t6 a_7764_4861.t7 29.0073
Rpar12 a_8176_6696.t0 a_8176_6696.t2 195.9870
Rpar13 a_8176_6696.t0 a_8176_6696.t3 160.2211
Rpar14 a_8176_6696.t0 a_8176_6696.t6 205.2605
Rpar15 a_8176_6696.t2 a_8176_6696.t3 28.0698
Rpar16 a_8176_6696.t2 a_8176_6696.t6 279.7630
Rpar17 a_8176_6696.t3 a_8176_6696.t6 228.7087
Rpar18 a_906_1290.t0 a_906_1290.t1 165.1104
Rpar19 a_906_1290.t0 a_906_1290.t7 144.1900
Rpar20 a_906_1290.t0 a_906_1290.t2 70.4577
Rpar21 a_906_1290.t0 a_906_1290.t5 235.9817
Rpar22 a_906_1290.t1 a_906_1290.t7 78.0125
Rpar23 a_906_1290.t1 a_906_1290.t2 274.0069
Rpar24 a_906_1290.t1 a_906_1290.t5 917.7223
Rpar25 a_906_1290.t7 a_906_1290.t2 239.2888
Rpar26 a_906_1290.t7 a_906_1290.t5 801.4421
Rpar27 a_906_1290.t2 a_906_1290.t5 108.0053
Rpar28 ib ib.t0 11.4770
Rpar29 ib ib.t1 10.1337
Rpar30 inn inn.t0 3.5164
Rpar31 inn inn.t2 35.5549
Rpar32 inp inp.t0 3.5650
Rpar33 inp inp.t2 35.5065
Rpar34 out out.t0 120.3869
Rpar35 out out.t8 5.1808
Rpar36 out out.t16 434.6534
Rpar37 out.t0 out.t8 117.8575
Rpar38 out.t0 out.t16 80.1525
Rpar39 out.t8 out.t16 425.5210
Rpar40 vdd vdd.t0 225.1502
Rpar41 vdd vdd.t1 448.6090
Rpar42 vdd vdd.t3 2581.5933
Rpar43 vdd vdd.t2 1869.9450
Rpar44 vdd vdd.t6 36.2504
Rpar45 vdd.t0 vdd.t1 4.1467
Rpar46 vdd.t0 vdd.t3 442.6413
Rpar47 vdd.t0 vdd.t2 320.6217
Rpar48 vdd.t0 vdd.t6 259.2387
Rpar49 vdd.t1 vdd.t3 879.2897
Rpar50 vdd.t1 vdd.t2 636.9026
Rpar51 vdd.t1 vdd.t6 516.5299
Rpar52 vdd.t3 vdd.t2 13.2128
Rpar53 vdd.t3 vdd.t6 2972.4549
Rpar54 vdd.t2 vdd.t6 2153.0607
Rpar55 vss vss.t0 507.9388
Rpar56 vss vss.t3 471.3131
Rpar57 vss vss.t2 219.3956
Rpar58 vss vss.t17 118.2893
Rpar59 vss vss.t18 765.3196
Rpar60 vss vss.t7 50.0453
Rpar61 vss.t0 vss.t3 40.9449
Rpar62 vss.t0 vss.t2 18.0020
Rpar63 vss.t0 vss.t17 3.9223
Rpar64 vss.t0 vss.t18 48.8297
Rpar65 vss.t0 vss.t7 581.7240
Rpar66 vss.t3 vss.t2 15.6516
Rpar67 vss.t3 vss.t17 9.9767
Rpar68 vss.t3 vss.t18 92.7723
Rpar69 vss.t3 vss.t7 564.5148
Rpar70 vss.t2 vss.t17 1.9658
Rpar71 vss.t2 vss.t18 24.4710
Rpar72 vss.t2 vss.t7 257.4135
Rpar73 vss.t17 vss.t18 7.0319
Rpar74 vss.t17 vss.t7 132.6362
Rpar75 vss.t18 vss.t7 819.9194
Cpar0 a_10180_3044.t0 vss 3.99864e-15
Cpar1 a_10180_3044.t2 vss 5.78456e-15
Cpar2 a_10180_3044.t3 vss 2.18146e-15
Cpar3 a_4690_1290.t0 vss 3.43600e-17
Cpar4 a_4690_2330.t0 vss 3.89000e-17
Cpar5 a_4690_3370.t0 vss 3.86600e-17
Cpar6 a_4690_4410.t0 vss 4.19200e-17
Cpar7 a_4690_5450.t0 vss 1.33200e-16
Cpar8 a_4690_5450.t1 vss 2.16625e-15
Cpar9 a_6634_10700.t0 vss 2.12499e-14
Cpar10 a_6634_10700.t12 vss 6.47223e-15
Cpar11 a_6634_8866.t0 vss 7.07116e-15
Cpar12 a_6634_8866.t4 vss 9.06870e-15
Cpar13 a_7644_1294.t0 vss 6.87833e-15
Cpar14 a_7644_1294.t1 vss 3.65314e-15
Cpar15 a_7644_1294.t4 vss 1.02953e-14
Cpar16 a_7764_4861.t0 vss 9.53426e-15
Cpar17 a_7764_4861.t6 vss 7.28714e-15
Cpar18 a_7764_4861.t7 vss 2.64286e-15
Cpar19 a_8176_6696.t0 vss 3.17355e-15
Cpar20 a_8176_6696.t2 vss 5.57681e-15
Cpar21 a_8176_6696.t3 vss 2.64030e-15
Cpar22 a_8176_6696.t6 vss 4.19467e-15
Cpar23 a_906_1290.t0 vss 3.32889e-15
Cpar24 a_906_1290.t1 vss 3.55692e-15
Cpar25 a_906_1290.t2 vss 3.47456e-15
Cpar26 a_906_1290.t5 vss 2.50260e-15
Cpar27 a_906_1290.t7 vss 1.01172e-14
Cpar28 a_906_1810.t0 vss 3.20200e-17
Cpar29 a_906_2850.t0 vss 2.93600e-17
Cpar30 a_906_3890.t0 vss 3.00800e-17
Cpar31 a_906_4930.t0 vss 3.10600e-17
Cpar32 ib out 8.43210e-16
Cpar33 ib vss 1.84367e-14
Cpar34 ib.t0 vss 5.09043e-15
Cpar35 ib.t1 vss 4.94475e-16
Cpar36 inn inp 1.68460e-16
Cpar37 inn vdd 1.26201e-14
Cpar38 inn vss 8.68618e-15
Cpar39 inn.t0 vss 2.35209e-15
Cpar40 inn.t2 vss 1.69077e-14
Cpar41 inp vdd 1.45678e-14
Cpar42 inp vss 8.50176e-15
Cpar43 inp.t0 vss 2.45119e-15
Cpar44 inp.t2 vss 1.74490e-14
Cpar45 out vdd 6.49988e-15
Cpar46 out vss 1.12664e-14
Cpar47 out.t0 vss 3.47741e-15
Cpar48 out.t16 vss 8.89237e-15
Cpar49 out.t8 vss 1.92451e-15
Cpar50 vdd vss 1.63091e-13
Cpar51 vdd.t0 vss 1.39480e-14
Cpar52 vdd.t1 vss 6.41224e-15
Cpar53 vdd.t2 vss 5.14162e-15
Cpar54 vdd.t3 vss 3.18182e-15
Cpar55 vdd.t6 vss 4.06061e-14
.ends opamp_dut

Vdd vdd 0 1.800000
Vss vss 0 0
Ibias vdd ib 2.125000e-07
Vinp inp 0 DC 0.895000 AC 1 PWL(0 0.895000 5.955138e-08 0.895000 6.550652e-08 0.905000)
Rfb out inn 1m
Cload out 0 2.000000e-13
Xdut vdd vss inp inn out ib opamp_dut
.end
