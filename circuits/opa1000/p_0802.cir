* opa1000[0802]: 2p/symmetrical_ota_1v8_i2u_weak (symmetrical_ota, VDD=1.8V, CL=2.0pF, Iref=0.4333uA)
.include "pdk_opa.inc"
.temp 27
.option gmin=1e-12 rshunt=1e12 reltol=1e-3 abstol=1e-12 vntol=1e-5 method=gear
* Post-PEX R+C extracted netlist for symmetrical_ota_1v8_i2u_weak
.subckt opamp_dut vdd vss inp inn out ib
XMpar0 a_1730_1249.t8 ib.t0 vss.t21 vss.t20 nfet_03v3 w=0.42u l=2.08u ad=2.5200e-13 pd=2.0400e-06 as=1.8480e-13 ps=1.5100e-06 nf=1 m=4 par=4
XMpar1 out.t0 a_2388_10436.t4 vss.t1 vss.t0 nfet_03v3 w=0.5u l=3.4u ad=1.4000e-13 pd=1.0600e-06 as=2.2000e-13 ps=1.6300e-06 nf=1 m=4 par=4
XMpar2 out.t1 a_1850_6745.t4 vdd.t1 vdd.t0 pfet_03v3 w=2.08u l=3.4u ad=1.2480e-12 pd=5.3600e-06 as=9.1520e-13 ps=4.0000e-06 nf=1 m=4 par=4
XMpar3 a_2388_10436.t0 a_6324_4275.t4 vdd.t1 vdd.t0 pfet_03v3 w=2.08u l=3.4u ad=1.2480e-12 pd=5.3600e-06 as=9.1520e-13 ps=4.0000e-06 nf=1 m=4 par=4
XMpar4 a_1730_1249.t0 inn.t0 a_6324_4275.t0 vss.t4 nfet_03v3 w=1.38u l=3.75u ad=8.2800e-13 pd=3.9600e-06 as=3.8640e-13 ps=1.9400e-06 nf=1 m=4 par=4
XMpar5 a_2388_10436.t5 a_2388_10436.t4 vss.t1 vss.t0 nfet_03v3 w=0.5u l=3.4u ad=1.4000e-13 pd=1.0600e-06 as=1.4000e-13 ps=1.0600e-06 nf=1 m=4 par=4
XMpar6 a_1850_6745.t5 a_1850_6745.t4 vdd.t1 vdd.t0 pfet_03v3 w=2.08u l=3.4u ad=1.2480e-12 pd=5.3600e-06 as=5.8240e-13 ps=2.6400e-06 nf=1 m=2 par=2
XMpar7 ib.t1 ib.t0 vss.t21 vss.t20 nfet_03v3 w=0.42u l=2.08u ad=2.5200e-13 pd=2.0400e-06 as=1.1760e-13 ps=9.8000e-07 nf=1 m=2 par=2
XMpar8 a_6324_4275.t5 a_6324_4275.t4 vdd.t1 vdd.t0 pfet_03v3 w=2.08u l=3.4u ad=1.2480e-12 pd=5.3600e-06 as=5.8240e-13 ps=2.6400e-06 nf=1 m=2 par=2
XMpar9 a_1730_1249.t0 inp.t0 a_1850_6745.t0 vss.t4 nfet_03v3 w=1.38u l=3.75u ad=8.2800e-13 pd=3.9600e-06 as=3.8640e-13 ps=1.9400e-06 nf=1 m=4 par=4
Rpar0 a_1730_1249.t0 a_1730_1249.t8 41.1146
Rpar1 a_1850_6745.t0 a_1850_6745.t4 130.7084
Rpar2 a_1850_6745.t0 a_1850_6745.t5 96.1425
Rpar3 a_1850_6745.t4 a_1850_6745.t5 11.8779
Rpar4 a_2388_10436.t0 a_2388_10436.t4 166.7646
Rpar5 a_2388_10436.t0 a_2388_10436.t5 73.8026
Rpar6 a_2388_10436.t4 a_2388_10436.t5 22.0616
Rpar7 a_6324_4275.t0 a_6324_4275.t4 130.7079
Rpar8 a_6324_4275.t0 a_6324_4275.t5 96.1428
Rpar9 a_6324_4275.t4 a_6324_4275.t5 11.8779
Rpar10 ib ib.t0 11.0757
Rpar11 ib ib.t1 14.5103
Rpar12 ib.t0 ib.t1 34.9783
Rpar13 inn inn.t0 3.3173
Rpar14 inp inp.t0 3.3173
Rpar15 out out.t0 57.2283
Rpar16 out out.t1 3.9622
Rpar17 vdd vdd.t0 195.8031
Rpar18 vdd vdd.t1 43.7048
Rpar19 vdd.t0 vdd.t1 6.6261
Rpar20 vss vss.t0 435.8424
Rpar21 vss vss.t1 1008.9698
Rpar22 vss vss.t20 234.9081
Rpar23 vss vss.t21 59.2853
Rpar24 vss vss.t4 126.0804
Rpar25 vss.t0 vss.t1 7.2899
Rpar26 vss.t0 vss.t20 137.0449
Rpar27 vss.t0 vss.t21 250.2212
Rpar28 vss.t0 vss.t4 63.7479
Rpar29 vss.t1 vss.t20 317.5057
Rpar30 vss.t1 vss.t21 579.4925
Rpar31 vss.t1 vss.t4 147.6773
Rpar32 vss.t20 vss.t21 38.4785
Rpar33 vss.t20 vss.t4 8.5421
Rpar34 vss.t21 vss.t4 25.8473
Cpar0 a_1730_1249.t0 vss 7.32078e-15
Cpar1 a_1730_1249.t8 vss 4.64410e-15
Cpar2 a_1850_6745.t0 vss 4.98093e-15
Cpar3 a_1850_6745.t4 vss 1.75186e-14
Cpar4 a_1850_6745.t5 vss 6.29572e-15
Cpar5 a_2388_10436.t0 vss 5.41052e-15
Cpar6 a_2388_10436.t4 vss 8.36725e-15
Cpar7 a_2388_10436.t5 vss 2.25089e-15
Cpar8 a_6324_4275.t0 vss 4.91943e-15
Cpar9 a_6324_4275.t4 vss 1.73023e-14
Cpar10 a_6324_4275.t5 vss 6.21796e-15
Cpar11 ib vss 1.47416e-14
Cpar12 ib.t0 vss 1.89676e-15
Cpar13 ib.t1 vss 3.81314e-16
Cpar14 inn inp 1.02860e-16
Cpar15 inn vss 8.13524e-15
Cpar16 inn.t0 vss 2.04614e-15
Cpar17 inp vss 8.25961e-15
Cpar18 inp.t0 vss 2.07986e-15
Cpar19 out vdd 6.69669e-15
Cpar20 out vss 1.16846e-14
Cpar21 out.t0 vss 5.35097e-15
Cpar22 out.t1 vss 5.51436e-15
Cpar23 vdd vss 9.17597e-14
Cpar24 vdd.t0 vss 3.51379e-14
Cpar25 vdd.t1 vss 7.86322e-15
.ends opamp_dut

Vdd vdd 0 1.800000
Vss vss 0 0
Ibias vdd ib 4.333000e-07
Vinp inp 0 DC 0.895000 AC 1 PWL(0 0.895000 8.708830e-08 0.895000 9.579713e-08 0.905000)
Rfb out inn 1m
Cload out 0 2.000000e-12
Xdut vdd vss inp inn out ib opamp_dut
.end
