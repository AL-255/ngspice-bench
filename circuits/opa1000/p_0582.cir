* opa1000[0582]: 2p/pmos_5t_3v3_i500u_weak (pmos_5t, VDD=3.3V, CL=2.0pF, Iref=70.0uA)
.include "pdk_opa.inc"
.temp 27
.option gmin=1e-12 rshunt=1e12 reltol=1e-3 abstol=1e-12 vntol=1e-5 method=gear
* Post-PEX R+C extracted netlist for pmos_5t_3v3_i500u_weak
.subckt opamp_dut vdd vss inp inn out ib
XMpar0 a_1778_8087.t0 inp.t0 a_2006_8087.t40 vdd.t65 pfet_03v3 w=4.98u l=0.54u ad=1.4940e-12 pd=5.8912e-06 as=1.3944e-12 ps=5.5400e-06 nf=1 m=160 par=160
XMpar1 a_1722_996.t17 a_1722_996.t16 vdd.t1 vdd.t0 pfet_03v3 w=4.25u l=0.36u ad=1.1900e-12 pd=4.8100e-06 as=1.1900e-12 ps=4.8100e-06 nf=1 m=16 par=16
XMpar2 a_1722_996.t0 ib.t0 vss.t34 vss.t0 nfet_03v3 w=1.35u l=0.36u ad=4.3200e-13 pd=2.1587e-06 as=3.7800e-13 ps=1.9100e-06 nf=1 m=16 par=16
XMpar3 a_1778_8087.t0 inn.t0 out.t0 vdd.t65 pfet_03v3 w=4.98u l=0.54u ad=1.4940e-12 pd=5.8912e-06 as=1.3944e-12 ps=5.5400e-06 nf=1 m=160 par=160
XMpar4 ib.t1 ib.t0 vss.t34 vss.t0 nfet_03v3 w=1.35u l=0.36u ad=4.8600e-13 pd=2.4075e-06 as=3.7800e-13 ps=1.9100e-06 nf=1 m=16 par=16
XMpar5 a_2006_8087.t1 a_2006_8087.t0 vss.t1 vss.t0 nfet_03v3 w=1.98u l=0.63u ad=6.1776e-13 pd=2.8020e-06 as=5.5440e-13 ps=2.5400e-06 nf=1 m=20 par=20
XMpar6 out.t28 a_2006_8087.t0 vss.t1 vss.t0 nfet_03v3 w=1.98u l=0.63u ad=5.5440e-13 pd=2.5400e-06 as=5.5440e-13 ps=2.5400e-06 nf=1 m=20 par=20
XMpar7 a_1778_8087.t320 a_1722_996.t16 vdd.t1 vdd.t0 pfet_03v3 w=4.25u l=0.36u ad=1.1900e-12 pd=4.8100e-06 as=1.2750e-12 ps=5.1156e-06 nf=1 m=64 par=64
X274 out.t180 vss.t16 cap_mim_2f0fF c_width=11.49u c_length=11.49u
Rpar0 a_1722_996.t0 a_1722_996.t16 469.8815
Rpar1 a_1722_996.t0 a_1722_996.t17 27.1775
Rpar2 a_1722_996.t16 a_1722_996.t17 8.2224
Rpar3 a_1778_8087.t0 a_1778_8087.t320 48.2985
Rpar4 a_2006_8087.t0 a_2006_8087.t1 13.8222
Rpar5 a_2006_8087.t0 a_2006_8087.t40 335.8082
Rpar6 a_2006_8087.t1 a_2006_8087.t40 71.6999
Rpar7 ib ib.t0 12.2779
Rpar8 ib ib.t1 3.7260
Rpar9 ib.t0 ib.t1 9.6730
Rpar10 inn inn.t0 1.9051
Rpar11 inp inp.t0 1.9051
Rpar12 out out.t0 33.4522
Rpar13 out out.t28 68.4080
Rpar14 out out.t180 14.7474
Rpar15 out.t0 out.t28 97.7908
Rpar16 vdd vdd.t1 120.8715
Rpar17 vdd vdd.t65 19.9551
Rpar18 vdd.t0 vdd.t1 9.9162
Rpar19 vdd.t1 vdd.t65 353.3197
Rpar20 vss vss.t0 172.3373
Rpar21 vss vss.t1 1597.5229
Rpar22 vss vss.t16 80.0591
Rpar23 vss vss.t34 84.4948
Rpar24 vss.t0 vss.t1 3.3997
Rpar25 vss.t0 vss.t16 233.3172
Rpar26 vss.t0 vss.t34 8.9909
Rpar27 vss.t1 vss.t16 2162.7909
Rpar28 vss.t1 vss.t34 231.5167
Rpar29 vss.t16 vss.t34 114.3924
Cpar0 a_1722_996.t0 vss 1.07879e-14
Cpar1 a_1722_996.t16 vss 4.93392e-14
Cpar2 a_1722_996.t17 vss 2.65886e-14
Cpar3 a_1778_8087.t0 vss 3.69557e-13
Cpar4 a_1778_8087.t320 vss 7.03953e-14
Cpar5 a_2006_8087.t0 vss 2.55285e-14
Cpar6 a_2006_8087.t1 vss 1.65599e-14
Cpar7 a_2006_8087.t40 vss 1.60016e-13
Cpar8 ib vdd 1.24510e-16
Cpar9 ib vss 3.12730e-14
Cpar10 ib.t0 vss 4.02838e-15
Cpar11 ib.t1 vss 2.44986e-15
Cpar12 inn inp 2.55700e-16
Cpar13 inn out 3.47316e-14
Cpar14 inn vdd 5.58149e-14
Cpar15 inn vss 1.18610e-14
Cpar16 inn.t0 vss 1.06471e-13
Cpar17 inp vdd 5.59863e-14
Cpar18 inp vss 1.18930e-14
Cpar19 inp.t0 vss 1.06527e-13
Cpar20 out vdd 1.50394e-14
Cpar21 out vss 2.62103e-14
Cpar22 out.t0 vss 1.33002e-13
Cpar23 out.t180 vss 4.66479e-14
Cpar24 out.t28 vss 1.25280e-14
Cpar25 vdd vss 5.80894e-13
Cpar26 vdd.t0 vss 5.95832e-14
Cpar27 vdd.t1 vss 2.03327e-14
Cpar28 vdd.t65 vss 2.09140e-13
.ends opamp_dut

Vdd vdd 0 3.300000
Vss vss 0 0
Ibias vdd ib 7.000000e-05
Vinp inp 0 DC 1.480000 AC 1 PWL(0 1.480000 3.000000e-09 1.480000 3.300000e-09 1.490000)
Rfb out inn 1m
Cload out 0 2.000000e-12
Xdut vdd vss inp inn out ib opamp_dut
.end
