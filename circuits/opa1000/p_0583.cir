* opa1000[0583]: 2p/pmos_5t_3v3_i500u_subth (pmos_5t, VDD=3.3V, CL=2.0pF, Iref=100.0uA)
.include "pdk_opa.inc"
.temp 27
.option gmin=1e-12 rshunt=1e12 reltol=1e-3 abstol=1e-12 vntol=1e-5 method=gear
* Post-PEX R+C extracted netlist for pmos_5t_3v3_i500u_subth
.subckt opamp_dut vdd vss inp inn out ib
XMpar0 out.t2 a_1640_10195.t160 vss.t1 vss.t0 nfet_03v3 w=2.01u l=0.35u ad=5.6280e-13 pd=2.5700e-06 as=5.6280e-13 ps=2.5700e-06 nf=1 m=66 par=66
XMpar1 a_1640_10195.t161 a_1640_10195.t160 vss.t1 vss.t0 nfet_03v3 w=2.01u l=0.35u ad=6.2127e-13 pd=2.8109e-06 as=5.6280e-13 ps=2.5700e-06 nf=1 m=66 par=66
XMpar2 a_1430_10195.t0 inn.t0 out.t0 vdd.t46 pfet_03v3 w=14u l=0.45u ad=4.0320e-12 pd=1.4926e-05 as=3.9760e-12 ps=1.4743e-05 nf=1 m=160 par=160
XMpar3 a_1430_10195.t0 inp.t0 a_1640_10195.t0 vdd.t46 pfet_03v3 w=14u l=0.45u ad=4.0320e-12 pd=1.4926e-05 as=3.9760e-12 ps=1.4743e-05 nf=1 m=160 par=160
XMpar4 a_1430_10195.t320 a_1393_6407.t16 vdd.t1 vdd.t0 pfet_03v3 w=10u l=0.45u ad=2.8000e-12 pd=1.0560e-05 as=2.9000e-12 ps=1.0893e-05 nf=1 m=64 par=64
XMpar5 ib.t1 ib.t0 vss.t8 vss.t7 nfet_03v3 w=6.38u l=0.45u ad=1.7864e-12 pd=6.9400e-06 as=2.0416e-12 ps=7.8175e-06 nf=1 m=16 par=16
XMpar6 a_1393_6407.t0 ib.t0 vss.t8 vss.t7 nfet_03v3 w=6.38u l=0.45u ad=1.7864e-12 pd=6.9400e-06 as=2.0416e-12 ps=7.8175e-06 nf=1 m=16 par=16
XMpar7 a_1393_6407.t17 a_1393_6407.t16 vdd.t1 vdd.t0 pfet_03v3 w=10u l=0.45u ad=2.8000e-12 pd=1.0560e-05 as=2.8000e-12 ps=1.0560e-05 nf=1 m=16 par=16
X350 out.t226 vss.t4 cap_mim_2f0fF c_width=16.58u c_length=16.59u
Rpar0 a_1393_6407.t0 a_1393_6407.t16 204.0976
Rpar1 a_1393_6407.t0 a_1393_6407.t17 59.9697
Rpar2 a_1393_6407.t16 a_1393_6407.t17 18.1094
Rpar3 a_1430_10195.t0 a_1430_10195.t320 39.1538
Rpar4 a_1640_10195.t0 a_1640_10195.t160 478.1083
Rpar5 a_1640_10195.t0 a_1640_10195.t161 78.5825
Rpar6 a_1640_10195.t160 a_1640_10195.t161 4.4130
Rpar7 ib ib.t0 15.6190
Rpar8 ib ib.t1 2.6481
Rpar9 ib.t0 ib.t1 18.3083
Rpar10 inn inn.t0 2.5985
Rpar11 inp inp.t0 2.5985
Rpar12 out out.t0 69.5568
Rpar13 out out.t2 61.0052
Rpar14 out out.t226 15.8995
Rpar15 out.t0 out.t2 165.5663
Rpar16 out.t0 out.t226 610.7515
Rpar17 out.t2 out.t226 535.6632
Rpar18 vdd vdd.t0 246.1235
Rpar19 vdd vdd.t46 20.1912
Rpar20 vdd.t0 vdd.t1 3.9102
Rpar21 vdd.t0 vdd.t46 85.9807
Rpar22 vss vss.t0 1235.5299
Rpar23 vss vss.t1 68.5777
Rpar24 vss vss.t8 44.2705
Rpar25 vss vss.t7 428.7308
Rpar26 vss vss.t4 142.6599
Rpar27 vss.t0 vss.t1 8.6919
Rpar28 vss.t0 vss.t7 1812.9077
Rpar29 vss.t0 vss.t4 1360.6671
Rpar30 vss.t1 vss.t8 292.6545
Rpar31 vss.t1 vss.t4 75.4342
Rpar32 vss.t8 vss.t7 11.5344
Rpar33 vss.t8 vss.t4 609.0132
Rpar34 vss.t7 vss.t4 5894.4859
Cpar0 a_1393_6407.t0 vss 1.87192e-14
Cpar1 a_1393_6407.t16 vss 7.04507e-14
Cpar2 a_1393_6407.t17 vss 2.89911e-14
Cpar3 a_1430_10195.t0 vss 8.75171e-13
Cpar4 a_1430_10195.t320 vss 1.29605e-13
Cpar5 a_1640_10195.t0 vss 3.75298e-13
Cpar6 a_1640_10195.t160 vss 5.15003e-14
Cpar7 a_1640_10195.t161 vss 4.68986e-14
Cpar8 ib vss 4.50580e-14
Cpar9 ib.t0 vss 3.92873e-15
Cpar10 ib.t1 vss 3.32971e-15
Cpar11 inn inp 1.05030e-16
Cpar12 inn out 5.34232e-14
Cpar13 inn vdd 5.55379e-14
Cpar14 inn vss 2.18670e-14
Cpar15 inn.t0 vss 1.36071e-13
Cpar16 inp vdd 5.53734e-14
Cpar17 inp vss 2.17156e-14
Cpar18 inp.t0 vss 1.35788e-13
Cpar19 out vdd 2.53192e-14
Cpar20 out vss 7.03307e-14
Cpar21 out.t0 vss 3.35722e-13
Cpar22 out.t2 vss 3.82304e-14
Cpar23 out.t226 vss 9.63411e-14
Cpar24 vdd vss 9.88407e-13
Cpar25 vdd.t0 vss 6.42040e-14
Cpar26 vdd.t1 vss 2.80505e-14
Cpar27 vdd.t46 vss 2.74337e-13
.ends opamp_dut

Vdd vdd 0 3.300000
Vss vss 0 0
Ibias vdd ib 1.000000e-04
Vinp inp 0 DC 1.480000 AC 1 PWL(0 1.480000 3.000000e-09 1.480000 3.300000e-09 1.490000)
Rfb out inn 1m
Cload out 0 2.000000e-12
Xdut vdd vss inp inn out ib opamp_dut
.end
