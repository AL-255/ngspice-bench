* opa1000[0371]: 200f/nmos_5t_3v3_i150u_subth (nmos_5t, VDD=3.3V, CL=0.2pF, Iref=26.25uA)
.include "pdk_opa.inc"
.temp 27
.option gmin=1e-12 rshunt=1e12 reltol=1e-3 abstol=1e-12 vntol=1e-5 method=gear
* Post-PEX R+C extracted netlist for nmos_5t_3v3_i150u_subth
.subckt opamp_dut vdd vss inp inn out ib
XMpar0 a_1682_6173.t0 inn.t0 out.t0 vss.t0 nfet_03v3 w=2.87u l=0.53u ad=8.6100e-13 pd=3.6494e-06 as=8.0360e-13 ps=3.4300e-06 nf=1 m=160 par=160
XMpar1 a_1719_12991.t161 a_1719_12991.t160 vdd.t1 vdd.t0 pfet_03v3 w=1.98u l=0.56u ad=6.3221e-13 pd=2.8618e-06 as=5.6552e-13 ps=2.5860e-06 nf=1 m=114 par=114
XMpar2 a_1682_6173.t0 inp.t0 a_1719_12991.t0 vss.t0 nfet_03v3 w=2.87u l=0.53u ad=8.6285e-13 pd=3.6565e-06 as=8.0360e-13 ps=3.4300e-06 nf=1 m=155 par=155
XMpar3 out.t160 a_1719_12991.t160 vdd.t1 vdd.t0 pfet_03v3 w=1.98u l=0.56u ad=5.8775e-13 pd=2.6779e-06 as=6.3221e-13 ps=2.8618e-06 nf=1 m=114 par=114
XMpar4 a_1682_6173.t160 ib.t0 vss.t33 vss.t0 nfet_03v3 w=8.27u l=0.81u ad=2.3156e-12 pd=8.8300e-06 as=2.5457e-12 ps=9.6048e-06 nf=1 m=23 par=23
XMpar5 ib.t1 ib.t0 vss.t33 vss.t0 nfet_03v3 w=8.27u l=0.81u ad=2.3156e-12 pd=8.8300e-06 as=2.3156e-12 ps=8.8300e-06 nf=1 m=6 par=6
XMpar6 a_1682_6173.t0 inp.t0 a_1719_12991.t0 vss.t46 nfet_03v3 w=2.87u l=0.53u ad=8.0360e-13 pd=3.4300e-06 as=8.0360e-13 ps=3.4300e-06 nf=1 m=5 par=5
XMpar7 a_1682_6173.t160 ib.t0 vss.t33 vss.t46 nfet_03v3 w=8.27u l=0.81u ad=2.3156e-12 pd=8.8300e-06 as=2.3156e-12 ps=8.8300e-06 nf=1 m=1
X424 out.t274 vss.t92 cap_mim_2f0fF c_width=16.58u c_length=16.59u
Rpar0 a_1682_6173.t0 a_1682_6173.t160 39.6857
Rpar1 a_1719_12991.t0 a_1719_12991.t160 173.7621
Rpar2 a_1719_12991.t0 a_1719_12991.t161 45.3983
Rpar3 a_1719_12991.t160 a_1719_12991.t161 3.7322
Rpar4 ib ib.t0 58.8950
Rpar5 ib ib.t1 4.5479
Rpar6 ib.t0 ib.t1 24.4383
Rpar7 inn inn.t0 1.6229
Rpar8 inp inp.t0 1.6229
Rpar9 out out.t160 2.5207
Rpar10 out.t0 out.t160 47.4642
Rpar11 out.t0 out.t274 139.4397
Rpar12 out.t160 out.t274 134.7092
Rpar13 vdd vdd.t0 18.9458
Rpar14 vdd.t0 vdd.t1 8.5030
Rpar15 vss vss.t0 41.7454
Rpar16 vss vss.t33 1758.7412
Rpar17 vss vss.t46 2208.5398
Rpar18 vss vss.t92 106.8726
Rpar19 vss.t0 vss.t33 3.9521
Rpar20 vss.t0 vss.t46 3.8689
Rpar21 vss.t0 vss.t92 56.6658
Rpar22 vss.t33 vss.t46 257.7420
Rpar23 vss.t33 vss.t92 2387.3387
Rpar24 vss.t46 vss.t92 2997.9014
Cpar0 a_1682_6173.t0 vss 2.05582e-13
Cpar1 a_1682_6173.t160 vss 3.97666e-14
Cpar2 a_1719_12991.t0 vss 1.24572e-13
Cpar3 a_1719_12991.t160 vss 1.53863e-13
Cpar4 a_1719_12991.t161 vss 1.06358e-13
Cpar5 ib out 4.13200e-17
Cpar6 ib vss 3.79464e-14
Cpar7 ib.t0 vss 8.05337e-15
Cpar8 ib.t1 vss 1.79883e-15
Cpar9 inn inp 2.58410e-16
Cpar10 inn out 2.75423e-14
Cpar11 inn vdd 1.95800e-17
Cpar12 inn vss 5.89583e-14
Cpar13 inn.t0 vss 4.28424e-14
Cpar14 inp out 1.07790e-16
Cpar15 inp vdd 1.84500e-17
Cpar16 inp vss 5.90656e-14
Cpar17 inp.t0 vss 4.26641e-14
Cpar18 out vdd 7.80974e-14
Cpar19 out vss 3.42025e-14
Cpar20 out.t0 vss 8.69743e-14
Cpar21 out.t160 vss 6.53871e-14
Cpar22 out.t274 vss 9.58279e-14
Cpar23 vdd vss 3.36163e-13
Cpar24 vdd.t0 vss 2.42222e-13
Cpar25 vdd.t1 vss 3.96542e-14
.ends opamp_dut

Vdd vdd 0 3.300000
Vss vss 0 0
Ibias vdd ib 2.625000e-05
Vinp inp 0 DC 1.645000 AC 1 PWL(0 1.645000 3.000000e-09 1.645000 3.300000e-09 1.655000)
Rfb out inn 1m
Cload out 0 2.000000e-13
Xdut vdd vss inp inn out ib opamp_dut
.end
