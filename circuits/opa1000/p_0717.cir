* opa1000[0717]: 2p/rail_to_rail_1v8_i2u_subth (rail_to_rail, VDD=1.8V, CL=2.0pF, Iref=0.2125uA)
.include "pdk_opa.inc"
.temp 27
.option gmin=1e-12 rshunt=1e12 reltol=1e-3 abstol=1e-12 vntol=1e-5 method=gear
* Post-PEX R+C extracted netlist for rail_to_rail_1v8_i2u_subth
.subckt opamp_dut vdd vss inp inn out ib
XMpar0 a_1068_1290.t3 inp.t0 a_3327_10781.t0 vss.t3 nfet_03v3 w=1.22u l=1.9u ad=3.4160e-13 pd=1.7800e-06 as=7.3200e-13 ps=3.6400e-06 nf=1 m=2 par=2
XMpar1 a_7172_4129.t1 a_7172_4129.t0 vss.t2 vss.t1 nfet_03v3 w=0.4u l=3.4u ad=1.1200e-13 pd=9.6000e-07 as=1.1200e-13 ps=9.6000e-07 nf=1 m=2 par=2
XMpar2 out.t1 a_1068_1290.t7 vdd.t1 vdd.t0 pfet_03v3 w=7.99u l=1.69u ad=2.2372e-12 pd=8.5500e-06 as=2.8764e-12 ps=1.0708e-05 nf=1 m=8 par=8
XMpar3 ib.t1 ib.t0 vss.t15 vss.t14 nfet_03v3 w=0.61u l=2.08u ad=3.6600e-13 pd=2.4200e-06 as=1.7080e-13 ps=1.1700e-06 nf=1 m=2 par=2
XMpar4 a_5716_10781.t4 ib.t0 vss.t15 vss.t14 nfet_03v3 w=0.61u l=2.08u ad=1.7080e-13 pd=1.1700e-06 as=1.7080e-13 ps=1.1700e-06 nf=1 m=2 par=2
XMpar5 a_3327_10781.t2 ib.t0 vss.t15 vss.t14 nfet_03v3 w=0.61u l=2.08u ad=3.6600e-13 pd=2.4200e-06 as=1.7080e-13 ps=1.1700e-06 nf=1 m=2 par=2
XMpar6 a_6370_7753.t1 inp.t2 a_6870_7753.t0 vdd.t10 pfet_03v3 w=2.03u l=1.9u ad=8.9320e-13 pd=3.9250e-06 as=5.6840e-13 ps=2.5900e-06 nf=1 m=8 par=8
XMpar7 a_1068_1290.t0 a_7856_996.t0 vdd.t1 vdd.t0 pfet_03v3 w=7.99u l=1.69u ad=4.7940e-12 pd=1.7180e-05 as=2.2372e-12 ps=8.5500e-06 nf=1 m=2 par=2
XMpar8 a_7856_996.t4 a_6870_7753.t8 vss.t2 vss.t1 nfet_03v3 w=0.4u l=3.4u ad=1.1200e-13 pd=9.6000e-07 as=1.1200e-13 ps=9.6000e-07 nf=1 m=2 par=2
XMpar9 a_1068_1290.t1 a_7172_4129.t0 vss.t2 vss.t1 nfet_03v3 w=0.4u l=3.4u ad=2.4000e-13 pd=2.0000e-06 as=1.1200e-13 ps=9.6000e-07 nf=1 m=2 par=2
XMpar10 a_6870_7753.t9 a_6870_7753.t8 vss.t2 vss.t1 nfet_03v3 w=0.4u l=3.4u ad=2.4000e-13 pd=2.0000e-06 as=1.1200e-13 ps=9.6000e-07 nf=1 m=2 par=2
XMpar11 a_6370_7753.t1 inn.t2 a_7172_4129.t4 vdd.t10 pfet_03v3 w=2.03u l=1.9u ad=8.9320e-13 pd=3.9250e-06 as=5.6840e-13 ps=2.5900e-06 nf=1 m=8 par=8
XMpar12 a_6370_7753.t0 a_5716_10781.t0 vdd.t7 vdd.t6 pfet_03v3 w=2.81u l=2.08u ad=1.6860e-12 pd=6.8200e-06 as=7.8680e-13 ps=3.3700e-06 nf=1 m=2 par=2
XMpar13 out.t0 ib.t0 vss.t15 vss.t14 nfet_03v3 w=0.61u l=2.08u ad=1.7080e-13 pd=1.1700e-06 as=2.1960e-13 ps=1.4825e-06 nf=1 m=8 par=8
XMpar14 a_5716_10781.t1 a_5716_10781.t0 vdd.t7 vdd.t6 pfet_03v3 w=2.81u l=2.08u ad=7.8680e-13 pd=3.3700e-06 as=7.8680e-13 ps=3.3700e-06 nf=1 m=2 par=2
XMpar15 a_7856_996.t1 a_7856_996.t0 vdd.t1 vdd.t0 pfet_03v3 w=7.99u l=1.69u ad=2.2372e-12 pd=8.5500e-06 as=2.2372e-12 ps=8.5500e-06 nf=1 m=2 par=2
XMpar16 a_3327_10781.t0 inn.t0 a_7856_996.t6 vss.t3 nfet_03v3 w=1.22u l=1.9u ad=7.3200e-13 pd=3.6400e-06 as=3.4160e-13 ps=1.7800e-06 nf=1 m=2 par=2
X1 a_1068_1290.t6 a_5074_1290.t0 vss.t0 ppolyf_u_1k r_width=1u r_length=19.37u
X5 a_1068_3890.t0 a_5074_3370.t0 vss.t0 ppolyf_u_1k r_width=1u r_length=19.37u
X19 a_1068_2850.t0 a_5074_3370.t0 vss.t0 ppolyf_u_1k r_width=1u r_length=19.37u
X28 a_1068_2850.t0 a_5074_2330.t0 vss.t0 ppolyf_u_1k r_width=1u r_length=19.37u
X38 a_1068_1810.t0 a_5074_2330.t0 vss.t0 ppolyf_u_1k r_width=1u r_length=19.37u
X43 a_1068_1810.t0 a_5074_1290.t0 vss.t0 ppolyf_u_1k r_width=1u r_length=19.37u
X57 a_1068_3890.t1 out.t2 cap_mim_2f0fF c_width=15.62u c_length=15.61u
X62 a_1068_3890.t1 out.t2 cap_mim_2f0fF c_width=15.62u c_length=15.61u
Rpar0 a_1068_1290.t0 a_1068_1290.t1 93.8738
Rpar1 a_1068_1290.t0 a_1068_1290.t7 400.6037
Rpar2 a_1068_1290.t0 a_1068_1290.t3 256.8159
Rpar3 a_1068_1290.t0 a_1068_1290.t6 96.3433
Rpar4 a_1068_1290.t1 a_1068_1290.t7 180.7494
Rpar5 a_1068_1290.t1 a_1068_1290.t3 115.8735
Rpar6 a_1068_1290.t1 a_1068_1290.t6 149.7084
Rpar7 a_1068_1290.t7 a_1068_1290.t3 149.1078
Rpar8 a_1068_1290.t7 a_1068_1290.t6 638.8764
Rpar9 a_1068_1290.t3 a_1068_1290.t6 409.5660
Rpar10 a_1068_3890.t0 a_1068_3890.t1 69.3572
Rpar11 a_3327_10781.t0 a_3327_10781.t2 145.3965
Rpar12 a_5716_10781.t0 a_5716_10781.t1 22.4102
Rpar13 a_5716_10781.t0 a_5716_10781.t4 291.4851
Rpar14 a_5716_10781.t1 a_5716_10781.t4 178.7090
Rpar15 a_6370_7753.t0 a_6370_7753.t1 47.2319
Rpar16 a_6870_7753.t0 a_6870_7753.t8 157.6178
Rpar17 a_6870_7753.t0 a_6870_7753.t9 116.5623
Rpar18 a_6870_7753.t8 a_6870_7753.t9 21.3761
Rpar19 a_7172_4129.t0 a_7172_4129.t1 29.4613
Rpar20 a_7172_4129.t0 a_7172_4129.t4 146.0772
Rpar21 a_7172_4129.t1 a_7172_4129.t4 148.6229
Rpar22 a_7856_996.t0 a_7856_996.t1 26.4147
Rpar23 a_7856_996.t0 a_7856_996.t4 775.6500
Rpar24 a_7856_996.t0 a_7856_996.t6 404.2306
Rpar25 a_7856_996.t1 a_7856_996.t4 251.0405
Rpar26 a_7856_996.t1 a_7856_996.t6 130.8300
Rpar27 a_7856_996.t4 a_7856_996.t6 174.1398
Rpar28 ib ib.t0 11.3928
Rpar29 ib ib.t1 9.8097
Rpar30 inn inn.t0 5.0242
Rpar31 inn inn.t2 63.9434
Rpar32 inp inp.t0 5.0728
Rpar33 inp inp.t2 43.8554
Rpar34 out out.t0 158.7649
Rpar35 out out.t1 2.5656
Rpar36 out out.t2 158.0460
Rpar37 out.t0 out.t1 116.0006
Rpar38 out.t0 out.t2 256.5589
Rpar39 out.t1 out.t2 115.4754
Rpar40 vdd vdd.t0 258.8317
Rpar41 vdd vdd.t1 728.3335
Rpar42 vdd vdd.t10 102.7217
Rpar43 vdd vdd.t6 2682.7622
Rpar44 vdd vdd.t7 3933.5676
Rpar45 vdd.t0 vdd.t1 3.5167
Rpar46 vdd.t0 vdd.t10 54.1012
Rpar47 vdd.t0 vdd.t6 139.9021
Rpar48 vdd.t0 vdd.t7 205.1297
Rpar49 vdd.t1 vdd.t10 157.0400
Rpar50 vdd.t1 vdd.t6 387.1941
Rpar51 vdd.t1 vdd.t7 567.7187
Rpar52 vdd.t10 vdd.t6 1092.7864
Rpar53 vdd.t10 vdd.t7 1602.2848
Rpar54 vdd.t6 vdd.t7 9.5566
Rpar55 vss vss.t0 174.7518
Rpar56 vss vss.t1 73.2262
Rpar57 vss vss.t2 253.6711
Rpar58 vss vss.t14 136.5242
Rpar59 vss vss.t15 619.2902
Rpar60 vss vss.t3 70.7538
Rpar61 vss.t0 vss.t1 26.4487
Rpar62 vss.t0 vss.t2 67.2647
Rpar63 vss.t0 vss.t14 356.3234
Rpar64 vss.t0 vss.t15 1624.3947
Rpar65 vss.t0 vss.t3 22.1112
Rpar66 vss.t1 vss.t2 13.7523
Rpar67 vss.t1 vss.t14 2.5646
Rpar68 vss.t1 vss.t15 22.3858
Rpar69 vss.t1 vss.t3 6.8335
Rpar70 vss.t2 vss.t14 15.9769
Rpar71 vss.t2 vss.t15 161.3535
Rpar72 vss.t2 vss.t3 21.0215
Rpar73 vss.t14 vss.t15 6.2172
Rpar74 vss.t14 vss.t3 238.0002
Cpar0 a_1068_1290.t0 vss 4.90729e-15
Cpar1 a_1068_1290.t1 vss 2.66919e-15
Cpar2 a_1068_1290.t3 vss 1.76000e-15
Cpar3 a_1068_1290.t6 vss 2.02569e-15
Cpar4 a_1068_1290.t7 vss 1.64007e-14
Cpar5 a_1068_1810.t0 vss 3.20200e-17
Cpar6 a_1068_2850.t0 vss 3.20200e-17
Cpar7 a_1068_3890.t0 vss 2.45024e-16
Cpar8 a_1068_3890.t1 vss 6.66698e-15
Cpar9 a_3327_10781.t0 vss 9.18904e-15
Cpar10 a_3327_10781.t2 vss 1.10309e-14
Cpar11 a_5074_1290.t0 vss 3.05200e-17
Cpar12 a_5074_2330.t0 vss 3.13600e-17
Cpar13 a_5074_3370.t0 vss 2.83600e-17
Cpar14 a_5716_10781.t0 vss 9.19148e-15
Cpar15 a_5716_10781.t1 vss 5.42465e-15
Cpar16 a_5716_10781.t4 vss 7.05749e-15
Cpar17 a_6370_7753.t0 vss 5.03034e-15
Cpar18 a_6370_7753.t1 vss 1.74678e-14
Cpar19 a_6870_7753.t0 vss 5.92164e-15
Cpar20 a_6870_7753.t8 vss 5.08791e-15
Cpar21 a_6870_7753.t9 vss 2.41794e-15
Cpar22 a_7172_4129.t0 vss 6.59657e-15
Cpar23 a_7172_4129.t1 vss 1.85332e-15
Cpar24 a_7172_4129.t4 vss 7.19011e-15
Cpar25 a_7856_996.t0 vss 9.27232e-15
Cpar26 a_7856_996.t1 vss 5.21254e-15
Cpar27 a_7856_996.t4 vss 4.68338e-15
Cpar28 a_7856_996.t6 vss 3.01745e-15
Cpar29 ib out 7.27880e-16
Cpar30 ib vdd 2.07870e-16
Cpar31 ib vss 2.20254e-14
Cpar32 ib.t0 vss 6.44858e-15
Cpar33 ib.t1 vss 6.25246e-16
Cpar34 inn inp 1.56630e-16
Cpar35 inn vdd 8.82537e-15
Cpar36 inn vss 6.73358e-15
Cpar37 inn.t0 vss 1.17710e-15
Cpar38 inn.t2 vss 1.36872e-14
Cpar39 inp vdd 8.88964e-15
Cpar40 inp vss 6.27259e-15
Cpar41 inp.t0 vss 1.00490e-15
Cpar42 inp.t2 vss 1.10858e-14
Cpar43 out vdd 9.10192e-15
Cpar44 out vss 1.50018e-14
Cpar45 out.t0 vss 2.69412e-15
Cpar46 out.t1 vss 5.45684e-15
Cpar47 out.t2 vss 1.33340e-14
Cpar48 vdd vss 1.65761e-13
Cpar49 vdd.t0 vss 2.37238e-14
Cpar50 vdd.t1 vss 1.10485e-14
Cpar51 vdd.t10 vss 2.44518e-14
Cpar52 vdd.t6 vss 6.02549e-15
Cpar53 vdd.t7 vss 3.75731e-15
.ends opamp_dut

Vdd vdd 0 1.800000
Vss vss 0 0
Ibias vdd ib 2.125000e-07
Vinp inp 0 DC 0.895000 AC 1 PWL(0 0.895000 1.529535e-07 0.895000 1.682488e-07 0.905000)
Rfb out inn 1m
Cload out 0 2.000000e-12
Xdut vdd vss inp inn out ib opamp_dut
.end
