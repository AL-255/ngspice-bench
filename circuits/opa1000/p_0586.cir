* opa1000[0586]: 200f/pmos_miller_1v8_i50n_weak (pmos_miller, VDD=1.8V, CL=0.2pF, Iref=0.0072uA)
.include "pdk_opa.inc"
.temp 27
.option gmin=1e-12 rshunt=1e12 reltol=1e-3 abstol=1e-12 vntol=1e-5 method=gear
* Post-PEX R+C extracted netlist for pmos_miller_1v8_i50n_weak
.subckt opamp_dut vdd vss inp inn out ib
XMpar0 out.t0 a_5143_11132.t0 vdd.t1 vdd.t0 pfet_03v3 w=0.4u l=4u ad=1.8880e-13 pd=1.5840e-06 as=1.6320e-13 ps=1.3760e-06 nf=1 m=10 par=10
XMpar1 out.t1 a_1134_1290.t5 vss.t2 vss.t1 nfet_03v3 w=0.4u l=6u ad=1.3760e-13 pd=1.1680e-06 as=1.8880e-13 ps=1.5840e-06 nf=1 m=10 par=10
XMpar2 a_5143_11132.t1 a_5143_11132.t0 vdd.t1 vdd.t0 pfet_03v3 w=0.4u l=4u ad=2.4000e-13 pd=2.0000e-06 as=1.1200e-13 ps=9.6000e-07 nf=1 m=2 par=2
XMpar3 a_6126_9030.t2 a_5143_11132.t0 vdd.t1 vdd.t0 pfet_03v3 w=0.4u l=4u ad=2.4000e-13 pd=2.0000e-06 as=1.1200e-13 ps=9.6000e-07 nf=1 m=4 par=4
XMpar4 a_5332_14516.t0 inn.t0 a_6126_9030.t0 vdd.t2 pfet_03v3 w=0.46u l=6.5u ad=2.7600e-13 pd=2.1200e-06 as=2.7600e-13 ps=2.1200e-06 nf=1 m=2 par=2
XMpar5 a_1134_1290.t0 inp.t0 a_6126_9030.t0 vdd.t2 pfet_03v3 w=0.46u l=6.5u ad=2.7600e-13 pd=2.1200e-06 as=2.7600e-13 ps=2.1200e-06 nf=1 m=2 par=2
XMpar6 a_1134_1290.t2 a_5332_14516.t2 vss.t2 vss.t1 nfet_03v3 w=0.4u l=6u ad=2.4000e-13 pd=2.0000e-06 as=1.1200e-13 ps=9.6000e-07 nf=1 m=2 par=2
XMpar7 a_5143_11132.t4 ib.t0 vss.t25 vss.t24 nfet_03v3 w=0.4u l=4u ad=1.1200e-13 pd=9.6000e-07 as=1.1200e-13 ps=9.6000e-07 nf=1 m=2 par=2
XMpar8 a_5332_14516.t3 a_5332_14516.t2 vss.t2 vss.t1 nfet_03v3 w=0.4u l=6u ad=1.1200e-13 pd=9.6000e-07 as=1.1200e-13 ps=9.6000e-07 nf=1 m=2 par=2
XMpar9 ib.t1 ib.t0 vss.t25 vss.t24 nfet_03v3 w=0.4u l=4u ad=2.4000e-13 pd=2.0000e-06 as=1.1200e-13 ps=9.6000e-07 nf=1 m=2 par=2
X1 a_1134_2850.t0 a_5112_2330.t0 vss.t0 ppolyf_u_1k r_width=1u r_length=19.23u
X7 a_1134_4930.t0 a_5112_5450.t0 vss.t0 ppolyf_u_1k r_width=1u r_length=19.23u
X8 a_1134_1810.t0 a_5112_2330.t0 vss.t0 ppolyf_u_1k r_width=1u r_length=19.23u
X13 a_1134_4930.t0 a_5112_4410.t0 vss.t0 ppolyf_u_1k r_width=1u r_length=19.23u
X15 a_1134_1810.t0 a_5112_1290.t0 vss.t0 ppolyf_u_1k r_width=1u r_length=19.23u
X16 a_1134_7010.t0 a_5112_7530.t0 vss.t0 ppolyf_u_1k r_width=1u r_length=19.23u
X21 a_1134_3890.t0 a_5112_4410.t0 vss.t0 ppolyf_u_1k r_width=1u r_length=19.23u
X24 a_1134_7010.t0 a_5112_6490.t0 vss.t0 ppolyf_u_1k r_width=1u r_length=19.23u
X33 a_1134_1290.t4 a_5112_1290.t0 vss.t0 ppolyf_u_1k r_width=1u r_length=19.23u
X35 a_5112_7530.t1 out.t7 cap_mim_2f0fF c_width=11.46u c_length=11.46u
X37 a_1134_3890.t0 a_5112_3370.t0 vss.t0 ppolyf_u_1k r_width=1u r_length=19.23u
X48 a_1134_5970.t0 a_5112_6490.t0 vss.t0 ppolyf_u_1k r_width=1u r_length=19.23u
X49 a_1134_2850.t0 a_5112_3370.t0 vss.t0 ppolyf_u_1k r_width=1u r_length=19.23u
X51 a_1134_5970.t0 a_5112_5450.t0 vss.t0 ppolyf_u_1k r_width=1u r_length=19.23u
Rpar0 a_1134_1290.t0 a_1134_1290.t5 169.4237
Rpar1 a_1134_1290.t0 a_1134_1290.t2 85.4869
Rpar2 a_1134_1290.t0 a_1134_1290.t4 588.4713
Rpar3 a_1134_1290.t5 a_1134_1290.t2 451.4101
Rpar4 a_1134_1290.t5 a_1134_1290.t4 65.1031
Rpar5 a_1134_1290.t2 a_1134_1290.t4 1567.9141
Rpar6 a_5112_7530.t0 a_5112_7530.t1 62.0434
Rpar7 a_5143_11132.t0 a_5143_11132.t1 16.8359
Rpar8 a_5143_11132.t0 a_5143_11132.t4 114.4527
Rpar9 a_5143_11132.t1 a_5143_11132.t4 108.7872
Rpar10 a_5332_14516.t0 a_5332_14516.t2 159.0004
Rpar11 a_5332_14516.t0 a_5332_14516.t3 152.0004
Rpar12 a_5332_14516.t2 a_5332_14516.t3 30.3305
Rpar13 a_6126_9030.t0 a_6126_9030.t2 52.9833
Rpar14 ib ib.t0 17.4704
Rpar15 ib ib.t1 9.3115
Rpar16 ib.t0 ib.t1 82.7570
Rpar17 inn inn.t0 4.0298
Rpar18 inp inp.t0 4.0294
Rpar19 out out.t0 176.9876
Rpar20 out out.t1 6.5977
Rpar21 out out.t7 93.4222
Rpar22 out.t0 out.t7 118.0274
Rpar23 vdd vdd.t0 45.0587
Rpar24 vdd vdd.t1 646.6599
Rpar25 vdd vdd.t2 192.9455
Rpar26 vdd.t0 vdd.t1 12.3351
Rpar27 vdd.t0 vdd.t2 59.1802
Rpar28 vdd.t1 vdd.t2 849.3247
Rpar29 vss vss.t0 46.4454
Rpar30 vss vss.t1 119.8186
Rpar31 vss vss.t2 65.5227
Rpar32 vss vss.t24 272.8615
Rpar33 vss vss.t25 861.4827
Rpar34 vss.t0 vss.t1 197.5946
Rpar35 vss.t0 vss.t2 144.2417
Rpar36 vss.t0 vss.t24 562.0676
Rpar37 vss.t0 vss.t25 1796.6274
Rpar38 vss.t1 vss.t2 6.8277
Rpar39 vss.t1 vss.t24 6.8367
Rpar40 vss.t1 vss.t25 23.7719
Rpar41 vss.t2 vss.t24 84.3208
Rpar42 vss.t2 vss.t25 288.3548
Rpar43 vss.t24 vss.t25 19.5185
Cpar0 a_1134_1290.t0 vss 2.36893e-15
Cpar1 a_1134_1290.t2 vss 1.91623e-15
Cpar2 a_1134_1290.t4 vss 1.22067e-15
Cpar3 a_1134_1290.t5 vss 9.77702e-15
Cpar4 a_1134_1810.t0 vss 3.20200e-17
Cpar5 a_1134_2850.t0 vss 2.93600e-17
Cpar6 a_1134_3890.t0 vss 2.93600e-17
Cpar7 a_1134_4930.t0 vss 2.93600e-17
Cpar8 a_1134_5970.t0 vss 3.00800e-17
Cpar9 a_1134_7010.t0 vss 3.30400e-17
Cpar10 a_5112_1290.t0 vss 3.08600e-17
Cpar11 a_5112_2330.t0 vss 3.50800e-17
Cpar12 a_5112_3370.t0 vss 3.97000e-17
Cpar13 a_5112_4410.t0 vss 3.74000e-17
Cpar14 a_5112_5450.t0 vss 3.83400e-17
Cpar15 a_5112_6490.t0 vss 4.01400e-17
Cpar16 a_5112_7530.t0 vss 2.70170e-16
Cpar17 a_5112_7530.t1 vss 3.82217e-15
Cpar18 a_5143_11132.t0 vss 4.50805e-14
Cpar19 a_5143_11132.t1 vss 8.72569e-15
Cpar20 a_5143_11132.t4 vss 5.08480e-15
Cpar21 a_5332_14516.t0 vss 3.05040e-15
Cpar22 a_5332_14516.t2 vss 6.16432e-15
Cpar23 a_5332_14516.t3 vss 1.79672e-15
Cpar24 a_6126_9030.t0 vss 1.16820e-14
Cpar25 a_6126_9030.t2 vss 1.87425e-14
Cpar26 ib vss 1.26379e-14
Cpar27 ib.t0 vss 1.33526e-15
Cpar28 ib.t1 vss 8.58727e-17
Cpar29 inn inp 1.02720e-16
Cpar30 inn vdd 6.01027e-15
Cpar31 inn vss 3.64292e-15
Cpar32 inn.t0 vss 4.58766e-15
Cpar33 inp out 3.26600e-17
Cpar34 inp vdd 5.97173e-15
Cpar35 inp vss 3.65879e-15
Cpar36 inp.t0 vss 4.60533e-15
Cpar37 out vdd 1.19419e-14
Cpar38 out vss 3.66815e-14
Cpar39 out.t0 vss 9.56780e-15
Cpar40 out.t1 vss 4.42522e-15
Cpar41 out.t7 vss 8.46154e-15
Cpar42 vdd vss 1.43954e-13
Cpar43 vdd.t0 vss 5.28399e-14
Cpar44 vdd.t1 vss 6.34670e-15
Cpar45 vdd.t2 vss 1.53781e-14
.ends opamp_dut

Vdd vdd 0 1.800000
Vss vss 0 0
Ibias vdd ib 7.200000e-09
Vinp inp 0 DC 0.805000 AC 1 PWL(0 0.805000 1.276627e-06 0.805000 1.404290e-06 0.815000)
Rfb out inn 1m
Cload out 0 2.000000e-13
Xdut vdd vss inp inn out ib opamp_dut
.end
