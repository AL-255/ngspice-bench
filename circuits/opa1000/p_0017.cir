* opa1000[0017]: 200f/cherry_hooper_1v8_i150u_weak (cherry_hooper, VDD=1.8V, CL=0.2pF, Iref=11.875uA)
.include "pdk_opa.inc"
.temp 27
.option gmin=1e-12 rshunt=1e12 reltol=1e-3 abstol=1e-12 vntol=1e-5 method=gear
* Post-PEX R+C extracted netlist for cherry_hooper_1v8_i150u_weak
.subckt opamp_dut vdd vss inp inn out ib
XMpar0 a_14974_19976.t3 a_14974_19976.t2 vdd.t1 vdd.t0 pfet_03v3 w=10u l=0.32u ad=2.8000e-12 pd=1.0560e-05 as=3.2000e-12 ps=1.1890e-05 nf=1 m=16 par=16
XMpar1 a_4005_7553.t2 a_4005_7553.t1 vdd.t1 vdd.t0 pfet_03v3 w=10u l=0.32u ad=2.8000e-12 pd=1.0560e-05 as=3.0667e-12 ps=1.1447e-05 nf=1 m=48 par=48
XMpar2 a_1338_17760.t0 ib.t0 vss.t2 vss.t1 nfet_03v3 w=9.92u l=0.5u ad=2.7776e-12 pd=1.0480e-05 as=3.3067e-12 ps=1.2240e-05 nf=1 m=12 par=12
XMpar3 a_1098_1249.t12 a_16174_14389.t103 out.t13 vss.t158 nfet_03v3 w=7.76u l=0.4u ad=4.6560e-12 pd=1.6720e-05 as=2.1728e-12 ps=8.3200e-06 nf=1 m=2 par=2
XMpar4 a_1292_21414.t0 a_1292_21414.t16 vdd.t1 vdd.t0 pfet_03v3 w=10u l=0.32u ad=2.8000e-12 pd=1.0560e-05 as=3.2000e-12 ps=1.1890e-05 nf=1 m=16 par=16
XMpar5 a_1762_17760.t0 ib.t0 vss.t2 vss.t1 nfet_03v3 w=9.92u l=0.5u ad=2.7776e-12 pd=1.0480e-05 as=2.7776e-12 ps=1.0480e-05 nf=1 m=36 par=36
XMpar6 a_16174_14389.t0 a_16174_1294.t10 a_1762_17760.t36 vss.t0 nfet_03v3 w=9.31u l=0.4u ad=3.2026e-12 pd=1.1860e-05 as=3.2026e-12 ps=1.1860e-05 nf=1 m=5 par=5
XMpar7 a_16174_14389.t6 a_16174_14389.t5 vdd.t1 vdd.t0 pfet_03v3 w=10u l=0.32u ad=2.8000e-12 pd=1.0560e-05 as=3.0667e-12 ps=1.1447e-05 nf=1 m=48 par=48
XMpar8 a_1762_17760.t36 a_15018_14181.t10 a_4005_7553.t98 vss.t0 nfet_03v3 w=9.31u l=0.4u ad=3.2026e-12 pd=1.1860e-05 as=3.2026e-12 ps=1.1860e-05 nf=1 m=5 par=5
XMpar9 a_1292_21414.t0 a_1412_21206.t0 a_1412_21206.t1 vdd.t0 pfet_03v3 w=10u l=0.32u ad=3.2000e-12 pd=1.1890e-05 as=2.8000e-12 ps=1.0560e-05 nf=1 m=16 par=16
XMpar10 a_1098_1249.t0 ib.t0 vss.t2 vss.t1 nfet_03v3 w=9.92u l=0.5u ad=2.7776e-12 pd=1.0480e-05 as=3.3067e-12 ps=1.2240e-05 nf=1 m=12 par=12
XMpar11 a_1098_1249.t12 a_4005_7553.t103 a_14974_19976.t0 vss.t158 nfet_03v3 w=7.76u l=0.4u ad=4.6560e-12 pd=1.6720e-05 as=2.1728e-12 ps=8.3200e-06 nf=1 m=2 par=2
XMpar12 a_15018_14181.t1 a_5976_26925.t6 vdd.t19 vdd.t18 pfet_03v3 w=6.35u l=0.5u ad=1.7780e-12 pd=6.9100e-06 as=3.8100e-12 ps=1.3900e-05 nf=1 m=2 par=2
XMpar13 ib.t1 ib.t0 vss.t2 vss.t1 nfet_03v3 w=9.92u l=0.5u ad=3.8357e-12 pd=1.4000e-05 as=2.7776e-12 ps=1.0480e-05 nf=1 m=6 par=6
XMpar14 out.t0 a_14974_19976.t2 vdd.t1 vdd.t0 pfet_03v3 w=10u l=0.32u ad=2.8000e-12 pd=1.0560e-05 as=3.2000e-12 ps=1.1890e-05 nf=1 m=16 par=16
XMpar15 a_5976_26925.t0 ib.t0 vss.t2 vss.t1 nfet_03v3 w=9.92u l=0.5u ad=3.8357e-12 pd=1.4000e-05 as=2.7776e-12 ps=1.0480e-05 nf=1 m=6 par=6
XMpar16 a_1412_21206.t32 ib.t0 vss.t2 vss.t1 nfet_03v3 w=9.92u l=0.5u ad=3.8357e-12 pd=1.4000e-05 as=2.7776e-12 ps=1.0480e-05 nf=1 m=6 par=6
XMpar17 a_15018_14181.t0 a_1412_21206.t38 a_4005_7553.t0 vdd.t40 pfet_03v3 w=4.57u l=0.32u ad=1.2796e-12 pd=5.1300e-06 as=2.7420e-12 ps=1.0340e-05 nf=1 m=2 par=2
XMpar18 a_5976_26925.t7 a_5976_26925.t6 vdd.t19 vdd.t18 pfet_03v3 w=6.35u l=0.5u ad=1.7780e-12 pd=6.9100e-06 as=3.8100e-12 ps=1.3900e-05 nf=1 m=2 par=2
XMpar19 a_1338_17760.t12 inp.t0 a_15018_14181.t4 vss.t158 nfet_03v3 w=1.8u l=0.45u ad=6.9600e-13 pd=3.1733e-06 as=6.9600e-13 ps=3.1733e-06 nf=1 m=6 par=6
XMpar20 a_1338_17760.t12 inn.t0 a_16174_1294.t3 vss.t158 nfet_03v3 w=1.8u l=0.45u ad=6.9600e-13 pd=3.1733e-06 as=6.9600e-13 ps=3.1733e-06 nf=1 m=6 par=6
XMpar21 a_16174_1294.t2 a_1412_21206.t38 a_16174_14389.t101 vdd.t40 pfet_03v3 w=4.57u l=0.32u ad=1.2796e-12 pd=5.1300e-06 as=2.7420e-12 ps=1.0340e-05 nf=1 m=2 par=2
XMpar22 a_16174_1294.t0 a_5976_26925.t6 vdd.t19 vdd.t18 pfet_03v3 w=6.35u l=0.5u ad=1.7780e-12 pd=6.9100e-06 as=3.8100e-12 ps=1.3900e-05 nf=1 m=2 par=2
X30 out.t18 vss.t162 cap_mim_2f0fF c_width=19.69u c_length=19.69u
X35 out.t18 vss.t162 cap_mim_2f0fF c_width=19.69u c_length=19.69u
X65 out.t18 vss.t162 cap_mim_2f0fF c_width=19.69u c_length=19.69u
X93 out.t18 vss.t162 cap_mim_2f0fF c_width=19.69u c_length=19.69u
X95 out.t18 vss.t162 cap_mim_2f0fF c_width=19.69u c_length=19.69u
X96 out.t18 vss.t162 cap_mim_2f0fF c_width=19.69u c_length=19.69u
X261 out.t18 vss.t162 cap_mim_2f0fF c_width=19.69u c_length=19.69u
X269 out.t18 vss.t162 cap_mim_2f0fF c_width=19.69u c_length=19.69u
Rpar0 a_1098_1249.t0 a_1098_1249.t12 71.6711
Rpar1 a_1292_21414.t0 a_1292_21414.t16 21.7837
Rpar2 a_1338_17760.t0 a_1338_17760.t12 78.1143
Rpar3 a_1412_21206.t0 a_1412_21206.t1 22.0762
Rpar4 a_1412_21206.t0 a_1412_21206.t32 2514.4969
Rpar5 a_1412_21206.t0 a_1412_21206.t38 5631.4944
Rpar6 a_1412_21206.t1 a_1412_21206.t32 87.4078
Rpar7 a_1412_21206.t1 a_1412_21206.t38 195.7594
Rpar8 a_1412_21206.t32 a_1412_21206.t38 111.5351
Rpar9 a_14974_19976.t0 a_14974_19976.t2 560.1359
Rpar10 a_14974_19976.t0 a_14974_19976.t3 68.8521
Rpar11 a_14974_19976.t2 a_14974_19976.t3 11.7895
Rpar12 a_15018_14181.t0 a_15018_14181.t1 205.1210
Rpar13 a_15018_14181.t0 a_15018_14181.t10 146.3941
Rpar14 a_15018_14181.t0 a_15018_14181.t4 153.5552
Rpar15 a_15018_14181.t1 a_15018_14181.t10 215.5915
Rpar16 a_15018_14181.t1 a_15018_14181.t4 58.9465
Rpar17 a_15018_14181.t10 a_15018_14181.t4 161.3936
Rpar18 a_16174_1294.t0 a_16174_1294.t10 117.1007
Rpar19 a_16174_1294.t0 a_16174_1294.t2 181.2528
Rpar20 a_16174_1294.t0 a_16174_1294.t3 82.8778
Rpar21 a_16174_1294.t10 a_16174_1294.t2 165.6903
Rpar22 a_16174_1294.t10 a_16174_1294.t3 129.1020
Rpar23 a_16174_1294.t2 a_16174_1294.t3 199.8289
Rpar24 a_16174_14389.t0 a_16174_14389.t6 94.1869
Rpar25 a_16174_14389.t0 a_16174_14389.t101 43.4633
Rpar26 a_16174_14389.t0 a_16174_14389.t103 256.4738
Rpar27 a_16174_14389.t0 a_16174_14389.t5 3480.5930
Rpar28 a_16174_14389.t6 a_16174_14389.t101 188.8851
Rpar29 a_16174_14389.t6 a_16174_14389.t103 284.8045
Rpar30 a_16174_14389.t6 a_16174_14389.t5 9.3147
Rpar31 a_16174_14389.t101 a_16174_14389.t103 514.3401
Rpar32 a_16174_14389.t103 a_16174_14389.t5 10524.7019
Rpar33 a_1762_17760.t0 a_1762_17760.t36 55.3454
Rpar34 a_4005_7553.t0 a_4005_7553.t2 350.6828
Rpar35 a_4005_7553.t0 a_4005_7553.t98 64.5803
Rpar36 a_4005_7553.t0 a_4005_7553.t103 946.3836
Rpar37 a_4005_7553.t1 a_4005_7553.t2 9.3095
Rpar38 a_4005_7553.t1 a_4005_7553.t98 3685.1752
Rpar39 a_4005_7553.t1 a_4005_7553.t103 8650.5919
Rpar40 a_4005_7553.t2 a_4005_7553.t98 99.7230
Rpar41 a_4005_7553.t2 a_4005_7553.t103 234.0900
Rpar42 a_4005_7553.t98 a_4005_7553.t103 269.1212
Rpar43 a_5976_26925.t0 a_5976_26925.t6 100.5377
Rpar44 a_5976_26925.t0 a_5976_26925.t7 153.0408
Rpar45 a_5976_26925.t6 a_5976_26925.t7 50.1174
Rpar46 ib ib.t0 1.8639
Rpar47 ib ib.t1 124.1245
Rpar48 ib.t0 ib.t1 17.7950
Rpar49 inn inn.t0 10.5119
Rpar50 inp inp.t0 10.5119
Rpar51 out out.t0 2.5931
Rpar52 out out.t13 460.0779
Rpar53 out out.t18 424.2609
Rpar54 out.t0 out.t13 119.2565
Rpar55 out.t0 out.t18 109.9724
Rpar56 out.t13 out.t18 315.4232
Rpar57 vdd vdd.t0 100.6481
Rpar58 vdd vdd.t1 128.4139
Rpar59 vdd vdd.t18 634.1562
Rpar60 vdd vdd.t19 286.5404
Rpar61 vdd vdd.t40 743.6167
Rpar62 vdd.t0 vdd.t1 1.9733
Rpar63 vdd.t0 vdd.t18 209.7078
Rpar64 vdd.t0 vdd.t19 93.0405
Rpar65 vdd.t0 vdd.t40 312.8142
Rpar66 vdd.t1 vdd.t18 129.1844
Rpar67 vdd.t1 vdd.t19 38.3045
Rpar68 vdd.t1 vdd.t40 72.8102
Rpar69 vdd.t18 vdd.t19 6.1947
Rpar70 vdd.t18 vdd.t40 611.7102
Rpar71 vdd.t19 vdd.t40 183.3515
Rpar72 vss vss.t0 591.2579
Rpar73 vss vss.t1 48.2738
Rpar74 vss vss.t2 315.1612
Rpar75 vss vss.t158 46.8341
Rpar76 vss vss.t162 8740.0469
Rpar77 vss.t0 vss.t1 63.3318
Rpar78 vss.t0 vss.t2 766.9751
Rpar79 vss.t0 vss.t158 45.3961
Rpar80 vss.t0 vss.t162 131.4719
Rpar81 vss.t1 vss.t2 1.5735
Rpar82 vss.t1 vss.t158 133.3755
Rpar83 vss.t1 vss.t162 122.2461
Rpar84 vss.t2 vss.t158 1031.7855
Rpar85 vss.t2 vss.t162 1503.6291
Rpar86 vss.t158 vss.t162 673.7352
Cpar0 a_1098_1249.t0 vss 7.34528e-15
Cpar1 a_1098_1249.t12 vss 4.45540e-15
Cpar2 a_1292_21414.t0 vss 7.49365e-14
Cpar3 a_1292_21414.t16 vss 1.40726e-14
Cpar4 a_1338_17760.t0 vss 2.10082e-14
Cpar5 a_1338_17760.t12 vss 6.82510e-15
Cpar6 a_1412_21206.t0 vss 1.00781e-14
Cpar7 a_1412_21206.t1 vss 2.96713e-14
Cpar8 a_1412_21206.t32 vss 1.95410e-14
Cpar9 a_1412_21206.t38 vss 4.15821e-15
Cpar10 a_14974_19976.t0 vss 6.87197e-15
Cpar11 a_14974_19976.t2 vss 2.77925e-14
Cpar12 a_14974_19976.t3 vss 4.59604e-14
Cpar13 a_15018_14181.t0 vss 5.47778e-15
Cpar14 a_15018_14181.t1 vss 5.87365e-15
Cpar15 a_15018_14181.t10 vss 7.20112e-15
Cpar16 a_15018_14181.t4 vss 7.72791e-15
Cpar17 a_16174_1294.t0 vss 4.33020e-15
Cpar18 a_16174_1294.t10 vss 4.79609e-15
Cpar19 a_16174_1294.t2 vss 3.75151e-15
Cpar20 a_16174_1294.t3 vss 4.72523e-15
Cpar21 a_16174_14389.t0 vss 1.45457e-14
Cpar22 a_16174_14389.t101 vss 6.26772e-15
Cpar23 a_16174_14389.t103 vss 3.15730e-15
Cpar24 a_16174_14389.t5 vss 3.93002e-14
Cpar25 a_16174_14389.t6 vss 9.81259e-14
Cpar26 a_1762_17760.t0 vss 2.79906e-14
Cpar27 a_1762_17760.t36 vss 8.89453e-15
Cpar28 a_4005_7553.t0 vss 5.62412e-15
Cpar29 a_4005_7553.t1 vss 4.02377e-14
Cpar30 a_4005_7553.t103 vss 3.67391e-15
Cpar31 a_4005_7553.t2 vss 1.01058e-13
Cpar32 a_4005_7553.t98 vss 1.51009e-14
Cpar33 a_5976_26925.t0 vss 1.33416e-14
Cpar34 a_5976_26925.t6 vss 5.85872e-15
Cpar35 a_5976_26925.t7 vss 6.07863e-15
Cpar36 ib vss 8.17904e-14
Cpar37 ib.t0 vss 1.16604e-14
Cpar38 ib.t1 vss 3.17769e-15
Cpar39 inn inp 1.02880e-16
Cpar40 inn vss 4.62500e-15
Cpar41 inn.t0 vss 8.24072e-16
Cpar42 inp vss 4.63564e-15
Cpar43 inp.t0 vss 8.24708e-16
Cpar44 out vdd 4.67951e-14
Cpar45 out vss 6.76195e-14
Cpar46 out.t0 vss 1.85806e-15
Cpar47 out.t13 vss 4.78251e-16
Cpar48 out.t18 vss 6.31046e-14
Cpar49 vdd vss 4.43865e-13
Cpar50 vdd.t0 vss 2.83627e-13
Cpar51 vdd.t1 vss 1.26216e-13
Cpar52 vdd.t18 vss 1.28709e-14
Cpar53 vdd.t19 vss 1.80605e-14
Cpar54 vdd.t40 vss 1.06891e-14
.ends opamp_dut

Vdd vdd 0 1.800000
Vss vss 0 0
Ibias vdd ib 1.187500e-05
Vinp inp 0 DC 1.256300 AC 1 PWL(0 1.256300 6.276664e-09 1.256300 6.904331e-09 1.266300)
Rfb out inn 1m
Cload out 0 2.000000e-13
Xdut vdd vss inp inn out ib opamp_dut
.end
