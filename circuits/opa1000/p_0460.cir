* opa1000[0460]: 2p/nmos_miller_1v8_i50n_subth (nmos_miller, VDD=1.8V, CL=2.0pF, Iref=0.0071uA)
.include "pdk_opa.inc"
.temp 27
.option gmin=1e-12 rshunt=1e12 reltol=1e-3 abstol=1e-12 vntol=1e-5 method=gear
* Post-PEX R+C extracted netlist for nmos_miller_1v8_i50n_subth
.subckt opamp_dut vdd vss inp inn out ib
XMpar0 out.t0 ib.t0 vss.t9 vss.t8 nfet_03v3 w=0.4u l=5u ad=1.8880e-13 pd=1.5840e-06 as=1.6320e-13 ps=1.3760e-06 nf=1 m=10 par=10
XMpar1 a_7766_1249.t2 ib.t0 vss.t9 vss.t8 nfet_03v3 w=0.4u l=5u ad=2.4000e-13 pd=2.0000e-06 as=1.1200e-13 ps=9.6000e-07 nf=1 m=4 par=4
XMpar2 out.t1 a_940_1290.t5 vdd.t1 vdd.t0 pfet_03v3 w=0.52u l=4u ad=1.4560e-13 pd=1.0800e-06 as=1.7888e-13 ps=1.3120e-06 nf=1 m=10 par=10
XMpar3 a_7572_8911.t1 a_7572_8911.t0 vdd.t1 vdd.t0 pfet_03v3 w=0.52u l=4u ad=1.4560e-13 pd=1.0800e-06 as=1.4560e-13 ps=1.0800e-06 nf=1 m=2 par=2
XMpar4 a_7572_8911.t4 inn.t0 a_7766_1249.t0 vss.t4 nfet_03v3 w=0.92u l=5.5u ad=5.5200e-13 pd=3.0400e-06 as=5.5200e-13 ps=3.0400e-06 nf=1 m=2 par=2
XMpar5 ib.t1 ib.t0 vss.t9 vss.t8 nfet_03v3 w=0.4u l=5u ad=2.4000e-13 pd=2.0000e-06 as=1.1200e-13 ps=9.6000e-07 nf=1 m=2 par=2
XMpar6 a_940_1290.t0 a_7572_8911.t0 vdd.t1 vdd.t0 pfet_03v3 w=0.52u l=4u ad=3.1200e-13 pd=2.2400e-06 as=1.4560e-13 ps=1.0800e-06 nf=1 m=2 par=2
XMpar7 a_7766_1249.t0 inp.t0 a_940_1290.t2 vss.t4 nfet_03v3 w=0.92u l=5.5u ad=5.5200e-13 pd=3.0400e-06 as=5.5200e-13 ps=3.0400e-06 nf=1 m=2 par=2
X4 a_940_5970.t0 a_4918_6490.t0 vss.t0 ppolyf_u_1k r_width=1u r_length=19.23u
X5 a_940_2850.t0 a_4918_3370.t0 vss.t0 ppolyf_u_1k r_width=1u r_length=19.23u
X7 a_940_5970.t0 a_4918_5450.t0 vss.t0 ppolyf_u_1k r_width=1u r_length=19.23u
X9 a_940_2850.t0 a_4918_2330.t0 vss.t0 ppolyf_u_1k r_width=1u r_length=19.23u
X15 a_4918_7530.t1 out.t6 cap_mim_2f0fF c_width=16.58u c_length=16.59u
X16 a_940_4930.t0 a_4918_5450.t0 vss.t0 ppolyf_u_1k r_width=1u r_length=19.23u
X18 a_940_1810.t0 a_4918_2330.t0 vss.t0 ppolyf_u_1k r_width=1u r_length=19.23u
X21 a_940_4930.t0 a_4918_4410.t0 vss.t0 ppolyf_u_1k r_width=1u r_length=19.23u
X22 a_940_1810.t0 a_4918_1290.t0 vss.t0 ppolyf_u_1k r_width=1u r_length=19.23u
X28 a_940_7010.t0 a_4918_7530.t0 vss.t0 ppolyf_u_1k r_width=1u r_length=19.23u
X33 a_940_3890.t0 a_4918_4410.t0 vss.t0 ppolyf_u_1k r_width=1u r_length=19.23u
X36 a_940_7010.t0 a_4918_6490.t0 vss.t0 ppolyf_u_1k r_width=1u r_length=19.23u
X37 a_4918_7530.t1 out.t6 cap_mim_2f0fF c_width=16.58u c_length=16.59u
X39 a_940_1290.t1 a_4918_1290.t0 vss.t0 ppolyf_u_1k r_width=1u r_length=19.23u
X47 a_940_3890.t0 a_4918_3370.t0 vss.t0 ppolyf_u_1k r_width=1u r_length=19.23u
Rpar0 a_4918_7530.t0 a_4918_7530.t1 57.2532
Rpar1 a_7572_8911.t0 a_7572_8911.t1 27.5886
Rpar2 a_7572_8911.t0 a_7572_8911.t4 192.4847
Rpar3 a_7572_8911.t1 a_7572_8911.t4 171.8741
Rpar4 a_7766_1249.t0 a_7766_1249.t2 72.7125
Rpar5 a_940_1290.t0 a_940_1290.t1 348.7235
Rpar6 a_940_1290.t0 a_940_1290.t5 86.3255
Rpar7 a_940_1290.t0 a_940_1290.t2 370.6855
Rpar8 a_940_1290.t1 a_940_1290.t5 70.1071
Rpar9 a_940_1290.t1 a_940_1290.t2 139.2968
Rpar10 a_940_1290.t5 a_940_1290.t2 74.5223
Rpar11 ib ib.t0 16.4424
Rpar12 ib ib.t1 15.2949
Rpar13 ib.t0 ib.t1 34.2079
Rpar14 inn inn.t0 4.5240
Rpar15 inp inp.t0 4.5234
Rpar16 out out.t0 97.7092
Rpar17 out out.t1 101.5098
Rpar18 out out.t6 22.5463
Rpar19 out.t0 out.t1 73.6277
Rpar20 out.t0 out.t6 574.4675
Rpar21 out.t1 out.t6 596.8130
Rpar22 vdd vdd.t0 61.6008
Rpar23 vdd vdd.t1 123.4974
Rpar24 vdd.t0 vdd.t1 4.6009
Rpar25 vss vss.t0 56.9806
Rpar26 vss vss.t8 445.4313
Rpar27 vss vss.t9 185.2436
Rpar28 vss vss.t4 121.7407
Rpar29 vss.t0 vss.t8 384.5215
Rpar30 vss.t0 vss.t9 309.2671
Rpar31 vss.t0 vss.t4 184.1867
Rpar32 vss.t8 vss.t9 13.2626
Rpar33 vss.t8 vss.t4 370.9207
Rpar34 vss.t9 vss.t4 139.1129
Cpar0 a_4918_1290.t0 vss 3.40200e-17
Cpar1 a_4918_2330.t0 vss 4.22800e-17
Cpar2 a_4918_3370.t0 vss 4.03800e-17
Cpar3 a_4918_4410.t0 vss 3.96000e-17
Cpar4 a_4918_5450.t0 vss 4.01000e-17
Cpar5 a_4918_6490.t0 vss 4.13800e-17
Cpar6 a_4918_7530.t0 vss 1.29266e-16
Cpar7 a_4918_7530.t1 vss 5.46593e-15
Cpar8 a_7572_8911.t0 vss 1.03173e-14
Cpar9 a_7572_8911.t1 vss 4.16903e-15
Cpar10 a_7572_8911.t4 vss 7.98086e-15
Cpar11 a_7766_1249.t0 vss 9.68443e-15
Cpar12 a_7766_1249.t2 vss 1.73706e-14
Cpar13 a_940_1290.t0 vss 4.59595e-15
Cpar14 a_940_1290.t1 vss 3.54873e-15
Cpar15 a_940_1290.t2 vss 4.25280e-15
Cpar16 a_940_1290.t5 vss 2.28002e-14
Cpar17 a_940_1810.t0 vss 3.20200e-17
Cpar18 a_940_2850.t0 vss 2.93600e-17
Cpar19 a_940_3890.t0 vss 2.93600e-17
Cpar20 a_940_4930.t0 vss 2.93600e-17
Cpar21 a_940_5970.t0 vss 3.00800e-17
Cpar22 a_940_7010.t0 vss 2.64400e-17
Cpar23 ib out 2.25848e-15
Cpar24 ib vdd 3.07710e-16
Cpar25 ib vss 5.68942e-14
Cpar26 ib.t0 vss 9.55380e-15
Cpar27 ib.t1 vss 7.28875e-16
Cpar28 inn inp 1.03420e-16
Cpar29 inn vss 6.31953e-15
Cpar30 inn.t0 vss 1.16807e-15
Cpar31 inp vss 6.37182e-15
Cpar32 inp.t0 vss 1.17113e-15
Cpar33 out vdd 1.06720e-14
Cpar34 out vss 2.70495e-14
Cpar35 out.t0 vss 7.91159e-15
Cpar36 out.t1 vss 4.15356e-15
Cpar37 out.t6 vss 1.56408e-14
Cpar38 vdd vss 8.97147e-14
Cpar39 vdd.t0 vss 2.76009e-14
Cpar40 vdd.t1 vss 1.32798e-14
.ends opamp_dut

Vdd vdd 0 1.800000
Vss vss 0 0
Ibias vdd ib 7.100000e-09
Vinp inp 0 DC 0.895000 AC 1 PWL(0 0.895000 4.399057e-06 0.895000 4.838963e-06 0.905000)
Rfb out inn 1m
Cload out 0 2.000000e-12
Xdut vdd vss inp inn out ib opamp_dut
.end
