* opa1000[0553]: 2p/pmos_5t_1v8_1u_10u_subth (pmos_5t, VDD=1.8V, CL=2.0pF, Iref=1.3uA)
.include "pdk_opa.inc"
.temp 27
.option gmin=1e-12 rshunt=1e12 reltol=1e-3 abstol=1e-12 vntol=1e-5 method=gear
* Post-PEX R+C extracted netlist for pmos_5t_1v8_1u_10u_subth
.subckt opamp_dut vdd vss inp inn out ib
XMpar0 a_1852_3107.t0 inn.t0 out.t0 vdd.t10 pfet_03v3 w=4.59u l=1.3u ad=1.4229e-12 pd=5.6403e-06 as=1.3770e-12 ps=5.4769e-06 nf=1 m=64 par=64
XMpar1 a_1852_3107.t0 inp.t0 a_3380_996.t0 vdd.t10 pfet_03v3 w=4.59u l=1.3u ad=1.4229e-12 pd=5.6403e-06 as=1.3770e-12 ps=5.4769e-06 nf=1 m=64 par=64
XMpar2 a_3380_996.t65 a_3380_996.t64 vss.t1 vss.t0 nfet_03v3 w=2.06u l=2.5u ad=5.7680e-13 pd=2.6200e-06 as=6.5920e-13 ps=2.9575e-06 nf=1 m=8 par=8
XMpar3 out.t4 a_3380_996.t64 vss.t1 vss.t0 nfet_03v3 w=2.06u l=2.5u ad=5.7680e-13 pd=2.6200e-06 as=6.5920e-13 ps=2.9575e-06 nf=1 m=8 par=8
XMpar4 a_1252_2899.t3 a_1252_2899.t2 vdd.t1 vdd.t0 pfet_03v3 w=10u l=3u ad=2.8000e-12 pd=1.0560e-05 as=2.8000e-12 ps=1.0560e-05 nf=1 m=2 par=2
XMpar5 a_1852_3107.t128 a_1252_2899.t2 vdd.t1 vdd.t0 pfet_03v3 w=10u l=3u ad=2.8000e-12 pd=1.0560e-05 as=3.6000e-12 ps=1.3220e-05 nf=1 m=8 par=8
XMpar6 a_1252_2899.t0 ib.t0 vss.t7 vss.t6 nfet_03v3 w=6.08u l=3u ad=1.7024e-12 pd=6.6400e-06 as=1.7024e-12 ps=6.6400e-06 nf=1 m=2 par=2
XMpar7 ib.t1 ib.t0 vss.t7 vss.t6 nfet_03v3 w=6.08u l=3u ad=3.6480e-12 pd=1.3360e-05 as=1.7024e-12 ps=6.6400e-06 nf=1 m=2 par=2
X121 out.t72 vss.t36 cap_mim_2f0fF c_width=9u c_length=9u
Rpar0 a_1252_2899.t0 a_1252_2899.t2 133.8958
Rpar1 a_1252_2899.t0 a_1252_2899.t3 47.1816
Rpar2 a_1252_2899.t2 a_1252_2899.t3 26.4708
Rpar3 a_1852_3107.t0 a_1852_3107.t128 39.2536
Rpar4 a_3380_996.t0 a_3380_996.t64 252.1997
Rpar5 a_3380_996.t0 a_3380_996.t65 103.1244
Rpar6 a_3380_996.t64 a_3380_996.t65 15.8601
Rpar7 ib ib.t0 14.3985
Rpar8 ib ib.t1 3.6296
Rpar9 inn inn.t0 1.7846
Rpar10 inp inp.t0 1.7846
Rpar11 out out.t0 49.5129
Rpar12 out out.t4 120.2161
Rpar13 out out.t72 14.9689
Rpar14 out.t0 out.t4 83.5407
Rpar15 out.t0 out.t72 717.9170
Rpar16 out.t4 out.t72 1743.0835
Rpar17 vdd vdd.t0 161.5327
Rpar18 vdd vdd.t1 743.1474
Rpar19 vdd vdd.t10 19.9193
Rpar20 vdd.t0 vdd.t1 5.8019
Rpar21 vdd.t0 vdd.t10 474.1124
Rpar22 vdd.t1 vdd.t10 2181.2010
Rpar23 vss vss.t0 66.6455
Rpar24 vss vss.t1 229.2591
Rpar25 vss vss.t6 202.1438
Rpar26 vss vss.t7 513.2101
Rpar27 vss vss.t36 230.7758
Rpar28 vss.t0 vss.t1 6.0509
Rpar29 vss.t0 vss.t6 4.4110
Rpar30 vss.t0 vss.t7 11.5974
Rpar31 vss.t0 vss.t36 87.3928
Rpar32 vss.t1 vss.t6 20.3111
Rpar33 vss.t1 vss.t7 70.5899
Rpar34 vss.t1 vss.t36 412.0170
Rpar35 vss.t6 vss.t7 24.2511
Rpar36 vss.t6 vss.t36 218.4420
Rpar37 vss.t7 vss.t36 386.2686
Cpar0 a_1252_2899.t0 vss 2.17747e-15
Cpar1 a_1252_2899.t2 vss 3.24059e-14
Cpar2 a_1252_2899.t3 vss 3.59063e-15
Cpar3 a_1852_3107.t0 vss 1.24837e-13
Cpar4 a_1852_3107.t128 vss 1.67300e-14
Cpar5 a_3380_996.t0 vss 5.02229e-14
Cpar6 a_3380_996.t64 vss 2.32454e-14
Cpar7 a_3380_996.t65 vss 7.65434e-15
Cpar8 ib out 3.44500e-17
Cpar9 ib vdd 2.43240e-16
Cpar10 ib vss 1.28918e-14
Cpar11 ib.t0 vss 1.82955e-15
Cpar12 ib.t1 vss 3.91940e-16
Cpar13 inn inp 2.28020e-16
Cpar14 inn out 2.31613e-14
Cpar15 inn vdd 3.96196e-14
Cpar16 inn vss 7.04176e-15
Cpar17 inn.t0 vss 7.39825e-14
Cpar18 inp vdd 3.97814e-14
Cpar19 inp vss 6.93270e-15
Cpar20 inp.t0 vss 7.41554e-14
Cpar21 out vdd 1.04607e-14
Cpar22 out vss 1.83665e-14
Cpar23 out.t0 vss 4.70098e-14
Cpar24 out.t4 vss 7.12884e-15
Cpar25 out.t72 vss 2.18094e-14
Cpar26 vdd vss 4.10737e-13
Cpar27 vdd.t0 vss 2.74043e-14
Cpar28 vdd.t1 vss 9.04137e-15
Cpar29 vdd.t10 vss 1.09080e-13
.ends opamp_dut

Vdd vdd 0 1.800000
Vss vss 0 0
Ibias vdd ib 1.300000e-06
Vinp inp 0 DC 0.805000 AC 1 PWL(0 0.805000 2.705441e-08 0.805000 2.975985e-08 0.815000)
Rfb out inn 1m
Cload out 0 2.000000e-12
Xdut vdd vss inp inn out ib opamp_dut
.end
