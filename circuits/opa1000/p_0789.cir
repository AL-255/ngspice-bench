* opa1000[0789]: 200f/symmetrical_ota_3v3_i150u_subth (symmetrical_ota, VDD=3.3V, CL=0.2pF, Iref=17.5uA)
.include "pdk_opa.inc"
.temp 27
.option gmin=1e-12 rshunt=1e12 reltol=1e-3 abstol=1e-12 vntol=1e-5 method=gear
* Post-PEX R+C extracted netlist for symmetrical_ota_3v3_i150u_subth
.subckt opamp_dut vdd vss inp inn out ib
XMpar0 a_7358_6273.t0 a_8494_10812.t44 vdd.t1 vdd.t0 pfet_03v3 w=10u l=0.56u ad=2.8000e-12 pd=1.0560e-05 as=3.3333e-12 ps=1.2333e-05 nf=1 m=12 par=12
XMpar1 a_4758_10812.t0 inn.t0 a_8494_10812.t0 vss.t0 nfet_03v3 w=1.94u l=0.28u ad=8.9064e-13 pd=3.0345e-06 as=8.6242e-13 ps=2.9173e-06 nf=1 m=44 par=44
XMpar2 a_1267_6273.t0 inp.t0 a_4758_10812.t0 vss.t0 nfet_03v3 w=1.94u l=0.28u ad=8.6242e-13 pd=2.9173e-06 as=8.9064e-13 ps=3.0345e-06 nf=1 m=44 par=44
XMpar3 a_7358_6273.t11 a_7358_6273.t10 vss.t1 vss.t0 nfet_03v3 w=3.68u l=0.56u ad=1.0304e-12 pd=4.2400e-06 as=1.0304e-12 ps=4.2400e-06 nf=1 m=12 par=12
XMpar4 a_4758_10812.t88 ib.t0 vss.t86 vss.t85 nfet_03v3 w=4.23u l=0.65u ad=1.6356e-12 pd=6.4133e-06 as=1.4100e-12 ps=5.6017e-06 nf=1 m=12 par=12
XMpar5 a_8494_10812.t45 a_8494_10812.t44 vdd.t1 vdd.t0 pfet_03v3 w=10u l=0.56u ad=2.8000e-12 pd=1.0560e-05 as=2.8000e-12 ps=1.0560e-05 nf=1 m=6 par=6
XMpar6 out.t0 a_7358_6273.t10 vss.t1 vss.t0 nfet_03v3 w=3.68u l=0.56u ad=1.4229e-12 pd=5.6800e-06 as=1.0304e-12 ps=4.2400e-06 nf=1 m=12 par=12
XMpar7 ib.t1 ib.t0 vss.t86 vss.t85 nfet_03v3 w=4.23u l=0.65u ad=1.6356e-12 pd=6.4133e-06 as=1.1844e-12 ps=4.7900e-06 nf=1 m=6 par=6
XMpar8 a_1267_6273.t45 a_1267_6273.t44 vdd.t1 vdd.t0 pfet_03v3 w=10u l=0.56u ad=2.8000e-12 pd=1.0560e-05 as=2.8000e-12 ps=1.0560e-05 nf=1 m=6 par=6
XMpar9 out.t9 a_1267_6273.t44 vdd.t1 vdd.t0 pfet_03v3 w=10u l=0.56u ad=2.8000e-12 pd=1.0560e-05 as=3.3333e-12 ps=1.2333e-05 nf=1 m=12 par=12
X94 out.t24 vss.t48 cap_mim_2f0fF c_width=17.91u c_length=17.91u
X143 out.t24 vss.t48 cap_mim_2f0fF c_width=17.91u c_length=17.91u
Rpar0 a_1267_6273.t0 a_1267_6273.t44 227.6805
Rpar1 a_1267_6273.t0 a_1267_6273.t45 47.8253
Rpar2 a_1267_6273.t44 a_1267_6273.t45 21.6468
Rpar3 a_4758_10812.t0 a_4758_10812.t88 63.1816
Rpar4 a_7358_6273.t0 a_7358_6273.t10 316.6221
Rpar5 a_7358_6273.t0 a_7358_6273.t11 37.2995
Rpar6 a_7358_6273.t10 a_7358_6273.t11 9.1483
Rpar7 a_8494_10812.t0 a_8494_10812.t44 227.6747
Rpar8 a_8494_10812.t0 a_8494_10812.t45 47.8256
Rpar9 a_8494_10812.t44 a_8494_10812.t45 21.6469
Rpar10 ib ib.t0 21.1487
Rpar11 ib ib.t1 3.7243
Rpar12 ib.t0 ib.t1 16.9959
Rpar13 inn inn.t0 2.9334
Rpar14 inp inp.t0 2.9334
Rpar15 out out.t0 69.1155
Rpar16 out out.t9 126.6580
Rpar17 out out.t24 18.3956
Rpar18 out.t0 out.t9 42.7707
Rpar19 out.t0 out.t24 289.0534
Rpar20 out.t9 out.t24 529.7063
Rpar21 vdd vdd.t0 67.1016
Rpar22 vdd vdd.t1 355.8313
Rpar23 vdd.t0 vdd.t1 2.3858
Rpar24 vss vss.t0 237.8566
Rpar25 vss vss.t1 981.4584
Rpar26 vss vss.t85 473.8594
Rpar27 vss vss.t86 53.1576
Rpar28 vss vss.t48 79.1185
Rpar29 vss.t0 vss.t1 8.2316
Rpar30 vss.t0 vss.t85 447.4556
Rpar31 vss.t0 vss.t86 115.0975
Rpar32 vss.t0 vss.t48 587.0414
Rpar33 vss.t1 vss.t86 479.6686
Rpar34 vss.t1 vss.t48 2422.2861
Rpar35 vss.t85 vss.t86 12.0438
Rpar36 vss.t85 vss.t48 1169.5075
Rpar37 vss.t86 vss.t48 131.1955
Cpar0 a_1267_6273.t0 vss 2.40192e-14
Cpar1 a_1267_6273.t44 vss 2.12074e-14
Cpar2 a_1267_6273.t45 vss 1.41008e-14
Cpar3 a_4758_10812.t0 vss 4.67069e-14
Cpar4 a_4758_10812.t88 vss 1.76052e-14
Cpar5 a_7358_6273.t0 vss 1.22832e-14
Cpar6 a_7358_6273.t10 vss 9.65756e-15
Cpar7 a_7358_6273.t11 vss 8.31971e-15
Cpar8 a_8494_10812.t0 vss 2.48597e-14
Cpar9 a_8494_10812.t44 vss 2.19493e-14
Cpar10 a_8494_10812.t45 vss 1.45940e-14
Cpar11 ib out 1.74600e-17
Cpar12 ib vdd 3.07700e-17
Cpar13 ib vss 2.40156e-14
Cpar14 ib.t0 vss 3.35735e-15
Cpar15 ib.t1 vss 1.89274e-15
Cpar16 inn inp 1.25740e-16
Cpar17 inn vdd 4.93000e-17
Cpar18 inn vss 2.04904e-14
Cpar19 inn.t0 vss 6.96805e-15
Cpar20 inp vdd 3.95100e-17
Cpar21 inp vss 2.04846e-14
Cpar22 inp.t0 vss 6.95366e-15
Cpar23 out vdd 2.20703e-14
Cpar24 out vss 3.35316e-14
Cpar25 out.t0 vss 1.80850e-15
Cpar26 out.t24 vss 2.80974e-14
Cpar27 out.t9 vss 2.44879e-15
Cpar28 vdd vss 1.33066e-13
Cpar29 vdd.t0 vss 5.75259e-14
Cpar30 vdd.t1 vss 2.63221e-14
.ends opamp_dut

Vdd vdd 0 3.300000
Vss vss 0 0
Ibias vdd ib 1.750000e-05
Vinp inp 0 DC 1.645000 AC 1 PWL(0 1.645000 3.000000e-09 1.645000 3.300000e-09 1.655000)
Rfb out inn 1m
Cload out 0 2.000000e-13
Xdut vdd vss inp inn out ib opamp_dut
.end
