* opa1000[0648]: 2p/pmos_miller_3v3_i50n_subth (pmos_miller, VDD=3.3V, CL=2.0pF, Iref=0.0072uA)
.include "pdk_opa.inc"
.temp 27
.option gmin=1e-12 rshunt=1e12 reltol=1e-3 abstol=1e-12 vntol=1e-5 method=gear
* Post-PEX R+C extracted netlist for pmos_miller_3v3_i50n_subth
.subckt opamp_dut vdd vss inp inn out ib
XMpar0 a_794_1290.t0 a_9012_7297.t8 vss.t2 vss.t1 nfet_03v3 w=0.4u l=4u ad=2.4000e-13 pd=2.0000e-06 as=1.1200e-13 ps=9.6000e-07 nf=1 m=2 par=2
XMpar1 out.t0 a_794_1290.t11 vss.t2 vss.t1 nfet_03v3 w=0.4u l=4u ad=1.3760e-13 pd=1.1680e-06 as=1.3760e-13 ps=1.1680e-06 nf=1 m=10 par=10
XMpar2 a_4928_9255.t16 a_1816_9047.t0 vdd.t1 vdd.t0 pfet_03v3 w=0.4u l=7.5u ad=2.4000e-13 pd=2.0000e-06 as=1.1200e-13 ps=9.6000e-07 nf=1 m=4 par=4
XMpar3 out.t2 a_1816_9047.t0 vdd.t1 vdd.t0 pfet_03v3 w=0.4u l=7.5u ad=1.8880e-13 pd=1.5840e-06 as=1.6320e-13 ps=1.3760e-06 nf=1 m=10 par=10
XMpar4 a_4928_9255.t0 inp.t0 a_794_1290.t2 vdd.t5 pfet_03v3 w=1.72u l=5.5u ad=7.5680e-13 pd=3.4600e-06 as=4.8160e-13 ps=2.2800e-06 nf=1 m=8 par=8
XMpar5 a_4928_9255.t0 inn.t0 a_9012_7297.t0 vdd.t5 pfet_03v3 w=1.72u l=5.5u ad=7.5680e-13 pd=3.4600e-06 as=4.8160e-13 ps=2.2800e-06 nf=1 m=8 par=8
XMpar6 ib.t1 ib.t0 vss.t23 vss.t22 nfet_03v3 w=0.4u l=7.5u ad=2.4000e-13 pd=2.0000e-06 as=1.1200e-13 ps=9.6000e-07 nf=1 m=2 par=2
XMpar7 a_1816_9047.t4 ib.t0 vss.t23 vss.t22 nfet_03v3 w=0.4u l=7.5u ad=2.4000e-13 pd=2.0000e-06 as=1.1200e-13 ps=9.6000e-07 nf=1 m=2 par=2
XMpar8 a_1816_9047.t1 a_1816_9047.t0 vdd.t1 vdd.t0 pfet_03v3 w=0.4u l=7.5u ad=2.4000e-13 pd=2.0000e-06 as=1.1200e-13 ps=9.6000e-07 nf=1 m=2 par=2
XMpar9 a_9012_7297.t9 a_9012_7297.t8 vss.t2 vss.t1 nfet_03v3 w=0.4u l=4u ad=1.1200e-13 pd=9.6000e-07 as=1.1200e-13 ps=9.6000e-07 nf=1 m=2 par=2
X10 a_794_4930.t0 a_4772_5450.t0 vss.t0 ppolyf_u_1k r_width=1u r_length=19.23u
X13 a_794_1810.t0 a_4772_2330.t0 vss.t0 ppolyf_u_1k r_width=1u r_length=19.23u
X15 a_794_4930.t0 a_4772_4410.t0 vss.t0 ppolyf_u_1k r_width=1u r_length=19.23u
X17 a_794_1810.t0 a_4772_1290.t0 vss.t0 ppolyf_u_1k r_width=1u r_length=19.23u
X22 a_794_7010.t0 a_4772_7530.t0 vss.t0 ppolyf_u_1k r_width=1u r_length=19.23u
X24 a_794_3890.t0 a_4772_4410.t0 vss.t0 ppolyf_u_1k r_width=1u r_length=19.23u
X33 a_794_7010.t0 a_4772_6490.t0 vss.t0 ppolyf_u_1k r_width=1u r_length=19.23u
X40 a_794_1290.t10 a_4772_1290.t0 vss.t0 ppolyf_u_1k r_width=1u r_length=19.23u
X44 a_794_3890.t0 a_4772_3370.t0 vss.t0 ppolyf_u_1k r_width=1u r_length=19.23u
X54 a_794_5970.t0 a_4772_6490.t0 vss.t0 ppolyf_u_1k r_width=1u r_length=19.23u
X56 a_794_2850.t0 a_4772_3370.t0 vss.t0 ppolyf_u_1k r_width=1u r_length=19.23u
X57 a_4772_7530.t1 out.t1 cap_mim_2f0fF c_width=16.58u c_length=16.59u
X62 a_794_5970.t0 a_4772_5450.t0 vss.t0 ppolyf_u_1k r_width=1u r_length=19.23u
X63 a_4772_7530.t1 out.t1 cap_mim_2f0fF c_width=16.58u c_length=16.59u
X64 a_794_2850.t0 a_4772_2330.t0 vss.t0 ppolyf_u_1k r_width=1u r_length=19.23u
Rpar0 a_1816_9047.t0 a_1816_9047.t1 18.1379
Rpar1 a_1816_9047.t0 a_1816_9047.t4 214.3488
Rpar2 a_1816_9047.t1 a_1816_9047.t4 168.7736
Rpar3 a_4772_7530.t0 a_4772_7530.t1 59.4982
Rpar4 a_4928_9255.t0 a_4928_9255.t16 45.0400
Rpar5 a_794_1290.t0 a_794_1290.t10 114.2760
Rpar6 a_794_1290.t0 a_794_1290.t11 112.8994
Rpar7 a_794_1290.t0 a_794_1290.t2 160.6825
Rpar8 a_794_1290.t10 a_794_1290.t11 247.9865
Rpar9 a_794_1290.t10 a_794_1290.t2 198.1089
Rpar10 a_794_1290.t11 a_794_1290.t2 348.6917
Rpar11 a_9012_7297.t0 a_9012_7297.t8 117.9890
Rpar12 a_9012_7297.t0 a_9012_7297.t9 118.0517
Rpar13 a_9012_7297.t8 a_9012_7297.t9 30.4952
Rpar14 ib ib.t0 9.6001
Rpar15 ib ib.t1 11.8130
Rpar16 ib.t0 ib.t1 43.7377
Rpar17 inn inn.t0 2.0346
Rpar18 inp inp.t0 2.0345
Rpar19 out out.t0 5.6270
Rpar20 out out.t1 171.7627
Rpar21 out out.t2 89.0680
Rpar22 out.t0 out.t1 197.1356
Rpar23 out.t0 out.t2 102.2252
Rpar24 out.t1 out.t2 198.9795
Rpar25 vdd vdd.t0 156.4747
Rpar26 vdd vdd.t1 1061.2873
Rpar27 vdd vdd.t5 22.3454
Rpar28 vdd.t0 vdd.t1 13.9218
Rpar29 vdd.t0 vdd.t5 66.6394
Rpar30 vdd.t1 vdd.t5 451.9809
Rpar31 vss vss.t0 28.6908
Rpar32 vss vss.t1 257.8818
Rpar33 vss vss.t2 293.2955
Rpar34 vss vss.t22 1423.8201
Rpar35 vss vss.t23 277.6245
Rpar36 vss.t0 vss.t1 273.9312
Rpar37 vss.t0 vss.t2 337.3328
Rpar38 vss.t0 vss.t22 1705.9406
Rpar39 vss.t0 vss.t23 335.0044
Rpar40 vss.t1 vss.t2 6.5780
Rpar41 vss.t1 vss.t22 5.3548
Rpar42 vss.t1 vss.t23 24.4348
Rpar43 vss.t2 vss.t22 62.3403
Rpar44 vss.t2 vss.t23 134.0192
Rpar45 vss.t22 vss.t23 75.2054
Cpar0 a_1816_9047.t0 vss 7.50627e-14
Cpar1 a_1816_9047.t1 vss 1.35193e-14
Cpar2 a_1816_9047.t4 vss 1.12692e-14
Cpar3 a_4772_1290.t0 vss 3.89800e-17
Cpar4 a_4772_2330.t0 vss 4.41200e-17
Cpar5 a_4772_3370.t0 vss 4.33800e-17
Cpar6 a_4772_4410.t0 vss 4.12000e-17
Cpar7 a_4772_5450.t0 vss 3.82400e-17
Cpar8 a_4772_6490.t0 vss 4.05800e-17
Cpar9 a_4772_7530.t0 vss 1.12320e-16
Cpar10 a_4772_7530.t1 vss 5.70360e-15
Cpar11 a_4928_9255.t0 vss 2.90902e-14
Cpar12 a_4928_9255.t16 vss 2.73240e-14
Cpar13 a_794_1290.t0 vss 3.70177e-15
Cpar14 a_794_1290.t10 vss 3.23335e-15
Cpar15 a_794_1290.t11 vss 1.07829e-14
Cpar16 a_794_1290.t2 vss 5.96013e-15
Cpar17 a_794_1810.t0 vss 3.20200e-17
Cpar18 a_794_2850.t0 vss 2.93600e-17
Cpar19 a_794_3890.t0 vss 2.93600e-17
Cpar20 a_794_4930.t0 vss 2.93600e-17
Cpar21 a_794_5970.t0 vss 3.00800e-17
Cpar22 a_794_7010.t0 vss 3.08200e-17
Cpar23 a_9012_7297.t0 vss 8.02299e-15
Cpar24 a_9012_7297.t8 vss 7.48560e-15
Cpar25 a_9012_7297.t9 vss 2.17631e-15
Cpar26 ib vss 2.36068e-14
Cpar27 ib.t0 vss 3.23855e-15
Cpar28 ib.t1 vss 3.35603e-16
Cpar29 inn inp 1.04260e-16
Cpar30 inn vdd 1.78088e-14
Cpar31 inn vss 4.81059e-15
Cpar32 inn.t0 vss 1.96943e-14
Cpar33 inp vdd 1.80934e-14
Cpar34 inp vss 4.85933e-15
Cpar35 inp.t0 vss 1.99278e-14
Cpar36 out vdd 1.71957e-14
Cpar37 out vss 2.84841e-14
Cpar38 out.t0 vss 3.87880e-15
Cpar39 out.t1 vss 2.12081e-14
Cpar40 out.t2 vss 1.20784e-14
Cpar41 vdd vss 2.57435e-13
Cpar42 vdd.t0 vss 7.22625e-14
Cpar43 vdd.t1 vss 1.44694e-14
Cpar44 vdd.t5 vss 5.02412e-14
.ends opamp_dut

Vdd vdd 0 3.300000
Vss vss 0 0
Ibias vdd ib 7.200000e-09
Vinp inp 0 DC 1.480000 AC 1 PWL(0 1.480000 3.903615e-06 1.480000 4.293977e-06 1.490000)
Rfb out inn 1m
Cload out 0 2.000000e-12
Xdut vdd vss inp inn out ib opamp_dut
.end
