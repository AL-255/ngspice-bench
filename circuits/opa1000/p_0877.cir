* opa1000[0877]: 2p/telescopic_nmos_1v8_i50n_subth (telescopic_nmos, VDD=1.8V, CL=2.0pF, Iref=0.0144uA)
.include "pdk_opa.inc"
.temp 27
.option gmin=1e-12 rshunt=1e12 reltol=1e-3 abstol=1e-12 vntol=1e-5 method=gear
* Post-PEX R+C extracted netlist for telescopic_nmos_1v8_i50n_subth
.subckt opamp_dut vdd vss inp inn out ib
XMpar0 ib.t1 ib.t0 vss.t10 vss.t9 nfet_03v3 w=0.4u l=4u ad=1.1200e-13 pd=9.6000e-07 as=1.1200e-13 ps=9.6000e-07 nf=1 m=2 par=2
XMpar1 a_1450_1204.t8 ib.t0 vss.t10 vss.t9 nfet_03v3 w=0.4u l=4u ad=1.1200e-13 pd=9.6000e-07 as=1.4400e-13 ps=1.2200e-06 nf=1 m=8 par=8
XMpar2 a_6820_8056.t0 a_4688_7848.t2 out.t0 vdd.t0 pfet_03v3 w=1.73u l=4.38u ad=7.6120e-13 pd=3.4750e-06 as=4.8440e-13 ps=2.2900e-06 nf=1 m=4 par=4
XMpar3 a_4568_8056.t1 a_4688_7848.t10 vdd.t2 vdd.t1 pfet_03v3 w=0.82u l=5.2u ad=4.9200e-13 pd=2.8400e-06 as=2.2960e-13 ps=1.3800e-06 nf=1 m=2 par=2
XMpar4 a_6820_8056.t3 a_4688_7848.t10 vdd.t2 vdd.t1 pfet_03v3 w=0.82u l=5.2u ad=2.2960e-13 pd=1.3800e-06 as=2.2960e-13 ps=1.3800e-06 nf=1 m=2 par=2
XMpar5 a_3220_1204.t8 vdd.t16 a_4688_7848.t0 vss.t5 nfet_03v3 w=0.75u l=4.38u ad=4.5000e-13 pd=2.7000e-06 as=2.1000e-13 ps=1.3100e-06 nf=1 m=2 par=2
XMpar6 a_1450_1204.t0 inn.t0 a_8814_10053.t2 vss.t1 nfet_03v3 w=7.9u l=8.25u ad=3.4760e-12 pd=1.2730e-05 as=2.2120e-12 ps=8.4600e-06 nf=1 m=8 par=8
XMpar7 a_4568_8056.t0 a_4688_7848.t2 a_4688_7848.t3 vdd.t0 pfet_03v3 w=1.73u l=4.38u ad=1.0380e-12 pd=4.6600e-06 as=4.8440e-13 ps=2.2900e-06 nf=1 m=4 par=4
XMpar8 a_1450_1204.t0 inp.t0 a_3220_1204.t0 vss.t1 nfet_03v3 w=7.9u l=8.25u ad=3.4760e-12 pd=1.2730e-05 as=2.2120e-12 ps=8.4600e-06 nf=1 m=8 par=8
XMpar9 a_8814_10053.t0 vdd.t16 out.t3 vss.t5 nfet_03v3 w=0.75u l=4.38u ad=4.5000e-13 pd=2.7000e-06 as=2.1000e-13 ps=1.3100e-06 nf=1 m=2 par=2
X13 out.t6 vss.t0 cap_mim_2f0fF c_width=7.75u c_length=7.75u
Rpar0 a_1450_1204.t0 a_1450_1204.t8 54.2465
Rpar1 a_3220_1204.t0 a_3220_1204.t8 58.1844
Rpar2 a_4568_8056.t0 a_4568_8056.t1 70.6772
Rpar3 a_4688_7848.t0 a_4688_7848.t10 135.6470
Rpar4 a_4688_7848.t0 a_4688_7848.t2 267.6188
Rpar5 a_4688_7848.t0 a_4688_7848.t3 148.4460
Rpar6 a_4688_7848.t10 a_4688_7848.t2 280.3067
Rpar7 a_4688_7848.t10 a_4688_7848.t3 155.4838
Rpar8 a_4688_7848.t2 a_4688_7848.t3 19.6680
Rpar9 a_6820_8056.t0 a_6820_8056.t3 70.9114
Rpar10 a_8814_10053.t0 a_8814_10053.t2 58.1844
Rpar11 ib ib.t0 10.9492
Rpar12 ib ib.t1 17.7214
Rpar13 inn inn.t0 2.6741
Rpar14 inp inp.t0 2.6741
Rpar15 out out.t0 7.9013
Rpar16 out out.t3 151.9121
Rpar17 out out.t6 337.9632
Rpar18 out.t0 out.t3 153.2901
Rpar19 out.t0 out.t6 341.0288
Rpar20 out.t3 out.t6 106.3151
Rpar21 vdd vdd.t0 1754.6628
Rpar22 vdd vdd.t1 468.6800
Rpar23 vdd vdd.t2 830.8752
Rpar24 vdd vdd.t16 126.6369
Rpar25 vdd.t0 vdd.t1 101.8294
Rpar26 vdd.t0 vdd.t2 180.5230
Rpar27 vdd.t0 vdd.t16 393.8083
Rpar28 vdd.t1 vdd.t2 14.3595
Rpar29 vdd.t1 vdd.t16 105.1884
Rpar30 vdd.t2 vdd.t16 186.4778
Rpar31 vss vss.t0 1462.9484
Rpar32 vss vss.t1 82.2501
Rpar33 vss vss.t10 1885.4627
Rpar34 vss vss.t9 522.0121
Rpar35 vss vss.t5 643.5574
Rpar36 vss.t0 vss.t1 690.8256
Rpar37 vss.t0 vss.t10 394.8925
Rpar38 vss.t0 vss.t9 119.9352
Rpar39 vss.t0 vss.t5 153.2257
Rpar40 vss.t1 vss.t10 812.3555
Rpar41 vss.t1 vss.t9 224.9926
Rpar42 vss.t1 vss.t5 279.4028
Rpar43 vss.t10 vss.t9 10.4169
Rpar44 vss.t10 vss.t5 14.3985
Rpar45 vss.t9 vss.t5 3.3370
Cpar0 a_1450_1204.t0 vss 3.08175e-14
Cpar1 a_1450_1204.t8 vss 4.85263e-15
Cpar2 a_3220_1204.t0 vss 1.70260e-14
Cpar3 a_3220_1204.t8 vss 3.48300e-15
Cpar4 a_4568_8056.t0 vss 1.12149e-14
Cpar5 a_4568_8056.t1 vss 7.00384e-15
Cpar6 a_4688_7848.t0 vss 3.37061e-15
Cpar7 a_4688_7848.t10 vss 1.34086e-14
Cpar8 a_4688_7848.t2 vss 2.56098e-14
Cpar9 a_4688_7848.t3 vss 6.18215e-15
Cpar10 a_6820_8056.t0 vss 1.35828e-14
Cpar11 a_6820_8056.t3 vss 7.30163e-15
Cpar12 a_8814_10053.t0 vss 3.15301e-15
Cpar13 a_8814_10053.t2 vss 1.54129e-14
Cpar14 ib out 2.04990e-16
Cpar15 ib vdd 1.88930e-16
Cpar16 ib vss 2.84965e-14
Cpar17 ib.t0 vss 3.96770e-15
Cpar18 ib.t1 vss 2.23478e-16
Cpar19 inn inp 1.05020e-16
Cpar20 inn vdd 1.41200e-17
Cpar21 inn vss 2.95604e-14
Cpar22 inn.t0 vss 1.29612e-14
Cpar23 inp vdd 1.27900e-17
Cpar24 inp vss 2.92202e-14
Cpar25 inp.t0 vss 1.30072e-14
Cpar26 out vdd 5.54981e-15
Cpar27 out vss 1.16083e-14
Cpar28 out.t0 vss 1.18814e-15
Cpar29 out.t3 vss 1.36711e-15
Cpar30 out.t6 vss 8.85794e-15
Cpar31 vdd vss 1.15958e-13
Cpar32 vdd.t0 vss 2.41889e-14
Cpar33 vdd.t1 vss 8.30405e-15
Cpar34 vdd.t16 vss 3.71932e-15
Cpar35 vdd.t2 vss 4.71417e-15
.ends opamp_dut

Vdd vdd 0 1.800000
Vss vss 0 0
Ibias vdd ib 1.440000e-08
Vinp inp 0 DC 0.931000 AC 1 PWL(0 0.931000 1.765841e-06 0.931000 1.942425e-06 0.941000)
Rfb out inn 1m
Cload out 0 2.000000e-12
Xdut vdd vss inp inn out ib opamp_dut
.end
