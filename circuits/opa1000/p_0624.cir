* opa1000[0624]: 200f/pmos_miller_3v3_i500u_weak (pmos_miller, VDD=3.3V, CL=0.2pF, Iref=53.125uA)
.include "pdk_opa.inc"
.temp 27
.option gmin=1e-12 rshunt=1e12 reltol=1e-3 abstol=1e-12 vntol=1e-5 method=gear
* Post-PEX R+C extracted netlist for pmos_miller_3v3_i500u_weak
.subckt opamp_dut vdd vss inp inn out ib
XMpar0 a_1588_1205.t176 a_1452_996.t16 vdd.t60 vdd.t59 pfet_03v3 w=7.08u l=0.68u ad=1.9824e-12 pd=7.6400e-06 as=2.2656e-12 ps=8.6050e-06 nf=1 m=32 par=32
XMpar1 a_1096_6644.t1 inp.t0 a_1588_1205.t0 vdd.t0 pfet_03v3 w=2.01u l=0.36u ad=5.7742e-13 pd=2.6302e-06 as=5.9204e-13 ps=2.6905e-06 nf=1 m=88 par=88
XMpar2 out a_1096_6644.t105 vss.t0 vss.t0 nfet_03v3 w=1.95u l=0.4u ad=5.4600e-13 pd=2.5100e-06 as=5.6160e-13 ps=2.5747e-06 nf=1 m=80 par=80
XMpar3 a_1588_1205.t0 inn.t0 a_5844_12742.t0 vdd.t0 pfet_03v3 w=2.01u l=0.36u ad=5.9204e-13 pd=2.6905e-06 as=5.7742e-13 ps=2.6302e-06 nf=1 m=88 par=88
XMpar4 out.t8 a_1452_996.t16 vdd.t60 vdd.t59 pfet_03v3 w=7.08u l=0.68u ad=1.9824e-12 pd=7.6400e-06 as=1.9824e-12 ps=7.6400e-06 nf=1 m=80 par=80
XMpar5 a_1452_996.t0 ib.t0 vss.t21 vss.t0 nfet_03v3 w=1.79u l=0.68u ad=5.0120e-13 pd=2.3500e-06 as=5.7280e-13 ps=2.6537e-06 nf=1 m=16 par=16
XMpar6 ib.t1 ib.t0 vss.t21 vss.t0 nfet_03v3 w=1.79u l=0.68u ad=5.0120e-13 pd=2.3500e-06 as=5.7280e-13 ps=2.6537e-06 nf=1 m=16 par=16
XMpar7 a_5844_12742.t89 a_5844_12742.t88 vss.t0 vss.t0 nfet_03v3 w=1.95u l=0.4u ad=5.4600e-13 pd=2.5100e-06 as=5.4600e-13 ps=2.5100e-06 nf=1 m=16 par=16
XMpar8 a_1096_6644.t89 a_5844_12742.t88 vss.t0 vss.t0 nfet_03v3 w=1.95u l=0.4u ad=5.4600e-13 pd=2.5100e-06 as=6.2400e-13 ps=2.8337e-06 nf=1 m=16 par=16
XMpar9 a_1452_996.t17 a_1452_996.t16 vdd.t60 vdd.t59 pfet_03v3 w=7.08u l=0.68u ad=1.9824e-12 pd=7.6400e-06 as=2.2656e-12 ps=8.6050e-06 nf=1 m=16 par=16
X408 a_1096_6644.t0 a_5820_11450.t0 vss.t78 ppolyf_u_1k r_width=1u r_length=1u
X414 a_5820_11450.t1 out.t17 cap_mim_2f0fF c_width=17.5u c_length=17.5u
Rpar0 a_1096_6644.t0 a_1096_6644.t1 400.4375
Rpar1 a_1096_6644.t0 a_1096_6644.t89 71.0350
Rpar2 a_1096_6644.t0 a_1096_6644.t105 612.7430
Rpar3 a_1096_6644.t1 a_1096_6644.t89 110.5825
Rpar4 a_1096_6644.t1 a_1096_6644.t105 99.5693
Rpar5 a_1096_6644.t89 a_1096_6644.t105 169.2115
Rpar6 a_1452_996.t0 a_1452_996.t16 87.7560
Rpar7 a_1452_996.t0 a_1452_996.t17 39.7847
Rpar8 a_1452_996.t16 a_1452_996.t17 15.2412
Rpar9 a_1588_1205.t0 a_1588_1205.t176 62.5900
Rpar10 a_5820_11450.t0 a_5820_11450.t1 56.3979
Rpar11 a_5844_12742.t0 a_5844_12742.t88 1340.3672
Rpar12 a_5844_12742.t0 a_5844_12742.t89 59.6295
Rpar13 a_5844_12742.t88 a_5844_12742.t89 14.4387
Rpar14 ib ib.t0 11.2655
Rpar15 ib ib.t1 3.3306
Rpar16 ib.t0 ib.t1 16.5676
Rpar17 inn inn.t0 1.9078
Rpar18 inp inp.t0 1.9078
Rpar19 out out.t8 42.1107
Rpar20 out out.t17 88.2076
Rpar21 out.t8 out.t17 64.4479
Rpar22 vdd vdd.t0 20.7496
Rpar23 vdd vdd.t59 210.1808
Rpar24 vdd vdd.t60 1743.3404
Rpar25 vdd.t0 vdd.t59 76.6430
Rpar26 vdd.t0 vdd.t60 635.7137
Rpar27 vdd.t59 vdd.t60 3.1536
Rpar28 vss vss.t0 40.9999
Rpar29 vss vss.t21 829.4915
Rpar30 vss vss.t78 6320.4883
Rpar31 vss.t0 vss.t21 7.6760
Rpar32 vss.t0 vss.t78 26.2260
Rpar33 vss.t21 vss.t78 1004.1115
Cpar0 a_1096_6644.t0 vss 2.52341e-15
Cpar1 a_1096_6644.t1 vss 3.99397e-14
Cpar2 a_1096_6644.t105 vss 3.23336e-14
Cpar3 a_1096_6644.t89 vss 1.14643e-14
Cpar4 a_1452_996.t0 vss 8.41829e-15
Cpar5 a_1452_996.t16 vss 1.22236e-13
Cpar6 a_1452_996.t17 vss 1.76362e-14
Cpar7 a_1588_1205.t0 vss 1.20664e-13
Cpar8 a_1588_1205.t176 vss 7.99544e-14
Cpar9 a_5820_11450.t0 vss 4.54400e-17
Cpar10 a_5820_11450.t1 vss 2.97840e-15
Cpar11 a_5844_12742.t0 vss 5.06562e-14
Cpar12 a_5844_12742.t88 vss 1.54337e-14
Cpar13 a_5844_12742.t89 vss 1.39526e-14
Cpar14 ib vdd 1.82680e-16
Cpar15 ib vss 3.36209e-14
Cpar16 ib.t0 vss 5.07047e-15
Cpar17 ib.t1 vss 1.54937e-15
Cpar18 inn inp 1.07450e-16
Cpar19 inn vdd 2.71923e-14
Cpar20 inn vss 8.76405e-15
Cpar21 inn.t0 vss 3.72909e-14
Cpar22 inp vdd 2.71167e-14
Cpar23 inp vss 8.76525e-15
Cpar24 inp.t0 vss 3.72347e-14
Cpar25 out vdd 9.00805e-14
Cpar26 out vss 9.21504e-14
Cpar27 out.t17 vss 1.25161e-14
Cpar28 out.t8 vss 8.85517e-14
Cpar29 vdd vss 4.58618e-13
Cpar30 vdd.t0 vss 9.21323e-14
Cpar31 vdd.t59 vss 1.76281e-13
Cpar32 vdd.t60 vss 5.67364e-14
.ends opamp_dut

Vdd vdd 0 3.300000
Vss vss 0 0
Ibias vdd ib 5.312500e-05
Vinp inp 0 DC 1.480000 AC 1 PWL(0 1.480000 3.000000e-09 1.480000 3.300000e-09 1.490000)
Rfb out inn 1m
Cload out 0 2.000000e-13
Xdut vdd vss inp inn out ib opamp_dut
.end
