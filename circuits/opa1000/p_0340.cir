* opa1000[0340]: 200f/nmos_5t_1v8_i1u_subth (nmos_5t, VDD=1.8V, CL=0.2pF, Iref=0.2625uA)
.include "pdk_opa.inc"
.temp 27
.option gmin=1e-12 rshunt=1e12 reltol=1e-3 abstol=1e-12 vntol=1e-5 method=gear
* Post-PEX R+C extracted netlist for nmos_5t_1v8_i1u_subth
.subckt opamp_dut vdd vss inp inn out ib
XMpar0 out.t0 a_2090_4510.t0 vdd.t1 vdd.t0 pfet_03v3 w=1.76u l=2.93u ad=4.9280e-13 pd=2.3200e-06 as=4.9280e-13 ps=2.3200e-06 nf=1 m=8 par=8
XMpar1 a_1554_4510.t0 inn.t0 out.t1 vss.t0 nfet_03v3 w=1.89u l=2.08u ad=6.8040e-13 pd=3.0825e-06 as=5.2920e-13 ps=2.4500e-06 nf=1 m=24 par=24
XMpar2 a_1554_4510.t48 ib.t0 vss.t17 vss.t16 nfet_03v3 w=1.34u l=3.5u ad=3.7520e-13 pd=1.9000e-06 as=6.9680e-13 ps=3.3850e-06 nf=1 m=8 par=8
XMpar3 a_1554_4510.t0 inp.t0 a_2090_4510.t16 vss.t0 nfet_03v3 w=1.89u l=2.08u ad=6.8040e-13 pd=3.0825e-06 as=5.2920e-13 ps=2.4500e-06 nf=1 m=24 par=24
XMpar4 a_2090_4510.t1 a_2090_4510.t0 vdd.t1 vdd.t0 pfet_03v3 w=1.76u l=2.93u ad=4.9280e-13 pd=2.3200e-06 as=7.7440e-13 ps=3.5200e-06 nf=1 m=8 par=8
XMpar5 ib.t1 ib.t0 vss.t17 vss.t16 nfet_03v3 w=1.34u l=3.5u ad=8.0400e-13 pd=3.8800e-06 as=3.7520e-13 ps=1.9000e-06 nf=1 m=2 par=2
X60 out.t32 vss.t31 cap_mim_2f0fF c_width=7.99u c_length=7.99u
Rpar0 a_1554_4510.t0 a_1554_4510.t48 41.0626
Rpar1 a_2090_4510.t0 a_2090_4510.t1 8.9132
Rpar2 a_2090_4510.t0 a_2090_4510.t16 111.9035
Rpar3 a_2090_4510.t1 a_2090_4510.t16 57.7799
Rpar4 ib ib.t0 12.9458
Rpar5 ib ib.t1 11.5397
Rpar6 ib.t0 ib.t1 30.0131
Rpar7 inn inn.t0 1.5798
Rpar8 inp inp.t0 1.5798
Rpar9 out out.t0 5.1468
Rpar10 out out.t1 89.6304
Rpar11 out out.t32 106.0042
Rpar12 out.t1 out.t32 113.2400
Rpar13 vdd vdd.t0 21.7443
Rpar14 vdd vdd.t1 239.5805
Rpar15 vdd.t0 vdd.t1 11.5874
Rpar16 vss vss.t0 98.7963
Rpar17 vss vss.t16 207.1353
Rpar18 vss vss.t17 66.8046
Rpar19 vss vss.t31 104.4227
Rpar20 vss.t0 vss.t16 1.6671
Rpar21 vss.t0 vss.t17 16.9307
Rpar22 vss.t0 vss.t31 213.9678
Rpar23 vss.t16 vss.t17 38.9877
Rpar24 vss.t16 vss.t31 459.2134
Rpar25 vss.t17 vss.t31 85.9993
Cpar0 a_1554_4510.t0 vss 3.15352e-14
Cpar1 a_1554_4510.t48 vss 7.03150e-15
Cpar2 a_2090_4510.t0 vss 3.70646e-14
Cpar3 a_2090_4510.t1 vss 8.86142e-15
Cpar4 a_2090_4510.t16 vss 1.89979e-14
Cpar5 ib inn 2.19900e-17
Cpar6 ib inp 1.34900e-17
Cpar7 ib vss 2.99208e-14
Cpar8 ib.t0 vss 4.70049e-15
Cpar9 ib.t1 vss 4.19799e-16
Cpar10 inn inp 1.55930e-16
Cpar11 inn out 7.18935e-15
Cpar12 inn vdd 1.52300e-17
Cpar13 inn vss 2.38961e-14
Cpar14 inn.t0 vss 1.12793e-14
Cpar15 inp out 2.83600e-16
Cpar16 inp vdd 1.51200e-17
Cpar17 inp vss 2.37703e-14
Cpar18 inp.t0 vss 1.13318e-14
Cpar19 out vdd 8.72625e-15
Cpar20 out vss 2.16474e-14
Cpar21 out.t0 vss 2.93765e-15
Cpar22 out.t1 vss 1.27888e-14
Cpar23 out.t32 vss 1.73893e-14
Cpar24 vdd vss 7.95885e-14
Cpar25 vdd.t0 vss 3.29614e-14
Cpar26 vdd.t1 vss 5.14765e-15
.ends opamp_dut

Vdd vdd 0 1.800000
Vss vss 0 0
Ibias vdd ib 2.625000e-07
Vinp inp 0 DC 0.895000 AC 1 PWL(0 0.895000 2.668498e-08 0.895000 2.935348e-08 0.905000)
Rfb out inn 1m
Cload out 0 2.000000e-13
Xdut vdd vss inp inn out ib opamp_dut
.end
