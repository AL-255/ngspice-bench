* opa1000[0256]: 200f/folded_cascode_pmos_1v8_0p1u_1u_weak (folded_cascode_pmos, VDD=1.8V, CL=0.2pF, Iref=0.0778uA)
.include "pdk_opa.inc"
.temp 27
.option gmin=1e-12 rshunt=1e12 reltol=1e-3 abstol=1e-12 vntol=1e-5 method=gear
* Post-PEX R+C extracted netlist for folded_cascode_pmos_1v8_0p1u_1u_weak
.subckt opamp_dut vdd vss inp inn out ib
XMpar0 ib.t1 ib.t0 vss.t2 vss.t1 nfet_03v3 w=0.4u l=7.5u ad=2.4000e-13 pd=2.0000e-06 as=1.1200e-13 ps=9.6000e-07 nf=1 m=2 par=2
XMpar1 a_4974_6828.t0 ib.t0 vss.t2 vss.t1 nfet_03v3 w=0.4u l=7.5u ad=1.1200e-13 pd=9.6000e-07 as=2.4000e-13 ps=2.0000e-06 nf=1 m=4 par=4
XMpar2 a_1480_5063.t0 a_1618_9635.t6 a_3054_1205.t0 vss.t0 nfet_03v3 w=0.5u l=2u ad=1.4000e-13 pd=1.0600e-06 as=3.0000e-13 ps=2.2000e-06 nf=1 m=2 par=2
XMpar3 a_3054_1205.t3 ib.t0 vss.t2 vss.t1 nfet_03v3 w=0.4u l=7.5u ad=1.1200e-13 pd=9.6000e-07 as=2.4000e-13 ps=2.0000e-06 nf=1 m=4 par=4
XMpar4 out.t0 a_1480_5063.t2 vdd.t1 vdd.t0 pfet_03v3 w=1.15u l=8.13u ad=3.2200e-13 pd=1.7100e-06 as=3.2200e-13 ps=1.7100e-06 nf=1 m=2 par=2
XMpar5 a_1498_9843.t2 inp.t0 a_3054_1205.t1 vdd.t13 pfet_03v3 w=1.04u l=4u ad=6.2400e-13 pd=3.2800e-06 as=2.9120e-13 ps=1.6000e-06 nf=1 m=2 par=2
XMpar6 a_4974_6828.t6 a_1618_9635.t6 out.t2 vss.t0 nfet_03v3 w=0.5u l=2u ad=3.0000e-13 pd=2.2000e-06 as=1.4000e-13 ps=1.0600e-06 nf=1 m=2 par=2
XMpar7 a_1498_9843.t0 a_1618_9635.t2 vdd.t1 vdd.t0 pfet_03v3 w=1.15u l=8.13u ad=6.9000e-13 pd=3.5000e-06 as=5.0600e-13 ps=2.6050e-06 nf=1 m=4 par=4
XMpar8 a_1618_9635.t3 a_1618_9635.t2 vdd.t1 vdd.t0 pfet_03v3 w=1.15u l=8.13u ad=6.9000e-13 pd=3.5000e-06 as=3.2200e-13 ps=1.7100e-06 nf=1 m=2 par=2
XMpar9 a_1480_5063.t3 a_1480_5063.t2 vdd.t1 vdd.t0 pfet_03v3 w=1.15u l=8.13u ad=6.9000e-13 pd=3.5000e-06 as=3.2200e-13 ps=1.7100e-06 nf=1 m=2 par=2
XMpar10 a_1498_9843.t2 inn.t0 a_4974_6828.t4 vdd.t13 pfet_03v3 w=1.04u l=4u ad=6.2400e-13 pd=3.2800e-06 as=2.9120e-13 ps=1.6000e-06 nf=1 m=2 par=2
XMpar11 a_1618_9635.t0 ib.t0 vss.t2 vss.t1 nfet_03v3 w=0.4u l=7.5u ad=1.1200e-13 pd=9.6000e-07 as=1.1200e-13 ps=9.6000e-07 nf=1 m=2 par=2
Rpar0 a_1480_5063.t0 a_1480_5063.t2 155.6506
Rpar1 a_1480_5063.t0 a_1480_5063.t3 94.4009
Rpar2 a_1480_5063.t2 a_1480_5063.t3 20.4855
Rpar3 a_1498_9843.t0 a_1498_9843.t2 60.5825
Rpar4 a_1618_9635.t0 a_1618_9635.t2 519.2689
Rpar5 a_1618_9635.t0 a_1618_9635.t3 393.3874
Rpar6 a_1618_9635.t0 a_1618_9635.t6 92.9592
Rpar7 a_1618_9635.t2 a_1618_9635.t3 14.8029
Rpar8 a_1618_9635.t2 a_1618_9635.t6 171.7639
Rpar9 a_1618_9635.t3 a_1618_9635.t6 130.1247
Rpar10 a_3054_1205.t0 a_3054_1205.t1 65.2728
Rpar11 a_3054_1205.t0 a_3054_1205.t3 108.1904
Rpar12 a_3054_1205.t1 a_3054_1205.t3 132.7466
Rpar13 a_4974_6828.t0 a_4974_6828.t4 107.2764
Rpar14 a_4974_6828.t0 a_4974_6828.t6 90.6869
Rpar15 a_4974_6828.t4 a_4974_6828.t6 84.7603
Rpar16 ib ib.t0 8.8946
Rpar17 ib ib.t1 9.0001
Rpar18 inn inn.t0 3.5899
Rpar19 inp inp.t0 3.6385
Rpar20 out out.t0 14.3167
Rpar21 out out.t2 54.1038
Rpar22 vdd vdd.t0 24.0819
Rpar23 vdd vdd.t1 160.9794
Rpar24 vdd vdd.t13 63.2938
Rpar25 vdd.t0 vdd.t1 7.1440
Rpar26 vdd.t0 vdd.t13 62.8159
Rpar27 vdd.t1 vdd.t13 161.1552
Rpar28 vss vss.t0 287.1697
Rpar29 vss vss.t1 52.8843
Rpar30 vss vss.t2 185.4944
Rpar31 vss.t0 vss.t1 87.2904
Rpar32 vss.t0 vss.t2 302.8304
Rpar33 vss.t1 vss.t2 5.1811
Cpar0 a_1480_5063.t0 vss 2.19582e-15
Cpar1 a_1480_5063.t2 vss 1.98793e-14
Cpar2 a_1480_5063.t3 vss 4.84301e-15
Cpar3 a_1498_9843.t0 vss 1.62803e-14
Cpar4 a_1498_9843.t2 vss 7.96988e-15
Cpar5 a_1618_9635.t0 vss 4.74312e-15
Cpar6 a_1618_9635.t2 vss 3.08527e-14
Cpar7 a_1618_9635.t3 vss 6.56601e-15
Cpar8 a_1618_9635.t6 vss 7.63081e-15
Cpar9 a_3054_1205.t0 vss 2.26361e-15
Cpar10 a_3054_1205.t1 vss 2.11632e-15
Cpar11 a_3054_1205.t3 vss 4.05716e-15
Cpar12 a_4974_6828.t0 vss 5.18227e-15
Cpar13 a_4974_6828.t4 vss 2.28201e-15
Cpar14 a_4974_6828.t6 vss 2.52224e-15
Cpar15 ib vdd 9.67200e-17
Cpar16 ib vss 5.08843e-14
Cpar17 ib.t0 vss 6.67699e-15
Cpar18 ib.t1 vss 1.09690e-16
Cpar19 inn inp 5.19700e-17
Cpar20 inn vdd 4.03653e-15
Cpar21 inn vss 2.29703e-15
Cpar22 inn.t0 vss 2.73246e-15
Cpar23 inp vdd 3.93928e-15
Cpar24 inp vss 2.23377e-15
Cpar25 inp.t0 vss 2.70346e-15
Cpar26 out vdd 4.67550e-15
Cpar27 out vss 9.27746e-15
Cpar28 out.t0 vss 1.18467e-15
Cpar29 out.t2 vss 2.47497e-15
Cpar30 vdd vss 1.36520e-13
Cpar31 vdd.t0 vss 5.02435e-14
Cpar32 vdd.t1 vss 1.34148e-14
Cpar33 vdd.t13 vss 1.30799e-14
.ends opamp_dut

Vdd vdd 0 1.800000
Vss vss 0 0
Ibias vdd ib 7.780000e-08
Vinp inp 0 DC 0.751000 AC 1 PWL(0 0.751000 1.358781e-07 0.751000 1.494659e-07 0.761000)
Rfb out inn 1m
Cload out 0 2.000000e-13
Xdut vdd vss inp inn out ib opamp_dut
.end
