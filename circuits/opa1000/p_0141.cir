* opa1000[0141]: 2p/current_reuse_1v8_10u_100u_weak (current_reuse, VDD=1.8V, CL=2.0pF, Iref=5.0uA)
.include "pdk_opa.inc"
.temp 27
.option gmin=1e-12 rshunt=1e12 reltol=1e-3 abstol=1e-12 vntol=1e-5 method=gear
* Post-PEX R+C extracted netlist for current_reuse_1v8_10u_100u_weak
.subckt opamp_dut vdd vss inp inn out ib
XMpar0 a_4763_3877.t4 inn.t0 a_4889_4085.t0 vdd.t2 pfet_03v3 w=1.88u l=0.35u ad=5.2640e-13 pd=2.4400e-06 as=7.2693e-13 ps=3.2800e-06 nf=1 m=6 par=6
XMpar1 a_4763_3877.t11 a_4763_3877.t10 vdd.t1 vdd.t0 pfet_03v3 w=5.83u l=0.63u ad=3.4980e-12 pd=1.2860e-05 as=1.6324e-12 ps=6.3900e-06 nf=1 m=1
XMpar2 a_2755_10038.t4 ib.t0 vss.t5 vss.t4 nfet_03v3 w=2.76u l=1.25u ad=7.7280e-13 pd=3.3200e-06 as=7.7280e-13 ps=3.3200e-06 nf=1 m=4 par=4
XMpar3 a_2755_10038.t0 inn.t6 a_4763_3877.t0 vss.t0 nfet_03v3 w=1.58u l=0.35u ad=6.9520e-13 pd=3.2500e-06 as=4.4240e-13 ps=2.1400e-06 nf=1 m=4 par=4
XMpar4 a_1078_1041.t2 inp.t0 a_4889_4085.t0 vdd.t2 pfet_03v3 w=1.88u l=0.35u ad=5.2640e-13 pd=2.4400e-06 as=7.2693e-13 ps=3.2800e-06 nf=1 m=6 par=6
XMpar5 out.t3 a_1078_1041.t12 vdd.t1 vdd.t0 pfet_03v3 w=5.83u l=0.63u ad=1.6324e-12 pd=6.3900e-06 as=2.0055e-12 ps=7.6840e-06 nf=1 m=10 par=10
XMpar6 a_1078_1041.t10 a_4763_3877.t10 vdd.t1 vdd.t0 pfet_03v3 w=5.83u l=0.63u ad=3.4980e-12 pd=1.2860e-05 as=1.6324e-12 ps=6.3900e-06 nf=1 m=1
XMpar7 a_1078_1041.t0 inp.t6 a_2755_10038.t0 vss.t0 nfet_03v3 w=1.58u l=0.35u ad=4.4240e-13 pd=2.1400e-06 as=6.9520e-13 ps=3.2500e-06 nf=1 m=4 par=4
XMpar8 out.t0 ib.t0 vss.t5 vss.t4 nfet_03v3 w=2.76u l=1.25u ad=9.4944e-13 pd=4.0000e-06 as=7.7280e-13 ps=3.3200e-06 nf=1 m=10 par=10
XMpar9 a_4889_4085.t12 a_4763_3877.t10 vdd.t1 vdd.t0 pfet_03v3 w=5.83u l=0.63u ad=1.6324e-12 pd=6.3900e-06 as=3.4980e-12 ps=1.2860e-05 nf=1 m=2 par=2
XMpar10 ib.t1 ib.t0 vss.t5 vss.t4 nfet_03v3 w=2.76u l=1.25u ad=7.7280e-13 pd=3.3200e-06 as=7.7280e-13 ps=3.3200e-06 nf=1 m=2 par=2
X0 a_6157_8538.t1 out.t6 cap_mim_2f0fF c_width=17.1u c_length=17.11u
X8 a_1078_1041.t11 a_6157_8538.t0 vss.t40 ppolyf_u_1k r_width=1u r_length=6u
X36 a_6157_8538.t1 out.t6 cap_mim_2f0fF c_width=17.1u c_length=17.11u
X45 a_6157_8538.t1 out.t6 cap_mim_2f0fF c_width=17.1u c_length=17.11u
Rpar0 a_1078_1041.t0 a_1078_1041.t10 383.3252
Rpar1 a_1078_1041.t0 a_1078_1041.t11 70.4813
Rpar2 a_1078_1041.t0 a_1078_1041.t12 617.4578
Rpar3 a_1078_1041.t0 a_1078_1041.t2 80.6628
Rpar4 a_1078_1041.t10 a_1078_1041.t11 561.8028
Rpar5 a_1078_1041.t10 a_1078_1041.t12 89.9503
Rpar6 a_1078_1041.t10 a_1078_1041.t2 173.1310
Rpar7 a_1078_1041.t11 a_1078_1041.t12 904.9484
Rpar8 a_1078_1041.t11 a_1078_1041.t2 118.2198
Rpar9 a_1078_1041.t12 a_1078_1041.t2 278.8783
Rpar10 a_2755_10038.t0 a_2755_10038.t4 80.4840
Rpar11 a_4763_3877.t0 a_4763_3877.t10 342.9082
Rpar12 a_4763_3877.t0 a_4763_3877.t11 210.5954
Rpar13 a_4763_3877.t0 a_4763_3877.t4 60.6536
Rpar14 a_4763_3877.t10 a_4763_3877.t11 46.0212
Rpar15 a_4763_3877.t10 a_4763_3877.t4 205.8249
Rpar16 a_4763_3877.t11 a_4763_3877.t4 126.4063
Rpar17 a_4889_4085.t0 a_4889_4085.t12 37.1546
Rpar18 a_6157_8538.t0 a_6157_8538.t1 83.6400
Rpar19 ib ib.t0 22.5719
Rpar20 ib ib.t1 11.2704
Rpar21 ib.t0 ib.t1 61.5046
Rpar22 inn inn.t0 48.4028
Rpar23 inn inn.t6 12.8589
Rpar24 inp inp.t0 48.3542
Rpar25 inp inp.t6 12.9075
Rpar26 out out.t0 2.2185
Rpar27 out out.t3 635.7318
Rpar28 out out.t6 452.9509
Rpar29 out.t0 out.t3 210.4988
Rpar30 out.t0 out.t6 149.9778
Rpar31 out.t3 out.t6 147.9715
Rpar32 vdd vdd.t0 131.5605
Rpar33 vdd vdd.t1 138.4287
Rpar34 vdd vdd.t2 190.4467
Rpar35 vdd.t0 vdd.t1 3.2791
Rpar36 vdd.t0 vdd.t2 66.5508
Rpar37 vdd.t1 vdd.t2 74.3009
Rpar38 vss vss.t0 104.3146
Rpar39 vss vss.t4 311.3661
Rpar40 vss vss.t5 2609.5584
Rpar41 vss vss.t40 2989.5403
Rpar42 vss.t0 vss.t4 14.6578
Rpar43 vss.t0 vss.t5 100.7351
Rpar44 vss.t0 vss.t40 133.9143
Rpar45 vss.t4 vss.t5 4.5934
Rpar46 vss.t4 vss.t40 3.3911
Rpar47 vss.t5 vss.t40 38.7059
Cpar0 a_1078_1041.t0 vss 2.61349e-15
Cpar1 a_1078_1041.t10 vss 4.40745e-15
Cpar2 a_1078_1041.t11 vss 2.07432e-15
Cpar3 a_1078_1041.t12 vss 1.09175e-14
Cpar4 a_1078_1041.t2 vss 4.42364e-15
Cpar5 a_2755_10038.t0 vss 6.67012e-15
Cpar6 a_2755_10038.t4 vss 1.01357e-14
Cpar7 a_4763_3877.t0 vss 3.39468e-15
Cpar8 a_4763_3877.t10 vss 6.09106e-15
Cpar9 a_4763_3877.t11 vss 6.54933e-15
Cpar10 a_4763_3877.t4 vss 6.18287e-15
Cpar11 a_4889_4085.t0 vss 1.00469e-14
Cpar12 a_4889_4085.t12 vss 4.09351e-15
Cpar13 a_6157_8538.t0 vss 1.39730e-16
Cpar14 a_6157_8538.t1 vss 1.02188e-14
Cpar15 ib out 1.55306e-15
Cpar16 ib vdd 1.56510e-16
Cpar17 ib vss 2.03584e-14
Cpar18 ib.t0 vss 4.08681e-15
Cpar19 ib.t1 vss 3.36843e-16
Cpar20 inn inp 1.04210e-16
Cpar21 inn vdd 2.84095e-15
Cpar22 inn vss 5.45460e-15
Cpar23 inn.t0 vss 2.69195e-15
Cpar24 inn.t6 vss 5.35982e-16
Cpar25 inp out 1.14800e-17
Cpar26 inp vdd 2.67142e-15
Cpar27 inp vss 4.94461e-15
Cpar28 inp.t0 vss 2.84781e-15
Cpar29 inp.t6 vss 5.70715e-16
Cpar30 out vdd 1.17654e-14
Cpar31 out vss 2.08167e-14
Cpar32 out.t0 vss 4.00580e-15
Cpar33 out.t3 vss 6.03909e-15
Cpar34 out.t6 vss 1.92721e-14
Cpar35 vdd vss 8.74378e-14
Cpar36 vdd.t0 vss 1.52701e-14
Cpar37 vdd.t1 vss 1.26155e-14
Cpar38 vdd.t2 vss 9.00256e-15
.ends opamp_dut

Vdd vdd 0 1.800000
Vss vss 0 0
Ibias vdd ib 5.000000e-06
Vinp inp 0 DC 0.895000 AC 1 PWL(0 0.895000 8.676073e-09 0.895000 9.543681e-09 0.905000)
Rfb out inn 1m
Cload out 0 2.000000e-12
Xdut vdd vss inp inn out ib opamp_dut
.end
