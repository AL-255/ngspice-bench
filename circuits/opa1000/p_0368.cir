* opa1000[0368]: 200f/nmos_5t_3v3_i20u_subth (nmos_5t, VDD=3.3V, CL=0.2pF, Iref=5.0uA)
.include "pdk_opa.inc"
.temp 27
.option gmin=1e-12 rshunt=1e12 reltol=1e-3 abstol=1e-12 vntol=1e-5 method=gear
* Post-PEX R+C extracted netlist for nmos_5t_3v3_i20u_subth
.subckt opamp_dut vdd vss inp inn out ib
XMpar0 a_1402_5812.t0 inp.t0 a_1718_5812.t108 vss.t0 nfet_03v3 w=8u l=0.98u ad=2.4000e-12 pd=9.1000e-06 as=2.3200e-12 ps=8.8300e-06 nf=1 m=64 par=64
XMpar1 a_1402_5812.t0 inn.t0 out.t8 vss.t0 nfet_03v3 w=8u l=0.98u ad=2.4000e-12 pd=9.1000e-06 as=2.3200e-12 ps=8.8300e-06 nf=1 m=64 par=64
XMpar2 out.t0 a_1718_5812.t0 vdd.t1 vdd.t0 pfet_03v3 w=1.95u l=1.35u ad=6.1533e-13 pd=2.7978e-06 as=5.4600e-13 ps=2.5100e-06 nf=1 m=54 par=54
XMpar3 a_1718_5812.t1 a_1718_5812.t0 vdd.t1 vdd.t0 pfet_03v3 w=1.95u l=1.35u ad=5.4600e-13 pd=2.5100e-06 as=5.4600e-13 ps=2.5100e-06 nf=1 m=54 par=54
XMpar4 a_1402_5812.t64 ib.t0 vss.t44 vss.t0 nfet_03v3 w=9.88u l=1.5u ad=2.7664e-12 pd=1.0440e-05 as=3.5568e-12 ps=1.3070e-05 nf=1 m=8 par=8
XMpar5 ib.t1 ib.t0 vss.t44 vss.t0 nfet_03v3 w=9.88u l=1.5u ad=2.7664e-12 pd=1.0440e-05 as=2.7664e-12 ps=1.0440e-05 nf=1 m=2 par=2
X100 out.t118 vss.t63 cap_mim_2f0fF c_width=14.79u c_length=14.79u
Rpar0 a_1402_5812.t0 a_1402_5812.t64 51.2075
Rpar1 a_1718_5812.t0 a_1718_5812.t1 4.9699
Rpar2 a_1718_5812.t0 a_1718_5812.t108 141.0812
Rpar3 a_1718_5812.t1 a_1718_5812.t108 49.0670
Rpar4 ib ib.t0 15.1736
Rpar5 ib ib.t1 8.0412
Rpar6 inn inn.t0 2.1403
Rpar7 inp inp.t0 2.1403
Rpar8 out out.t0 2.7375
Rpar9 out.t0 out.t8 43.9704
Rpar10 out.t0 out.t118 222.1897
Rpar11 out.t8 out.t118 95.0706
Rpar12 vdd vdd.t0 19.2571
Rpar13 vdd vdd.t1 1376.9903
Rpar14 vdd.t0 vdd.t1 9.0947
Rpar15 vss vss.t0 49.7574
Rpar16 vss vss.t44 1808.6140
Rpar17 vss vss.t63 71.8156
Rpar18 vss.t0 vss.t44 4.8090
Rpar19 vss.t0 vss.t63 108.8981
Rpar20 vss.t44 vss.t63 3958.2960
Cpar0 a_1402_5812.t0 vss 1.49733e-13
Cpar1 a_1402_5812.t64 vss 1.31993e-14
Cpar2 a_1718_5812.t0 vss 1.15741e-13
Cpar3 a_1718_5812.t1 vss 4.35148e-14
Cpar4 a_1718_5812.t108 vss 9.43489e-14
Cpar5 ib out 7.47700e-17
Cpar6 ib vss 1.97532e-14
Cpar7 ib.t0 vss 4.60141e-15
Cpar8 ib.t1 vss 4.72940e-16
Cpar9 inn inp 9.49000e-17
Cpar10 inn out 2.49152e-14
Cpar11 inn vdd 1.92400e-17
Cpar12 inn vss 4.11723e-14
Cpar13 inn.t0 vss 4.07577e-14
Cpar14 inp out 1.49970e-16
Cpar15 inp vdd 1.99000e-17
Cpar16 inp vss 4.12264e-14
Cpar17 inp.t0 vss 4.08128e-14
Cpar18 out vdd 3.76495e-14
Cpar19 out vss 2.86569e-14
Cpar20 out.t0 vss 2.77608e-14
Cpar21 out.t118 vss 5.70963e-14
Cpar22 out.t8 vss 6.36867e-14
Cpar23 vdd vss 2.36852e-13
Cpar24 vdd.t0 vss 1.50720e-13
Cpar25 vdd.t1 vss 1.81615e-14
.ends opamp_dut

Vdd vdd 0 3.300000
Vss vss 0 0
Ibias vdd ib 5.000000e-06
Vinp inp 0 DC 1.645000 AC 1 PWL(0 1.645000 4.354403e-09 1.645000 4.789844e-09 1.655000)
Rfb out inn 1m
Cload out 0 2.000000e-13
Xdut vdd vss inp inn out ib opamp_dut
.end
