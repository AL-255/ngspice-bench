* opa1000[0156]: 2p/current_reuse_3v3_1u_10u_subth (current_reuse, VDD=3.3V, CL=2.0pF, Iref=0.9286uA)
.include "pdk_opa.inc"
.temp 27
.option gmin=1e-12 rshunt=1e12 reltol=1e-3 abstol=1e-12 vntol=1e-5 method=gear
* Post-PEX R+C extracted netlist for current_reuse_3v3_1u_10u_subth
.subckt opamp_dut vdd vss inp inn out ib
XMpar0 a_1115_18267.t38 inn a_2994_13036.t4 vss.t0 nfet_03v3 w=1.97u l=2u ad=5.5160e-13 pd=2.5300e-06 as=6.5667e-13 ps=2.9650e-06 nf=1 m=12 par=12
XMpar1 a_1043_10824.t1 inp.t12 a_1365_18475.t0 vdd.t8 pfet_03v3 w=1.97u l=2u ad=5.8478e-13 pd=2.6674e-06 as=6.5114e-13 ps=2.9421e-06 nf=1 m=38 par=38
XMpar2 a_1115_18267.t0 inn.t12 a_1365_18475.t0 vdd.t8 pfet_03v3 w=1.97u l=2u ad=5.8478e-13 pd=2.6674e-06 as=6.5114e-13 ps=2.9421e-06 nf=1 m=38 par=38
XMpar3 out.t4 ib.t0 vss.t1 vss.t0 nfet_03v3 w=2.56u l=2u ad=8.8064e-13 pd=3.7600e-06 as=7.1680e-13 ps=3.1200e-06 nf=1 m=10 par=10
XMpar4 a_1043_10824.t33 inp a_2994_13036.t4 vss.t0 nfet_03v3 w=1.97u l=2u ad=5.5160e-13 pd=2.5300e-06 as=6.5667e-13 ps=2.9650e-06 nf=1 m=12 par=12
XMpar5 a_2994_13036.t0 ib.t0 vss.t1 vss.t0 nfet_03v3 w=2.56u l=2u ad=7.1680e-13 pd=3.1200e-06 as=7.1680e-13 ps=3.1200e-06 nf=1 m=4 par=4
XMpar6 out.t0 a_1043_10824.t52 vdd.t1 vdd.t0 pfet_03v3 w=10u l=1.25u ad=2.8000e-12 pd=1.0560e-05 as=3.4400e-12 ps=1.2688e-05 nf=1 m=10 par=10
XMpar7 a_1365_18475.t38 a_1115_18267.t50 vdd.t1 vdd.t0 pfet_03v3 w=10u l=1.25u ad=2.8000e-12 pd=1.0560e-05 as=6.0000e-12 ps=2.1200e-05 nf=1 m=2 par=2
XMpar8 a_1043_10824.t0 a_1115_18267.t50 vdd.t1 vdd.t0 pfet_03v3 w=10u l=1.25u ad=6.0000e-12 pd=2.1200e-05 as=2.8000e-12 ps=1.0560e-05 nf=1 m=1
XMpar9 a_1115_18267.t51 a_1115_18267.t50 vdd.t1 vdd.t0 pfet_03v3 w=10u l=1.25u ad=6.0000e-12 pd=2.1200e-05 as=2.8000e-12 ps=1.0560e-05 nf=1 m=1
XMpar10 ib.t1 ib.t0 vss.t1 vss.t0 nfet_03v3 w=2.56u l=2u ad=7.1680e-13 pd=3.1200e-06 as=7.1680e-13 ps=3.1200e-06 nf=1 m=2 par=2
X1 a_3391_10824.t1 out.t14 cap_mim_2f0fF c_width=18.91u c_length=18.91u
X7 a_3391_10824.t1 out.t14 cap_mim_2f0fF c_width=18.91u c_length=18.91u
X64 a_3391_10824.t1 out.t14 cap_mim_2f0fF c_width=18.91u c_length=18.91u
X72 a_3391_10824.t1 out.t14 cap_mim_2f0fF c_width=18.91u c_length=18.91u
X111 a_1043_10824.t51 a_3391_10824.t0 vss.t56 ppolyf_u_1k r_width=1u r_length=11.08u
Rpar0 a_1043_10824.t0 a_1043_10824.t1 1179.3438
Rpar1 a_1043_10824.t0 a_1043_10824.t33 79.4520
Rpar2 a_1043_10824.t0 a_1043_10824.t51 340.7609
Rpar3 a_1043_10824.t0 a_1043_10824.t52 274.8988
Rpar4 a_1043_10824.t1 a_1043_10824.t33 349.6165
Rpar5 a_1043_10824.t1 a_1043_10824.t51 768.8353
Rpar6 a_1043_10824.t1 a_1043_10824.t52 99.1614
Rpar7 a_1043_10824.t33 a_1043_10824.t51 101.0186
Rpar8 a_1043_10824.t33 a_1043_10824.t52 81.4938
Rpar9 a_1043_10824.t51 a_1043_10824.t52 179.2114
Rpar10 a_1115_18267.t0 a_1115_18267.t38 60.6967
Rpar11 a_1115_18267.t0 a_1115_18267.t50 352.6524
Rpar12 a_1115_18267.t0 a_1115_18267.t51 242.9033
Rpar13 a_1115_18267.t38 a_1115_18267.t50 351.8138
Rpar14 a_1115_18267.t38 a_1115_18267.t51 242.3257
Rpar15 a_1115_18267.t50 a_1115_18267.t51 32.5035
Rpar16 a_1365_18475.t0 a_1365_18475.t38 46.6847
Rpar17 a_2994_13036.t0 a_2994_13036.t4 59.3474
Rpar18 a_3391_10824.t0 a_3391_10824.t1 60.2646
Rpar19 ib ib.t0 11.5245
Rpar20 ib ib.t1 11.0389
Rpar21 inn inn.t12 55.4812
Rpar22 inp inp.t12 86.4610
Rpar23 out out.t0 2.2148
Rpar24 out out.t4 198.4077
Rpar25 out out.t14 448.4318
Rpar26 out.t0 out.t4 110.0010
Rpar27 out.t0 out.t14 248.6191
Rpar28 out.t4 out.t14 220.8329
Rpar29 vdd vdd.t0 85.3800
Rpar30 vdd vdd.t1 252.5495
Rpar31 vdd vdd.t8 34.2954
Rpar32 vdd.t0 vdd.t1 2.9429
Rpar33 vdd.t0 vdd.t8 114.3757
Rpar34 vdd.t1 vdd.t8 338.3172
Rpar35 vss vss.t0 35.6071
Rpar36 vss vss.t1 432.3294
Rpar37 vss vss.t56 1080.4067
Rpar38 vss.t0 vss.t1 4.0482
Rpar39 vss.t0 vss.t56 13.4302
Rpar40 vss.t1 vss.t56 769.4622
Cpar0 a_1043_10824.t0 vss 5.39194e-15
Cpar1 a_1043_10824.t1 vss 2.49300e-14
Cpar2 a_1043_10824.t33 vss 9.62753e-15
Cpar3 a_1043_10824.t51 vss 3.17769e-15
Cpar4 a_1043_10824.t52 vss 2.65646e-14
Cpar5 a_1115_18267.t0 vss 2.82503e-14
Cpar6 a_1115_18267.t38 vss 1.08742e-14
Cpar7 a_1115_18267.t50 vss 1.35493e-14
Cpar8 a_1115_18267.t51 vss 9.17449e-15
Cpar9 a_1365_18475.t0 vss 5.92002e-14
Cpar10 a_1365_18475.t38 vss 4.71303e-15
Cpar11 a_2994_13036.t0 vss 6.81833e-15
Cpar12 a_2994_13036.t4 vss 1.60810e-14
Cpar13 a_3391_10824.t0 vss 6.09245e-17
Cpar14 a_3391_10824.t1 vss 1.00665e-14
Cpar15 ib inn 2.85700e-17
Cpar16 ib inp 2.00800e-17
Cpar17 ib out 2.04603e-15
Cpar18 ib vss 2.78220e-14
Cpar19 ib.t0 vss 5.39475e-15
Cpar20 ib.t1 vss 3.59273e-16
Cpar21 inn inp 1.88280e-16
Cpar22 inn vdd 3.21578e-14
Cpar23 inn vss 3.09128e-14
Cpar24 inn.t12 vss 4.38967e-14
Cpar25 inp out 1.13759e-15
Cpar26 inp vdd 3.46705e-14
Cpar27 inp vss 3.26095e-14
Cpar28 inp.t12 vss 4.73698e-14
Cpar29 out vdd 1.16291e-14
Cpar30 out vss 2.40826e-14
Cpar31 out.t0 vss 6.73966e-15
Cpar32 out.t14 vss 2.22619e-14
Cpar33 out.t4 vss 4.65445e-15
Cpar34 vdd vss 2.78642e-13
Cpar35 vdd.t0 vss 2.89381e-14
Cpar36 vdd.t1 vss 1.51786e-14
Cpar37 vdd.t8 vss 8.10150e-14
.ends opamp_dut

Vdd vdd 0 3.300000
Vss vss 0 0
Ibias vdd ib 9.286000e-07
Vinp inp 0 DC 1.645000 AC 1 PWL(0 1.645000 6.037331e-08 1.645000 6.641064e-08 1.655000)
Rfb out inn 1m
Cload out 0 2.000000e-12
Xdut vdd vss inp inn out ib opamp_dut
.end
