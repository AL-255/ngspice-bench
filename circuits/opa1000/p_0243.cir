* opa1000[0243]: 2p/folded_cascode_nmos_3v3_i20u_weak (folded_cascode_nmos, VDD=3.3V, CL=2.0pF, Iref=5.1111uA)
.include "pdk_opa.inc"
.temp 27
.option gmin=1e-12 rshunt=1e12 reltol=1e-3 abstol=1e-12 vntol=1e-5 method=gear
* Post-PEX R+C extracted netlist for folded_cascode_nmos_3v3_i20u_weak
.subckt opamp_dut vdd vss inp inn out ib
XMpar0 a_3420_8457.t9 ib.t10 a_3698_10284.t0 vdd.t6 pfet_03v3 w=1.97u l=0.6u ad=6.7768e-13 pd=3.0520e-06 as=5.5160e-13 ps=2.5300e-06 nf=1 m=10 par=10
XMpar1 a_1151_5807.t4 ib.t0 vss.t9 vss.t0 nfet_03v3 w=4.08u l=1.8u ad=2.4480e-12 pd=9.3600e-06 as=1.1424e-12 ps=4.6400e-06 nf=1 m=2 par=2
XMpar2 a_6094_10284.t2 ib.t10 out.t0 vdd.t6 pfet_03v3 w=1.97u l=0.6u ad=6.7768e-13 pd=3.0520e-06 as=5.5160e-13 ps=2.5300e-06 nf=1 m=10 par=10
XMpar3 a_6094_10284.t0 a_1151_5807.t0 vdd.t1 vdd.t0 pfet_03v3 w=9.07u l=1.35u ad=2.5396e-12 pd=9.6300e-06 as=3.9908e-12 ps=1.4485e-05 nf=1 m=4 par=4
XMpar4 a_3074_8457.t0 inp.t0 a_3420_8457.t1 vss.t0 nfet_03v3 w=2.03u l=1.13u ad=7.3080e-13 pd=3.2575e-06 as=5.6840e-13 ps=2.5900e-06 nf=1 m=8 par=8
XMpar5 a_3074_8457.t8 ib.t0 vss.t9 vss.t0 nfet_03v3 w=4.08u l=1.8u ad=2.4480e-12 pd=9.3600e-06 as=1.1424e-12 ps=4.6400e-06 nf=1 m=4 par=4
XMpar6 ib.t1 ib.t0 vss.t9 vss.t0 nfet_03v3 w=4.08u l=1.8u ad=2.4480e-12 pd=9.3600e-06 as=1.1424e-12 ps=4.6400e-06 nf=1 m=2 par=2
XMpar7 out.t6 a_3698_10284.t10 vss.t9 vss.t0 nfet_03v3 w=4.08u l=1.8u ad=1.1424e-12 pd=4.6400e-06 as=1.1424e-12 ps=4.6400e-06 nf=1 m=2 par=2
XMpar8 a_3074_8457.t0 inn.t0 a_6094_10284.t14 vss.t0 nfet_03v3 w=2.03u l=1.13u ad=7.3080e-13 pd=3.2575e-06 as=5.6840e-13 ps=2.5900e-06 nf=1 m=8 par=8
XMpar9 a_3698_10284.t11 a_3698_10284.t10 vss.t9 vss.t0 nfet_03v3 w=4.08u l=1.8u ad=2.4480e-12 pd=9.3600e-06 as=1.1424e-12 ps=4.6400e-06 nf=1 m=2 par=2
XMpar10 a_3420_8457.t0 a_1151_5807.t0 vdd.t1 vdd.t0 pfet_03v3 w=9.07u l=1.35u ad=2.5396e-12 pd=9.6300e-06 as=3.9908e-12 ps=1.4485e-05 nf=1 m=4 par=4
XMpar11 a_1151_5807.t1 a_1151_5807.t0 vdd.t1 vdd.t0 pfet_03v3 w=9.07u l=1.35u ad=2.5396e-12 pd=9.6300e-06 as=5.4420e-12 ps=1.9340e-05 nf=1 m=2 par=2
X54 out.t12 vss.t24 cap_mim_2f0fF c_width=14.79u c_length=14.79u
Rpar0 a_1151_5807.t0 a_1151_5807.t1 27.8005
Rpar1 a_1151_5807.t0 a_1151_5807.t4 126.8239
Rpar2 a_1151_5807.t1 a_1151_5807.t4 82.9219
Rpar3 a_3074_8457.t0 a_3074_8457.t8 38.1300
Rpar4 a_3420_8457.t0 a_3420_8457.t1 128.0663
Rpar5 a_3420_8457.t0 a_3420_8457.t9 65.3749
Rpar6 a_3420_8457.t1 a_3420_8457.t9 41.6998
Rpar7 a_3698_10284.t0 a_3698_10284.t10 332.6771
Rpar8 a_3698_10284.t0 a_3698_10284.t11 84.1849
Rpar9 a_3698_10284.t10 a_3698_10284.t11 18.7984
Rpar10 a_6094_10284.t0 a_6094_10284.t2 65.3749
Rpar11 a_6094_10284.t0 a_6094_10284.t14 128.0663
Rpar12 a_6094_10284.t2 a_6094_10284.t14 41.6998
Rpar13 ib ib.t0 15.7716
Rpar14 ib ib.t1 6.5375
Rpar15 ib ib.t10 44.3378
Rpar16 ib.t0 ib.t1 23.2322
Rpar17 inn inn.t0 2.2806
Rpar18 inp inp.t0 2.3292
Rpar19 out out.t0 101.1158
Rpar20 out out.t6 64.1394
Rpar21 out out.t12 15.6071
Rpar22 out.t0 out.t6 277.2193
Rpar23 out.t0 out.t12 956.0455
Rpar24 out.t6 out.t12 606.4348
Rpar25 vdd vdd.t0 76.4538
Rpar26 vdd vdd.t1 55.9371
Rpar27 vdd vdd.t6 49.2737
Rpar28 vdd.t0 vdd.t1 4.2825
Rpar29 vdd.t0 vdd.t6 78.6274
Rpar30 vdd.t1 vdd.t6 69.0831
Rpar31 vss vss.t0 55.2286
Rpar32 vss vss.t9 55.9129
Rpar33 vss vss.t24 55.4736
Rpar34 vss.t0 vss.t9 4.2534
Rpar35 vss.t0 vss.t24 305.3354
Rpar36 vss.t9 vss.t24 151.1395
Cpar0 a_1151_5807.t0 vss 1.84946e-14
Cpar1 a_1151_5807.t1 vss 4.76898e-15
Cpar2 a_1151_5807.t4 vss 5.52723e-15
Cpar3 a_3074_8457.t0 vss 7.86643e-15
Cpar4 a_3074_8457.t8 vss 7.57110e-15
Cpar5 a_3420_8457.t0 vss 7.81018e-15
Cpar6 a_3420_8457.t1 vss 5.23078e-15
Cpar7 a_3420_8457.t9 vss 6.39435e-15
Cpar8 a_3698_10284.t0 vss 4.40797e-15
Cpar9 a_3698_10284.t10 vss 5.42377e-15
Cpar10 a_3698_10284.t11 vss 3.80601e-15
Cpar11 a_6094_10284.t0 vss 7.51095e-15
Cpar12 a_6094_10284.t14 vss 5.03036e-15
Cpar13 a_6094_10284.t2 vss 6.14928e-15
Cpar14 ib inn 1.67800e-17
Cpar15 ib inp 1.48700e-17
Cpar16 ib out 1.51245e-15
Cpar17 ib vdd 9.86536e-15
Cpar18 ib vss 2.08925e-14
Cpar19 ib.t0 vss 1.11836e-14
Cpar20 ib.t1 vss 3.00948e-15
Cpar21 ib.t10 vss 8.38449e-15
Cpar22 inn inp 5.12600e-17
Cpar23 inn out 3.09600e-17
Cpar24 inn vss 6.82813e-15
Cpar25 inn.t0 vss 1.34003e-15
Cpar26 inp out 2.20700e-17
Cpar27 inp vdd 1.63400e-17
Cpar28 inp vss 6.75679e-15
Cpar29 inp.t0 vss 1.36839e-15
Cpar30 out vdd 2.20032e-15
Cpar31 out vss 1.46278e-14
Cpar32 out.t0 vss 1.01475e-15
Cpar33 out.t12 vss 1.05973e-14
Cpar34 out.t6 vss 5.06203e-16
Cpar35 vdd vss 9.37378e-14
Cpar36 vdd.t0 vss 1.55416e-14
Cpar37 vdd.t1 vss 1.09292e-14
Cpar38 vdd.t6 vss 1.19148e-14
.ends opamp_dut

Vdd vdd 0 3.300000
Vss vss 0 0
Ibias vdd ib 5.111100e-06
Vinp inp 0 DC 1.810000 AC 1 PWL(0 1.810000 1.670405e-08 1.810000 1.837445e-08 1.820000)
Rfb out inn 1m
Cload out 0 2.000000e-12
Xdut vdd vss inp inn out ib opamp_dut
.end
