* opa1000[0444]: 200f/nmos_miller_3v3_i1u_weak (nmos_miller, VDD=3.3V, CL=0.2pF, Iref=0.1857uA)
.include "pdk_opa.inc"
.temp 27
.option gmin=1e-12 rshunt=1e12 reltol=1e-3 abstol=1e-12 vntol=1e-5 method=gear
* Post-PEX R+C extracted netlist for nmos_miller_3v3_i1u_weak
.subckt opamp_dut vdd vss inp inn out ib
XMpar0 out.t0 a_1492_6052.t5 vdd.t1 vdd.t0 pfet_03v3 w=1.03u l=2.25u ad=3.5432e-13 pd=1.9240e-06 as=4.2024e-13 ps=2.2580e-06 nf=1 m=10 par=10
XMpar1 a_3345_1249.t0 inn.t0 a_5872_10147.t0 vss.t0 nfet_03v3 w=1.25u l=5u ad=7.5000e-13 pd=3.7000e-06 as=3.5000e-13 ps=1.8100e-06 nf=1 m=2 par=2
XMpar2 a_3345_1249.t4 ib.t0 vss.t6 vss.t5 nfet_03v3 w=0.4u l=3.5u ad=2.4000e-13 pd=2.0000e-06 as=1.1200e-13 ps=9.6000e-07 nf=1 m=4 par=4
XMpar3 out.t11 ib.t0 vss.t6 vss.t5 nfet_03v3 w=0.4u l=3.5u ad=1.8880e-13 pd=1.5840e-06 as=1.6320e-13 ps=1.3760e-06 nf=1 m=10 par=10
XMpar4 a_1492_6052.t2 a_5872_10147.t2 vdd.t1 vdd.t0 pfet_03v3 w=1.03u l=2.25u ad=6.1800e-13 pd=3.2600e-06 as=2.8840e-13 ps=1.5900e-06 nf=1 m=2 par=2
XMpar5 a_5872_10147.t3 a_5872_10147.t2 vdd.t1 vdd.t0 pfet_03v3 w=1.03u l=2.25u ad=2.8840e-13 pd=1.5900e-06 as=2.8840e-13 ps=1.5900e-06 nf=1 m=2 par=2
XMpar6 ib.t1 ib.t0 vss.t6 vss.t5 nfet_03v3 w=0.4u l=3.5u ad=2.4000e-13 pd=2.0000e-06 as=1.1200e-13 ps=9.6000e-07 nf=1 m=2 par=2
XMpar7 a_1492_6052.t0 inp.t0 a_3345_1249.t0 vss.t0 nfet_03v3 w=1.25u l=5u ad=3.5000e-13 pd=1.8100e-06 as=7.5000e-13 ps=3.7000e-06 nf=1 m=2 par=2
X0 a_5100_8900.t1 out.t8 cap_mim_2f0fF c_width=11.46u c_length=11.46u
X3 a_5100_7860.t0 a_9222_7340.t0 vss.t4 ppolyf_u_1k r_width=1u r_length=19.95u
X12 a_5100_6820.t0 a_9222_7340.t0 vss.t4 ppolyf_u_1k r_width=1u r_length=19.95u
X16 a_5100_6820.t0 a_9222_6300.t0 vss.t4 ppolyf_u_1k r_width=1u r_length=19.95u
X19 a_1492_6052.t3 a_9222_6300.t0 vss.t4 ppolyf_u_1k r_width=1u r_length=19.95u
X27 a_5100_8900.t0 a_9222_8380.t0 vss.t4 ppolyf_u_1k r_width=1u r_length=19.95u
X40 a_5100_7860.t0 a_9222_8380.t0 vss.t4 ppolyf_u_1k r_width=1u r_length=19.95u
Rpar0 a_1492_6052.t0 a_1492_6052.t5 76.3984
Rpar1 a_1492_6052.t0 a_1492_6052.t2 150.0370
Rpar2 a_1492_6052.t0 a_1492_6052.t3 129.1076
Rpar3 a_1492_6052.t5 a_1492_6052.t2 189.5689
Rpar4 a_1492_6052.t5 a_1492_6052.t3 45.4208
Rpar5 a_1492_6052.t2 a_1492_6052.t3 320.3574
Rpar6 a_3345_1249.t0 a_3345_1249.t4 43.7939
Rpar7 a_5100_8900.t0 a_5100_8900.t1 58.2990
Rpar8 a_5872_10147.t0 a_5872_10147.t2 173.5910
Rpar9 a_5872_10147.t0 a_5872_10147.t3 145.5036
Rpar10 a_5872_10147.t2 a_5872_10147.t3 26.6482
Rpar11 ib ib.t0 14.4641
Rpar12 ib ib.t1 14.6955
Rpar13 ib.t0 ib.t1 34.2155
Rpar14 inn inn.t0 3.4170
Rpar15 inp inp.t0 3.4655
Rpar16 out out.t0 4.3699
Rpar17 out out.t11 214.6787
Rpar18 out out.t8 359.7931
Rpar19 out.t0 out.t11 691.6610
Rpar20 out.t0 out.t8 1159.1967
Rpar21 out.t11 out.t8 61.1142
Rpar22 vdd vdd.t0 24.3909
Rpar23 vdd vdd.t1 123.3313
Rpar24 vdd.t0 vdd.t1 6.1536
Rpar25 vss vss.t0 331.8976
Rpar26 vss vss.t6 1743.2459
Rpar27 vss vss.t5 70.6773
Rpar28 vss vss.t4 413.6203
Rpar29 vss.t0 vss.t6 84.8319
Rpar30 vss.t0 vss.t5 3.0421
Rpar31 vss.t0 vss.t4 18.3940
Rpar32 vss.t6 vss.t5 15.0746
Rpar33 vss.t6 vss.t4 126.9962
Rpar34 vss.t5 vss.t4 4.9613
Cpar0 a_1492_6052.t0 vss 2.95816e-15
Cpar1 a_1492_6052.t2 vss 4.00867e-15
Cpar2 a_1492_6052.t3 vss 2.74693e-15
Cpar3 a_1492_6052.t5 vss 1.41925e-14
Cpar4 a_3345_1249.t0 vss 6.37125e-15
Cpar5 a_3345_1249.t4 vss 1.22369e-14
Cpar6 a_5100_6820.t0 vss 3.82200e-17
Cpar7 a_5100_7860.t0 vss 3.71000e-17
Cpar8 a_5100_8900.t0 vss 8.58700e-17
Cpar9 a_5100_8900.t1 vss 1.51808e-15
Cpar10 a_5872_10147.t0 vss 5.22833e-15
Cpar11 a_5872_10147.t2 vss 7.99460e-15
Cpar12 a_5872_10147.t3 vss 3.55045e-15
Cpar13 a_9222_6300.t0 vss 3.53400e-17
Cpar14 a_9222_7340.t0 vss 4.09800e-17
Cpar15 a_9222_8380.t0 vss 3.38800e-17
Cpar16 ib inn 1.44900e-17
Cpar17 ib inp 1.50800e-17
Cpar18 ib out 2.20509e-15
Cpar19 ib vss 4.42167e-14
Cpar20 ib.t0 vss 7.37080e-15
Cpar21 ib.t1 vss 6.08267e-16
Cpar22 inn inp 5.12600e-17
Cpar23 inn out 1.58700e-17
Cpar24 inn vss 5.33688e-15
Cpar25 inn.t0 vss 5.72085e-16
Cpar26 inp vss 5.43325e-15
Cpar27 inp.t0 vss 5.89540e-16
Cpar28 out vdd 1.34123e-14
Cpar29 out vss 2.75279e-14
Cpar30 out.t0 vss 4.08243e-15
Cpar31 out.t11 vss 1.16632e-14
Cpar32 out.t8 vss 1.00764e-14
Cpar33 vdd vss 6.96057e-14
Cpar34 vdd.t0 vss 2.60835e-14
Cpar35 vdd.t1 vss 6.40148e-15
.ends opamp_dut

Vdd vdd 0 3.300000
Vss vss 0 0
Ibias vdd ib 1.857000e-07
Vinp inp 0 DC 1.645000 AC 1 PWL(0 1.645000 5.834955e-08 1.645000 6.418451e-08 1.655000)
Rfb out inn 1m
Cload out 0 2.000000e-13
Xdut vdd vss inp inn out ib opamp_dut
.end
