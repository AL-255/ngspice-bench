* opa1000[0852]: 200f/telescopic_nmos_1v8_i150u_subth (telescopic_nmos, VDD=1.8V, CL=0.2pF, Iref=48.75uA)
.include "pdk_opa.inc"
.temp 27
.option gmin=1e-12 rshunt=1e12 reltol=1e-3 abstol=1e-12 vntol=1e-5 method=gear
* Post-PEX R+C extracted netlist for telescopic_nmos_1v8_i150u_subth
.subckt opamp_dut vdd vss inp inn out ib
XMpar0 a_2303_19337.t17 a_1695_19129.t640 vdd.t38 vdd.t37 pfet_03v3 w=5.07u l=0.88u ad=1.4196e-12 pd=5.6300e-06 as=1.5210e-12 ps=5.9869e-06 nf=1 m=160 par=160
XMpar1 a_1575_19337.t21 a_1695_19129.t640 vdd.t38 vdd.t37 pfet_03v3 w=5.07u l=0.88u ad=1.4196e-12 pd=5.6300e-06 as=1.4196e-12 ps=5.6300e-06 nf=1 m=160 par=160
XMpar2 a_1308_1204.t0 inn.t0 a_19374_8132.t0 vss.t0 nfet_03v3 w=2.77u l=0.44u ad=8.3100e-13 pd=3.5431e-06 as=7.7560e-13 ps=3.3300e-06 nf=1 m=160 par=160
XMpar3 a_11826_8132.t160 vdd.t594 a_1695_19129.t320 vss.t0 nfet_03v3 w=2.81u l=0.57u ad=8.4300e-13 pd=3.5856e-06 as=7.8680e-13 ps=3.3700e-06 nf=1 m=160 par=160
XMpar4 a_11826_8132.t0 inp.t0 a_1308_1204.t0 vss.t0 nfet_03v3 w=2.77u l=0.44u ad=7.7560e-13 pd=3.3300e-06 as=8.3100e-13 ps=3.5431e-06 nf=1 m=160 par=160
XMpar5 a_2303_19337.t0 a_1695_19129.t0 out.t160 vdd.t0 pfet_03v3 w=14u l=0.57u ad=5.9360e-12 pd=2.1148e-05 as=4.9280e-12 ps=1.7854e-05 nf=1 m=160 par=160
XMpar6 a_19374_8132.t160 vdd.t594 out.t0 vss.t0 nfet_03v3 w=2.81u l=0.57u ad=8.4300e-13 pd=3.5856e-06 as=7.8680e-13 ps=3.3700e-06 nf=1 m=160 par=160
XMpar7 a_1575_19337.t0 a_1695_19129.t0 a_1695_19129.t1 vdd.t0 pfet_03v3 w=14u l=0.57u ad=6.2160e-12 pd=2.2063e-05 as=4.8160e-12 ps=1.7488e-05 nf=1 m=160 par=160
XMpar8 a_1308_1204.t160 ib.t0 vss.t33 vss.t32 nfet_03v3 w=9.55u l=0.52u ad=2.6740e-12 pd=1.0110e-05 as=2.9287e-12 ps=1.0959e-05 nf=1 m=24 par=24
XMpar9 ib.t1 ib.t0 vss.t33 vss.t32 nfet_03v3 w=9.55u l=0.52u ad=2.6740e-12 pd=1.0110e-05 as=2.6740e-12 ps=1.0110e-05 nf=1 m=6 par=6
X305 out.t320 vss.t188 cap_mim_2f0fF c_width=18.71u c_length=18.71u
X527 out.t320 vss.t188 cap_mim_2f0fF c_width=18.71u c_length=18.71u
Rpar0 a_11826_8132.t0 a_11826_8132.t160 47.4494
Rpar1 a_1308_1204.t0 a_1308_1204.t160 44.3346
Rpar2 a_1575_19337.t0 a_1575_19337.t21 66.5587
Rpar3 a_1695_19129.t0 a_1695_19129.t1 6.6884
Rpar4 a_1695_19129.t0 a_1695_19129.t320 573.8701
Rpar5 a_1695_19129.t0 a_1695_19129.t640 530.9001
Rpar6 a_1695_19129.t1 a_1695_19129.t320 83.9530
Rpar7 a_1695_19129.t1 a_1695_19129.t640 77.6668
Rpar8 a_1695_19129.t320 a_1695_19129.t640 283.7953
Rpar9 a_19374_8132.t0 a_19374_8132.t160 47.4494
Rpar10 a_2303_19337.t0 a_2303_19337.t17 42.4490
Rpar11 ib ib.t0 14.9255
Rpar12 ib ib.t1 3.9395
Rpar13 inn inn.t0 1.6613
Rpar14 inp inp.t0 1.6613
Rpar15 out out.t160 3.4429
Rpar16 out.t0 out.t160 449.5314
Rpar17 out.t0 out.t320 242.6192
Rpar18 out.t160 out.t320 102.9772
Rpar19 vdd vdd.t0 207.1471
Rpar20 vdd vdd.t37 20.4797
Rpar21 vdd vdd.t594 966.7589
Rpar22 vdd.t0 vdd.t37 72.4180
Rpar23 vdd.t0 vdd.t594 108.7002
Rpar24 vdd.t37 vdd.t38 9.3682
Rpar25 vdd.t37 vdd.t594 337.9761
Rpar26 vss vss.t0 36.2710
Rpar27 vss vss.t188 208.7162
Rpar28 vss vss.t32 85.7116
Rpar29 vss vss.t33 954.6452
Rpar30 vss.t0 vss.t188 102.6176
Rpar31 vss.t0 vss.t32 76.6954
Rpar32 vss.t0 vss.t33 854.2227
Rpar33 vss.t188 vss.t32 215.2286
Rpar34 vss.t188 vss.t33 2397.1906
Rpar35 vss.t32 vss.t33 4.1608
Cpar0 a_11826_8132.t0 vss 1.21389e-13
Cpar1 a_11826_8132.t160 vss 1.22935e-13
Cpar2 a_1308_1204.t0 vss 2.08708e-13
Cpar3 a_1308_1204.t160 vss 4.41843e-14
Cpar4 a_1575_19337.t0 vss 5.95740e-13
Cpar5 a_1575_19337.t21 vss 1.96835e-13
Cpar6 a_1695_19129.t0 vss 4.59478e-13
Cpar7 a_1695_19129.t1 vss 3.89624e-13
Cpar8 a_1695_19129.t320 vss 8.09888e-14
Cpar9 a_1695_19129.t640 vss 3.26012e-13
Cpar10 a_19374_8132.t0 vss 1.22138e-13
Cpar11 a_19374_8132.t160 vss 1.23691e-13
Cpar12 a_2303_19337.t0 vss 6.17847e-13
Cpar13 a_2303_19337.t17 vss 2.02076e-13
Cpar14 ib vss 3.52621e-14
Cpar15 ib.t0 vss 5.73264e-15
Cpar16 ib.t1 vss 1.67441e-15
Cpar17 inn inp 2.62970e-16
Cpar18 inn out 1.93680e-16
Cpar19 inn vdd 2.93200e-17
Cpar20 inn vss 5.49113e-14
Cpar21 inn.t0 vss 3.80661e-14
Cpar22 inp out 2.88500e-17
Cpar23 inp vdd 2.93200e-17
Cpar24 inp vss 5.51284e-14
Cpar25 inp.t0 vss 3.79482e-14
Cpar26 out vdd 1.08330e-13
Cpar27 out vss 5.77133e-14
Cpar28 out.t0 vss 8.16709e-14
Cpar29 out.t160 vss 3.76307e-13
Cpar30 out.t320 vss 2.16492e-13
Cpar31 vdd vss 2.18702e-12
Cpar32 vdd.t0 vss 5.70142e-13
Cpar33 vdd.t37 vss 2.97339e-13
Cpar34 vdd.t38 vss 7.00206e-14
Cpar35 vdd.t594 vss 4.91299e-14
.ends opamp_dut

Vdd vdd 0 1.800000
Vss vss 0 0
Ibias vdd ib 4.875000e-05
Vinp inp 0 DC 0.931000 AC 1 PWL(0 0.931000 3.000000e-09 0.931000 3.300000e-09 0.941000)
Rfb out inn 1m
Cload out 0 2.000000e-13
Xdut vdd vss inp inn out ib opamp_dut
.end
