* opa1000[0792]: 2p/symmetrical_ota_1v8_ulp_lt0p1uw_weak (symmetrical_ota, VDD=1.8V, CL=2.0pF, Iref=0.0034uA)
.include "pdk_opa.inc"
.temp 27
.option gmin=1e-12 rshunt=1e12 reltol=1e-3 abstol=1e-12 vntol=1e-5 method=gear
* Post-PEX R+C extracted netlist for symmetrical_ota_1v8_ulp_lt0p1uw_weak
.subckt opamp_dut vdd vss inp inn out ib
XMpar0 a_7390_3971.t0 a_10171_9707.t0 vdd.t1 vdd.t0 pfet_03v3 w=0.4u l=10u ad=2.4000e-13 pd=2.0000e-06 as=1.7600e-13 ps=1.4800e-06 nf=1 m=4 par=4
XMpar1 a_5554_12890.t4 ib.t0 vss.t15 vss.t14 nfet_03v3 w=0.4u l=9.5u ad=2.4000e-13 pd=2.0000e-06 as=1.7600e-13 ps=1.4800e-06 nf=1 m=4 par=4
XMpar2 ib.t1 ib.t0 vss.t15 vss.t14 nfet_03v3 w=0.4u l=9.5u ad=2.4000e-13 pd=2.0000e-06 as=1.1200e-13 ps=9.6000e-07 nf=1 m=2 par=2
XMpar3 out.t0 a_1729_9707.t2 vdd.t1 vdd.t0 pfet_03v3 w=0.4u l=10u ad=2.4000e-13 pd=2.0000e-06 as=1.7600e-13 ps=1.4800e-06 nf=1 m=4 par=4
XMpar4 a_7390_3971.t4 a_7390_3971.t3 vss.t6 vss.t5 nfet_03v3 w=0.4u l=10u ad=2.4000e-13 pd=2.0000e-06 as=1.1200e-13 ps=9.6000e-07 nf=1 m=4 par=4
XMpar5 a_1729_9707.t0 inp.t0 a_5554_12890.t0 vss.t1 nfet_03v3 w=0.4u l=8u ad=1.1200e-13 pd=9.6000e-07 as=2.4000e-13 ps=2.0000e-06 nf=1 m=2 par=2
XMpar6 a_10171_9707.t1 a_10171_9707.t0 vdd.t1 vdd.t0 pfet_03v3 w=0.4u l=10u ad=2.4000e-13 pd=2.0000e-06 as=1.1200e-13 ps=9.6000e-07 nf=1 m=2 par=2
XMpar7 a_10171_9707.t4 inn.t0 a_5554_12890.t0 vss.t1 nfet_03v3 w=0.4u l=8u ad=1.1200e-13 pd=9.6000e-07 as=2.4000e-13 ps=2.0000e-06 nf=1 m=2 par=2
XMpar8 out.t4 a_7390_3971.t3 vss.t6 vss.t5 nfet_03v3 w=0.4u l=10u ad=2.4000e-13 pd=2.0000e-06 as=1.1200e-13 ps=9.6000e-07 nf=1 m=4 par=4
XMpar9 a_1729_9707.t3 a_1729_9707.t2 vdd.t1 vdd.t0 pfet_03v3 w=0.4u l=10u ad=2.4000e-13 pd=2.0000e-06 as=1.1200e-13 ps=9.6000e-07 nf=1 m=2 par=2
X22 out.t8 vss.t0 cap_mim_2f0fF c_width=19.62u c_length=19.63u
Rpar0 a_10171_9707.t0 a_10171_9707.t1 16.9386
Rpar1 a_10171_9707.t0 a_10171_9707.t4 89.0379
Rpar2 a_10171_9707.t1 a_10171_9707.t4 138.7987
Rpar3 a_1729_9707.t0 a_1729_9707.t2 89.0379
Rpar4 a_1729_9707.t0 a_1729_9707.t3 138.7986
Rpar5 a_1729_9707.t2 a_1729_9707.t3 16.9386
Rpar6 a_5554_12890.t0 a_5554_12890.t4 85.9892
Rpar7 a_7390_3971.t0 a_7390_3971.t4 178.3729
Rpar8 a_7390_3971.t0 a_7390_3971.t3 199.6506
Rpar9 a_7390_3971.t4 a_7390_3971.t3 8.5119
Rpar10 ib ib.t0 14.1544
Rpar11 ib ib.t1 13.7601
Rpar12 ib.t0 ib.t1 37.1419
Rpar13 inn inn.t0 3.3924
Rpar14 inp inp.t0 3.4410
Rpar15 out out.t0 121.9813
Rpar16 out out.t4 52.9364
Rpar17 out out.t8 16.2179
Rpar18 out.t0 out.t4 201.6149
Rpar19 out.t0 out.t8 907.7014
Rpar20 out.t4 out.t8 393.9166
Rpar21 vdd vdd.t0 335.1357
Rpar22 vdd vdd.t1 114.7311
Rpar23 vdd.t0 vdd.t1 9.3126
Rpar24 vss vss.t0 143.3249
Rpar25 vss vss.t1 237.7011
Rpar26 vss vss.t6 332.0219
Rpar27 vss vss.t14 355.5158
Rpar28 vss vss.t15 118.9848
Rpar29 vss vss.t5 481.1576
Rpar30 vss.t0 vss.t1 398.9639
Rpar31 vss.t0 vss.t6 507.6281
Rpar32 vss.t0 vss.t14 339.9266
Rpar33 vss.t0 vss.t15 103.0591
Rpar34 vss.t0 vss.t5 458.3101
Rpar35 vss.t1 vss.t6 234.9780
Rpar36 vss.t1 vss.t14 567.9242
Rpar37 vss.t1 vss.t15 322.5856
Rpar38 vss.t1 vss.t5 779.0419
Rpar39 vss.t6 vss.t14 25.2866
Rpar40 vss.t6 vss.t15 155.5519
Rpar41 vss.t6 vss.t5 35.4666
Rpar42 vss.t14 vss.t15 30.8290
Rpar43 vss.t14 vss.t5 5.5976
Rpar44 vss.t15 vss.t5 41.3807
Cpar0 a_10171_9707.t0 vss 3.83606e-14
Cpar1 a_10171_9707.t1 vss 7.98406e-15
Cpar2 a_10171_9707.t4 vss 4.83111e-15
Cpar3 a_1729_9707.t0 vss 4.76452e-15
Cpar4 a_1729_9707.t2 vss 3.78322e-14
Cpar5 a_1729_9707.t3 vss 7.87392e-15
Cpar6 a_5554_12890.t0 vss 6.06764e-15
Cpar7 a_5554_12890.t4 vss 7.76020e-15
Cpar8 a_7390_3971.t0 vss 7.04583e-15
Cpar9 a_7390_3971.t3 vss 2.05601e-14
Cpar10 a_7390_3971.t4 vss 5.94299e-15
Cpar11 ib out 1.39900e-17
Cpar12 ib vss 4.02478e-14
Cpar13 ib.t0 vss 5.31655e-15
Cpar14 ib.t1 vss 4.63377e-16
Cpar15 inn inp 5.19700e-17
Cpar16 inn vdd 1.24710e-16
Cpar17 inn vss 8.22937e-15
Cpar18 inn.t0 vss 6.37628e-16
Cpar19 inp vdd 9.08900e-17
Cpar20 inp vss 8.25012e-15
Cpar21 inp.t0 vss 5.86498e-16
Cpar22 out vdd 1.09861e-14
Cpar23 out vss 3.09673e-14
Cpar24 out.t0 vss 1.86040e-15
Cpar25 out.t4 vss 2.31026e-15
Cpar26 out.t8 vss 2.46558e-14
Cpar27 vdd vss 1.56760e-13
Cpar28 vdd.t0 vss 6.34066e-14
Cpar29 vdd.t1 vss 2.97554e-14
.ends opamp_dut

Vdd vdd 0 1.800000
Vss vss 0 0
Ibias vdd ib 3.400000e-09
Vinp inp 0 DC 0.895000 AC 1 PWL(0 0.895000 1.105447e-05 0.895000 1.215992e-05 0.905000)
Rfb out inn 1m
Cload out 0 2.000000e-12
Xdut vdd vss inp inn out ib opamp_dut
.end
