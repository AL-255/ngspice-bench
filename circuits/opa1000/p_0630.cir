* opa1000[0630]: 2p/pmos_miller_1v8_i200n_subth (pmos_miller, VDD=1.8V, CL=2.0pF, Iref=0.0325uA)
.include "pdk_opa.inc"
.temp 27
.option gmin=1e-12 rshunt=1e12 reltol=1e-3 abstol=1e-12 vntol=1e-5 method=gear
* Post-PEX R+C extracted netlist for pmos_miller_1v8_i200n_subth
.subckt opamp_dut vdd vss inp inn out ib
XMpar0 out.t0 a_852_1290.t7 vss.t1 vss.t0 nfet_03v3 w=0.61u l=4u ad=2.0984e-13 pd=1.4200e-06 as=2.4888e-13 ps=1.6700e-06 nf=1 m=10 par=10
XMpar1 out.t6 a_2916_13098.t0 vdd.t1 vdd.t0 pfet_03v3 w=0.84u l=4u ad=3.9648e-13 pd=2.2880e-06 as=3.4272e-13 ps=1.9920e-06 nf=1 m=10 par=10
XMpar2 ib.t1 ib.t0 vss.t27 vss.t26 nfet_03v3 w=0.4u l=4u ad=2.4000e-13 pd=2.0000e-06 as=1.1200e-13 ps=9.6000e-07 nf=1 m=2 par=2
XMpar3 a_2916_13098.t1 a_2916_13098.t0 vdd.t1 vdd.t0 pfet_03v3 w=0.84u l=4u ad=5.0400e-13 pd=2.8800e-06 as=2.3520e-13 ps=1.4000e-06 nf=1 m=2 par=2
XMpar4 a_7122_1250.t2 inp.t0 a_852_1290.t0 vdd.t6 pfet_03v3 w=1.8u l=2.88u ad=1.0800e-12 pd=4.8000e-06 as=5.0400e-13 ps=2.3600e-06 nf=1 m=4 par=4
XMpar5 a_7092_3888.t0 inn.t0 a_7122_1250.t2 vdd.t6 pfet_03v3 w=1.8u l=2.88u ad=5.0400e-13 pd=2.3600e-06 as=1.0800e-12 ps=4.8000e-06 nf=1 m=4 par=4
XMpar6 a_7122_1250.t0 a_2916_13098.t0 vdd.t1 vdd.t0 pfet_03v3 w=0.84u l=4u ad=5.0400e-13 pd=2.8800e-06 as=2.3520e-13 ps=1.4000e-06 nf=1 m=4 par=4
XMpar7 a_852_1290.t5 a_7092_3888.t4 vss.t1 vss.t0 nfet_03v3 w=0.61u l=4u ad=3.6600e-13 pd=2.4200e-06 as=1.7080e-13 ps=1.1700e-06 nf=1 m=2 par=2
XMpar8 a_7092_3888.t5 a_7092_3888.t4 vss.t1 vss.t0 nfet_03v3 w=0.61u l=4u ad=1.7080e-13 pd=1.1700e-06 as=1.7080e-13 ps=1.1700e-06 nf=1 m=2 par=2
XMpar9 a_2916_13098.t4 ib.t0 vss.t27 vss.t26 nfet_03v3 w=0.4u l=4u ad=1.1200e-13 pd=9.6000e-07 as=1.1200e-13 ps=9.6000e-07 nf=1 m=2 par=2
X1 a_852_7010.t0 a_4830_7530.t0 vss.t13 ppolyf_u_1k r_width=1u r_length=19.23u
X5 a_852_3890.t0 a_4830_4410.t0 vss.t13 ppolyf_u_1k r_width=1u r_length=19.23u
X9 a_852_7010.t0 a_4830_6490.t0 vss.t13 ppolyf_u_1k r_width=1u r_length=19.23u
X15 a_4830_7530.t1 out.t16 cap_mim_2f0fF c_width=14.37u c_length=14.36u
X21 a_852_1290.t4 a_4830_1290.t0 vss.t13 ppolyf_u_1k r_width=1u r_length=19.23u
X25 a_852_3890.t0 a_4830_3370.t0 vss.t13 ppolyf_u_1k r_width=1u r_length=19.23u
X29 a_852_5970.t0 a_4830_6490.t0 vss.t13 ppolyf_u_1k r_width=1u r_length=19.23u
X31 a_852_2850.t0 a_4830_3370.t0 vss.t13 ppolyf_u_1k r_width=1u r_length=19.23u
X39 a_852_5970.t0 a_4830_5450.t0 vss.t13 ppolyf_u_1k r_width=1u r_length=19.23u
X41 a_852_2850.t0 a_4830_2330.t0 vss.t13 ppolyf_u_1k r_width=1u r_length=19.23u
X46 a_852_4930.t0 a_4830_5450.t0 vss.t13 ppolyf_u_1k r_width=1u r_length=19.23u
X48 a_852_1810.t0 a_4830_2330.t0 vss.t13 ppolyf_u_1k r_width=1u r_length=19.23u
X50 a_852_4930.t0 a_4830_4410.t0 vss.t13 ppolyf_u_1k r_width=1u r_length=19.23u
X51 a_852_1810.t0 a_4830_1290.t0 vss.t13 ppolyf_u_1k r_width=1u r_length=19.23u
X56 a_4830_7530.t1 out.t16 cap_mim_2f0fF c_width=14.37u c_length=14.36u
Rpar0 a_2916_13098.t0 a_2916_13098.t1 15.1865
Rpar1 a_2916_13098.t0 a_2916_13098.t4 169.6215
Rpar2 a_2916_13098.t1 a_2916_13098.t4 133.4232
Rpar3 a_4830_7530.t0 a_4830_7530.t1 69.2991
Rpar4 a_7092_3888.t0 a_7092_3888.t4 91.3470
Rpar5 a_7092_3888.t0 a_7092_3888.t5 85.8498
Rpar6 a_7092_3888.t4 a_7092_3888.t5 30.9579
Rpar7 a_7122_1250.t0 a_7122_1250.t2 59.8566
Rpar8 a_852_1290.t0 a_852_1290.t7 219.2394
Rpar9 a_852_1290.t0 a_852_1290.t4 100.7855
Rpar10 a_852_1290.t0 a_852_1290.t5 92.1850
Rpar11 a_852_1290.t7 a_852_1290.t4 311.4343
Rpar12 a_852_1290.t7 a_852_1290.t5 88.9925
Rpar13 a_852_1290.t4 a_852_1290.t5 130.9508
Rpar14 ib ib.t0 11.6041
Rpar15 ib ib.t1 8.5198
Rpar16 inn inn.t0 3.6717
Rpar17 inp inp.t0 3.6717
Rpar18 out out.t0 247.2808
Rpar19 out out.t6 4.1442
Rpar20 out out.t16 207.3040
Rpar21 out.t0 out.t6 139.0223
Rpar22 out.t0 out.t16 110.1729
Rpar23 out.t6 out.t16 116.5472
Rpar24 vdd vdd.t0 525.5629
Rpar25 vdd vdd.t1 138.2984
Rpar26 vdd vdd.t6 176.3196
Rpar27 vdd.t0 vdd.t1 12.3960
Rpar28 vdd.t0 vdd.t6 361.1678
Rpar29 vdd.t1 vdd.t6 95.0389
Rpar30 vss vss.t0 155.2716
Rpar31 vss vss.t1 136.0918
Rpar32 vss vss.t13 26.1223
Rpar33 vss vss.t26 6150.3819
Rpar34 vss vss.t27 1222.9695
Rpar35 vss.t0 vss.t1 10.3806
Rpar36 vss.t0 vss.t13 25.9718
Rpar37 vss.t0 vss.t26 1689.8940
Rpar38 vss.t0 vss.t27 302.4587
Rpar39 vss.t1 vss.t13 48.2411
Rpar40 vss.t1 vss.t26 505.3601
Rpar41 vss.t1 vss.t27 98.9661
Rpar42 vss.t13 vss.t26 8204.6646
Rpar43 vss.t13 vss.t27 1613.9197
Rpar44 vss.t26 vss.t27 71.5223
Cpar0 a_2916_13098.t0 vss 4.30362e-14
Cpar1 a_2916_13098.t1 vss 9.87310e-15
Cpar2 a_2916_13098.t4 vss 6.41754e-15
Cpar3 a_4830_1290.t0 vss 3.55400e-17
Cpar4 a_4830_2330.t0 vss 4.14600e-17
Cpar5 a_4830_3370.t0 vss 3.88400e-17
Cpar6 a_4830_4410.t0 vss 4.05400e-17
Cpar7 a_4830_5450.t0 vss 3.88600e-17
Cpar8 a_4830_6490.t0 vss 4.10600e-17
Cpar9 a_4830_7530.t0 vss 3.08747e-16
Cpar10 a_4830_7530.t1 vss 8.50830e-15
Cpar11 a_7092_3888.t0 vss 2.39253e-15
Cpar12 a_7092_3888.t4 vss 5.29495e-15
Cpar13 a_7092_3888.t5 vss 1.09595e-15
Cpar14 a_7122_1250.t0 vss 1.92855e-14
Cpar15 a_7122_1250.t2 vss 1.45441e-14
Cpar16 a_852_1290.t0 vss 1.81813e-15
Cpar17 a_852_1290.t4 vss 1.26853e-15
Cpar18 a_852_1290.t5 vss 1.56834e-15
Cpar19 a_852_1290.t7 vss 8.63985e-15
Cpar20 a_852_1810.t0 vss 3.20200e-17
Cpar21 a_852_2850.t0 vss 2.93600e-17
Cpar22 a_852_3890.t0 vss 2.93600e-17
Cpar23 a_852_4930.t0 vss 2.93600e-17
Cpar24 a_852_5970.t0 vss 3.00800e-17
Cpar25 a_852_7010.t0 vss 3.07200e-17
Cpar26 ib vdd 6.00400e-17
Cpar27 ib vss 1.26900e-14
Cpar28 ib.t0 vss 1.44917e-15
Cpar29 ib.t1 vss 7.87000e-17
Cpar30 inn inp 1.03380e-16
Cpar31 inn vdd 6.05816e-15
Cpar32 inn vss 2.74445e-15
Cpar33 inn.t0 vss 6.23199e-15
Cpar34 inp vdd 6.09796e-15
Cpar35 inp vss 2.80029e-15
Cpar36 inp.t0 vss 6.26751e-15
Cpar37 out vdd 1.31760e-14
Cpar38 out vss 2.78398e-14
Cpar39 out.t0 vss 5.71192e-15
Cpar40 out.t16 vss 1.51683e-14
Cpar41 out.t6 vss 4.73788e-15
Cpar42 vdd vss 1.60829e-13
Cpar43 vdd.t0 vss 5.05792e-14
Cpar44 vdd.t1 vss 7.54442e-15
Cpar45 vdd.t6 vss 2.19890e-14
.ends opamp_dut

Vdd vdd 0 1.800000
Vss vss 0 0
Ibias vdd ib 3.250000e-08
Vinp inp 0 DC 0.805000 AC 1 PWL(0 0.805000 8.212160e-07 0.805000 9.033376e-07 0.815000)
Rfb out inn 1m
Cload out 0 2.000000e-12
Xdut vdd vss inp inn out ib opamp_dut
.end
