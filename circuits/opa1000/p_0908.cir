* opa1000[0908]: 2p/telescopic_nmos_3v3_i10u_subth (telescopic_nmos, VDD=3.3V, CL=2.0pF, Iref=2.875uA)
.include "pdk_opa.inc"
.temp 27
.option gmin=1e-12 rshunt=1e12 reltol=1e-3 abstol=1e-12 vntol=1e-5 method=gear
* Post-PEX R+C extracted netlist for telescopic_nmos_3v3_i10u_subth
.subckt opamp_dut vdd vss inp inn out ib
XMpar0 a_3061_20532.t17 a_2305_20324.t200 vdd.t27 vdd.t26 pfet_03v3 w=1.89u l=1.08u ad=5.2920e-13 pd=2.4500e-06 as=5.2920e-13 ps=2.4500e-06 nf=1 m=22 par=22
XMpar1 a_4850_1205.t8 inn.t0 a_9356_10655.t24 vss.t20 nfet_03v3 w=7.5u l=1.13u ad=2.4000e-12 pd=9.0775e-06 as=2.1000e-12 ps=8.0600e-06 nf=1 m=64 par=64
XMpar2 a_4850_1205.t8 inp.t0 a_5196_1205.t0 vss.t20 nfet_03v3 w=7.5u l=1.13u ad=2.4000e-12 pd=9.0775e-06 as=2.1000e-12 ps=8.0600e-06 nf=1 m=64 par=64
XMpar3 a_4850_1205.t0 ib.t0 vss.t1 vss.t0 nfet_03v3 w=4.23u l=1.2u ad=1.1844e-12 pd=4.7900e-06 as=1.5228e-12 ps=6.0075e-06 nf=1 m=8 par=8
XMpar4 a_3061_20532.t0 a_2305_20324.t0 out.t0 vdd.t0 pfet_03v3 w=4.51u l=0.94u ad=1.7138e-12 pd=6.6794e-06 as=1.6236e-12 ps=6.3575e-06 nf=1 m=64 par=64
XMpar5 a_2185_20532.t11 a_2305_20324.t200 vdd.t27 vdd.t26 pfet_03v3 w=1.89u l=1.08u ad=5.8418e-13 pd=2.6800e-06 as=5.2920e-13 ps=2.4500e-06 nf=1 m=22 par=22
XMpar6 a_2305_20324.t129 a_2305_20324.t128 a_5196_1205.t64 vss.t20 nfet_03v3 w=1.9u l=0.94u ad=5.3200e-13 pd=2.4600e-06 as=8.3600e-13 ps=3.7300e-06 nf=1 m=24 par=24
XMpar7 a_2185_20532.t0 a_2305_20324.t0 a_2305_20324.t1 vdd.t0 pfet_03v3 w=4.51u l=0.94u ad=1.7138e-12 pd=6.6794e-06 as=1.5785e-12 ps=6.1966e-06 nf=1 m=64 par=64
XMpar8 a_9356_10655.t0 a_2305_20324.t128 out.t23 vss.t20 nfet_03v3 w=1.9u l=0.94u ad=6.8400e-13 pd=3.0950e-06 as=5.3200e-13 ps=2.4600e-06 nf=1 m=24 par=24
XMpar9 ib.t1 ib.t0 vss.t1 vss.t0 nfet_03v3 w=4.23u l=1.2u ad=1.1844e-12 pd=4.7900e-06 as=1.1844e-12 ps=4.7900e-06 nf=1 m=2 par=2
Rpar0 a_2185_20532.t0 a_2185_20532.t11 68.8381
Rpar1 a_2305_20324.t0 a_2305_20324.t1 5.5574
Rpar2 a_2305_20324.t0 a_2305_20324.t200 389.0049
Rpar3 a_2305_20324.t1 a_2305_20324.t128 1012.3889
Rpar4 a_2305_20324.t1 a_2305_20324.t129 307.1418
Rpar5 a_2305_20324.t1 a_2305_20324.t200 89.7905
Rpar6 a_2305_20324.t128 a_2305_20324.t129 5.2665
Rpar7 a_2305_20324.t128 a_2305_20324.t200 288.0707
Rpar8 a_2305_20324.t129 a_2305_20324.t200 87.3958
Rpar9 a_3061_20532.t0 a_3061_20532.t17 36.9468
Rpar10 a_4850_1205.t0 a_4850_1205.t8 48.9186
Rpar11 a_5196_1205.t0 a_5196_1205.t64 40.5551
Rpar12 a_9356_10655.t0 a_9356_10655.t24 56.3957
Rpar13 ib ib.t0 20.1632
Rpar14 ib ib.t1 8.8268
Rpar15 ib.t0 ib.t1 79.1567
Rpar16 inn inn.t0 2.1297
Rpar17 inp inp.t0 2.1297
Rpar18 out out.t0 259.6445
Rpar19 out out.t23 3.6005
Rpar20 out.t0 out.t23 84.8366
Rpar21 vdd vdd.t0 20.1170
Rpar22 vdd vdd.t27 873.6324
Rpar23 vdd vdd.t26 105.6115
Rpar24 vdd.t0 vdd.t27 2544.2269
Rpar25 vdd.t0 vdd.t26 307.5659
Rpar26 vdd.t27 vdd.t26 3.5949
Rpar27 vss vss.t0 329.2510
Rpar28 vss vss.t1 1584.1532
Rpar29 vss vss.t20 19.7577
Rpar30 vss.t0 vss.t1 5.4272
Rpar31 vss.t0 vss.t20 3.4071
Rpar32 vss.t1 vss.t20 16.5699
Cpar0 a_2185_20532.t0 vss 1.04611e-13
Cpar1 a_2185_20532.t11 vss 2.09870e-14
Cpar2 a_2305_20324.t0 vss 1.35854e-13
Cpar3 a_2305_20324.t1 vss 7.70627e-14
Cpar4 a_2305_20324.t128 vss 3.34114e-14
Cpar5 a_2305_20324.t129 vss 1.84788e-14
Cpar6 a_2305_20324.t200 vss 3.46898e-14
Cpar7 a_3061_20532.t0 vss 1.11179e-13
Cpar8 a_3061_20532.t17 vss 2.05220e-14
Cpar9 a_4850_1205.t0 vss 7.30243e-15
Cpar10 a_4850_1205.t8 vss 1.43919e-13
Cpar11 a_5196_1205.t0 vss 8.10839e-14
Cpar12 a_5196_1205.t64 vss 2.14788e-14
Cpar13 a_9356_10655.t0 vss 2.34305e-14
Cpar14 a_9356_10655.t24 vss 8.67905e-14
Cpar15 ib vss 1.39966e-14
Cpar16 ib.t0 vss 2.79116e-15
Cpar17 ib.t1 vss 3.24647e-16
Cpar18 inn inp 2.05580e-16
Cpar19 inn vss 4.36724e-14
Cpar20 inn.t0 vss 4.47294e-14
Cpar21 inp vss 4.40137e-14
Cpar22 inp.t0 vss 4.47230e-14
Cpar23 out vdd 2.98418e-14
Cpar24 out vss 2.55583e-14
Cpar25 out.t0 vss 1.07638e-13
Cpar26 out.t23 vss 2.26908e-14
Cpar27 vdd vss 4.73100e-13
Cpar28 vdd.t0 vss 1.67646e-13
Cpar29 vdd.t26 vss 3.38076e-14
Cpar30 vdd.t27 vss 7.00263e-15
.ends opamp_dut

Vdd vdd 0 3.300000
Vss vss 0 0
Ibias vdd ib 2.875000e-06
Vinp inp 0 DC 1.711000 AC 1 PWL(0 1.711000 1.343839e-08 1.711000 1.478222e-08 1.721000)
Rfb out inn 1m
Cload out 0 2.000000e-12
Xdut vdd vss inp inn out ib opamp_dut
.end
