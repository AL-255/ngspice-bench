* opa1000[0163]: 2p/current_reuse_3v3_i150u_subth (current_reuse, VDD=3.3V, CL=2.0pF, Iref=21.4286uA)
.include "pdk_opa.inc"
.temp 27
.option gmin=1e-12 rshunt=1e12 reltol=1e-3 abstol=1e-12 vntol=1e-5 method=gear
* Post-PEX R+C extracted netlist for current_reuse_3v3_i150u_subth
.subckt opamp_dut vdd vss inp inn out ib
XMpar0 a_1069_10739.t0 inn.t50 a_949_10531.t0 vdd.t0 pfet_03v3 w=3.75u l=0.44u ad=1.1250e-12 pd=4.5844e-06 as=1.0875e-12 ps=4.4472e-06 nf=1 m=64 par=64
XMpar1 a_1011_14154.t65 inp.t0 a_6538_10783.t0 vss.t0 nfet_03v3 w=1.95u l=0.44u ad=5.7096e-13 pd=2.6136e-06 as=5.7096e-13 ps=2.6136e-06 nf=1 m=50 par=50
XMpar2 a_6538_10783.t0 inn.t0 a_949_10531.t59 vss.t0 nfet_03v3 w=1.95u l=0.44u ad=5.7096e-13 pd=2.6136e-06 as=5.7096e-13 ps=2.6136e-06 nf=1 m=50 par=50
XMpar3 out.t0 ib.t0 vss.t26 vss.t25 nfet_03v3 w=4.12u l=0.52u ad=1.1536e-12 pd=4.6800e-06 as=1.4173e-12 ps=5.6320e-06 nf=1 m=30 par=30
XMpar4 a_1011_14154.t3 inp.t50 a_1069_10739.t0 vdd.t0 pfet_03v3 w=3.75u l=0.44u ad=1.0875e-12 pd=4.4472e-06 as=1.1250e-12 ps=4.5844e-06 nf=1 m=64 par=64
XMpar5 a_6538_10783.t50 ib.t0 vss.t26 vss.t25 nfet_03v3 w=4.12u l=0.52u ad=1.1536e-12 pd=4.6800e-06 as=1.1536e-12 ps=4.6800e-06 nf=1 m=12 par=12
XMpar6 a_1011_14154.t0 a_949_10531.t114 vdd.t44 vdd.t43 pfet_03v3 w=10u l=0.6u ad=3.8667e-12 pd=1.4107e-05 as=2.8000e-12 ps=1.0560e-05 nf=1 m=3 par=3
XMpar7 ib.t1 ib.t0 vss.t26 vss.t25 nfet_03v3 w=4.12u l=0.52u ad=1.1536e-12 pd=4.6800e-06 as=1.5931e-12 ps=6.2667e-06 nf=1 m=6 par=6
XMpar8 a_1069_10739.t64 a_949_10531.t114 vdd.t44 vdd.t43 pfet_03v3 w=10u l=0.6u ad=2.8000e-12 pd=1.0560e-05 as=3.8667e-12 ps=1.4107e-05 nf=1 m=6 par=6
XMpar9 out.t16 a_1011_14154.t118 vdd.t44 vdd.t43 pfet_03v3 w=10u l=0.6u ad=2.8000e-12 pd=1.0560e-05 as=3.0133e-12 ps=1.1269e-05 nf=1 m=30 par=30
XMpar10 a_949_10531.t115 a_949_10531.t114 vdd.t44 vdd.t43 pfet_03v3 w=10u l=0.6u ad=3.8667e-12 pd=1.4107e-05 as=2.8000e-12 ps=1.0560e-05 nf=1 m=3 par=3
X62 a_1343_14154.t1 out.t8 cap_mim_2f0fF c_width=18.91u c_length=18.91u
X73 a_1011_14154.t117 a_1343_14154.t0 vss.t118 ppolyf_u_1k r_width=1u r_length=1u
X76 a_1343_14154.t1 out.t8 cap_mim_2f0fF c_width=18.91u c_length=18.91u
X192 a_1343_14154.t1 out.t8 cap_mim_2f0fF c_width=18.91u c_length=18.91u
X220 a_1343_14154.t1 out.t8 cap_mim_2f0fF c_width=18.91u c_length=18.91u
Rpar0 a_1011_14154.t0 a_1011_14154.t3 495.8305
Rpar1 a_1011_14154.t0 a_1011_14154.t65 456.8721
Rpar2 a_1011_14154.t0 a_1011_14154.t117 927.7338
Rpar3 a_1011_14154.t0 a_1011_14154.t118 49.2453
Rpar4 a_1011_14154.t3 a_1011_14154.t65 64.3365
Rpar5 a_1011_14154.t3 a_1011_14154.t117 130.6429
Rpar6 a_1011_14154.t3 a_1011_14154.t118 1205.5425
Rpar7 a_1011_14154.t65 a_1011_14154.t117 112.6969
Rpar8 a_1011_14154.t65 a_1011_14154.t118 1110.8206
Rpar9 a_1011_14154.t117 a_1011_14154.t118 2255.6551
Rpar10 a_1069_10739.t0 a_1069_10739.t64 39.3578
Rpar11 a_1343_14154.t0 a_1343_14154.t1 70.9116
Rpar12 a_6538_10783.t0 a_6538_10783.t50 60.7437
Rpar13 a_949_10531.t0 a_949_10531.t59 51.7306
Rpar14 a_949_10531.t0 a_949_10531.t114 361.2712
Rpar15 a_949_10531.t0 a_949_10531.t115 1187.6017
Rpar16 a_949_10531.t59 a_949_10531.t114 226.8173
Rpar17 a_949_10531.t59 a_949_10531.t115 745.6134
Rpar18 a_949_10531.t114 a_949_10531.t115 26.1419
Rpar19 ib ib.t0 3.1704
Rpar20 ib ib.t1 436.6742
Rpar21 ib.t0 ib.t1 18.4055
Rpar22 inn inn.t0 1.9600
Rpar23 inn inn.t50 44.7741
Rpar24 inp inp.t0 1.9600
Rpar25 inp inp.t50 44.7255
Rpar26 out out.t0 2.1260
Rpar27 out out.t16 280.1614
Rpar28 out out.t8 1370.5718
Rpar29 out.t0 out.t16 138.7621
Rpar30 out.t0 out.t8 678.8354
Rpar31 out.t16 out.t8 74.9517
Rpar32 vdd vdd.t0 37.3790
Rpar33 vdd vdd.t43 86.3389
Rpar34 vdd vdd.t44 212.1028
Rpar35 vdd.t0 vdd.t43 114.7045
Rpar36 vdd.t0 vdd.t44 281.7865
Rpar37 vdd.t43 vdd.t44 2.0207
Rpar38 vss vss.t0 205.9313
Rpar39 vss vss.t118 163.3851
Rpar40 vss vss.t25 2084.8305
Rpar41 vss vss.t26 1373.6105
Rpar42 vss.t0 vss.t118 169.4033
Rpar43 vss.t0 vss.t25 107.8254
Rpar44 vss.t0 vss.t26 95.9384
Rpar45 vss.t118 vss.t25 1875.7586
Rpar46 vss.t118 vss.t26 1248.7457
Rpar47 vss.t25 vss.t26 3.9568
Cpar0 a_1011_14154.t0 vss 1.72436e-14
Cpar1 a_1011_14154.t117 vss 5.04599e-15
Cpar2 a_1011_14154.t118 vss 4.56681e-14
Cpar3 a_1011_14154.t3 vss 5.28062e-14
Cpar4 a_1011_14154.t65 vss 2.98734e-14
Cpar5 a_1069_10739.t0 vss 1.25275e-13
Cpar6 a_1069_10739.t64 vss 1.62358e-14
Cpar7 a_1343_14154.t0 vss 7.91038e-17
Cpar8 a_1343_14154.t1 vss 1.30734e-14
Cpar9 a_6538_10783.t0 vss 5.02296e-14
Cpar10 a_6538_10783.t50 vss 2.05564e-14
Cpar11 a_949_10531.t0 vss 5.60315e-14
Cpar12 a_949_10531.t114 vss 2.74097e-14
Cpar13 a_949_10531.t115 vss 1.85533e-14
Cpar14 a_949_10531.t59 vss 3.27022e-14
Cpar15 ib out 7.10554e-15
Cpar16 ib vdd 2.40440e-16
Cpar17 ib vss 4.24901e-14
Cpar18 ib.t0 vss 6.20819e-15
Cpar19 ib.t1 vss 1.62972e-15
Cpar20 inn inp 2.09880e-16
Cpar21 inn vdd 2.26674e-14
Cpar22 inn vss 2.68225e-14
Cpar23 inn.t0 vss 1.41082e-14
Cpar24 inn.t50 vss 3.38271e-14
Cpar25 inp out 3.79700e-17
Cpar26 inp vdd 2.29308e-14
Cpar27 inp vss 2.66723e-14
Cpar28 inp.t0 vss 1.40127e-14
Cpar29 inp.t50 vss 3.35960e-14
Cpar30 out vdd 5.07860e-14
Cpar31 out vss 4.36672e-14
Cpar32 out.t0 vss 1.50127e-14
Cpar33 out.t16 vss 3.11348e-14
Cpar34 out.t8 vss 3.42926e-14
Cpar35 vdd vss 3.12793e-13
Cpar36 vdd.t0 vss 8.08208e-14
Cpar37 vdd.t43 vss 5.64864e-14
Cpar38 vdd.t44 vss 2.85563e-14
.ends opamp_dut

Vdd vdd 0 3.300000
Vss vss 0 0
Ibias vdd ib 2.142860e-05
Vinp inp 0 DC 1.645000 AC 1 PWL(0 1.645000 3.000000e-09 1.645000 3.300000e-09 1.655000)
Rfb out inn 1m
Cload out 0 2.000000e-12
Xdut vdd vss inp inn out ib opamp_dut
.end
