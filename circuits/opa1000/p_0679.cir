* opa1000[0679]: 200f/rail_to_rail_1v8_1u_10u_weak (rail_to_rail, VDD=1.8V, CL=0.2pF, Iref=0.8125uA)
.include "pdk_opa.inc"
.temp 27
.option gmin=1e-12 rshunt=1e12 reltol=1e-3 abstol=1e-12 vntol=1e-5 method=gear
* Post-PEX R+C extracted netlist for rail_to_rail_1v8_1u_10u_weak
.subckt opamp_dut vdd vss inp inn out ib
XMpar0 out.t0 a_881_16878.t9 vdd.t1 vdd.t0 pfet_03v3 w=3.68u l=1.5u ad=1.0304e-12 pd=4.2400e-06 as=1.3248e-12 ps=5.3200e-06 nf=1 m=8 par=8
XMpar1 a_1041_7378.t0 inp.t4 a_5338_11685.t0 vdd.t4 pfet_03v3 w=1.81u l=3.2u ad=6.7229e-13 pd=3.0700e-06 as=5.8954e-13 ps=2.7200e-06 nf=1 m=14 par=14
XMpar2 a_1041_7378.t0 inn.t4 a_7732_15307.t0 vdd.t4 pfet_03v3 w=1.81u l=3.2u ad=6.7229e-13 pd=3.0700e-06 as=5.8954e-13 ps=2.7200e-06 nf=1 m=14 par=14
XMpar3 a_7932_9206.t7 a_7932_9206.t6 vdd.t1 vdd.t0 pfet_03v3 w=3.68u l=1.5u ad=1.0304e-12 pd=4.2400e-06 as=1.0304e-12 ps=4.2400e-06 nf=1 m=2 par=2
XMpar4 ib.t1 ib.t0 vss.t19 vss.t18 nfet_03v3 w=0.58u l=1.6u ad=3.4800e-13 pd=2.3600e-06 as=1.6240e-13 ps=1.1400e-06 nf=1 m=2 par=2
XMpar5 a_2377_1204.t0 inp.t0 a_881_16878.t0 vss.t0 nfet_03v3 w=1.53u l=3.2u ad=9.1800e-13 pd=4.2600e-06 as=6.7320e-13 ps=3.1750e-06 nf=1 m=4 par=4
XMpar6 out.t7 ib.t0 vss.t19 vss.t18 nfet_03v3 w=0.58u l=1.6u ad=1.6240e-13 pd=1.1400e-06 as=2.0880e-13 ps=1.4450e-06 nf=1 m=8 par=8
XMpar7 a_7732_15307.t15 a_7732_15307.t14 vss.t4 vss.t3 nfet_03v3 w=0.4u l=2u ad=1.1200e-13 pd=9.6000e-07 as=1.1200e-13 ps=9.6000e-07 nf=1 m=2 par=2
XMpar8 a_1041_7378.t28 a_1161_7170.t0 vdd.t35 vdd.t34 pfet_03v3 w=2.5u l=1.6u ad=1.5000e-12 pd=6.2000e-06 as=7.0000e-13 ps=3.0600e-06 nf=1 m=2 par=2
XMpar9 a_7932_9206.t0 a_5338_11685.t14 vss.t4 vss.t3 nfet_03v3 w=0.4u l=2u ad=1.1200e-13 pd=9.6000e-07 as=1.1200e-13 ps=9.6000e-07 nf=1 m=2 par=2
XMpar10 a_1161_7170.t4 ib.t0 vss.t19 vss.t18 nfet_03v3 w=0.58u l=1.6u ad=1.6240e-13 pd=1.1400e-06 as=1.6240e-13 ps=1.1400e-06 nf=1 m=2 par=2
XMpar11 a_2377_1204.t8 ib.t0 vss.t19 vss.t18 nfet_03v3 w=0.58u l=1.6u ad=3.4800e-13 pd=2.3600e-06 as=1.6240e-13 ps=1.1400e-06 nf=1 m=2 par=2
XMpar12 a_881_16878.t6 a_7732_15307.t14 vss.t4 vss.t3 nfet_03v3 w=0.4u l=2u ad=2.4000e-13 pd=2.0000e-06 as=1.1200e-13 ps=9.6000e-07 nf=1 m=2 par=2
XMpar13 a_881_16878.t4 a_7932_9206.t6 vdd.t1 vdd.t0 pfet_03v3 w=3.68u l=1.5u ad=2.2080e-12 pd=8.5600e-06 as=1.0304e-12 ps=4.2400e-06 nf=1 m=2 par=2
XMpar14 a_2377_1204.t0 inn.t0 a_7932_9206.t1 vss.t0 nfet_03v3 w=1.53u l=3.2u ad=9.1800e-13 pd=4.2600e-06 as=6.7320e-13 ps=3.1750e-06 nf=1 m=4 par=4
XMpar15 a_1161_7170.t1 a_1161_7170.t0 vdd.t35 vdd.t34 pfet_03v3 w=2.5u l=1.6u ad=7.0000e-13 pd=3.0600e-06 as=7.0000e-13 ps=3.0600e-06 nf=1 m=2 par=2
XMpar16 a_5338_11685.t15 a_5338_11685.t14 vss.t4 vss.t3 nfet_03v3 w=0.4u l=2u ad=2.4000e-13 pd=2.0000e-06 as=1.1200e-13 ps=9.6000e-07 nf=1 m=2 par=2
X29 a_11228_1810.t0 a_14328_2330.t0 vss.t15 ppolyf_u_1k r_width=1u r_length=14.84u
X31 a_14328_2330.t1 out.t5 cap_mim_2f0fF c_width=12.99u c_length=12.99u
X37 a_11228_1810.t0 a_14328_1290.t0 vss.t15 ppolyf_u_1k r_width=1u r_length=14.84u
X67 a_881_16878.t8 a_14328_1290.t0 vss.t15 ppolyf_u_1k r_width=1u r_length=14.84u
Rpar0 a_1041_7378.t0 a_1041_7378.t28 48.5254
Rpar1 a_1161_7170.t0 a_1161_7170.t1 23.5927
Rpar2 a_1161_7170.t0 a_1161_7170.t4 175.3872
Rpar3 a_1161_7170.t1 a_1161_7170.t4 101.6609
Rpar4 a_14328_2330.t0 a_14328_2330.t1 103.2800
Rpar5 a_2377_1204.t0 a_2377_1204.t8 65.2576
Rpar6 a_5338_11685.t0 a_5338_11685.t14 174.1284
Rpar7 a_5338_11685.t0 a_5338_11685.t15 121.1367
Rpar8 a_5338_11685.t14 a_5338_11685.t15 21.4732
Rpar9 a_7732_15307.t0 a_7732_15307.t14 105.7733
Rpar10 a_7732_15307.t0 a_7732_15307.t15 108.4229
Rpar11 a_7732_15307.t14 a_7732_15307.t15 30.4803
Rpar12 a_7932_9206.t0 a_7932_9206.t1 201.8497
Rpar13 a_7932_9206.t0 a_7932_9206.t6 390.9013
Rpar14 a_7932_9206.t0 a_7932_9206.t7 159.4415
Rpar15 a_7932_9206.t1 a_7932_9206.t6 226.7268
Rpar16 a_7932_9206.t1 a_7932_9206.t7 92.4777
Rpar17 a_7932_9206.t6 a_7932_9206.t7 24.9394
Rpar18 a_881_16878.t0 a_881_16878.t9 416.8066
Rpar19 a_881_16878.t0 a_881_16878.t4 74.0829
Rpar20 a_881_16878.t0 a_881_16878.t6 382.3691
Rpar21 a_881_16878.t0 a_881_16878.t8 129.7775
Rpar22 a_881_16878.t9 a_881_16878.t4 201.9070
Rpar23 a_881_16878.t9 a_881_16878.t6 70.2458
Rpar24 a_881_16878.t9 a_881_16878.t8 2026.4341
Rpar25 a_881_16878.t4 a_881_16878.t6 185.2250
Rpar26 a_881_16878.t4 a_881_16878.t8 360.1768
Rpar27 a_881_16878.t6 a_881_16878.t8 1859.0056
Rpar28 ib ib.t0 23.3338
Rpar29 ib ib.t1 10.6996
Rpar30 ib.t0 ib.t1 53.8475
Rpar31 inn inn.t0 4.5761
Rpar32 inn inn.t4 47.6988
Rpar33 inp inp.t0 4.5764
Rpar34 inp inp.t4 47.6502
Rpar35 out out.t0 165.6493
Rpar36 out out.t7 4.9379
Rpar37 out out.t5 51.2640
Rpar38 out.t0 out.t5 671.9131
Rpar39 vdd vdd.t0 67.7725
Rpar40 vdd vdd.t1 147.6606
Rpar41 vdd vdd.t4 113.3529
Rpar42 vdd vdd.t34 2382.0373
Rpar43 vdd vdd.t35 2926.9134
Rpar44 vdd.t0 vdd.t1 3.3050
Rpar45 vdd.t0 vdd.t4 86.5298
Rpar46 vdd.t0 vdd.t34 201.5374
Rpar47 vdd.t0 vdd.t35 247.6378
Rpar48 vdd.t1 vdd.t4 187.8287
Rpar49 vdd.t1 vdd.t34 434.1192
Rpar50 vdd.t1 vdd.t35 533.4212
Rpar51 vdd.t4 vdd.t34 758.7555
Rpar52 vdd.t4 vdd.t35 932.3161
Rpar53 vdd.t34 vdd.t35 10.0940
Rpar54 vss vss.t0 130.0883
Rpar55 vss vss.t4 1027.9615
Rpar56 vss vss.t3 1162.1648
Rpar57 vss vss.t15 143.1253
Rpar58 vss vss.t18 58.1573
Rpar59 vss vss.t19 325.9682
Rpar60 vss.t0 vss.t4 356.3110
Rpar61 vss.t0 vss.t3 402.8454
Rpar62 vss.t0 vss.t15 45.8120
Rpar63 vss.t0 vss.t18 3.1267
Rpar64 vss.t0 vss.t19 25.9864
Rpar65 vss.t4 vss.t3 9.4037
Rpar66 vss.t4 vss.t15 395.0381
Rpar67 vss.t4 vss.t18 256.1322
Rpar68 vss.t3 vss.t15 446.7964
Rpar69 vss.t3 vss.t18 289.6238
Rpar70 vss.t15 vss.t18 33.3022
Rpar71 vss.t15 vss.t19 320.2825
Rpar72 vss.t18 vss.t19 5.7165
Cpar0 a_1041_7378.t0 vss 3.04218e-14
Cpar1 a_1041_7378.t28 vss 6.71854e-15
Cpar2 a_11228_1810.t0 vss 3.21600e-17
Cpar3 a_1161_7170.t0 vss 5.58982e-15
Cpar4 a_1161_7170.t1 vss 3.13415e-15
Cpar5 a_1161_7170.t4 vss 3.76903e-15
Cpar6 a_14328_1290.t0 vss 2.91000e-17
Cpar7 a_14328_2330.t0 vss 5.78060e-16
Cpar8 a_14328_2330.t1 vss 7.42883e-15
Cpar9 a_2377_1204.t0 vss 1.45089e-14
Cpar10 a_2377_1204.t8 vss 6.52181e-15
Cpar11 a_5338_11685.t0 vss 1.41660e-14
Cpar12 a_5338_11685.t14 vss 6.16107e-15
Cpar13 a_5338_11685.t15 vss 3.25579e-15
Cpar14 a_7732_15307.t0 vss 1.25934e-14
Cpar15 a_7732_15307.t14 vss 5.83497e-15
Cpar16 a_7732_15307.t15 vss 1.93121e-15
Cpar17 a_7932_9206.t0 vss 3.28197e-15
Cpar18 a_7932_9206.t1 vss 5.22203e-15
Cpar19 a_7932_9206.t6 vss 5.30449e-15
Cpar20 a_7932_9206.t7 vss 3.77771e-15
Cpar21 a_881_16878.t0 vss 8.11422e-15
Cpar22 a_881_16878.t4 vss 7.11343e-15
Cpar23 a_881_16878.t6 vss 4.36687e-15
Cpar24 a_881_16878.t8 vss 5.10702e-15
Cpar25 a_881_16878.t9 vss 1.48705e-14
Cpar26 ib out 1.15866e-15
Cpar27 ib vss 1.81906e-14
Cpar28 ib.t0 vss 6.01781e-15
Cpar29 ib.t1 vss 5.33895e-16
Cpar30 inn inp 1.91040e-16
Cpar31 inn vdd 1.88342e-14
Cpar32 inn vss 1.61141e-14
Cpar33 inn.t0 vss 5.29125e-15
Cpar34 inn.t4 vss 2.45833e-14
Cpar35 inp out 5.31260e-16
Cpar36 inp vdd 1.98737e-14
Cpar37 inp vss 1.33116e-14
Cpar38 inp.t0 vss 5.97771e-15
Cpar39 inp.t4 vss 2.77707e-14
Cpar40 out vdd 7.70182e-15
Cpar41 out vss 2.46026e-14
Cpar42 out.t0 vss 9.58977e-15
Cpar43 out.t5 vss 8.90986e-15
Cpar44 out.t7 vss 1.06188e-15
Cpar45 vdd vss 1.89495e-13
Cpar46 vdd.t0 vss 1.68622e-14
Cpar47 vdd.t1 vss 8.61176e-15
Cpar48 vdd.t34 vss 5.49038e-15
Cpar49 vdd.t35 vss 3.91836e-15
Cpar50 vdd.t4 vss 5.28552e-14
.ends opamp_dut

Vdd vdd 0 1.800000
Vss vss 0 0
Ibias vdd ib 8.125000e-07
Vinp inp 0 DC 0.895000 AC 1 PWL(0 0.895000 1.694779e-08 0.895000 1.864257e-08 0.905000)
Rfb out inn 1m
Cload out 0 2.000000e-13
Xdut vdd vss inp inn out ib opamp_dut
.end
