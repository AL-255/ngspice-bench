* opa1000[0283]: 200f/folded_cascode_pmos_3v3_i10u_subth (folded_cascode_pmos, VDD=3.3V, CL=0.2pF, Iref=2.8889uA)
.include "pdk_opa.inc"
.temp 27
.option gmin=1e-12 rshunt=1e12 reltol=1e-3 abstol=1e-12 vntol=1e-5 method=gear
* Post-PEX R+C extracted netlist for folded_cascode_pmos_3v3_i10u_subth
.subckt opamp_dut vdd vss inp inn out ib
XMpar0 a_1542_1205.t1 inp.t0 a_1888_1205.t1 vdd.t2 pfet_03v3 w=7.65u l=1.13u ad=2.2950e-12 pd=8.7281e-06 as=2.2185e-12 ps=8.4691e-06 nf=1 m=64 par=64
XMpar1 a_1888_1205.t0 a_4366_13919.t10 a_4592_14127.t0 vss.t0 nfet_03v3 w=1.97u l=1.13u ad=6.4166e-13 pd=2.9029e-06 as=5.5160e-13 ps=2.5300e-06 nf=1 m=14 par=14
XMpar2 a_1888_1205.t69 ib.t0 vss.t16 vss.t0 nfet_03v3 w=3.04u l=0.9u ad=8.5120e-13 pd=3.6000e-06 as=1.3376e-12 ps=5.4400e-06 nf=1 m=4 par=4
XMpar3 a_1542_1205.t1 inn.t0 a_9294_14127.t8 vdd.t2 pfet_03v3 w=7.65u l=1.13u ad=2.2950e-12 pd=8.7281e-06 as=2.2185e-12 ps=8.4691e-06 nf=1 m=64 par=64
XMpar4 a_9294_14127.t0 a_4366_13919.t10 out.t0 vss.t0 nfet_03v3 w=1.97u l=1.13u ad=6.4166e-13 pd=2.9029e-06 as=5.5160e-13 ps=2.5300e-06 nf=1 m=14 par=14
XMpar5 a_9294_14127.t72 ib.t0 vss.t16 vss.t0 nfet_03v3 w=3.04u l=0.9u ad=8.5120e-13 pd=3.6000e-06 as=1.3376e-12 ps=5.4400e-06 nf=1 m=4 par=4
XMpar6 a_4592_14127.t10 a_4592_14127.t9 vdd.t1 vdd.t0 pfet_03v3 w=10u l=1.08u ad=6.0000e-12 pd=2.1200e-05 as=2.8000e-12 ps=1.0560e-05 nf=1 m=2 par=2
XMpar7 a_1542_1205.t0 a_4366_13919.t0 vdd.t1 vdd.t0 pfet_03v3 w=10u l=1.08u ad=2.8000e-12 pd=1.0560e-05 as=4.4000e-12 ps=1.5880e-05 nf=1 m=4 par=4
XMpar8 ib.t1 ib.t0 vss.t16 vss.t0 nfet_03v3 w=3.04u l=0.9u ad=1.8240e-12 pd=7.2800e-06 as=8.5120e-13 ps=3.6000e-06 nf=1 m=2 par=2
XMpar9 a_4366_13919.t1 a_4366_13919.t0 vdd.t1 vdd.t0 pfet_03v3 w=10u l=1.08u ad=2.8000e-12 pd=1.0560e-05 as=2.8000e-12 ps=1.0560e-05 nf=1 m=2 par=2
XMpar10 out.t8 a_4592_14127.t9 vdd.t1 vdd.t0 pfet_03v3 w=10u l=1.08u ad=2.8000e-12 pd=1.0560e-05 as=2.8000e-12 ps=1.0560e-05 nf=1 m=2 par=2
XMpar11 a_4366_13919.t4 ib.t0 vss.t16 vss.t0 nfet_03v3 w=3.04u l=0.9u ad=8.5120e-13 pd=3.6000e-06 as=8.5120e-13 ps=3.6000e-06 nf=1 m=2 par=2
X74 out.t16 vss.t11 cap_mim_2f0fF c_width=16.21u c_length=16.2u
X90 out.t16 vss.t11 cap_mim_2f0fF c_width=16.21u c_length=16.2u
Rpar0 a_1542_1205.t0 a_1542_1205.t1 52.1765
Rpar1 a_1888_1205.t0 a_1888_1205.t1 51.3995
Rpar2 a_1888_1205.t0 a_1888_1205.t69 77.7646
Rpar3 a_1888_1205.t1 a_1888_1205.t69 211.0289
Rpar4 a_4366_13919.t0 a_4366_13919.t1 32.8991
Rpar5 a_4366_13919.t0 a_4366_13919.t10 206.3027
Rpar6 a_4366_13919.t0 a_4366_13919.t4 172.7953
Rpar7 a_4366_13919.t1 a_4366_13919.t10 78.1478
Rpar8 a_4366_13919.t1 a_4366_13919.t4 65.4551
Rpar9 a_4366_13919.t10 a_4366_13919.t4 58.4246
Rpar10 a_4592_14127.t0 a_4592_14127.t10 96.2143
Rpar11 a_4592_14127.t0 a_4592_14127.t9 663.3139
Rpar12 a_4592_14127.t10 a_4592_14127.t9 26.9547
Rpar13 a_9294_14127.t0 a_9294_14127.t8 51.3995
Rpar14 a_9294_14127.t0 a_9294_14127.t72 77.7646
Rpar15 a_9294_14127.t8 a_9294_14127.t72 211.0289
Rpar16 ib ib.t0 12.5586
Rpar17 ib ib.t1 3.7457
Rpar18 ib.t0 ib.t1 331.8723
Rpar19 inn inn.t0 1.9719
Rpar20 inp inp.t0 1.9719
Rpar21 out out.t0 74.9475
Rpar22 out out.t16 369.1880
Rpar23 out out.t8 6.7493
Rpar24 out.t0 out.t16 87.9590
Rpar25 out.t0 out.t8 683.1289
Rpar26 out.t16 out.t8 3365.0635
Rpar27 vdd vdd.t0 140.4842
Rpar28 vdd vdd.t1 485.3947
Rpar29 vdd vdd.t2 204.1271
Rpar30 vdd.t0 vdd.t1 3.6769
Rpar31 vdd.t0 vdd.t2 50.0956
Rpar32 vdd.t1 vdd.t2 173.0881
Rpar33 vss vss.t0 113.7067
Rpar34 vss vss.t11 722.4550
Rpar35 vss vss.t16 514.0931
Rpar36 vss.t0 vss.t11 46.2485
Rpar37 vss.t0 vss.t16 2.9076
Rpar38 vss.t11 vss.t16 379.1610
Cpar0 a_1542_1205.t0 vss 8.95376e-15
Cpar1 a_1542_1205.t1 vss 1.59181e-13
Cpar2 a_1888_1205.t0 vss 1.02690e-14
Cpar3 a_1888_1205.t1 vss 8.43437e-14
Cpar4 a_1888_1205.t69 vss 4.91148e-15
Cpar5 a_4366_13919.t0 vss 6.79781e-15
Cpar6 a_4366_13919.t1 vss 2.88705e-15
Cpar7 a_4366_13919.t10 vss 1.22250e-14
Cpar8 a_4366_13919.t4 vss 1.31699e-15
Cpar9 a_4592_14127.t0 vss 7.41416e-15
Cpar10 a_4592_14127.t10 vss 8.24812e-15
Cpar11 a_4592_14127.t9 vss 6.20634e-15
Cpar12 a_9294_14127.t0 vss 1.02793e-14
Cpar13 a_9294_14127.t72 vss 4.91646e-15
Cpar14 a_9294_14127.t8 vss 8.44292e-14
Cpar15 ib vdd 2.19310e-16
Cpar16 ib vss 1.48046e-14
Cpar17 ib.t0 vss 2.27027e-15
Cpar18 ib.t1 vss 3.57058e-16
Cpar19 inn inp 9.25500e-17
Cpar20 inn vdd 3.71314e-14
Cpar21 inn vss 1.09231e-14
Cpar22 inn.t0 vss 7.64989e-14
Cpar23 inp vdd 3.71097e-14
Cpar24 inp vss 1.11662e-14
Cpar25 inp.t0 vss 7.66407e-14
Cpar26 out vdd 8.24640e-15
Cpar27 out vss 2.14033e-14
Cpar28 out.t0 vss 8.99299e-16
Cpar29 out.t16 vss 1.70126e-14
Cpar30 out.t8 vss 2.72939e-16
Cpar31 vdd vss 4.51869e-13
Cpar32 vdd.t0 vss 1.56025e-14
Cpar33 vdd.t1 vss 7.13012e-15
Cpar34 vdd.t2 vss 1.12664e-13
.ends opamp_dut

Vdd vdd 0 3.300000
Vss vss 0 0
Ibias vdd ib 2.888900e-06
Vinp inp 0 DC 1.381000 AC 1 PWL(0 1.381000 1.355418e-08 1.381000 1.490960e-08 1.391000)
Rfb out inn 1m
Cload out 0 2.000000e-13
Xdut vdd vss inp inn out ib opamp_dut
.end
