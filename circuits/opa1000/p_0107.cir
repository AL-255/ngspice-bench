* opa1000[0107]: 200f/current_reuse_3v3_i200n_subth (current_reuse, VDD=3.3V, CL=0.2pF, Iref=0.0286uA)
.include "pdk_opa.inc"
.temp 27
.option gmin=1e-12 rshunt=1e12 reltol=1e-3 abstol=1e-12 vntol=1e-5 method=gear
* Post-PEX R+C extracted netlist for current_reuse_3v3_i200n_subth
.subckt opamp_dut vdd vss inp inn out ib
XMpar0 a_9042_5900.t2 ib.t0 vss.t6 vss.t5 nfet_03v3 w=0.4u l=7.5u ad=2.4000e-13 pd=2.0000e-06 as=1.1200e-13 ps=9.6000e-07 nf=1 m=4 par=4
XMpar1 a_880_5940.t2 inp.t0 a_9042_5900.t0 vss.t2 nfet_03v3 w=0.58u l=2.88u ad=1.6240e-13 pd=1.1400e-06 as=3.4800e-13 ps=2.3600e-06 nf=1 m=2 par=2
XMpar2 a_9042_9356.t0 a_9924_10884.t4 vdd.t1 vdd.t0 pfet_03v3 w=2.5u l=4u ad=7.0000e-13 pd=3.0600e-06 as=1.5000e-12 ps=6.2000e-06 nf=1 m=2 par=2
XMpar3 out.t0 a_880_5940.t6 vdd.t1 vdd.t0 pfet_03v3 w=2.5u l=4u ad=7.0000e-13 pd=3.0600e-06 as=8.6000e-13 ps=3.6880e-06 nf=1 m=10 par=10
XMpar4 a_880_5940.t0 inp.t2 a_9042_9356.t1 vdd.t8 pfet_03v3 w=1.58u l=2.88u ad=4.4240e-13 pd=2.1400e-06 as=9.4800e-13 ps=4.3600e-06 nf=1 m=2 par=2
XMpar5 ib.t1 ib.t0 vss.t6 vss.t5 nfet_03v3 w=0.4u l=7.5u ad=2.4000e-13 pd=2.0000e-06 as=1.1200e-13 ps=9.6000e-07 nf=1 m=2 par=2
XMpar6 a_9042_5900.t0 inn.t0 a_9924_10884.t2 vss.t2 nfet_03v3 w=0.58u l=2.88u ad=3.4800e-13 pd=2.3600e-06 as=1.6240e-13 ps=1.1400e-06 nf=1 m=2 par=2
XMpar7 out.t4 ib.t0 vss.t6 vss.t5 nfet_03v3 w=0.4u l=7.5u ad=1.8880e-13 pd=1.5840e-06 as=1.6320e-13 ps=1.3760e-06 nf=1 m=10 par=10
XMpar8 a_880_5940.t5 a_9924_10884.t4 vdd.t1 vdd.t0 pfet_03v3 w=2.5u l=4u ad=1.5000e-12 pd=6.2000e-06 as=7.0000e-13 ps=3.0600e-06 nf=1 m=1
XMpar9 a_9042_9356.t1 inn.t2 a_9924_10884.t0 vdd.t8 pfet_03v3 w=1.58u l=2.88u ad=9.4800e-13 pd=4.3600e-06 as=4.4240e-13 ps=2.1400e-06 nf=1 m=2 par=2
XMpar10 a_9924_10884.t5 a_9924_10884.t4 vdd.t1 vdd.t0 pfet_03v3 w=2.5u l=4u ad=1.5000e-12 pd=6.2000e-06 as=7.0000e-13 ps=3.0600e-06 nf=1 m=1
X1 a_880_8540.t0 a_4858_8020.t0 vss.t0 ppolyf_u_1k r_width=1u r_length=19.23u
X7 a_880_11660.t0 a_4858_12180.t0 vss.t0 ppolyf_u_1k r_width=1u r_length=19.23u
X11 a_880_7500.t0 a_4858_8020.t0 vss.t0 ppolyf_u_1k r_width=1u r_length=19.23u
X15 a_880_11660.t0 a_4858_11140.t0 vss.t0 ppolyf_u_1k r_width=1u r_length=19.23u
X20 a_880_7500.t0 a_4858_6980.t0 vss.t0 ppolyf_u_1k r_width=1u r_length=19.23u
X23 a_880_10620.t0 a_4858_11140.t0 vss.t0 ppolyf_u_1k r_width=1u r_length=19.23u
X29 a_880_10620.t0 a_4858_10100.t0 vss.t0 ppolyf_u_1k r_width=1u r_length=19.23u
X33 a_880_9580.t0 a_4858_10100.t0 vss.t0 ppolyf_u_1k r_width=1u r_length=19.23u
X34 a_880_6460.t0 a_4858_6980.t0 vss.t0 ppolyf_u_1k r_width=1u r_length=19.23u
X40 a_4858_12180.t1 out.t16 cap_mim_2f0fF c_width=15u c_length=15u
X42 a_880_9580.t0 a_4858_9060.t0 vss.t0 ppolyf_u_1k r_width=1u r_length=19.23u
X43 a_880_6460.t0 a_4858_5940.t0 vss.t0 ppolyf_u_1k r_width=1u r_length=19.23u
X46 a_880_5940.t4 a_4858_5940.t0 vss.t0 ppolyf_u_1k r_width=1u r_length=19.23u
X48 a_880_8540.t0 a_4858_9060.t0 vss.t0 ppolyf_u_1k r_width=1u r_length=19.23u
Rpar0 a_4858_12180.t0 a_4858_12180.t1 55.8986
Rpar1 a_880_5940.t0 a_880_5940.t6 127.7794
Rpar2 a_880_5940.t0 a_880_5940.t2 292.4900
Rpar3 a_880_5940.t0 a_880_5940.t4 168.9806
Rpar4 a_880_5940.t0 a_880_5940.t5 93.6672
Rpar5 a_880_5940.t6 a_880_5940.t2 136.4813
Rpar6 a_880_5940.t6 a_880_5940.t4 78.8495
Rpar7 a_880_5940.t6 a_880_5940.t5 172.6122
Rpar8 a_880_5940.t2 a_880_5940.t4 169.1146
Rpar9 a_880_5940.t2 a_880_5940.t5 395.1135
Rpar10 a_880_5940.t4 a_880_5940.t5 228.2693
Rpar11 a_9042_5900.t0 a_9042_5900.t2 55.8106
Rpar12 a_9042_9356.t0 a_9042_9356.t1 53.4510
Rpar13 a_9924_10884.t0 a_9924_10884.t2 599.8714
Rpar14 a_9924_10884.t0 a_9924_10884.t4 87.1274
Rpar15 a_9924_10884.t0 a_9924_10884.t5 73.7524
Rpar16 a_9924_10884.t2 a_9924_10884.t4 67.1434
Rpar17 a_9924_10884.t2 a_9924_10884.t5 1144.8374
Rpar18 a_9924_10884.t4 a_9924_10884.t5 25.1155
Rpar19 ib ib.t0 19.8255
Rpar20 ib ib.t1 16.2333
Rpar21 ib.t0 ib.t1 34.4712
Rpar22 inn inn.t0 3.6183
Rpar23 inn inn.t2 79.3515
Rpar24 inp inp.t0 3.6669
Rpar25 inp inp.t2 153.5734
Rpar26 out out.t0 1871.1711
Rpar27 out out.t4 5.1225
Rpar28 out out.t16 834.6421
Rpar29 out.t0 out.t4 255.2059
Rpar30 out.t0 out.t16 163.2464
Rpar31 out.t4 out.t16 113.8354
Rpar32 vdd vdd.t0 67.3788
Rpar33 vdd vdd.t1 57.0672
Rpar34 vdd vdd.t8 238.0410
Rpar35 vdd.t0 vdd.t1 3.7613
Rpar36 vdd.t0 vdd.t8 45.6386
Rpar37 vdd.t1 vdd.t8 86.0372
Rpar38 vss vss.t0 542.7631
Rpar39 vss vss.t6 55.4503
Rpar40 vss vss.t5 231.6550
Rpar41 vss vss.t2 138.6421
Rpar42 vss.t0 vss.t6 481.9590
Rpar43 vss.t0 vss.t5 170.3305
Rpar44 vss.t0 vss.t2 98.3005
Rpar45 vss.t6 vss.t5 34.6536
Rpar46 vss.t6 vss.t2 21.9324
Rpar47 vss.t5 vss.t2 4.2153
Cpar0 a_4858_10100.t0 vss 3.77800e-17
Cpar1 a_4858_11140.t0 vss 3.73000e-17
Cpar2 a_4858_12180.t0 vss 2.60760e-16
Cpar3 a_4858_12180.t1 vss 5.07425e-15
Cpar4 a_4858_5940.t0 vss 3.54000e-17
Cpar5 a_4858_6980.t0 vss 4.46000e-17
Cpar6 a_4858_8020.t0 vss 4.11200e-17
Cpar7 a_4858_9060.t0 vss 3.72000e-17
Cpar8 a_880_10620.t0 vss 3.83200e-17
Cpar9 a_880_11660.t0 vss 3.74800e-17
Cpar10 a_880_5940.t0 vss 2.25752e-15
Cpar11 a_880_5940.t2 vss 1.84917e-15
Cpar12 a_880_5940.t4 vss 2.58394e-15
Cpar13 a_880_5940.t5 vss 2.59822e-15
Cpar14 a_880_5940.t6 vss 2.49785e-14
Cpar15 a_880_6460.t0 vss 4.02400e-17
Cpar16 a_880_7500.t0 vss 3.75800e-17
Cpar17 a_880_8540.t0 vss 3.75800e-17
Cpar18 a_880_9580.t0 vss 3.75800e-17
Cpar19 a_9042_5900.t0 vss 7.11988e-15
Cpar20 a_9042_5900.t2 vss 2.23575e-14
Cpar21 a_9042_9356.t0 vss 4.85069e-15
Cpar22 a_9042_9356.t1 vss 5.54878e-15
Cpar23 a_9924_10884.t0 vss 3.21707e-15
Cpar24 a_9924_10884.t2 vss 2.62494e-15
Cpar25 a_9924_10884.t4 vss 1.56581e-14
Cpar26 a_9924_10884.t5 vss 3.08352e-15
Cpar27 ib out 2.38349e-15
Cpar28 ib vss 8.08065e-14
Cpar29 ib.t0 vss 1.24436e-14
Cpar30 ib.t1 vss 9.04226e-16
Cpar31 inn inp 9.13790e-16
Cpar32 inn out 1.61500e-17
Cpar33 inn vdd 4.93992e-15
Cpar34 inn vss 9.28971e-15
Cpar35 inn.t0 vss 9.33361e-16
Cpar36 inn.t2 vss 4.74747e-15
Cpar37 inp vdd 7.45713e-15
Cpar38 inp vss 2.01293e-14
Cpar39 inp.t0 vss 9.95617e-16
Cpar40 inp.t2 vss 8.23275e-15
Cpar41 out vdd 1.22961e-14
Cpar42 out vss 3.47265e-14
Cpar43 out.t0 vss 1.01425e-14
Cpar44 out.t16 vss 1.22730e-14
Cpar45 out.t4 vss 9.61134e-15
Cpar46 vdd vss 1.22852e-13
Cpar47 vdd.t0 vss 2.64124e-14
Cpar48 vdd.t1 vss 2.06080e-14
Cpar49 vdd.t8 vss 9.79456e-15
.ends opamp_dut

Vdd vdd 0 3.300000
Vss vss 0 0
Ibias vdd ib 2.860000e-08
Vinp inp 0 DC 1.645000 AC 1 PWL(0 1.645000 3.427676e-07 1.645000 3.770444e-07 1.655000)
Rfb out inn 1m
Cload out 0 2.000000e-13
Xdut vdd vss inp inn out ib opamp_dut
.end
