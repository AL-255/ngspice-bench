* opa1000[0605]: 200f/pmos_miller_3v3_i50n_subth (pmos_miller, VDD=3.3V, CL=0.2pF, Iref=0.0066uA)
.include "pdk_opa.inc"
.temp 27
.option gmin=1e-12 rshunt=1e12 reltol=1e-3 abstol=1e-12 vntol=1e-5 method=gear
* Post-PEX R+C extracted netlist for pmos_miller_3v3_i50n_subth
.subckt opamp_dut vdd vss inp inn out ib
XMpar0 a_6002_9030.t0 inp.t0 a_954_1290.t2 vdd.t0 pfet_03v3 w=1.69u l=4.4u ad=6.5347e-13 pd=3.0267e-06 as=6.5347e-13 ps=3.0267e-06 nf=1 m=6 par=6
XMpar1 out.t0 a_954_1290.t9 vss.t2 vss.t1 nfet_03v3 w=0.4u l=4u ad=1.1200e-13 pd=9.6000e-07 as=1.3760e-13 ps=1.1680e-06 nf=1 m=10 par=10
XMpar2 out.t3 a_7225_4202.t2 vdd.t4 vdd.t3 pfet_03v3 w=0.4u l=5u ad=1.8880e-13 pd=1.5840e-06 as=1.6320e-13 ps=1.3760e-06 nf=1 m=10 par=10
XMpar3 a_6002_9030.t0 inn.t0 a_8590_12867.t0 vdd.t0 pfet_03v3 w=1.69u l=4.4u ad=6.5347e-13 pd=3.0267e-06 as=6.5347e-13 ps=3.0267e-06 nf=1 m=6 par=6
XMpar4 a_8590_12867.t7 a_8590_12867.t6 vss.t2 vss.t1 nfet_03v3 w=0.4u l=4u ad=2.4000e-13 pd=2.0000e-06 as=1.1200e-13 ps=9.6000e-07 nf=1 m=2 par=2
XMpar5 a_6002_9030.t12 a_7225_4202.t2 vdd.t4 vdd.t3 pfet_03v3 w=0.4u l=5u ad=2.4000e-13 pd=2.0000e-06 as=1.1200e-13 ps=9.6000e-07 nf=1 m=4 par=4
XMpar6 a_7225_4202.t0 ib.t0 vss.t28 vss.t27 nfet_03v3 w=0.4u l=5u ad=1.1200e-13 pd=9.6000e-07 as=1.1200e-13 ps=9.6000e-07 nf=1 m=2 par=2
XMpar7 ib.t1 ib.t0 vss.t28 vss.t27 nfet_03v3 w=0.4u l=5u ad=2.4000e-13 pd=2.0000e-06 as=1.1200e-13 ps=9.6000e-07 nf=1 m=2 par=2
XMpar8 a_954_1290.t0 a_8590_12867.t6 vss.t2 vss.t1 nfet_03v3 w=0.4u l=4u ad=2.4000e-13 pd=2.0000e-06 as=1.1200e-13 ps=9.6000e-07 nf=1 m=2 par=2
XMpar9 a_7225_4202.t3 a_7225_4202.t2 vdd.t4 vdd.t3 pfet_03v3 w=0.4u l=5u ad=2.4000e-13 pd=2.0000e-06 as=1.1200e-13 ps=9.6000e-07 nf=1 m=2 par=2
X1 a_954_4930.t0 a_4932_5450.t0 vss.t0 ppolyf_u_1k r_width=1u r_length=19.23u
X2 a_954_1810.t0 a_4932_2330.t0 vss.t0 ppolyf_u_1k r_width=1u r_length=19.23u
X7 a_954_4930.t0 a_4932_4410.t0 vss.t0 ppolyf_u_1k r_width=1u r_length=19.23u
X8 a_4932_7530.t1 out.t9 cap_mim_2f0fF c_width=12.2u c_length=12.2u
X9 a_954_1810.t0 a_4932_1290.t0 vss.t0 ppolyf_u_1k r_width=1u r_length=19.23u
X14 a_954_7010.t0 a_4932_7530.t0 vss.t0 ppolyf_u_1k r_width=1u r_length=19.23u
X16 a_954_3890.t0 a_4932_4410.t0 vss.t0 ppolyf_u_1k r_width=1u r_length=19.23u
X23 a_954_7010.t0 a_4932_6490.t0 vss.t0 ppolyf_u_1k r_width=1u r_length=19.23u
X30 a_954_1290.t1 a_4932_1290.t0 vss.t0 ppolyf_u_1k r_width=1u r_length=19.23u
X36 a_954_3890.t0 a_4932_3370.t0 vss.t0 ppolyf_u_1k r_width=1u r_length=19.23u
X47 a_954_5970.t0 a_4932_6490.t0 vss.t0 ppolyf_u_1k r_width=1u r_length=19.23u
X49 a_954_2850.t0 a_4932_3370.t0 vss.t0 ppolyf_u_1k r_width=1u r_length=19.23u
X53 a_954_5970.t0 a_4932_5450.t0 vss.t0 ppolyf_u_1k r_width=1u r_length=19.23u
X57 a_954_2850.t0 a_4932_2330.t0 vss.t0 ppolyf_u_1k r_width=1u r_length=19.23u
Rpar0 a_4932_7530.t0 a_4932_7530.t1 61.9576
Rpar1 a_6002_9030.t0 a_6002_9030.t12 133.0579
Rpar2 a_7225_4202.t0 a_7225_4202.t2 145.6743
Rpar3 a_7225_4202.t0 a_7225_4202.t3 130.2896
Rpar4 a_7225_4202.t2 a_7225_4202.t3 17.1637
Rpar5 a_8590_12867.t0 a_8590_12867.t6 83.2348
Rpar6 a_8590_12867.t0 a_8590_12867.t7 87.0712
Rpar7 a_8590_12867.t6 a_8590_12867.t7 16.8896
Rpar8 a_954_1290.t0 a_954_1290.t1 669.0184
Rpar9 a_954_1290.t0 a_954_1290.t9 568.5364
Rpar10 a_954_1290.t0 a_954_1290.t2 65.4044
Rpar11 a_954_1290.t1 a_954_1290.t9 53.8321
Rpar12 a_954_1290.t1 a_954_1290.t2 223.6775
Rpar13 a_954_1290.t9 a_954_1290.t2 190.0827
Rpar14 ib ib.t0 11.4748
Rpar15 ib ib.t1 8.6641
Rpar16 inn inn.t0 2.4354
Rpar17 inp inp.t0 2.4354
Rpar18 out out.t0 343.7687
Rpar19 out out.t3 4.6696
Rpar20 out out.t9 1028.7380
Rpar21 out.t0 out.t3 54.7382
Rpar22 out.t0 out.t9 238.3969
Rpar23 out.t3 out.t9 163.8058
Rpar24 vdd vdd.t0 42.8966
Rpar25 vdd vdd.t4 2610.0078
Rpar26 vdd vdd.t3 241.2832
Rpar27 vdd.t0 vdd.t4 550.7833
Rpar28 vdd.t0 vdd.t3 50.9174
Rpar29 vdd.t4 vdd.t3 12.6848
Rpar30 vss vss.t0 76.4821
Rpar31 vss vss.t1 77.3991
Rpar32 vss vss.t2 203.9968
Rpar33 vss vss.t27 126.6901
Rpar34 vss vss.t28 411.9951
Rpar35 vss.t0 vss.t1 85.7263
Rpar36 vss.t0 vss.t2 150.2355
Rpar37 vss.t0 vss.t27 158.0095
Rpar38 vss.t0 vss.t28 549.7802
Rpar39 vss.t1 vss.t2 7.7261
Rpar40 vss.t1 vss.t27 5.0999
Rpar41 vss.t1 vss.t28 20.3178
Rpar42 vss.t2 vss.t27 18.7459
Rpar43 vss.t2 vss.t28 87.7522
Rpar44 vss.t27 vss.t28 29.0806
Cpar0 a_4932_1290.t0 vss 3.96400e-17
Cpar1 a_4932_2330.t0 vss 3.19600e-17
Cpar2 a_4932_3370.t0 vss 3.13800e-17
Cpar3 a_4932_4410.t0 vss 3.16600e-17
Cpar4 a_4932_5450.t0 vss 3.21400e-17
Cpar5 a_4932_6490.t0 vss 3.76000e-17
Cpar6 a_4932_7530.t0 vss 1.49040e-16
Cpar7 a_4932_7530.t1 vss 2.37977e-15
Cpar8 a_6002_9030.t0 vss 2.12628e-14
Cpar9 a_6002_9030.t12 vss 2.51954e-14
Cpar10 a_7225_4202.t0 vss 6.56694e-15
Cpar11 a_7225_4202.t2 vss 5.16709e-14
Cpar12 a_7225_4202.t3 vss 9.89349e-15
Cpar13 a_8590_12867.t0 vss 5.51786e-15
Cpar14 a_8590_12867.t6 vss 8.05358e-15
Cpar15 a_8590_12867.t7 vss 2.71616e-15
Cpar16 a_954_1290.t0 vss 2.65099e-15
Cpar17 a_954_1290.t1 vss 2.21119e-15
Cpar18 a_954_1290.t2 vss 4.47542e-15
Cpar19 a_954_1290.t9 vss 8.95145e-15
Cpar20 a_954_1810.t0 vss 4.02400e-17
Cpar21 a_954_2850.t0 vss 3.63400e-17
Cpar22 a_954_3890.t0 vss 3.63400e-17
Cpar23 a_954_4930.t0 vss 3.63400e-17
Cpar24 a_954_5970.t0 vss 3.70800e-17
Cpar25 a_954_7010.t0 vss 3.98800e-17
Cpar26 ib vss 1.50220e-14
Cpar27 ib.t0 vss 1.57739e-15
Cpar28 ib.t1 vss 8.35500e-17
Cpar29 inn inp 1.03350e-16
Cpar30 inn vdd 1.14986e-14
Cpar31 inn vss 3.83812e-15
Cpar32 inn.t0 vss 1.24947e-14
Cpar33 inp out 4.16700e-17
Cpar34 inp vdd 1.13587e-14
Cpar35 inp vss 3.80214e-15
Cpar36 inp.t0 vss 1.24919e-14
Cpar37 out vdd 1.35681e-14
Cpar38 out vss 2.25680e-14
Cpar39 out.t0 vss 6.09845e-15
Cpar40 out.t3 vss 8.24905e-15
Cpar41 out.t9 vss 1.10327e-14
Cpar42 vdd vss 1.96476e-13
Cpar43 vdd.t0 vss 3.46359e-14
Cpar44 vdd.t3 vss 5.57700e-14
Cpar45 vdd.t4 vss 8.12715e-15
.ends opamp_dut

Vdd vdd 0 3.300000
Vss vss 0 0
Ibias vdd ib 6.600000e-09
Vinp inp 0 DC 1.480000 AC 1 PWL(0 1.480000 1.111351e-06 1.480000 1.222486e-06 1.490000)
Rfb out inn 1m
Cload out 0 2.000000e-13
Xdut vdd vss inp inn out ib opamp_dut
.end
