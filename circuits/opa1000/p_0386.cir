* opa1000[0386]: 2p/nmos_5t_1v8_1u_10u_subth (nmos_5t, VDD=1.8V, CL=2.0pF, Iref=1.625uA)
.include "pdk_opa.inc"
.temp 27
.option gmin=1e-12 rshunt=1e12 reltol=1e-3 abstol=1e-12 vntol=1e-5 method=gear
* Post-PEX R+C extracted netlist for nmos_5t_1v8_1u_10u_subth
.subckt opamp_dut vdd vss inp inn out ib
XMpar0 out.t0 a_1598_8146.t0 vdd.t1 vdd.t0 pfet_03v3 w=1.93u l=2u ad=5.4040e-13 pd=2.4900e-06 as=5.4040e-13 ps=2.4900e-06 nf=1 m=36 par=36
XMpar1 a_2898_4405.t0 ib.t0 vss.t1 vss.t0 nfet_03v3 w=5.76u l=2.5u ad=1.6128e-12 pd=6.3200e-06 as=2.0736e-12 ps=7.9200e-06 nf=1 m=8 par=8
XMpar2 a_1598_8146.t72 inp.t0 a_2898_4405.t8 vss.t0 nfet_03v3 w=2.01u l=1.6u ad=5.6280e-13 pd=2.5700e-06 as=6.9144e-13 ps=3.1000e-06 nf=1 m=30 par=30
XMpar3 a_1598_8146.t1 a_1598_8146.t0 vdd.t1 vdd.t0 pfet_03v3 w=1.93u l=2u ad=5.4040e-13 pd=2.4900e-06 as=6.4333e-13 ps=2.9183e-06 nf=1 m=36 par=36
XMpar4 a_2898_4405.t8 inn.t0 out.t23 vss.t0 nfet_03v3 w=2.01u l=1.6u ad=6.9144e-13 pd=3.1000e-06 as=5.6280e-13 ps=2.5700e-06 nf=1 m=30 par=30
XMpar5 ib.t1 ib.t0 vss.t1 vss.t0 nfet_03v3 w=5.76u l=2.5u ad=1.6128e-12 pd=6.3200e-06 as=1.6128e-12 ps=6.3200e-06 nf=1 m=2 par=2
X47 out.t66 vss.t20 cap_mim_2f0fF c_width=7.75u c_length=7.75u
Rpar0 a_1598_8146.t0 a_1598_8146.t1 5.0696
Rpar1 a_1598_8146.t0 a_1598_8146.t72 131.8961
Rpar2 a_1598_8146.t1 a_1598_8146.t72 51.0929
Rpar3 a_2898_4405.t0 a_2898_4405.t8 38.3609
Rpar4 ib ib.t0 25.3257
Rpar5 ib ib.t1 9.9749
Rpar6 ib.t0 ib.t1 55.7278
Rpar7 inn inn.t0 1.5376
Rpar8 inp inp.t0 1.5376
Rpar9 out out.t0 4.6476
Rpar10 out out.t23 4618.3594
Rpar11 out out.t66 11744.0435
Rpar12 out.t0 out.t23 86.4649
Rpar13 out.t0 out.t66 219.8719
Rpar14 out.t23 out.t66 100.2035
Rpar15 vdd vdd.t0 19.5874
Rpar16 vdd vdd.t1 778.6045
Rpar17 vdd.t0 vdd.t1 9.2416
Rpar18 vss vss.t0 48.5863
Rpar19 vss vss.t1 684.7124
Rpar20 vss vss.t20 90.7996
Rpar21 vss.t0 vss.t1 4.3957
Rpar22 vss.t0 vss.t20 65.4230
Rpar23 vss.t1 vss.t20 921.9872
Cpar0 a_1598_8146.t0 vss 1.13866e-13
Cpar1 a_1598_8146.t1 vss 3.39199e-14
Cpar2 a_1598_8146.t72 vss 2.08724e-14
Cpar3 a_2898_4405.t0 vss 1.01273e-14
Cpar4 a_2898_4405.t8 vss 3.53330e-14
Cpar5 ib out 7.73200e-17
Cpar6 ib vss 2.30210e-14
Cpar7 ib.t0 vss 4.84546e-15
Cpar8 ib.t1 vss 3.64272e-16
Cpar9 inn inp 1.57790e-16
Cpar10 inn out 7.94742e-15
Cpar11 inn vdd 1.92400e-17
Cpar12 inn vss 2.43937e-14
Cpar13 inn.t0 vss 1.24133e-14
Cpar14 inp out 3.10220e-16
Cpar15 inp vdd 1.92400e-17
Cpar16 inp vss 2.43971e-14
Cpar17 inp.t0 vss 1.23729e-14
Cpar18 out vdd 2.93755e-14
Cpar19 out vss 2.15806e-14
Cpar20 out.t0 vss 3.17740e-14
Cpar21 out.t23 vss 2.16613e-14
Cpar22 out.t66 vss 2.48050e-14
Cpar23 vdd vss 2.12855e-13
Cpar24 vdd.t0 vss 1.26265e-13
Cpar25 vdd.t1 vss 1.46521e-14
.ends opamp_dut

Vdd vdd 0 1.800000
Vss vss 0 0
Ibias vdd ib 1.625000e-06
Vinp inp 0 DC 0.895000 AC 1 PWL(0 0.895000 2.245682e-08 0.895000 2.470251e-08 0.905000)
Rfb out inn 1m
Cload out 0 2.000000e-12
Xdut vdd vss inp inn out ib opamp_dut
.end
