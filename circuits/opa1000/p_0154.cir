* opa1000[0154]: 2p/current_reuse_3v3_i2u_subth (current_reuse, VDD=3.3V, CL=2.0pF, Iref=0.3714uA)
.include "pdk_opa.inc"
.temp 27
.option gmin=1e-12 rshunt=1e12 reltol=1e-3 abstol=1e-12 vntol=1e-5 method=gear
* Post-PEX R+C extracted netlist for current_reuse_3v3_i2u_subth
.subckt opamp_dut vdd vss inp inn out ib
XMpar0 a_3202_6465.t0 inp a_881_17769.t1 vss.t1 nfet_03v3 w=1.87u l=2.85u ad=6.7320e-13 pd=3.0575e-06 as=5.2360e-13 ps=2.4300e-06 nf=1 m=8 par=8
XMpar1 out.t1 ib.t0 vss.t10 vss.t9 nfet_03v3 w=0.77u l=1.56u ad=2.6488e-13 pd=1.6120e-06 as=2.1560e-13 ps=1.3300e-06 nf=1 m=10 par=10
XMpar2 out.t2 a_881_17769.t30 vdd.t1 vdd.t0 pfet_03v3 w=7.63u l=0.81u ad=2.1364e-12 pd=8.1900e-06 as=2.6247e-12 ps=9.8440e-06 nf=1 m=10 par=10
XMpar3 a_881_17769.t29 a_953_6212.t0 vdd.t1 vdd.t0 pfet_03v3 w=7.63u l=0.81u ad=4.5780e-12 pd=1.6460e-05 as=2.1364e-12 ps=8.1900e-06 nf=1 m=1
XMpar4 a_3202_6465.t0 inn a_953_6212.t2 vss.t1 nfet_03v3 w=1.87u l=2.85u ad=6.7320e-13 pd=3.0575e-06 as=5.2360e-13 ps=2.4300e-06 nf=1 m=8 par=8
XMpar5 a_1115_6420.t20 a_953_6212.t0 vdd.t1 vdd.t0 pfet_03v3 w=7.63u l=0.81u ad=2.1364e-12 pd=8.1900e-06 as=4.5780e-12 ps=1.6460e-05 nf=1 m=2 par=2
XMpar6 a_1115_6420.t0 inn.t0 a_953_6212.t10 vdd.t6 pfet_03v3 w=2.04u l=2.85u ad=7.0176e-13 pd=3.1360e-06 as=7.0176e-13 ps=3.1360e-06 nf=1 m=20 par=20
XMpar7 ib.t1 ib.t0 vss.t10 vss.t9 nfet_03v3 w=0.77u l=1.56u ad=2.1560e-13 pd=1.3300e-06 as=2.1560e-13 ps=1.3300e-06 nf=1 m=2 par=2
XMpar8 a_1115_6420.t0 inp.t0 a_881_17769.t9 vdd.t6 pfet_03v3 w=2.04u l=2.85u ad=7.0176e-13 pd=3.1360e-06 as=7.0176e-13 ps=3.1360e-06 nf=1 m=20 par=20
XMpar9 a_3202_6465.t8 ib.t0 vss.t10 vss.t9 nfet_03v3 w=0.77u l=1.56u ad=2.1560e-13 pd=1.3300e-06 as=2.1560e-13 ps=1.3300e-06 nf=1 m=4 par=4
XMpar10 a_953_6212.t1 a_953_6212.t0 vdd.t1 vdd.t0 pfet_03v3 w=7.63u l=0.81u ad=4.5780e-12 pd=1.6460e-05 as=2.1364e-12 ps=8.1900e-06 nf=1 m=1
X18 a_3783_18809.t1 out.t0 cap_mim_2f0fF c_width=18.03u c_length=18.03u
X24 a_881_18289.t0 a_3783_17769.t0 vss.t0 ppolyf_u_1k r_width=1u r_length=13.85u
X32 a_881_17769.t0 a_3783_17769.t0 vss.t0 ppolyf_u_1k r_width=1u r_length=13.85u
X83 a_3783_18809.t1 out.t0 cap_mim_2f0fF c_width=18.03u c_length=18.03u
X84 a_881_18289.t0 a_3783_18809.t0 vss.t0 ppolyf_u_1k r_width=1u r_length=13.85u
Rpar0 a_1115_6420.t0 a_1115_6420.t20 60.9744
Rpar1 a_3202_6465.t0 a_3202_6465.t8 69.9614
Rpar2 a_3783_18809.t0 a_3783_18809.t1 96.0547
Rpar3 a_881_17769.t0 a_881_17769.t1 996.6486
Rpar4 a_881_17769.t0 a_881_17769.t9 1117.5377
Rpar5 a_881_17769.t0 a_881_17769.t29 157.9936
Rpar6 a_881_17769.t0 a_881_17769.t30 849.5884
Rpar7 a_881_17769.t1 a_881_17769.t9 77.3974
Rpar8 a_881_17769.t1 a_881_17769.t29 169.0408
Rpar9 a_881_17769.t1 a_881_17769.t30 99.6150
Rpar10 a_881_17769.t9 a_881_17769.t29 189.5448
Rpar11 a_881_17769.t9 a_881_17769.t30 111.6978
Rpar12 a_881_17769.t29 a_881_17769.t30 144.0981
Rpar13 a_953_6212.t0 a_953_6212.t1 38.5298
Rpar14 a_953_6212.t0 a_953_6212.t10 481.6517
Rpar15 a_953_6212.t0 a_953_6212.t2 184.9360
Rpar16 a_953_6212.t1 a_953_6212.t10 275.1320
Rpar17 a_953_6212.t1 a_953_6212.t2 105.6403
Rpar18 a_953_6212.t10 a_953_6212.t2 59.9049
Rpar19 ib ib.t0 20.8167
Rpar20 ib ib.t1 18.5281
Rpar21 ib.t0 ib.t1 84.4574
Rpar22 inn inn.t0 33.3253
Rpar23 inp inp.t0 33.2767
Rpar24 out out.t0 117.2287
Rpar25 out out.t1 405.4384
Rpar26 out out.t2 1.6793
Rpar27 out.t0 out.t1 283.4241
Rpar28 out.t0 out.t2 121.9474
Rpar29 out.t1 out.t2 421.7583
Rpar30 vdd vdd.t0 51.6803
Rpar31 vdd vdd.t1 153.3542
Rpar32 vdd vdd.t6 1423.5565
Rpar33 vdd.t0 vdd.t1 3.2959
Rpar34 vdd.t0 vdd.t6 111.2864
Rpar35 vdd.t1 vdd.t6 95.3461
Rpar36 vss vss.t0 402.8271
Rpar37 vss vss.t1 53.4642
Rpar38 vss vss.t10 2209.4535
Rpar39 vss vss.t9 435.5464
Rpar40 vss.t0 vss.t1 55.6512
Rpar41 vss.t0 vss.t10 2611.5535
Rpar42 vss.t0 vss.t9 470.4477
Rpar43 vss.t1 vss.t10 181.0476
Rpar44 vss.t1 vss.t9 25.5614
Rpar45 vss.t10 vss.t9 4.8955
Cpar0 a_1115_6420.t0 vss 4.07510e-14
Cpar1 a_1115_6420.t20 vss 5.61718e-15
Cpar2 a_3202_6465.t0 vss 1.48977e-14
Cpar3 a_3202_6465.t8 vss 7.19697e-15
Cpar4 a_3783_17769.t0 vss 4.04000e-17
Cpar5 a_3783_18809.t0 vss 2.08434e-16
Cpar6 a_3783_18809.t1 vss 8.19581e-15
Cpar7 a_881_17769.t0 vss 8.89631e-15
Cpar8 a_881_17769.t1 vss 8.63689e-15
Cpar9 a_881_17769.t29 vss 1.05973e-14
Cpar10 a_881_17769.t30 vss 1.82359e-14
Cpar11 a_881_17769.t9 vss 2.09845e-14
Cpar12 a_881_18289.t0 vss 4.26800e-17
Cpar13 a_953_6212.t0 vss 9.57947e-15
Cpar14 a_953_6212.t1 vss 8.32898e-15
Cpar15 a_953_6212.t10 vss 2.05518e-14
Cpar16 a_953_6212.t2 vss 9.87665e-15
Cpar17 ib out 1.15097e-15
Cpar18 ib vss 2.19976e-14
Cpar19 ib.t0 vss 3.92223e-15
Cpar20 ib.t1 vss 1.78460e-16
Cpar21 inn inp 2.60830e-16
Cpar22 inn vdd 2.33926e-14
Cpar23 inn vss 2.52016e-14
Cpar24 inn.t0 vss 2.97091e-14
Cpar25 inp vdd 2.37818e-14
Cpar26 inp vss 2.58711e-14
Cpar27 inp.t0 vss 3.02539e-14
Cpar28 out vdd 1.29970e-14
Cpar29 out vss 2.69174e-14
Cpar30 out.t0 vss 2.00406e-14
Cpar31 out.t1 vss 7.02156e-15
Cpar32 out.t2 vss 8.43239e-15
Cpar33 vdd vss 2.19785e-13
Cpar34 vdd.t0 vss 2.08354e-14
Cpar35 vdd.t1 vss 1.60830e-14
Cpar36 vdd.t6 vss 6.39113e-14
.ends opamp_dut

Vdd vdd 0 3.300000
Vss vss 0 0
Ibias vdd ib 3.714000e-07
Vinp inp 0 DC 1.645000 AC 1 PWL(0 1.645000 7.452442e-08 1.645000 8.197687e-08 1.655000)
Rfb out inn 1m
Cload out 0 2.000000e-12
Xdut vdd vss inp inn out ib opamp_dut
.end
