* opa1000[0797]: 2p/symmetrical_ota_1v8_0p1u_1u_subth (symmetrical_ota, VDD=1.8V, CL=2.0pF, Iref=0.0958uA)
.include "pdk_opa.inc"
.temp 27
.option gmin=1e-12 rshunt=1e12 reltol=1e-3 abstol=1e-12 vntol=1e-5 method=gear
* Post-PEX R+C extracted netlist for symmetrical_ota_1v8_0p1u_1u_subth
.subckt opamp_dut vdd vss inp inn out ib
XMpar0 a_1570_8053.t0 inp.t0 a_1636_997.t4 vss.t0 nfet_03v3 w=1.87u l=6.5u ad=7.4800e-13 pd=3.3713e-06 as=6.7320e-13 ps=3.0575e-06 nf=1 m=16 par=16
XMpar1 a_1570_8053.t0 inn.t0 a_8240_9134.t0 vss.t0 nfet_03v3 w=1.87u l=6.5u ad=7.4800e-13 pd=3.3713e-06 as=6.7320e-13 ps=3.0575e-06 nf=1 m=16 par=16
XMpar2 a_8240_9134.t17 a_8240_9134.t16 vdd.t1 vdd.t0 pfet_03v3 w=2.59u l=6.5u ad=1.5540e-12 pd=6.3800e-06 as=7.2520e-13 ps=3.1500e-06 nf=1 m=2 par=2
XMpar3 a_1570_8053.t16 ib.t0 vss.t12 vss.t0 nfet_03v3 w=0.45u l=3.25u ad=1.2600e-13 pd=1.0100e-06 as=1.9800e-13 ps=1.5550e-06 nf=1 m=4 par=4
XMpar4 a_4918_4803.t4 a_4918_4803.t3 vss.t8 vss.t7 nfet_03v3 w=0.68u l=6.5u ad=1.9040e-13 pd=1.2400e-06 as=1.9040e-13 ps=1.2400e-06 nf=1 m=4 par=4
XMpar5 a_4918_4803.t0 a_8240_9134.t16 vdd.t1 vdd.t0 pfet_03v3 w=2.59u l=6.5u ad=1.5540e-12 pd=6.3800e-06 as=1.1396e-12 ps=4.7650e-06 nf=1 m=4 par=4
XMpar6 a_1636_997.t1 a_1636_997.t0 vdd.t1 vdd.t0 pfet_03v3 w=2.59u l=6.5u ad=1.5540e-12 pd=6.3800e-06 as=7.2520e-13 ps=3.1500e-06 nf=1 m=2 par=2
XMpar7 out.t1 a_1636_997.t0 vdd.t1 vdd.t0 pfet_03v3 w=2.59u l=6.5u ad=1.5540e-12 pd=6.3800e-06 as=1.1396e-12 ps=4.7650e-06 nf=1 m=4 par=4
XMpar8 ib.t1 ib.t0 vss.t12 vss.t0 nfet_03v3 w=0.45u l=3.25u ad=1.2600e-13 pd=1.0100e-06 as=1.2600e-13 ps=1.0100e-06 nf=1 m=2 par=2
XMpar9 out.t0 a_4918_4803.t3 vss.t8 vss.t7 nfet_03v3 w=0.68u l=6.5u ad=4.0800e-13 pd=2.5600e-06 as=1.9040e-13 ps=1.2400e-06 nf=1 m=4 par=4
Rpar0 a_1570_8053.t0 a_1570_8053.t16 52.6332
Rpar1 a_1636_997.t0 a_1636_997.t1 12.2722
Rpar2 a_1636_997.t0 a_1636_997.t4 97.8200
Rpar3 a_1636_997.t1 a_1636_997.t4 77.1624
Rpar4 a_4918_4803.t0 a_4918_4803.t4 114.7363
Rpar5 a_4918_4803.t0 a_4918_4803.t3 131.9492
Rpar6 a_4918_4803.t4 a_4918_4803.t3 14.3635
Rpar7 a_8240_9134.t0 a_8240_9134.t16 96.9544
Rpar8 a_8240_9134.t0 a_8240_9134.t17 76.4800
Rpar9 a_8240_9134.t16 a_8240_9134.t17 12.2799
Rpar10 ib ib.t0 11.3235
Rpar11 ib ib.t1 15.4346
Rpar12 inn inn.t0 2.3852
Rpar13 inp inp.t0 2.3852
Rpar14 out out.t0 56.7881
Rpar15 out out.t1 3.9609
Rpar16 vdd vdd.t0 618.3421
Rpar17 vdd vdd.t1 146.5831
Rpar18 vdd.t0 vdd.t1 6.6958
Rpar19 vss vss.t0 30.8794
Rpar20 vss vss.t8 468.9112
Rpar21 vss vss.t12 957.8079
Rpar22 vss vss.t7 105.5454
Rpar23 vss.t0 vss.t8 18.1894
Rpar24 vss.t0 vss.t12 6.8637
Rpar25 vss.t0 vss.t7 1.7623
Rpar26 vss.t8 vss.t12 592.6309
Rpar27 vss.t8 vss.t7 59.3147
Rpar28 vss.t12 vss.t7 54.2006
Cpar0 a_1570_8053.t0 vss 4.50475e-14
Cpar1 a_1570_8053.t16 vss 4.07735e-15
Cpar2 a_1636_997.t0 vss 3.30524e-14
Cpar3 a_1636_997.t1 vss 7.95529e-15
Cpar4 a_1636_997.t4 vss 2.28127e-14
Cpar5 a_4918_4803.t0 vss 6.35562e-15
Cpar6 a_4918_4803.t3 vss 1.51247e-14
Cpar7 a_4918_4803.t4 vss 3.07163e-15
Cpar8 a_8240_9134.t0 vss 2.31947e-14
Cpar9 a_8240_9134.t16 vss 3.30775e-14
Cpar10 a_8240_9134.t17 vss 7.76878e-15
Cpar11 ib inp 2.97000e-17
Cpar12 ib vdd 6.34600e-17
Cpar13 ib vss 1.50062e-14
Cpar14 ib.t0 vss 1.96650e-15
Cpar15 ib.t1 vss 8.59989e-17
Cpar16 inn inp 6.41200e-17
Cpar17 inn vdd 2.42370e-16
Cpar18 inn vss 4.01098e-14
Cpar19 inn.t0 vss 1.71388e-14
Cpar20 inp vdd 2.12610e-16
Cpar21 inp vss 3.98667e-14
Cpar22 inp.t0 vss 1.71398e-14
Cpar23 out vdd 8.70775e-15
Cpar24 out vss 1.90687e-14
Cpar25 out.t0 vss 1.03048e-14
Cpar26 out.t1 vss 6.64549e-15
Cpar27 vdd vss 1.57049e-13
Cpar28 vdd.t0 vss 5.41811e-14
Cpar29 vdd.t1 vss 1.40259e-14
.ends opamp_dut

Vdd vdd 0 1.800000
Vss vss 0 0
Ibias vdd ib 9.580000e-08
Vinp inp 0 DC 0.895000 AC 1 PWL(0 0.895000 3.039339e-07 0.895000 3.343273e-07 0.905000)
Rfb out inn 1m
Cload out 0 2.000000e-12
Xdut vdd vss inp inn out ib opamp_dut
.end
