* opa1000[0161]: 2p/current_reuse_3v3_10u_100u_subth (current_reuse, VDD=3.3V, CL=2.0pF, Iref=7.1429uA)
.include "pdk_opa.inc"
.temp 27
.option gmin=1e-12 rshunt=1e12 reltol=1e-3 abstol=1e-12 vntol=1e-5 method=gear
* Post-PEX R+C extracted netlist for current_reuse_3v3_10u_100u_subth
.subckt opamp_dut vdd vss inp inn out ib
XMpar0 a_1874_11878.t0 inp.t14 a_816_10104.t1 vdd.t2 pfet_03v3 w=1.93u l=0.35u ad=5.7900e-13 pd=2.6506e-06 as=5.4040e-13 ps=2.4900e-06 nf=1 m=32 par=32
XMpar1 a_5150_10064.t0 inp.t0 a_816_10104.t33 vss.t1 nfet_03v3 w=1.97u l=0.35u ad=6.4166e-13 pd=2.9029e-06 as=5.5160e-13 ps=2.5300e-06 nf=1 m=14 par=14
XMpar2 a_1874_11878.t0 inn.t14 a_5947_13476.t0 vdd.t2 pfet_03v3 w=1.93u l=0.35u ad=5.7900e-13 pd=2.6506e-06 as=5.4040e-13 ps=2.4900e-06 nf=1 m=32 par=32
XMpar3 a_1874_11878.t32 a_5947_13476.t46 vdd.t1 vdd.t0 pfet_03v3 w=10u l=0.4u ad=2.8000e-12 pd=1.0560e-05 as=6.0000e-12 ps=2.1200e-05 nf=1 m=2 par=2
XMpar4 out.t1 a_816_10104.t48 vdd.t1 vdd.t0 pfet_03v3 w=10u l=0.4u ad=2.8000e-12 pd=1.0560e-05 as=3.4400e-12 ps=1.2688e-05 nf=1 m=10 par=10
XMpar5 a_5150_10064.t0 inn.t0 a_5947_13476.t32 vss.t1 nfet_03v3 w=1.97u l=0.35u ad=6.4166e-13 pd=2.9029e-06 as=5.5160e-13 ps=2.5300e-06 nf=1 m=14 par=14
XMpar6 a_5150_10064.t28 ib.t0 vss.t30 vss.t1 nfet_03v3 w=10u l=1.25u ad=6.0000e-12 pd=2.1200e-05 as=2.8000e-12 ps=1.0560e-05 nf=1 m=4 par=4
XMpar7 out.t9 ib.t0 vss.t30 vss.t1 nfet_03v3 w=10u l=1.25u ad=4.7200e-12 pd=1.6944e-05 as=4.0800e-12 ps=1.4816e-05 nf=1 m=10 par=10
XMpar8 a_816_10104.t47 a_5947_13476.t46 vdd.t1 vdd.t0 pfet_03v3 w=10u l=0.4u ad=6.0000e-12 pd=2.1200e-05 as=2.8000e-12 ps=1.0560e-05 nf=1 m=1
XMpar9 ib.t1 ib.t0 vss.t30 vss.t1 nfet_03v3 w=10u l=1.25u ad=6.0000e-12 pd=2.1200e-05 as=2.8000e-12 ps=1.0560e-05 nf=1 m=2 par=2
XMpar10 a_5947_13476.t47 a_5947_13476.t46 vdd.t1 vdd.t0 pfet_03v3 w=10u l=0.4u ad=6.0000e-12 pd=2.1200e-05 as=2.8000e-12 ps=1.0560e-05 nf=1 m=1
X3 a_1380_10104.t1 out.t0 cap_mim_2f0fF c_width=17.1u c_length=17.11u
X19 a_1380_10104.t1 out.t0 cap_mim_2f0fF c_width=17.1u c_length=17.11u
X38 a_1380_10104.t1 out.t0 cap_mim_2f0fF c_width=17.1u c_length=17.11u
X101 a_816_10104.t0 a_1380_10104.t0 vss.t0 ppolyf_u_1k r_width=1u r_length=2.16u
Rpar0 a_1380_10104.t0 a_1380_10104.t1 58.6249
Rpar1 a_1874_11878.t0 a_1874_11878.t32 70.2854
Rpar2 a_5150_10064.t0 a_5150_10064.t28 46.9424
Rpar3 a_5947_13476.t0 a_5947_13476.t32 66.6480
Rpar4 a_5947_13476.t0 a_5947_13476.t46 410.5394
Rpar5 a_5947_13476.t0 a_5947_13476.t47 133.3925
Rpar6 a_5947_13476.t32 a_5947_13476.t46 700.3330
Rpar7 a_5947_13476.t32 a_5947_13476.t47 227.5522
Rpar8 a_5947_13476.t46 a_5947_13476.t47 61.9780
Rpar9 a_816_10104.t0 a_816_10104.t1 171.4901
Rpar10 a_816_10104.t0 a_816_10104.t33 92.0118
Rpar11 a_816_10104.t0 a_816_10104.t47 771.6761
Rpar12 a_816_10104.t0 a_816_10104.t48 755.2981
Rpar13 a_816_10104.t1 a_816_10104.t33 126.0386
Rpar14 a_816_10104.t1 a_816_10104.t47 79.6728
Rpar15 a_816_10104.t1 a_816_10104.t48 77.9819
Rpar16 a_816_10104.t33 a_816_10104.t47 567.1522
Rpar17 a_816_10104.t33 a_816_10104.t48 555.1150
Rpar18 a_816_10104.t47 a_816_10104.t48 167.9419
Rpar19 ib ib.t0 20.5427
Rpar20 ib ib.t1 6.6171
Rpar21 ib.t0 ib.t1 25.4764
Rpar22 inn inn.t0 3.8022
Rpar23 inn inn.t14 43.4350
Rpar24 inp inp.t0 3.8508
Rpar25 inp inp.t14 51.9796
Rpar26 out out.t0 2011.4522
Rpar27 out out.t1 4125.6196
Rpar28 out out.t9 2.4940
Rpar29 out.t0 out.t1 260.2393
Rpar30 out.t0 out.t9 143.7025
Rpar31 out.t1 out.t9 294.7431
Rpar32 vdd vdd.t0 40.6000
Rpar33 vdd vdd.t1 52.8297
Rpar34 vdd vdd.t2 142.6098
Rpar35 vdd.t0 vdd.t1 3.2732
Rpar36 vdd.t0 vdd.t2 63.4812
Rpar37 vdd.t1 vdd.t2 84.1577
Rpar38 vss vss.t0 107.6882
Rpar39 vss vss.t1 232.8648
Rpar40 vss vss.t30 1880.0798
Rpar41 vss.t0 vss.t1 72.3200
Rpar42 vss.t0 vss.t30 618.2136
Rpar43 vss.t1 vss.t30 10.4509
Cpar0 a_1380_10104.t0 vss 5.60000e-17
Cpar1 a_1380_10104.t1 vss 7.38739e-15
Cpar2 a_1874_11878.t0 vss 4.51850e-14
Cpar3 a_1874_11878.t32 vss 9.05716e-15
Cpar4 a_5150_10064.t0 vss 1.26681e-14
Cpar5 a_5150_10064.t28 vss 1.79131e-14
Cpar6 a_5947_13476.t0 vss 2.14618e-14
Cpar7 a_5947_13476.t32 vss 1.15187e-14
Cpar8 a_5947_13476.t46 vss 6.11799e-15
Cpar9 a_5947_13476.t47 vss 1.20382e-14
Cpar10 a_816_10104.t0 vss 2.82285e-15
Cpar11 a_816_10104.t1 vss 2.08885e-14
Cpar12 a_816_10104.t33 vss 9.94502e-15
Cpar13 a_816_10104.t47 vss 7.15486e-15
Cpar14 a_816_10104.t48 vss 1.24702e-14
Cpar15 ib out 8.53490e-15
Cpar16 ib vss 3.20615e-14
Cpar17 ib.t0 vss 1.02984e-14
Cpar18 ib.t1 vss 2.36276e-15
Cpar19 inn inp 1.03190e-16
Cpar20 inn out 1.93630e-16
Cpar21 inn vdd 1.19686e-14
Cpar22 inn vss 1.19657e-14
Cpar23 inn.t0 vss 2.25622e-15
Cpar24 inn.t14 vss 1.29696e-14
Cpar25 inp out 2.34000e-17
Cpar26 inp vdd 1.20305e-14
Cpar27 inp vss 1.27073e-14
Cpar28 inp.t0 vss 2.40209e-15
Cpar29 inp.t14 vss 1.34179e-14
Cpar30 out vdd 2.38246e-14
Cpar31 out vss 4.30581e-14
Cpar32 out.t0 vss 2.23006e-14
Cpar33 out.t1 vss 1.10773e-14
Cpar34 out.t9 vss 1.62064e-14
Cpar35 vdd vss 1.30063e-13
Cpar36 vdd.t0 vss 2.27675e-14
Cpar37 vdd.t1 vss 1.81145e-14
Cpar38 vdd.t2 vss 3.84388e-14
.ends opamp_dut

Vdd vdd 0 3.300000
Vss vss 0 0
Ibias vdd ib 7.142900e-06
Vinp inp 0 DC 1.645000 AC 1 PWL(0 1.645000 5.446533e-09 1.645000 5.991186e-09 1.655000)
Rfb out inn 1m
Cload out 0 2.000000e-12
Xdut vdd vss inp inn out ib opamp_dut
.end
