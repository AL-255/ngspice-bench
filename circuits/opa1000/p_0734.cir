* opa1000[0734]: 2p/rail_to_rail_3v3_0p1u_1u_weak (rail_to_rail, VDD=3.3V, CL=2.0pF, Iref=0.0719uA)
.include "pdk_opa.inc"
.temp 27
.option gmin=1e-12 rshunt=1e12 reltol=1e-3 abstol=1e-12 vntol=1e-5 method=gear
* Post-PEX R+C extracted netlist for rail_to_rail_3v3_0p1u_1u_weak
.subckt opamp_dut vdd vss inp inn out ib
XMpar0 a_9320_5028.t5 a_9320_5028.t4 vdd.t3 vdd.t2 pfet_03v3 w=0.4u l=1.63u ad=1.1200e-13 pd=9.6000e-07 as=1.1200e-13 ps=9.6000e-07 nf=1 m=2 par=2
XMpar1 a_1524_9725.t0 inp.t2 a_4650_15971.t4 vdd.t6 pfet_03v3 w=1.4u l=8u ad=6.1600e-13 pd=2.9800e-06 as=3.9200e-13 ps=1.9600e-06 nf=1 m=4 par=4
XMpar2 a_4960_1294.t0 inp.t0 a_8074_12879.t1 vss.t0 nfet_03v3 w=0.73u l=8u ad=4.3800e-13 pd=2.6600e-06 as=2.0440e-13 ps=1.2900e-06 nf=1 m=2 par=2
XMpar3 out.t0 a_8074_12879.t7 vdd.t3 vdd.t2 pfet_03v3 w=0.4u l=1.63u ad=1.4400e-13 pd=1.2200e-06 as=1.7600e-13 ps=1.4800e-06 nf=1 m=8 par=8
XMpar4 a_1524_9725.t4 a_1644_9516.t2 vdd.t1 vdd.t0 pfet_03v3 w=0.58u l=4u ad=3.4800e-13 pd=2.3600e-06 as=1.6240e-13 ps=1.1400e-06 nf=1 m=2 par=2
XMpar5 a_1644_9516.t0 ib.t0 vss.t13 vss.t12 nfet_03v3 w=0.4u l=4u ad=2.4000e-13 pd=2.0000e-06 as=1.1200e-13 ps=9.6000e-07 nf=1 m=2 par=2
XMpar6 out.t3 ib.t0 vss.t13 vss.t12 nfet_03v3 w=0.4u l=4u ad=1.1200e-13 pd=9.6000e-07 as=2.0800e-13 ps=1.7400e-06 nf=1 m=8 par=8
XMpar7 a_8074_12879.t0 a_9320_5028.t4 vdd.t3 vdd.t2 pfet_03v3 w=0.4u l=1.63u ad=2.4000e-13 pd=2.0000e-06 as=1.1200e-13 ps=9.6000e-07 nf=1 m=2 par=2
XMpar8 a_8564_9606.t5 a_8564_9606.t4 vss.t1 vss.t0 nfet_03v3 w=0.4u l=8.13u ad=2.4000e-13 pd=2.0000e-06 as=1.1200e-13 ps=9.6000e-07 nf=1 m=2 par=2
XMpar9 a_1524_9725.t0 inn.t2 a_8564_9606.t0 vdd.t6 pfet_03v3 w=1.4u l=8u ad=6.1600e-13 pd=2.9800e-06 as=3.9200e-13 ps=1.9600e-06 nf=1 m=4 par=4
XMpar10 a_4960_1294.t0 inn.t0 a_9320_5028.t1 vss.t0 nfet_03v3 w=0.73u l=8u ad=4.3800e-13 pd=2.6600e-06 as=2.0440e-13 ps=1.2900e-06 nf=1 m=2 par=2
XMpar11 a_8074_12879.t3 a_8564_9606.t4 vss.t1 vss.t0 nfet_03v3 w=0.4u l=8.13u ad=2.4000e-13 pd=2.0000e-06 as=1.1200e-13 ps=9.6000e-07 nf=1 m=2 par=2
XMpar12 a_4650_15971.t1 a_4650_15971.t0 vss.t1 vss.t0 nfet_03v3 w=0.4u l=8.13u ad=2.4000e-13 pd=2.0000e-06 as=1.1200e-13 ps=9.6000e-07 nf=1 m=2 par=2
XMpar13 a_1644_9516.t3 a_1644_9516.t2 vdd.t1 vdd.t0 pfet_03v3 w=0.58u l=4u ad=3.4800e-13 pd=2.3600e-06 as=1.6240e-13 ps=1.1400e-06 nf=1 m=2 par=2
XMpar14 ib.t1 ib.t0 vss.t13 vss.t12 nfet_03v3 w=0.4u l=4u ad=2.4000e-13 pd=2.0000e-06 as=1.1200e-13 ps=9.6000e-07 nf=1 m=2 par=2
XMpar15 a_4960_1294.t2 ib.t0 vss.t13 vss.t12 nfet_03v3 w=0.4u l=4u ad=2.4000e-13 pd=2.0000e-06 as=1.1200e-13 ps=9.6000e-07 nf=1 m=2 par=2
XMpar16 a_9320_5028.t0 a_4650_15971.t0 vss.t1 vss.t0 nfet_03v3 w=0.4u l=8.13u ad=1.1200e-13 pd=9.6000e-07 as=1.1200e-13 ps=9.6000e-07 nf=1 m=2 par=2
X4 a_14951_5970.t0 a_18917_6490.t0 vss.t8 ppolyf_u_1k r_width=1u r_length=19.17u
X8 a_14951_2850.t0 a_18917_3370.t0 vss.t8 ppolyf_u_1k r_width=1u r_length=19.17u
X12 a_14951_8050.t1 out.t2 cap_mim_2f0fF c_width=15.62u c_length=15.61u
X15 a_14951_5970.t0 a_18917_5450.t0 vss.t8 ppolyf_u_1k r_width=1u r_length=19.17u
X16 a_14951_2850.t0 a_18917_2330.t0 vss.t8 ppolyf_u_1k r_width=1u r_length=19.17u
X23 a_14951_4930.t0 a_18917_5450.t0 vss.t8 ppolyf_u_1k r_width=1u r_length=19.17u
X24 a_14951_1810.t0 a_18917_2330.t0 vss.t8 ppolyf_u_1k r_width=1u r_length=19.17u
X31 a_14951_4930.t0 a_18917_4410.t0 vss.t8 ppolyf_u_1k r_width=1u r_length=19.17u
X32 a_14951_8050.t0 a_18917_7530.t0 vss.t8 ppolyf_u_1k r_width=1u r_length=19.17u
X33 a_14951_1810.t0 a_18917_1290.t0 vss.t8 ppolyf_u_1k r_width=1u r_length=19.17u
X34 a_14951_8050.t1 out.t2 cap_mim_2f0fF c_width=15.62u c_length=15.61u
X43 a_14951_7010.t0 a_18917_7530.t0 vss.t8 ppolyf_u_1k r_width=1u r_length=19.17u
X46 a_14951_3890.t0 a_18917_4410.t0 vss.t8 ppolyf_u_1k r_width=1u r_length=19.17u
X52 a_14951_7010.t0 a_18917_6490.t0 vss.t8 ppolyf_u_1k r_width=1u r_length=19.17u
X60 a_8074_12879.t6 a_18917_1290.t0 vss.t8 ppolyf_u_1k r_width=1u r_length=19.17u
X65 a_14951_3890.t0 a_18917_3370.t0 vss.t8 ppolyf_u_1k r_width=1u r_length=19.17u
Rpar0 a_14951_8050.t0 a_14951_8050.t1 72.0167
Rpar1 a_1524_9725.t0 a_1524_9725.t4 58.5399
Rpar2 a_1644_9516.t0 a_1644_9516.t2 100.1151
Rpar3 a_1644_9516.t0 a_1644_9516.t3 118.0410
Rpar4 a_1644_9516.t2 a_1644_9516.t3 15.3780
Rpar5 a_4650_15971.t0 a_4650_15971.t1 22.6766
Rpar6 a_4650_15971.t0 a_4650_15971.t4 126.3082
Rpar7 a_4650_15971.t1 a_4650_15971.t4 99.4882
Rpar8 a_4960_1294.t0 a_4960_1294.t2 106.6016
Rpar9 a_8074_12879.t0 a_8074_12879.t1 265.8050
Rpar10 a_8074_12879.t0 a_8074_12879.t7 155.3584
Rpar11 a_8074_12879.t0 a_8074_12879.t3 163.9638
Rpar12 a_8074_12879.t0 a_8074_12879.t6 257.1247
Rpar13 a_8074_12879.t1 a_8074_12879.t7 643.2826
Rpar14 a_8074_12879.t1 a_8074_12879.t3 85.7229
Rpar15 a_8074_12879.t1 a_8074_12879.t6 1064.6598
Rpar16 a_8074_12879.t7 a_8074_12879.t3 396.8136
Rpar17 a_8074_12879.t7 a_8074_12879.t6 54.1241
Rpar18 a_8074_12879.t3 a_8074_12879.t6 656.7432
Rpar19 a_8564_9606.t0 a_8564_9606.t4 140.4921
Rpar20 a_8564_9606.t0 a_8564_9606.t5 133.2952
Rpar21 a_8564_9606.t4 a_8564_9606.t5 17.1460
Rpar22 a_9320_5028.t0 a_9320_5028.t1 60.0737
Rpar23 a_9320_5028.t0 a_9320_5028.t4 375.8811
Rpar24 a_9320_5028.t0 a_9320_5028.t5 357.1303
Rpar25 a_9320_5028.t1 a_9320_5028.t4 319.5482
Rpar26 a_9320_5028.t1 a_9320_5028.t5 303.6075
Rpar27 a_9320_5028.t4 a_9320_5028.t5 28.1368
Rpar28 ib ib.t0 14.4067
Rpar29 ib ib.t1 15.9849
Rpar30 ib.t0 ib.t1 29.9501
Rpar31 inn inn.t0 3.4640
Rpar32 inn inn.t2 35.6778
Rpar33 inp inp.t0 3.5126
Rpar34 inp inp.t2 35.6292
Rpar35 out out.t0 211.3176
Rpar36 out out.t3 74.5955
Rpar37 out out.t2 22.1742
Rpar38 out.t0 out.t3 81.0667
Rpar39 out.t0 out.t2 1308.0408
Rpar40 out.t3 out.t2 461.7406
Rpar41 vdd vdd.t0 343.0350
Rpar42 vdd vdd.t1 114.6125
Rpar43 vdd vdd.t2 858.3361
Rpar44 vdd vdd.t3 979.7032
Rpar45 vdd vdd.t6 31.5271
Rpar46 vdd.t0 vdd.t1 23.9026
Rpar47 vdd.t0 vdd.t6 1156.2735
Rpar48 vdd.t1 vdd.t6 386.3260
Rpar49 vdd.t2 vdd.t3 6.0230
Rpar50 vdd.t2 vdd.t6 291.5855
Rpar51 vdd.t3 vdd.t6 332.8151
Rpar52 vss vss.t0 121.5839
Rpar53 vss vss.t1 752.6017
Rpar54 vss vss.t8 995.9092
Rpar55 vss vss.t12 397.8527
Rpar56 vss vss.t13 31.8884
Rpar57 vss.t0 vss.t1 7.3810
Rpar58 vss.t0 vss.t8 53.2433
Rpar59 vss.t0 vss.t12 31.9734
Rpar60 vss.t0 vss.t13 95.2725
Rpar61 vss.t1 vss.t8 338.8457
Rpar62 vss.t1 vss.t12 238.1092
Rpar63 vss.t1 vss.t13 634.0647
Rpar64 vss.t8 vss.t12 1588.7295
Rpar65 vss.t8 vss.t13 1190.2739
Rpar66 vss.t12 vss.t13 13.9483
Cpar0 a_14951_1810.t0 vss 4.24400e-17
Cpar1 a_14951_2850.t0 vss 3.81400e-17
Cpar2 a_14951_3890.t0 vss 3.61600e-17
Cpar3 a_14951_4930.t0 vss 3.67800e-17
Cpar4 a_14951_5970.t0 vss 2.93600e-17
Cpar5 a_14951_7010.t0 vss 3.20200e-17
Cpar6 a_14951_8050.t0 vss 1.47257e-16
Cpar7 a_14951_8050.t1 vss 5.49898e-15
Cpar8 a_1524_9725.t0 vss 1.49233e-14
Cpar9 a_1524_9725.t4 vss 8.98272e-15
Cpar10 a_1644_9516.t0 vss 1.09983e-14
Cpar11 a_1644_9516.t2 vss 1.25529e-14
Cpar12 a_1644_9516.t3 vss 5.14192e-15
Cpar13 a_18917_1290.t0 vss 2.64400e-17
Cpar14 a_18917_2330.t0 vss 3.00800e-17
Cpar15 a_18917_3370.t0 vss 2.93600e-17
Cpar16 a_18917_4410.t0 vss 2.93600e-17
Cpar17 a_18917_5450.t0 vss 2.93600e-17
Cpar18 a_18917_6490.t0 vss 3.00800e-17
Cpar19 a_18917_7530.t0 vss 2.64400e-17
Cpar20 a_4650_15971.t0 vss 9.18286e-15
Cpar21 a_4650_15971.t1 vss 2.63413e-15
Cpar22 a_4650_15971.t4 vss 3.40243e-15
Cpar23 a_4960_1294.t0 vss 1.06491e-14
Cpar24 a_4960_1294.t2 vss 1.38479e-14
Cpar25 a_8074_12879.t0 vss 3.68680e-15
Cpar26 a_8074_12879.t1 vss 3.05055e-15
Cpar27 a_8074_12879.t3 vss 5.49851e-15
Cpar28 a_8074_12879.t6 vss 2.99047e-15
Cpar29 a_8074_12879.t7 vss 8.43295e-15
Cpar30 a_8564_9606.t0 vss 3.85810e-15
Cpar31 a_8564_9606.t4 vss 9.88176e-15
Cpar32 a_8564_9606.t5 vss 2.91416e-15
Cpar33 a_9320_5028.t0 vss 4.65811e-15
Cpar34 a_9320_5028.t1 vss 4.24284e-15
Cpar35 a_9320_5028.t4 vss 5.82931e-15
Cpar36 a_9320_5028.t5 vss 3.03250e-15
Cpar37 ib out 1.84170e-15
Cpar38 ib vdd 1.94500e-17
Cpar39 ib vss 3.79406e-14
Cpar40 ib.t0 vss 1.22336e-14
Cpar41 ib.t1 vss 1.04173e-15
Cpar42 inn inp 1.03390e-16
Cpar43 inn vdd 1.48391e-14
Cpar44 inn vss 1.38337e-14
Cpar45 inn.t0 vss 2.79914e-15
Cpar46 inn.t2 vss 1.39874e-14
Cpar47 inp vdd 1.51947e-14
Cpar48 inp vss 1.36635e-14
Cpar49 inp.t0 vss 2.71927e-15
Cpar50 inp.t2 vss 1.34346e-14
Cpar51 out vdd 1.06291e-14
Cpar52 out vss 2.29977e-14
Cpar53 out.t0 vss 3.44328e-15
Cpar54 out.t2 vss 1.35783e-14
Cpar55 out.t3 vss 5.35344e-15
Cpar56 vdd vss 1.60571e-13
Cpar57 vdd.t0 vss 1.17944e-14
Cpar58 vdd.t1 vss 6.17029e-15
Cpar59 vdd.t2 vss 2.10641e-14
Cpar60 vdd.t3 vss 6.21873e-15
Cpar61 vdd.t6 vss 3.85666e-14
.ends opamp_dut

Vdd vdd 0 3.300000
Vss vss 0 0
Ibias vdd ib 7.190000e-08
Vinp inp 0 DC 1.645000 AC 1 PWL(0 1.645000 5.215681e-07 1.645000 5.737249e-07 1.655000)
Rfb out inn 1m
Cload out 0 2.000000e-12
Xdut vdd vss inp inn out ib opamp_dut
.end
