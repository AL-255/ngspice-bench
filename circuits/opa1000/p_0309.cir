* opa1000[0309]: 2p/folded_cascode_pmos_1v8_10u_100u_weak (folded_cascode_pmos, VDD=1.8V, CL=2.0pF, Iref=7.7778uA)
.include "pdk_opa.inc"
.temp 27
.option gmin=1e-12 rshunt=1e12 reltol=1e-3 abstol=1e-12 vntol=1e-5 method=gear
* Post-PEX R+C extracted netlist for folded_cascode_pmos_1v8_10u_100u_weak
.subckt opamp_dut vdd vss inp inn out ib
XMpar0 a_1314_8141.t3 inp.t0 a_1770_1204.t8 vdd.t10 pfet_03v3 w=2u l=0.8u ad=6.3111e-13 pd=2.8533e-06 as=5.8370e-13 ps=2.6578e-06 nf=1 m=54 par=54
XMpar1 a_1314_8141.t3 inn.t0 a_5614_7981.t8 vdd.t10 pfet_03v3 w=2u l=0.8u ad=6.3111e-13 pd=2.8533e-06 as=5.8370e-13 ps=2.6578e-06 nf=1 m=54 par=54
XMpar2 a_5614_7981.t0 a_1184_7933.t6 out.t0 vss.t0 nfet_03v3 w=1.42u l=0.45u ad=6.2480e-13 pd=3.0100e-06 as=3.9760e-13 ps=1.9800e-06 nf=1 m=4 par=4
XMpar3 out.t4 a_4700_7981.t4 vdd.t1 vdd.t0 pfet_03v3 w=6.81u l=0.65u ad=1.9068e-12 pd=7.3700e-06 as=1.9068e-12 ps=7.3700e-06 nf=1 m=2 par=2
XMpar4 a_1314_8141.t0 a_1184_7933.t2 vdd.t1 vdd.t0 pfet_03v3 w=6.81u l=0.65u ad=1.9068e-12 pd=7.3700e-06 as=2.9964e-12 ps=1.1095e-05 nf=1 m=4 par=4
XMpar5 a_1184_7933.t0 ib.t0 vss.t7 vss.t6 nfet_03v3 w=1.98u l=0.65u ad=5.5440e-13 pd=2.5400e-06 as=5.5440e-13 ps=2.5400e-06 nf=1 m=2 par=2
XMpar6 a_5614_7981.t2 ib.t0 vss.t7 vss.t6 nfet_03v3 w=1.98u l=0.65u ad=5.5440e-13 pd=2.5400e-06 as=8.7120e-13 ps=3.8500e-06 nf=1 m=4 par=4
XMpar7 a_1184_7933.t3 a_1184_7933.t2 vdd.t1 vdd.t0 pfet_03v3 w=6.81u l=0.65u ad=1.9068e-12 pd=7.3700e-06 as=1.9068e-12 ps=7.3700e-06 nf=1 m=2 par=2
XMpar8 a_1770_1204.t4 ib.t0 vss.t7 vss.t6 nfet_03v3 w=1.98u l=0.65u ad=5.5440e-13 pd=2.5400e-06 as=8.7120e-13 ps=3.8500e-06 nf=1 m=4 par=4
XMpar9 a_1770_1204.t0 a_1184_7933.t6 a_4700_7981.t0 vss.t0 nfet_03v3 w=1.42u l=0.45u ad=6.2480e-13 pd=3.0100e-06 as=3.9760e-13 ps=1.9800e-06 nf=1 m=4 par=4
XMpar10 ib.t1 ib.t0 vss.t7 vss.t6 nfet_03v3 w=1.98u l=0.65u ad=1.1880e-12 pd=5.1600e-06 as=5.5440e-13 ps=2.5400e-06 nf=1 m=2 par=2
XMpar11 a_4700_7981.t5 a_4700_7981.t4 vdd.t1 vdd.t0 pfet_03v3 w=6.81u l=0.65u ad=4.0860e-12 pd=1.4820e-05 as=1.9068e-12 ps=7.3700e-06 nf=1 m=2 par=2
Rpar0 a_1184_7933.t0 a_1184_7933.t6 96.6503
Rpar1 a_1184_7933.t0 a_1184_7933.t2 491.3568
Rpar2 a_1184_7933.t0 a_1184_7933.t3 135.2158
Rpar3 a_1184_7933.t6 a_1184_7933.t2 311.8888
Rpar4 a_1184_7933.t6 a_1184_7933.t3 85.8282
Rpar5 a_1184_7933.t2 a_1184_7933.t3 31.2495
Rpar6 a_1314_8141.t0 a_1314_8141.t3 48.5845
Rpar7 a_1770_1204.t0 a_1770_1204.t8 118.3926
Rpar8 a_1770_1204.t0 a_1770_1204.t4 47.7849
Rpar9 a_1770_1204.t8 a_1770_1204.t4 71.1429
Rpar10 a_4700_7981.t0 a_4700_7981.t4 350.0298
Rpar11 a_4700_7981.t0 a_4700_7981.t5 44.6830
Rpar12 a_4700_7981.t4 a_4700_7981.t5 31.0331
Rpar13 a_5614_7981.t0 a_5614_7981.t8 118.3926
Rpar14 a_5614_7981.t0 a_5614_7981.t2 47.7849
Rpar15 a_5614_7981.t8 a_5614_7981.t2 71.1429
Rpar16 ib ib.t0 13.7897
Rpar17 ib ib.t1 4.7591
Rpar18 ib.t0 ib.t1 604.5863
Rpar19 inn inn.t0 1.7981
Rpar20 inp inp.t0 1.7981
Rpar21 out out.t0 6.4226
Rpar22 out out.t4 36.9235
Rpar23 vdd vdd.t0 33.9932
Rpar24 vdd vdd.t1 62.2145
Rpar25 vdd vdd.t10 114.7091
Rpar26 vdd.t0 vdd.t1 4.1119
Rpar27 vdd.t0 vdd.t10 72.9503
Rpar28 vdd.t1 vdd.t10 124.0387
Rpar29 vss vss.t0 307.2549
Rpar30 vss vss.t6 179.2640
Rpar31 vss vss.t7 88.9416
Rpar32 vss.t0 vss.t6 4.0159
Rpar33 vss.t0 vss.t7 13.8157
Rpar34 vss.t6 vss.t7 7.5325
Cpar0 a_1184_7933.t0 vss 1.81550e-15
Cpar1 a_1184_7933.t2 vss 5.08160e-15
Cpar2 a_1184_7933.t3 vss 3.79696e-15
Cpar3 a_1184_7933.t6 vss 3.35553e-15
Cpar4 a_1314_8141.t0 vss 8.72052e-15
Cpar5 a_1314_8141.t3 vss 6.92135e-14
Cpar6 a_1770_1204.t0 vss 2.84435e-15
Cpar7 a_1770_1204.t4 vss 4.46937e-15
Cpar8 a_1770_1204.t8 vss 4.01380e-14
Cpar9 a_4700_7981.t0 vss 1.72300e-15
Cpar10 a_4700_7981.t4 vss 3.91824e-15
Cpar11 a_4700_7981.t5 vss 6.73950e-15
Cpar12 a_5614_7981.t0 vss 2.71590e-15
Cpar13 a_5614_7981.t2 vss 4.26749e-15
Cpar14 a_5614_7981.t8 vss 3.83254e-14
Cpar15 ib inp 2.22700e-17
Cpar16 ib vdd 6.69720e-16
Cpar17 ib vss 1.30902e-14
Cpar18 ib.t0 vss 1.87090e-15
Cpar19 ib.t1 vss 2.68053e-16
Cpar20 inn inp 1.48920e-16
Cpar21 inn vdd 2.48633e-14
Cpar22 inn vss 5.55257e-15
Cpar23 inn.t0 vss 3.78729e-14
Cpar24 inp vdd 2.48989e-14
Cpar25 inp vss 5.65859e-15
Cpar26 inp.t0 vss 3.79250e-14
Cpar27 out vdd 2.84550e-15
Cpar28 out vss 3.97948e-15
Cpar29 out.t0 vss 4.20905e-16
Cpar30 out.t4 vss 3.88606e-15
Cpar31 vdd vss 2.02886e-13
Cpar32 vdd.t0 vss 1.37161e-14
Cpar33 vdd.t1 vss 9.33714e-15
Cpar34 vdd.t10 vss 7.03541e-14
.ends opamp_dut

Vdd vdd 0 1.800000
Vss vss 0 0
Ibias vdd ib 7.777800e-06
Vinp inp 0 DC 0.751000 AC 1 PWL(0 0.751000 1.119305e-08 0.751000 1.231235e-08 0.761000)
Rfb out inn 1m
Cload out 0 2.000000e-12
Xdut vdd vss inp inn out ib opamp_dut
.end
