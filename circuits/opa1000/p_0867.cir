* opa1000[0867]: 200f/telescopic_nmos_3v3_i10u_weak (telescopic_nmos, VDD=3.3V, CL=0.2pF, Iref=2.125uA)
.include "pdk_opa.inc"
.temp 27
.option gmin=1e-12 rshunt=1e12 reltol=1e-3 abstol=1e-12 vntol=1e-5 method=gear
* Post-PEX R+C extracted netlist for telescopic_nmos_3v3_i10u_weak
.subckt opamp_dut vdd vss inp inn out ib
XMpar0 a_1016_7793.t9 a_1016_7793.t8 a_896_8001.t0 vdd.t0 pfet_03v3 w=2u l=1.13u ad=6.3111e-13 pd=2.8533e-06 as=9.1556e-13 ps=4.0267e-06 nf=1 m=18 par=18
XMpar1 a_1400_6190.t8 inn.t0 a_5080_4105.t3 vss.t21 nfet_03v3 w=1.82u l=1.95u ad=5.9280e-13 pd=2.7314e-06 as=5.9280e-13 ps=2.7314e-06 nf=1 m=14 par=14
XMpar2 a_1848_8001.t0 a_1016_7793.t8 out.t0 vdd.t0 pfet_03v3 w=2u l=1.13u ad=9.1556e-13 pd=4.0267e-06 as=6.3111e-13 ps=2.8533e-06 nf=1 m=18 par=18
XMpar3 a_1400_6190.t8 inp.t0 a_2454_1249.t1 vss.t21 nfet_03v3 w=1.82u l=1.95u ad=5.9280e-13 pd=2.7314e-06 as=5.9280e-13 ps=2.7314e-06 nf=1 m=14 par=14
XMpar4 a_896_8001.t12 a_1016_7793.t48 vdd.t18 vdd.t17 pfet_03v3 w=1.81u l=1.8u ad=6.2264e-13 pd=2.8600e-06 as=5.0680e-13 ps=2.3700e-06 nf=1 m=10 par=10
XMpar5 a_1400_6190.t0 ib.t0 vss.t2 vss.t1 nfet_03v3 w=1.38u l=1.5u ad=3.8640e-13 pd=1.9400e-06 as=4.9680e-13 ps=2.4450e-06 nf=1 m=8 par=8
XMpar6 a_5080_4105.t0 a_1016_7793.t0 out.t18 vss.t0 nfet_03v3 w=1.95u l=1.13u ad=8.5800e-13 pd=3.8050e-06 as=5.4600e-13 ps=2.5100e-06 nf=1 m=4 par=4
XMpar7 a_1848_8001.t15 a_1016_7793.t48 vdd.t18 vdd.t17 pfet_03v3 w=1.81u l=1.8u ad=5.0680e-13 pd=2.3700e-06 as=5.0680e-13 ps=2.3700e-06 nf=1 m=10 par=10
XMpar8 a_1016_7793.t1 a_1016_7793.t0 a_2454_1249.t0 vss.t0 nfet_03v3 w=1.95u l=1.13u ad=5.4600e-13 pd=2.5100e-06 as=1.1700e-12 ps=5.1000e-06 nf=1 m=4 par=4
XMpar9 ib.t1 ib.t0 vss.t2 vss.t1 nfet_03v3 w=1.38u l=1.5u ad=3.8640e-13 pd=1.9400e-06 as=3.8640e-13 ps=1.9400e-06 nf=1 m=2 par=2
Rpar0 a_1016_7793.t0 a_1016_7793.t1 19.9005
Rpar1 a_1016_7793.t0 a_1016_7793.t8 3233.4888
Rpar2 a_1016_7793.t0 a_1016_7793.t9 975.0523
Rpar3 a_1016_7793.t0 a_1016_7793.t48 243.9365
Rpar4 a_1016_7793.t1 a_1016_7793.t8 1367.8609
Rpar5 a_1016_7793.t1 a_1016_7793.t9 412.4758
Rpar6 a_1016_7793.t1 a_1016_7793.t48 103.1923
Rpar7 a_1016_7793.t8 a_1016_7793.t9 8.1278
Rpar8 a_1016_7793.t8 a_1016_7793.t48 220.6366
Rpar9 a_1016_7793.t9 a_1016_7793.t48 66.5325
Rpar10 a_1400_6190.t0 a_1400_6190.t8 48.0567
Rpar11 a_1848_8001.t0 a_1848_8001.t15 55.1826
Rpar12 a_2454_1249.t0 a_2454_1249.t1 37.8726
Rpar13 a_5080_4105.t0 a_5080_4105.t3 39.0081
Rpar14 a_896_8001.t0 a_896_8001.t12 55.0265
Rpar15 ib ib.t0 17.5957
Rpar16 ib ib.t1 15.6588
Rpar17 ib.t0 ib.t1 110.5043
Rpar18 inn inn.t0 1.8919
Rpar19 inp inp.t0 1.8919
Rpar20 out out.t0 3.4179
Rpar21 out out.t18 269.5162
Rpar22 out.t0 out.t18 110.6132
Rpar23 vdd vdd.t0 21.9317
Rpar24 vdd vdd.t17 133.8725
Rpar25 vdd vdd.t18 663.5102
Rpar26 vdd.t0 vdd.t17 51.7205
Rpar27 vdd.t0 vdd.t18 256.3417
Rpar28 vdd.t17 vdd.t18 4.6656
Rpar29 vss vss.t0 107.9830
Rpar30 vss vss.t1 139.8314
Rpar31 vss vss.t2 1079.2999
Rpar32 vss vss.t21 107.1003
Rpar33 vss.t0 vss.t1 3.1220
Rpar34 vss.t0 vss.t2 23.6533
Rpar35 vss.t0 vss.t21 1.9922
Rpar36 vss.t1 vss.t2 9.7113
Rpar37 vss.t1 vss.t21 2.1851
Rpar38 vss.t2 vss.t21 15.3103
Cpar0 a_1016_7793.t0 vss 8.47079e-15
Cpar1 a_1016_7793.t1 vss 4.95901e-15
Cpar2 a_1016_7793.t48 vss 2.91735e-14
Cpar3 a_1016_7793.t8 vss 3.45054e-14
Cpar4 a_1016_7793.t9 vss 1.81190e-14
Cpar5 a_1400_6190.t0 vss 5.81151e-15
Cpar6 a_1400_6190.t8 vss 1.68207e-14
Cpar7 a_1848_8001.t0 vss 3.29804e-14
Cpar8 a_1848_8001.t15 vss 1.18728e-14
Cpar9 a_2454_1249.t0 vss 6.16761e-15
Cpar10 a_2454_1249.t1 vss 8.48971e-15
Cpar11 a_5080_4105.t0 vss 5.96923e-15
Cpar12 a_5080_4105.t3 vss 9.33453e-15
Cpar13 a_896_8001.t0 vss 2.79553e-14
Cpar14 a_896_8001.t12 vss 1.06434e-14
Cpar15 ib out 1.40820e-16
Cpar16 ib vdd 1.22900e-17
Cpar17 ib vss 1.41508e-14
Cpar18 ib.t0 vss 2.57474e-15
Cpar19 ib.t1 vss 1.02421e-16
Cpar20 inn inp 1.02350e-16
Cpar21 inn vss 1.49484e-14
Cpar22 inn.t0 vss 5.16260e-15
Cpar23 inp vss 1.47737e-14
Cpar24 inp.t0 vss 5.19840e-15
Cpar25 out vdd 1.16368e-14
Cpar26 out vss 1.27401e-14
Cpar27 out.t0 vss 1.95268e-14
Cpar28 out.t18 vss 9.47118e-15
Cpar29 vdd vss 1.58023e-13
Cpar30 vdd.t0 vss 5.23973e-14
Cpar31 vdd.t17 vss 2.42749e-14
Cpar32 vdd.t18 vss 5.93274e-15
.ends opamp_dut

Vdd vdd 0 3.300000
Vss vss 0 0
Ibias vdd ib 2.125000e-06
Vinp inp 0 DC 1.711000 AC 1 PWL(0 1.711000 3.936461e-09 1.711000 4.330107e-09 1.721000)
Rfb out inn 1m
Cload out 0 2.000000e-13
Xdut vdd vss inp inn out ib opamp_dut
.end
