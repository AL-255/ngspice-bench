* opa1000[0720]: 2p/rail_to_rail_1v8_i10u_subth (rail_to_rail, VDD=1.8V, CL=2.0pF, Iref=1.25uA)
.include "pdk_opa.inc"
.temp 27
.option gmin=1e-12 rshunt=1e12 reltol=1e-3 abstol=1e-12 vntol=1e-5 method=gear
* Post-PEX R+C extracted netlist for rail_to_rail_1v8_i10u_subth
.subckt opamp_dut vdd vss inp inn out ib
XMpar0 a_1157_6688.t0 inp.t10 a_6046_6688.t0 vdd.t2 pfet_03v3 w=2.97u l=0.9u ad=9.5040e-13 pd=3.9812e-06 as=8.3160e-13 ps=3.5300e-06 nf=1 m=64 par=64
XMpar1 a_1157_6688.t0 inn.t10 a_9892_17719.t0 vdd.t2 pfet_03v3 w=2.97u l=0.9u ad=9.5040e-13 pd=3.9812e-06 as=8.3160e-13 ps=3.5300e-06 nf=1 m=64 par=64
XMpar2 a_2522_1249.t20 ib.t0 vss.t36 vss.t35 nfet_03v3 w=2.48u l=1.5u ad=1.4880e-12 pd=6.1600e-06 as=6.9440e-13 ps=3.0400e-06 nf=1 m=2 par=2
XMpar3 a_1157_6688.t128 a_1277_6480.t0 vdd.t29 vdd.t28 pfet_03v3 w=10u l=1.5u ad=6.0000e-12 pd=2.1200e-05 as=2.8000e-12 ps=1.0560e-05 nf=1 m=2 par=2
XMpar4 out.t0 a_1059_3686.t15 vdd.t1 vdd.t0 pfet_03v3 w=10u l=0.75u ad=2.8000e-12 pd=1.0560e-05 as=3.6000e-12 ps=1.3220e-05 nf=1 m=8 par=8
XMpar5 a_1059_3686.t0 inp.t0 a_2522_1249.t0 vss.t2 nfet_03v3 w=1.74u l=0.9u ad=4.8720e-13 pd=2.3000e-06 as=5.9856e-13 ps=2.7760e-06 nf=1 m=10 par=10
XMpar6 a_1277_6480.t4 ib.t0 vss.t36 vss.t35 nfet_03v3 w=2.48u l=1.5u ad=6.9440e-13 pd=3.0400e-06 as=6.9440e-13 ps=3.0400e-06 nf=1 m=2 par=2
XMpar7 out.t8 ib.t0 vss.t36 vss.t35 nfet_03v3 w=2.48u l=1.5u ad=6.9440e-13 pd=3.0400e-06 as=8.9280e-13 ps=3.8200e-06 nf=1 m=8 par=8
XMpar8 a_1059_3686.t10 a_9892_17719.t64 vss.t1 vss.t0 nfet_03v3 w=1.17u l=1.8u ad=7.0200e-13 pd=3.5400e-06 as=3.2760e-13 ps=1.7300e-06 nf=1 m=2 par=2
XMpar9 a_10312_1086.t0 inn.t0 a_2522_1249.t0 vss.t2 nfet_03v3 w=1.74u l=0.9u ad=4.8720e-13 pd=2.3000e-06 as=5.9856e-13 ps=2.7760e-06 nf=1 m=10 par=10
XMpar10 a_1277_6480.t1 a_1277_6480.t0 vdd.t29 vdd.t28 pfet_03v3 w=10u l=1.5u ad=2.8000e-12 pd=1.0560e-05 as=2.8000e-12 ps=1.0560e-05 nf=1 m=2 par=2
XMpar11 a_10312_1086.t10 a_6046_6688.t64 vss.t1 vss.t0 nfet_03v3 w=1.17u l=1.8u ad=3.2760e-13 pd=1.7300e-06 as=3.2760e-13 ps=1.7300e-06 nf=1 m=2 par=2
XMpar12 a_1059_3686.t13 a_10312_1086.t12 vdd.t1 vdd.t0 pfet_03v3 w=10u l=0.75u ad=6.0000e-12 pd=2.1200e-05 as=2.8000e-12 ps=1.0560e-05 nf=1 m=2 par=2
XMpar13 a_9892_17719.t65 a_9892_17719.t64 vss.t1 vss.t0 nfet_03v3 w=1.17u l=1.8u ad=3.2760e-13 pd=1.7300e-06 as=3.2760e-13 ps=1.7300e-06 nf=1 m=2 par=2
XMpar14 ib.t1 ib.t0 vss.t36 vss.t35 nfet_03v3 w=2.48u l=1.5u ad=1.4880e-12 pd=6.1600e-06 as=6.9440e-13 ps=3.0400e-06 nf=1 m=2 par=2
XMpar15 a_10312_1086.t13 a_10312_1086.t12 vdd.t1 vdd.t0 pfet_03v3 w=10u l=0.75u ad=2.8000e-12 pd=1.0560e-05 as=2.8000e-12 ps=1.0560e-05 nf=1 m=2 par=2
XMpar16 a_6046_6688.t65 a_6046_6688.t64 vss.t1 vss.t0 nfet_03v3 w=1.17u l=1.8u ad=7.0200e-13 pd=3.5400e-06 as=3.2760e-13 ps=1.7300e-06 nf=1 m=2 par=2
X67 a_1059_3686.t12 a_4297_3686.t0 vss.t26 ppolyf_u_1k r_width=1u r_length=15.53u
X74 a_4297_3686.t1 out.t4 cap_mim_2f0fF c_width=17.42u c_length=17.42u
X93 a_4297_3686.t1 out.t4 cap_mim_2f0fF c_width=17.42u c_length=17.42u
X115 a_4297_3686.t1 out.t4 cap_mim_2f0fF c_width=17.42u c_length=17.42u
Rpar0 a_10312_1086.t0 a_10312_1086.t10 102.3328
Rpar1 a_10312_1086.t0 a_10312_1086.t12 420.3473
Rpar2 a_10312_1086.t0 a_10312_1086.t13 86.1629
Rpar3 a_10312_1086.t10 a_10312_1086.t12 1454.3990
Rpar4 a_10312_1086.t10 a_10312_1086.t13 298.1230
Rpar5 a_10312_1086.t12 a_10312_1086.t13 38.8740
Rpar6 a_1059_3686.t0 a_1059_3686.t10 2275.0231
Rpar7 a_1059_3686.t0 a_1059_3686.t12 137.0265
Rpar8 a_1059_3686.t0 a_1059_3686.t13 105.7063
Rpar9 a_1059_3686.t0 a_1059_3686.t15 3514.6014
Rpar10 a_1059_3686.t10 a_1059_3686.t12 1814.0199
Rpar11 a_1059_3686.t10 a_1059_3686.t13 685.6113
Rpar12 a_1059_3686.t10 a_1059_3686.t15 70.8240
Rpar13 a_1059_3686.t12 a_1059_3686.t13 84.2863
Rpar14 a_1059_3686.t12 a_1059_3686.t15 2802.4141
Rpar15 a_1059_3686.t13 a_1059_3686.t15 1059.1762
Rpar16 a_1157_6688.t0 a_1157_6688.t128 34.9858
Rpar17 a_1277_6480.t0 a_1277_6480.t1 29.8596
Rpar18 a_1277_6480.t0 a_1277_6480.t4 190.4097
Rpar19 a_1277_6480.t1 a_1277_6480.t4 68.2728
Rpar20 a_2522_1249.t0 a_2522_1249.t20 69.5128
Rpar21 a_4297_3686.t0 a_4297_3686.t1 74.3593
Rpar22 a_6046_6688.t0 a_6046_6688.t64 169.2186
Rpar23 a_6046_6688.t0 a_6046_6688.t65 92.7035
Rpar24 a_6046_6688.t64 a_6046_6688.t65 20.6090
Rpar25 a_9892_17719.t0 a_9892_17719.t64 144.6362
Rpar26 a_9892_17719.t0 a_9892_17719.t65 128.6026
Rpar27 a_9892_17719.t64 a_9892_17719.t65 28.4610
Rpar28 ib ib.t0 12.2608
Rpar29 ib ib.t1 6.1821
Rpar30 inn inn.t0 1.6412
Rpar31 inn inn.t10 35.5788
Rpar32 inp inp.t0 2.0296
Rpar33 inp inp.t10 35.5302
Rpar34 out out.t0 61.5523
Rpar35 out out.t8 623.2008
Rpar36 out out.t4 22.5828
Rpar37 out.t0 out.t8 388.0559
Rpar38 out.t0 out.t4 346.6687
Rpar39 out.t8 out.t4 3509.9262
Rpar40 vdd vdd.t0 66.5133
Rpar41 vdd vdd.t1 273.3002
Rpar42 vdd vdd.t2 217.0601
Rpar43 vdd.t0 vdd.t1 3.8067
Rpar44 vdd.t0 vdd.t2 49.2254
Rpar45 vdd.t0 vdd.t28 136.1989
Rpar46 vdd.t0 vdd.t29 351.1424
Rpar47 vdd.t1 vdd.t2 183.0500
Rpar48 vdd.t1 vdd.t28 360.6613
Rpar49 vdd.t1 vdd.t29 929.8422
Rpar50 vdd.t2 vdd.t28 1736.5209
Rpar51 vdd.t2 vdd.t29 4477.0276
Rpar52 vdd.t28 vdd.t29 8.8964
Rpar53 vss vss.t0 4171.3981
Rpar54 vss vss.t2 83.1896
Rpar55 vss vss.t26 1330.2904
Rpar56 vss vss.t35 51.8725
Rpar57 vss vss.t36 211.7530
Rpar58 vss.t0 vss.t1 6.3521
Rpar59 vss.t0 vss.t2 264.3001
Rpar60 vss.t0 vss.t35 903.7701
Rpar61 vss.t1 vss.t2 397.8704
Rpar62 vss.t2 vss.t26 187.6375
Rpar63 vss.t2 vss.t35 6.5607
Rpar64 vss.t2 vss.t36 27.4097
Rpar65 vss.t26 vss.t35 28.2688
Rpar66 vss.t26 vss.t36 134.2858
Rpar67 vss.t35 vss.t36 5.0718
Cpar0 a_10312_1086.t0 vss 5.93230e-15
Cpar1 a_10312_1086.t10 vss 4.21699e-15
Cpar2 a_10312_1086.t12 vss 5.40240e-15
Cpar3 a_10312_1086.t13 vss 6.10780e-15
Cpar4 a_1059_3686.t0 vss 4.56306e-15
Cpar5 a_1059_3686.t10 vss 7.51426e-15
Cpar6 a_1059_3686.t12 vss 3.99977e-15
Cpar7 a_1059_3686.t13 vss 1.12104e-14
Cpar8 a_1059_3686.t15 vss 1.42313e-14
Cpar9 a_1157_6688.t0 vss 9.47155e-14
Cpar10 a_1157_6688.t128 vss 8.45088e-15
Cpar11 a_1277_6480.t0 vss 8.47215e-15
Cpar12 a_1277_6480.t1 vss 4.69278e-15
Cpar13 a_1277_6480.t4 vss 3.35933e-15
Cpar14 a_2522_1249.t0 vss 1.12066e-14
Cpar15 a_2522_1249.t20 vss 9.86321e-15
Cpar16 a_4297_3686.t0 vss 2.15760e-16
Cpar17 a_4297_3686.t1 vss 1.16031e-14
Cpar18 a_6046_6688.t0 vss 4.92055e-14
Cpar19 a_6046_6688.t64 vss 6.17654e-15
Cpar20 a_6046_6688.t65 vss 3.33325e-15
Cpar21 a_9892_17719.t0 vss 4.96148e-14
Cpar22 a_9892_17719.t64 vss 7.05357e-15
Cpar23 a_9892_17719.t65 vss 3.00130e-15
Cpar24 ib out 1.30435e-15
Cpar25 ib vss 1.88102e-14
Cpar26 ib.t0 vss 6.35539e-15
Cpar27 ib.t1 vss 8.82921e-16
Cpar28 inn inp 2.61340e-16
Cpar29 inn vdd 3.17193e-14
Cpar30 inn vss 1.36189e-14
Cpar31 inn.t0 vss 2.90584e-15
Cpar32 inn.t10 vss 5.33179e-14
Cpar33 inp out 2.18300e-17
Cpar34 inp vdd 3.25527e-14
Cpar35 inp vss 1.30624e-14
Cpar36 inp.t0 vss 3.52715e-15
Cpar37 inp.t10 vss 5.40416e-14
Cpar38 out vdd 1.36984e-14
Cpar39 out vss 3.24110e-14
Cpar40 out.t0 vss 8.98457e-15
Cpar41 out.t4 vss 1.75757e-14
Cpar42 out.t8 vss 7.89881e-15
Cpar43 vdd vss 3.12072e-13
Cpar44 vdd.t0 vss 2.15440e-14
Cpar45 vdd.t1 vss 1.15664e-14
Cpar46 vdd.t2 vss 8.97353e-14
Cpar47 vdd.t28 vss 1.08438e-14
Cpar48 vdd.t29 vss 4.76033e-15
.ends opamp_dut

Vdd vdd 0 1.800000
Vss vss 0 0
Ibias vdd ib 1.250000e-06
Vinp inp 0 DC 0.895000 AC 1 PWL(0 0.895000 4.222394e-08 0.895000 4.644633e-08 0.905000)
Rfb out inn 1m
Cload out 0 2.000000e-12
Xdut vdd vss inp inn out ib opamp_dut
.end
