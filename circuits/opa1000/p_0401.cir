* opa1000[0401]: 2p/nmos_5t_3v3_0p1u_1u_subth (nmos_5t, VDD=3.3V, CL=2.0pF, Iref=0.1437uA)
.include "pdk_opa.inc"
.temp 27
.option gmin=1e-12 rshunt=1e12 reltol=1e-3 abstol=1e-12 vntol=1e-5 method=gear
* Post-PEX R+C extracted netlist for nmos_5t_3v3_0p1u_1u_subth
.subckt opamp_dut vdd vss inp inn out ib
XMpar0 a_2802_1249.t65 a_2802_1249.t64 vdd.t1 vdd.t0 pfet_03v3 w=1.87u l=5u ad=6.4328e-13 pd=2.9320e-06 as=6.4328e-13 ps=2.9320e-06 nf=1 m=10 par=10
XMpar1 a_1682_1249.t8 inp.t0 a_2802_1249.t0 vss.t0 nfet_03v3 w=5.55u l=5u ad=1.9980e-12 pd=7.6575e-06 as=1.5540e-12 ps=6.1100e-06 nf=1 m=64 par=64
XMpar2 a_1682_1249.t8 inn.t0 out.t8 vss.t0 nfet_03v3 w=5.55u l=5u ad=1.9980e-12 pd=7.6575e-06 as=1.5540e-12 ps=6.1100e-06 nf=1 m=64 par=64
XMpar3 out.t0 a_2802_1249.t64 vdd.t1 vdd.t0 pfet_03v3 w=1.87u l=5u ad=6.4328e-13 pd=2.9320e-06 as=5.2360e-13 ps=2.4300e-06 nf=1 m=10 par=10
XMpar4 a_1682_1249.t0 ib.t0 vss.t1 vss.t0 nfet_03v3 w=1.47u l=6.25u ad=4.1160e-13 pd=2.0300e-06 as=5.2920e-13 ps=2.5575e-06 nf=1 m=8 par=8
XMpar5 ib.t1 ib.t0 vss.t1 vss.t0 nfet_03v3 w=1.47u l=6.25u ad=4.1160e-13 pd=2.0300e-06 as=4.1160e-13 ps=2.0300e-06 nf=1 m=2 par=2
X57 out.t74 vss.t28 cap_mim_2f0fF c_width=11.18u c_length=11.18u
Rpar0 a_1682_1249.t0 a_1682_1249.t8 64.1701
Rpar1 a_2802_1249.t0 a_2802_1249.t64 192.8709
Rpar2 a_2802_1249.t0 a_2802_1249.t65 103.5043
Rpar3 a_2802_1249.t64 a_2802_1249.t65 5.7024
Rpar4 ib ib.t0 32.8127
Rpar5 ib ib.t1 22.4285
Rpar6 ib.t0 ib.t1 63.6369
Rpar7 inn inn.t0 1.5858
Rpar8 inp inp.t0 1.5858
Rpar9 out out.t0 58.7582
Rpar10 out out.t8 237.3312
Rpar11 out out.t74 15.1323
Rpar12 out.t0 out.t8 101.2277
Rpar13 out.t0 out.t74 696.3393
Rpar14 out.t8 out.t74 2812.5967
Rpar15 vdd vdd.t0 20.3419
Rpar16 vdd vdd.t1 451.2371
Rpar17 vdd.t0 vdd.t1 10.3260
Rpar18 vss vss.t0 23.2949
Rpar19 vss vss.t1 691.6861
Rpar20 vss vss.t28 389.9981
Rpar21 vss.t0 vss.t1 5.6527
Rpar22 vss.t0 vss.t28 52.1037
Rpar23 vss.t1 vss.t28 1464.6267
Cpar0 a_1682_1249.t0 vss 7.87497e-15
Cpar1 a_1682_1249.t8 vss 1.73784e-13
Cpar2 a_2802_1249.t0 vss 9.74952e-14
Cpar3 a_2802_1249.t64 vss 7.05626e-14
Cpar4 a_2802_1249.t65 vss 1.89603e-14
Cpar5 ib inn 6.12200e-17
Cpar6 ib inp 5.71700e-17
Cpar7 ib out 2.35500e-17
Cpar8 ib vdd 3.65000e-17
Cpar9 ib vss 4.13455e-14
Cpar10 ib.t0 vss 6.44314e-15
Cpar11 ib.t1 vss 2.57837e-16
Cpar12 inn inp 4.13430e-16
Cpar13 inn out 5.08408e-14
Cpar14 inn vss 1.12588e-13
Cpar15 inn.t0 vss 8.66876e-14
Cpar16 inp vss 1.12960e-13
Cpar17 inp.t0 vss 8.66731e-14
Cpar18 out vdd 1.90620e-14
Cpar19 out vss 3.51459e-14
Cpar20 out.t0 vss 1.91138e-14
Cpar21 out.t74 vss 3.63664e-14
Cpar22 out.t8 vss 7.88525e-14
Cpar23 vdd vss 1.70685e-13
Cpar24 vdd.t0 vss 7.06366e-14
Cpar25 vdd.t1 vss 8.39160e-15
.ends opamp_dut

Vdd vdd 0 3.300000
Vss vss 0 0
Ibias vdd ib 1.437000e-07
Vinp inp 0 DC 1.645000 AC 1 PWL(0 1.645000 2.265238e-07 1.645000 2.491762e-07 1.655000)
Rfb out inn 1m
Cload out 0 2.000000e-12
Xdut vdd vss inp inn out ib opamp_dut
.end
