* opa1000[0071]: 2p/cherry_hooper_3v3_i2u_subth (cherry_hooper, VDD=3.3V, CL=2.0pF, Iref=0.1357uA)
.include "pdk_opa.inc"
.temp 27
.option gmin=1e-12 rshunt=1e12 reltol=1e-3 abstol=1e-12 vntol=1e-5 method=gear
* Post-PEX R+C extracted netlist for cherry_hooper_3v3_i2u_subth
.subckt opamp_dut vdd vss inp inn out ib
XMpar0 a_6766_6781.t0 ib.t0 vss.t4 vss.t3 nfet_03v3 w=1u l=2.6u ad=6.0000e-13 pd=3.2000e-06 as=2.8000e-13 ps=1.5600e-06 nf=1 m=2 par=2
XMpar1 a_7317_3807.t0 a_1368_3807.t3 a_9714_3807.t5 vdd.t13 pfet_03v3 w=0.44u l=1u ad=2.6400e-13 pd=2.0800e-06 as=2.6400e-13 ps=2.0800e-06 nf=1 m=1
XMpar2 a_11014_10050.t4 a_11014_10050.t3 vdd.t1 vdd.t0 pfet_03v3 w=6.73u l=1.35u ad=1.8844e-12 pd=7.2900e-06 as=4.0380e-12 ps=1.4660e-05 nf=1 m=2 par=2
XMpar3 out.t2 a_9730_13544.t0 vdd.t1 vdd.t0 pfet_03v3 w=6.73u l=1.35u ad=2.6023e-12 pd=9.7467e-06 as=1.8844e-12 ps=7.2900e-06 nf=1 m=3 par=3
XMpar4 a_7317_3807.t4 a_7317_3807.t3 vdd.t1 vdd.t0 pfet_03v3 w=6.73u l=1.35u ad=1.8844e-12 pd=7.2900e-06 as=4.0380e-12 ps=1.4660e-05 nf=1 m=2 par=2
XMpar5 a_5494_6781.t0 ib.t0 vss.t4 vss.t3 nfet_03v3 w=1u l=2.6u ad=6.0000e-13 pd=3.2000e-06 as=4.4000e-13 ps=2.3800e-06 nf=1 m=4 par=4
XMpar6 a_1248_4015.t2 a_1248_4015.t1 vdd.t1 vdd.t0 pfet_03v3 w=6.73u l=1.35u ad=4.0380e-12 pd=1.4660e-05 as=4.0380e-12 ps=1.4660e-05 nf=1 m=1
XMpar7 a_9730_13544.t1 a_9730_13544.t0 vdd.t1 vdd.t0 pfet_03v3 w=6.73u l=1.35u ad=2.6023e-12 pd=9.7467e-06 as=1.8844e-12 ps=7.2900e-06 nf=1 m=3 par=3
XMpar8 a_6074_10040.t6 a_11014_10050.t7 out.t0 vss.t2 nfet_03v3 w=9.33u l=1.9u ad=5.5980e-12 pd=1.9860e-05 as=2.6124e-12 ps=9.8900e-06 nf=1 m=2 par=2
XMpar9 a_10894_6680.t1 inn.t0 a_6766_6781.t2 vss.t0 nfet_03v3 w=1.56u l=1.9u ad=4.3680e-13 pd=2.1200e-06 as=9.3600e-13 ps=4.3200e-06 nf=1 m=4 par=4
XMpar10 a_10894_6680.t0 a_1368_3807.t3 a_11014_10050.t2 vdd.t13 pfet_03v3 w=0.44u l=1u ad=2.6400e-13 pd=2.0800e-06 as=2.6400e-13 ps=2.0800e-06 nf=1 m=1
XMpar11 a_6766_6781.t2 inp.t0 a_9714_3807.t1 vss.t0 nfet_03v3 w=1.56u l=1.9u ad=9.3600e-13 pd=4.3200e-06 as=4.3680e-13 ps=2.1200e-06 nf=1 m=4 par=4
XMpar12 a_6074_10040.t0 ib.t0 vss.t4 vss.t3 nfet_03v3 w=1u l=2.6u ad=3.8667e-13 pd=2.1067e-06 as=3.8667e-13 ps=2.1067e-06 nf=1 m=6 par=6
XMpar13 a_3204_6574.t2 a_3204_6574.t1 vdd.t3 vdd.t2 pfet_03v3 w=3.24u l=2.6u ad=1.9440e-12 pd=7.6800e-06 as=1.9440e-12 ps=7.6800e-06 nf=1 m=1
XMpar14 a_6074_10040.t6 a_7317_3807.t7 a_9730_13544.t6 vss.t2 nfet_03v3 w=9.33u l=1.9u ad=5.5980e-12 pd=1.9860e-05 as=2.6124e-12 ps=9.8900e-06 nf=1 m=2 par=2
XMpar15 a_5494_6781.t4 a_9714_3807.t6 a_7317_3807.t1 vss.t0 nfet_03v3 w=6.22u l=1.9u ad=3.7320e-12 pd=1.3640e-05 as=1.7416e-12 ps=6.7800e-06 nf=1 m=2 par=2
XMpar16 a_11014_10050.t0 a_10894_6680.t6 a_5494_6781.t4 vss.t0 nfet_03v3 w=6.22u l=1.9u ad=1.7416e-12 pd=6.7800e-06 as=3.7320e-12 ps=1.3640e-05 nf=1 m=2 par=2
XMpar17 ib.t1 ib.t0 vss.t4 vss.t3 nfet_03v3 w=1u l=2.6u ad=6.0000e-13 pd=3.2000e-06 as=2.8000e-13 ps=1.5600e-06 nf=1 m=1
XMpar18 a_10894_6680.t5 a_3204_6574.t1 vdd.t3 vdd.t2 pfet_03v3 w=3.24u l=2.6u ad=1.9440e-12 pd=7.6800e-06 as=1.9440e-12 ps=7.6800e-06 nf=1 m=1
XMpar19 a_3204_6574.t0 ib.t0 vss.t4 vss.t3 nfet_03v3 w=1u l=2.6u ad=6.0000e-13 pd=3.2000e-06 as=2.8000e-13 ps=1.5600e-06 nf=1 m=1
XMpar20 a_9714_3807.t0 a_3204_6574.t1 vdd.t3 vdd.t2 pfet_03v3 w=3.24u l=2.6u ad=1.9440e-12 pd=7.6800e-06 as=1.9440e-12 ps=7.6800e-06 nf=1 m=1
XMpar21 a_1248_4015.t0 a_1368_3807.t1 a_1368_3807.t2 vdd.t12 pfet_03v3 w=5.94u l=1u ad=3.5640e-12 pd=1.3080e-05 as=3.5640e-12 ps=1.3080e-05 nf=1 m=1
XMpar22 a_1368_3807.t0 ib.t0 vss.t4 vss.t3 nfet_03v3 w=1u l=2.6u ad=6.0000e-13 pd=3.2000e-06 as=6.0000e-13 ps=3.2000e-06 nf=1 m=1
X5 out.t5 vss.t33 cap_mim_2f0fF c_width=17.32u c_length=17.32u
X23 out.t5 vss.t33 cap_mim_2f0fF c_width=17.32u c_length=17.32u
X50 out.t5 vss.t33 cap_mim_2f0fF c_width=17.32u c_length=17.32u
Rpar0 a_10894_6680.t0 a_10894_6680.t1 276.7299
Rpar1 a_10894_6680.t0 a_10894_6680.t5 74.7863
Rpar2 a_10894_6680.t0 a_10894_6680.t6 147.8841
Rpar3 a_10894_6680.t1 a_10894_6680.t5 217.6347
Rpar4 a_10894_6680.t1 a_10894_6680.t6 77.3945
Rpar5 a_10894_6680.t5 a_10894_6680.t6 116.3037
Rpar6 a_11014_10050.t0 a_11014_10050.t2 89.5019
Rpar7 a_11014_10050.t0 a_11014_10050.t3 481.7018
Rpar8 a_11014_10050.t0 a_11014_10050.t4 101.8671
Rpar9 a_11014_10050.t0 a_11014_10050.t7 66.9841
Rpar10 a_11014_10050.t2 a_11014_10050.t3 1094.8037
Rpar11 a_11014_10050.t2 a_11014_10050.t4 231.5219
Rpar12 a_11014_10050.t2 a_11014_10050.t7 131.1050
Rpar13 a_11014_10050.t3 a_11014_10050.t4 37.6498
Rpar14 a_11014_10050.t3 a_11014_10050.t7 819.3620
Rpar15 a_11014_10050.t4 a_11014_10050.t7 173.2733
Rpar16 a_1248_4015.t0 a_1248_4015.t1 336.1055
Rpar17 a_1248_4015.t0 a_1248_4015.t2 49.2534
Rpar18 a_1248_4015.t1 a_1248_4015.t2 61.2388
Rpar19 a_1368_3807.t0 a_1368_3807.t1 515.4651
Rpar20 a_1368_3807.t0 a_1368_3807.t2 61.7849
Rpar21 a_1368_3807.t0 a_1368_3807.t3 406.0041
Rpar22 a_1368_3807.t1 a_1368_3807.t2 66.3480
Rpar23 a_1368_3807.t1 a_1368_3807.t3 1650.1514
Rpar24 a_1368_3807.t2 a_1368_3807.t3 197.7912
Rpar25 a_3204_6574.t0 a_3204_6574.t1 166.9786
Rpar26 a_3204_6574.t0 a_3204_6574.t2 89.6586
Rpar27 a_3204_6574.t1 a_3204_6574.t2 27.9781
Rpar28 a_5494_6781.t0 a_5494_6781.t4 46.4944
Rpar29 a_6074_10040.t0 a_6074_10040.t6 45.7995
Rpar30 a_6766_6781.t0 a_6766_6781.t2 94.6271
Rpar31 a_7317_3807.t0 a_7317_3807.t1 99.7790
Rpar32 a_7317_3807.t0 a_7317_3807.t3 866.4008
Rpar33 a_7317_3807.t0 a_7317_3807.t4 183.2208
Rpar34 a_7317_3807.t0 a_7317_3807.t7 133.2296
Rpar35 a_7317_3807.t1 a_7317_3807.t3 379.1517
Rpar36 a_7317_3807.t1 a_7317_3807.t4 80.1805
Rpar37 a_7317_3807.t1 a_7317_3807.t7 72.1066
Rpar38 a_7317_3807.t3 a_7317_3807.t4 39.0818
Rpar39 a_7317_3807.t3 a_7317_3807.t7 626.1158
Rpar40 a_7317_3807.t4 a_7317_3807.t7 132.4069
Rpar41 a_9714_3807.t0 a_9714_3807.t1 220.7175
Rpar42 a_9714_3807.t0 a_9714_3807.t5 97.6767
Rpar43 a_9714_3807.t0 a_9714_3807.t6 157.7535
Rpar44 a_9714_3807.t1 a_9714_3807.t5 197.4798
Rpar45 a_9714_3807.t1 a_9714_3807.t6 61.4604
Rpar46 a_9714_3807.t5 a_9714_3807.t6 141.1448
Rpar47 a_9730_13544.t0 a_9730_13544.t1 19.9263
Rpar48 a_9730_13544.t0 a_9730_13544.t6 278.0836
Rpar49 a_9730_13544.t1 a_9730_13544.t6 59.1618
Rpar50 ib ib.t0 2.5209
Rpar51 ib ib.t1 1636.8808
Rpar52 ib.t0 ib.t1 24.2866
Rpar53 inn inn.t0 4.2572
Rpar54 inp inp.t0 4.2572
Rpar55 out out.t0 85.2929
Rpar56 out out.t2 74.4085
Rpar57 out out.t5 18.1119
Rpar58 out.t0 out.t2 150.8316
Rpar59 out.t0 out.t5 364.6792
Rpar60 out.t2 out.t5 318.1415
Rpar61 vdd vdd.t0 69.0830
Rpar62 vdd vdd.t1 134.5751
Rpar63 vdd vdd.t13 428.3194
Rpar64 vdd vdd.t2 486.8532
Rpar65 vdd vdd.t3 210.3812
Rpar66 vdd.t0 vdd.t1 2.9102
Rpar67 vdd.t0 vdd.t12 199.1942
Rpar68 vdd.t0 vdd.t13 49.9643
Rpar69 vdd.t0 vdd.t2 243.5292
Rpar70 vdd.t0 vdd.t3 102.2570
Rpar71 vdd.t1 vdd.t12 187.2952
Rpar72 vdd.t1 vdd.t13 59.6798
Rpar73 vdd.t1 vdd.t2 319.2144
Rpar74 vdd.t1 vdd.t3 132.5140
Rpar75 vdd.t12 vdd.t13 2931.9192
Rpar76 vdd.t12 vdd.t2 460.5889
Rpar77 vdd.t12 vdd.t3 179.7535
Rpar78 vdd.t13 vdd.t2 557.7948
Rpar79 vdd.t13 vdd.t3 240.1295
Rpar80 vdd.t2 vdd.t3 9.0158
Rpar81 vss vss.t0 68.0326
Rpar82 vss vss.t4 133.4696
Rpar83 vss vss.t3 93.0725
Rpar84 vss vss.t2 665.1923
Rpar85 vss vss.t33 212.4205
Rpar86 vss.t0 vss.t4 567.9757
Rpar87 vss.t0 vss.t3 189.5688
Rpar88 vss.t0 vss.t2 159.0694
Rpar89 vss.t0 vss.t33 64.3825
Rpar90 vss.t4 vss.t3 5.5213
Rpar91 vss.t4 vss.t2 239.9731
Rpar92 vss.t4 vss.t33 1859.0381
Rpar93 vss.t3 vss.t2 45.8324
Rpar94 vss.t3 vss.t33 592.1996
Rpar95 vss.t2 vss.t33 485.5843
Cpar0 a_10894_6680.t0 vss 1.20663e-15
Cpar1 a_10894_6680.t1 vss 2.93776e-15
Cpar2 a_10894_6680.t5 vss 2.34744e-15
Cpar3 a_10894_6680.t6 vss 5.17954e-15
Cpar4 a_11014_10050.t0 vss 2.34235e-15
Cpar5 a_11014_10050.t2 vss 8.05392e-16
Cpar6 a_11014_10050.t3 vss 2.39106e-15
Cpar7 a_11014_10050.t4 vss 2.53738e-15
Cpar8 a_11014_10050.t7 vss 4.46167e-15
Cpar9 a_1248_4015.t0 vss 2.53149e-15
Cpar10 a_1248_4015.t1 vss 1.69000e-15
Cpar11 a_1248_4015.t2 vss 3.49658e-15
Cpar12 a_1368_3807.t0 vss 3.16396e-15
Cpar13 a_1368_3807.t1 vss 1.62290e-15
Cpar14 a_1368_3807.t2 vss 6.58280e-15
Cpar15 a_1368_3807.t3 vss 5.21498e-15
Cpar16 a_3204_6574.t0 vss 3.57610e-15
Cpar17 a_3204_6574.t1 vss 1.28410e-14
Cpar18 a_3204_6574.t2 vss 5.84049e-15
Cpar19 a_5494_6781.t0 vss 3.87610e-15
Cpar20 a_5494_6781.t4 vss 7.06507e-15
Cpar21 a_6074_10040.t0 vss 1.77621e-15
Cpar22 a_6074_10040.t6 vss 5.08742e-15
Cpar23 a_6766_6781.t0 vss 6.32940e-15
Cpar24 a_6766_6781.t2 vss 8.48999e-15
Cpar25 a_7317_3807.t0 vss 1.03549e-15
Cpar26 a_7317_3807.t1 vss 2.93347e-15
Cpar27 a_7317_3807.t3 vss 3.08689e-15
Cpar28 a_7317_3807.t4 vss 3.31978e-15
Cpar29 a_7317_3807.t7 vss 5.68466e-15
Cpar30 a_9714_3807.t0 vss 2.89618e-15
Cpar31 a_9714_3807.t1 vss 3.79398e-15
Cpar32 a_9714_3807.t5 vss 1.79240e-15
Cpar33 a_9714_3807.t6 vss 6.47148e-15
Cpar34 a_9730_13544.t0 vss 9.16417e-15
Cpar35 a_9730_13544.t1 vss 5.37034e-15
Cpar36 a_9730_13544.t6 vss 3.11338e-15
Cpar37 ib vdd 8.71820e-16
Cpar38 ib vss 3.28835e-14
Cpar39 ib.t0 vss 7.77096e-15
Cpar40 ib.t1 vss 7.39416e-16
Cpar41 inn inp 1.04700e-16
Cpar42 inn vss 5.76135e-15
Cpar43 inn.t0 vss 1.46629e-15
Cpar44 inp vss 5.69322e-15
Cpar45 inp.t0 vss 1.47127e-15
Cpar46 out vdd 4.84248e-15
Cpar47 out vss 2.41947e-14
Cpar48 out.t0 vss 1.06047e-16
Cpar49 out.t2 vss 1.67695e-16
Cpar50 out.t5 vss 9.15223e-15
Cpar51 vdd vss 1.34211e-13
Cpar52 vdd.t0 vss 1.92551e-14
Cpar53 vdd.t1 vss 1.60082e-14
Cpar54 vdd.t12 vss 3.61659e-15
Cpar55 vdd.t13 vss 3.70933e-15
Cpar56 vdd.t2 vss 5.50573e-15
Cpar57 vdd.t3 vss 6.84830e-15
.ends opamp_dut

Vdd vdd 0 3.300000
Vss vss 0 0
Ibias vdd ib 1.357000e-07
Vinp inp 0 DC 2.055500 AC 1 PWL(0 2.055500 7.669409e-08 2.055500 8.436350e-08 2.065500)
Rfb out inn 1m
Cload out 0 2.000000e-12
Xdut vdd vss inp inn out ib opamp_dut
.end
