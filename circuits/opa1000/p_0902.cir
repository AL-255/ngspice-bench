* opa1000[0902]: 2p/telescopic_nmos_3v3_i1u_subth (telescopic_nmos, VDD=3.3V, CL=2.0pF, Iref=0.2875uA)
.include "pdk_opa.inc"
.temp 27
.option gmin=1e-12 rshunt=1e12 reltol=1e-3 abstol=1e-12 vntol=1e-5 method=gear
* Post-PEX R+C extracted netlist for telescopic_nmos_3v3_i1u_subth
.subckt opamp_dut vdd vss inp inn out ib
XMpar0 a_5645_9472.t8 inp.t0 a_7450_1205.t3 vss.t0 nfet_03v3 w=4.11u l=2.08u ad=1.2741e-12 pd=5.1153e-06 as=1.2330e-12 ps=4.9669e-06 nf=1 m=64 par=64
XMpar1 a_12832_9472.t0 inn.t0 a_5645_9472.t8 vss.t0 nfet_03v3 w=4.11u l=2.08u ad=1.2330e-12 pd=4.9669e-06 as=1.2741e-12 ps=5.1153e-06 nf=1 m=64 par=64
XMpar2 a_6524_13128.t1 a_6524_13128.t0 a_7579_17002.t0 vdd.t0 pfet_03v3 w=1.97u l=2.55u ad=6.4166e-13 pd=2.9029e-06 as=7.6173e-13 ps=3.4000e-06 nf=1 m=42 par=42
XMpar3 a_7579_17002.t13 a_6524_13128.t150 vdd.t18 vdd.t17 pfet_03v3 w=2.01u l=6.75u ad=5.6280e-13 pd=2.5700e-06 as=8.8440e-13 ps=3.8950e-06 nf=1 m=16 par=16
XMpar4 a_6404_13337.t0 a_6524_13128.t0 out.t0 vdd.t0 pfet_03v3 w=1.97u l=2.55u ad=8.2177e-13 pd=3.6486e-06 as=5.8162e-13 ps=2.6543e-06 nf=1 m=42 par=42
XMpar5 a_6404_13337.t5 a_6524_13128.t150 vdd.t18 vdd.t17 pfet_03v3 w=2.01u l=6.75u ad=5.6280e-13 pd=2.5700e-06 as=5.6280e-13 ps=2.5700e-06 nf=1 m=16 par=16
XMpar6 ib.t1 ib.t0 vss.t2 vss.t0 nfet_03v3 w=1.47u l=3.5u ad=8.8200e-13 pd=4.1400e-06 as=4.1160e-13 ps=2.0300e-06 nf=1 m=2 par=2
XMpar7 a_12832_9472.t64 a_6524_13128.t84 out.t25 vss.t0 nfet_03v3 w=1.94u l=2.55u ad=8.5360e-13 pd=3.7900e-06 as=5.4320e-13 ps=2.5000e-06 nf=1 m=8 par=8
XMpar8 a_5645_9472.t0 ib.t0 vss.t2 vss.t0 nfet_03v3 w=1.47u l=3.5u ad=4.1160e-13 pd=2.0300e-06 as=7.6440e-13 ps=3.6125e-06 nf=1 m=8 par=8
XMpar9 a_6524_13128.t85 a_6524_13128.t84 a_7450_1205.t0 vss.t0 nfet_03v3 w=1.94u l=2.55u ad=5.4320e-13 pd=2.5000e-06 as=1.1640e-12 ps=5.0800e-06 nf=1 m=8 par=8
X158 out.t50 vss.t42 cap_mim_2f0fF c_width=11.49u c_length=11.49u
Rpar0 a_12832_9472.t0 a_12832_9472.t64 42.1643
Rpar1 a_5645_9472.t0 a_5645_9472.t8 79.5368
Rpar2 a_6404_13337.t0 a_6404_13337.t5 49.8588
Rpar3 a_6524_13128.t0 a_6524_13128.t1 4.0557
Rpar4 a_6524_13128.t0 a_6524_13128.t150 2921.7510
Rpar5 a_6524_13128.t1 a_6524_13128.t84 435.1402
Rpar6 a_6524_13128.t1 a_6524_13128.t150 88.5288
Rpar7 a_6524_13128.t1 a_6524_13128.t85 109.0646
Rpar8 a_6524_13128.t84 a_6524_13128.t150 1073.8181
Rpar9 a_6524_13128.t84 a_6524_13128.t85 9.1622
Rpar10 a_6524_13128.t150 a_6524_13128.t85 269.1445
Rpar11 a_7450_1205.t0 a_7450_1205.t3 91.8324
Rpar12 a_7579_17002.t0 a_7579_17002.t13 41.9650
Rpar13 ib ib.t0 13.0096
Rpar14 ib ib.t1 11.4615
Rpar15 ib.t0 ib.t1 29.9035
Rpar16 inn inn.t0 1.4678
Rpar17 inp inp.t0 1.4678
Rpar18 out out.t0 8.0399
Rpar19 out out.t25 5449.1180
Rpar20 out out.t50 6310.6962
Rpar21 out.t0 out.t25 63.3281
Rpar22 out.t0 out.t50 73.3412
Rpar23 out.t25 out.t50 219.8452
Rpar24 vdd vdd.t0 199.2235
Rpar25 vdd vdd.t17 21.9542
Rpar26 vdd vdd.t18 379.0549
Rpar27 vdd.t0 vdd.t17 82.6530
Rpar28 vdd.t0 vdd.t18 1427.0622
Rpar29 vdd.t17 vdd.t18 10.0024
Rpar30 vss vss.t0 31.4420
Rpar31 vss vss.t2 674.0813
Rpar32 vss vss.t42 276.9885
Rpar33 vss.t0 vss.t2 11.9868
Rpar34 vss.t0 vss.t42 51.0900
Rpar35 vss.t2 vss.t42 657.6422
Cpar0 a_12832_9472.t0 vss 6.51039e-14
Cpar1 a_12832_9472.t64 vss 1.33387e-14
Cpar2 a_5645_9472.t0 vss 9.97652e-15
Cpar3 a_5645_9472.t8 vss 1.11787e-13
Cpar4 a_6404_13337.t0 vss 7.98675e-14
Cpar5 a_6404_13337.t5 vss 4.94014e-14
Cpar6 a_6524_13128.t0 vss 1.40373e-13
Cpar7 a_6524_13128.t1 vss 4.69989e-14
Cpar8 a_6524_13128.t150 vss 1.38279e-13
Cpar9 a_6524_13128.t84 vss 2.82658e-14
Cpar10 a_6524_13128.t85 vss 1.05210e-14
Cpar11 a_7450_1205.t0 vss 1.72961e-14
Cpar12 a_7450_1205.t3 vss 6.66171e-14
Cpar13 a_7579_17002.t0 vss 8.13540e-14
Cpar14 a_7579_17002.t13 vss 5.05559e-14
Cpar15 ib inp 1.28400e-17
Cpar16 ib out 1.53820e-16
Cpar17 ib vdd 1.99500e-17
Cpar18 ib vss 2.96915e-14
Cpar19 ib.t0 vss 5.09276e-15
Cpar20 ib.t1 vss 4.35235e-16
Cpar21 inn inp 2.20300e-16
Cpar22 inn vss 5.76964e-14
Cpar23 inn.t0 vss 4.53857e-14
Cpar24 inp vss 5.74190e-14
Cpar25 inp.t0 vss 4.53626e-14
Cpar26 out vdd 2.20749e-14
Cpar27 out vss 2.02509e-14
Cpar28 out.t0 vss 3.94749e-14
Cpar29 out.t25 vss 1.00014e-14
Cpar30 out.t50 vss 4.20013e-14
Cpar31 vdd vss 6.39797e-13
Cpar32 vdd.t0 vss 1.92673e-13
Cpar33 vdd.t17 vss 1.30637e-13
Cpar34 vdd.t18 vss 1.60088e-14
.ends opamp_dut

Vdd vdd 0 3.300000
Vss vss 0 0
Ibias vdd ib 2.875000e-07
Vinp inp 0 DC 1.711000 AC 1 PWL(0 1.711000 1.333295e-07 1.711000 1.466624e-07 1.721000)
Rfb out inn 1m
Cload out 0 2.000000e-12
Xdut vdd vss inp inn out ib opamp_dut
.end
