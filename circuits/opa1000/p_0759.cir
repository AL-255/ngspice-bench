* opa1000[0759]: 200f/symmetrical_ota_1v8_i2u_subth (symmetrical_ota, VDD=1.8V, CL=0.2pF, Iref=0.2833uA)
.include "pdk_opa.inc"
.temp 27
.option gmin=1e-12 rshunt=1e12 reltol=1e-3 abstol=1e-12 vntol=1e-5 method=gear
* Post-PEX R+C extracted netlist for symmetrical_ota_1v8_i2u_subth
.subckt opamp_dut vdd vss inp inn out ib
XMpar0 a_1290_5036.t12 ib.t0 vss.t23 vss.t0 nfet_03v3 w=1.64u l=3.9u ad=9.8400e-13 pd=4.4800e-06 as=7.2160e-13 ps=3.3400e-06 nf=1 m=4 par=4
XMpar1 a_3156_3192.t4 a_3156_3192.t3 vss.t7 vss.t0 nfet_03v3 w=0.72u l=2.04u ad=2.0160e-13 pd=1.2800e-06 as=2.0160e-13 ps=1.2800e-06 nf=1 m=4 par=4
XMpar2 out.t3 a_1324_1041.t6 vdd.t1 vdd.t0 pfet_03v3 w=3.08u l=2.04u ad=8.6240e-13 pd=3.6400e-06 as=1.3552e-12 ps=5.5000e-06 nf=1 m=4 par=4
XMpar3 a_3156_3192.t0 a_5730_5036.t6 vdd.t1 vdd.t0 pfet_03v3 w=3.08u l=2.04u ad=8.6240e-13 pd=3.6400e-06 as=1.3552e-12 ps=5.5000e-06 nf=1 m=4 par=4
XMpar4 a_5730_5036.t7 a_5730_5036.t6 vdd.t1 vdd.t0 pfet_03v3 w=3.08u l=2.04u ad=8.6240e-13 pd=3.6400e-06 as=8.6240e-13 ps=3.6400e-06 nf=1 m=2 par=2
XMpar5 a_1290_5036.t0 inn.t0 a_5730_5036.t0 vss.t0 nfet_03v3 w=1.52u l=2.38u ad=5.8773e-13 pd=2.8000e-06 as=4.2560e-13 ps=2.0800e-06 nf=1 m=6 par=6
XMpar6 a_1290_5036.t0 inp.t0 a_1324_1041.t0 vss.t0 nfet_03v3 w=1.52u l=2.38u ad=5.8773e-13 pd=2.8000e-06 as=4.2560e-13 ps=2.0800e-06 nf=1 m=6 par=6
XMpar7 ib.t1 ib.t0 vss.t23 vss.t0 nfet_03v3 w=1.64u l=3.9u ad=9.8400e-13 pd=4.4800e-06 as=4.5920e-13 ps=2.2000e-06 nf=1 m=2 par=2
XMpar8 out.t0 a_3156_3192.t3 vss.t7 vss.t0 nfet_03v3 w=0.72u l=2.04u ad=2.0160e-13 pd=1.2800e-06 as=3.1680e-13 ps=1.9600e-06 nf=1 m=4 par=4
XMpar9 a_1324_1041.t7 a_1324_1041.t6 vdd.t1 vdd.t0 pfet_03v3 w=3.08u l=2.04u ad=8.6240e-13 pd=3.6400e-06 as=8.6240e-13 ps=3.6400e-06 nf=1 m=2 par=2
X15 out.t8 vss.t31 cap_mim_2f0fF c_width=14.79u c_length=14.79u
Rpar0 a_1290_5036.t0 a_1290_5036.t12 58.1715
Rpar1 a_1324_1041.t0 a_1324_1041.t6 101.7073
Rpar2 a_1324_1041.t0 a_1324_1041.t7 67.5551
Rpar3 a_1324_1041.t6 a_1324_1041.t7 23.7693
Rpar4 a_3156_3192.t0 a_3156_3192.t4 89.0393
Rpar5 a_3156_3192.t0 a_3156_3192.t3 193.8989
Rpar6 a_3156_3192.t4 a_3156_3192.t3 20.6384
Rpar7 a_5730_5036.t0 a_5730_5036.t6 101.7073
Rpar8 a_5730_5036.t0 a_5730_5036.t7 67.5551
Rpar9 a_5730_5036.t6 a_5730_5036.t7 23.7693
Rpar10 ib ib.t0 13.0985
Rpar11 ib ib.t1 8.4316
Rpar12 ib.t0 ib.t1 26.7860
Rpar13 inn inn.t0 1.2896
Rpar14 inp inp.t0 1.6636
Rpar15 out out.t0 72.7744
Rpar16 out out.t3 4.2773
Rpar17 out out.t8 231.9583
Rpar18 out.t0 out.t3 151.2607
Rpar19 out.t0 out.t8 108.8616
Rpar20 out.t3 out.t8 482.1226
Rpar21 vdd vdd.t0 124.1144
Rpar22 vdd vdd.t1 197.7261
Rpar23 vdd.t0 vdd.t1 3.0642
Rpar24 vss vss.t0 43.9534
Rpar25 vss vss.t7 631.9812
Rpar26 vss vss.t23 434.6756
Rpar27 vss vss.t31 1016.3731
Rpar28 vss.t0 vss.t7 5.1351
Rpar29 vss.t0 vss.t23 10.8613
Rpar30 vss.t0 vss.t31 70.5727
Rpar31 vss.t7 vss.t23 358.9690
Rpar32 vss.t7 vss.t31 2147.1649
Rpar33 vss.t23 vss.t31 137.9066
Cpar0 a_1290_5036.t0 vss 6.01099e-15
Cpar1 a_1290_5036.t12 vss 6.50947e-15
Cpar2 a_1324_1041.t0 vss 3.60035e-15
Cpar3 a_1324_1041.t6 vss 1.21692e-14
Cpar4 a_1324_1041.t7 vss 3.36984e-15
Cpar5 a_3156_3192.t0 vss 2.70139e-15
Cpar6 a_3156_3192.t3 vss 4.80423e-15
Cpar7 a_3156_3192.t4 vss 1.56106e-15
Cpar8 a_5730_5036.t0 vss 3.42001e-15
Cpar9 a_5730_5036.t6 vss 1.15597e-14
Cpar10 a_5730_5036.t7 vss 3.20107e-15
Cpar11 ib inn 2.43300e-17
Cpar12 ib out 1.14400e-17
Cpar13 ib vss 2.16487e-14
Cpar14 ib.t0 vss 3.29803e-15
Cpar15 ib.t1 vss 4.15129e-16
Cpar16 inn inp 5.25100e-17
Cpar17 inn vss 8.83614e-15
Cpar18 inn.t0 vss 1.08923e-15
Cpar19 inp out 5.51100e-17
Cpar20 inp vdd 3.79800e-17
Cpar21 inp vss 8.60189e-15
Cpar22 inp.t0 vss 1.31986e-15
Cpar23 out vdd 8.27921e-15
Cpar24 out vss 1.43589e-14
Cpar25 out.t0 vss 8.12064e-16
Cpar26 out.t3 vss 4.44803e-16
Cpar27 out.t8 vss 1.24324e-14
Cpar28 vdd vss 6.61864e-14
Cpar29 vdd.t0 vss 1.78090e-14
Cpar30 vdd.t1 vss 1.08133e-14
.ends opamp_dut

Vdd vdd 0 1.800000
Vss vss 0 0
Ibias vdd ib 2.833000e-07
Vinp inp 0 DC 0.895000 AC 1 PWL(0 0.895000 3.830102e-08 0.895000 4.213112e-08 0.905000)
Rfb out inn 1m
Cload out 0 2.000000e-13
Xdut vdd vss inp inn out ib opamp_dut
.end
