* opa1000[0078]: 2p/cherry_hooper_3v3_10u_100u_subth (cherry_hooper, VDD=3.3V, CL=2.0pF, Iref=3.5937uA)
.include "pdk_opa.inc"
.temp 27
.option gmin=1e-12 rshunt=1e12 reltol=1e-3 abstol=1e-12 vntol=1e-5 method=gear
* Post-PEX R+C extracted netlist for cherry_hooper_3v3_10u_100u_subth
.subckt opamp_dut vdd vss inp inn out ib
XMpar0 a_13894_13428.t0 inn.t0 a_6863_10867.t0 vss.t0 nfet_03v3 w=2.39u l=0.68u ad=6.9310e-13 pd=3.0447e-06 as=7.1700e-13 ps=3.1394e-06 nf=1 m=64 par=64
XMpar1 a_6863_10867.t64 ib.t0 vss.t57 vss.t0 nfet_03v3 w=4.87u l=0.6u ad=1.3636e-12 pd=5.4300e-06 as=1.3636e-12 ps=5.4300e-06 nf=1 m=4 par=4
XMpar2 a_6607_1041.t6 a_6607_1041.t5 vdd.t0 vdd.t0 pfet_03v3 w=8.86u l=0.5u ad=2.4808e-12 pd=9.4200e-06 as=2.7643e-12 ps=1.0370e-05 nf=1 m=20 par=20
XMpar3 a_6399_10867.t5 ib.t0 vss.t57 vss.t0 nfet_03v3 w=4.87u l=0.6u ad=1.3636e-12 pd=5.4300e-06 as=1.7532e-12 ps=6.8075e-06 nf=1 m=8 par=8
XMpar4 a_13774_11124.t42 a_13894_13428.t70 a_6399_10867.t0 vss.t0 nfet_03v3 w=10u l=0.68u ad=2.8000e-12 pd=1.0560e-05 as=3.6000e-12 ps=1.3220e-05 nf=1 m=16 par=16
XMpar5 a_10728_8019.t0 a_13774_11124.t58 out.t1 vss.t2 nfet_03v3 w=9.54u l=0.68u ad=3.4344e-12 pd=1.2645e-05 as=2.6712e-12 ps=1.0100e-05 nf=1 m=8 par=8
XMpar6 a_13774_11124.t3 a_13774_11124.t2 vdd.t0 vdd.t0 pfet_03v3 w=8.86u l=0.5u ad=2.4808e-12 pd=9.4200e-06 as=2.7643e-12 ps=1.0370e-05 nf=1 m=20 par=20
XMpar7 a_6863_10867.t0 inp.t0 a_8258_19763.t6 vss.t0 nfet_03v3 w=2.39u l=0.68u ad=7.1700e-13 pd=3.1394e-06 as=6.9310e-13 ps=3.0447e-06 nf=1 m=64 par=64
XMpar8 a_6399_10867.t0 a_8258_19763.t70 a_6607_1041.t0 vss.t0 nfet_03v3 w=10u l=0.68u ad=3.6000e-12 pd=1.3220e-05 as=2.8000e-12 ps=1.0560e-05 nf=1 m=16 par=16
XMpar9 a_4241_7630.t2 a_4241_7630.t1 vdd.t17 vdd.t16 pfet_03v3 w=7.75u l=0.6u ad=2.1700e-12 pd=8.3100e-06 as=4.6500e-12 ps=1.6700e-05 nf=1 m=2 par=2
XMpar10 a_1288_4394.t6 a_1288_4394.t5 vdd.t0 vdd.t0 pfet_03v3 w=8.86u l=0.5u ad=3.0478e-12 pd=1.1320e-05 as=3.0478e-12 ps=1.1320e-05 nf=1 m=5 par=5
XMpar11 a_10728_8019.t0 a_6607_1041.t58 a_11730_4646.t0 vss.t2 nfet_03v3 w=9.54u l=0.68u ad=3.4344e-12 pd=1.2645e-05 as=2.6712e-12 ps=1.0100e-05 nf=1 m=8 par=8
XMpar12 a_11730_4646.t9 a_11730_4646.t8 vdd.t0 vdd.t0 pfet_03v3 w=8.86u l=0.5u ad=3.0478e-12 pd=1.1320e-05 as=2.4808e-12 ps=9.4200e-06 nf=1 m=5 par=5
XMpar13 a_10728_8019.t8 ib.t0 vss.t57 vss.t0 nfet_03v3 w=4.87u l=0.6u ad=1.3636e-12 pd=5.4300e-06 as=2.9220e-12 ps=1.0940e-05 nf=1 m=2 par=2
XMpar14 a_1483_7630.t10 ib.t0 vss.t57 vss.t0 nfet_03v3 w=4.87u l=0.6u ad=2.9220e-12 pd=1.0940e-05 as=2.9220e-12 ps=1.0940e-05 nf=1 m=1
XMpar15 a_1288_4394.t0 a_1483_7630.t0 a_1483_7630.t1 vdd.t3 pfet_03v3 w=9.76u l=0.45u ad=3.3574e-12 pd=1.2400e-05 as=3.3574e-12 ps=1.2400e-05 nf=1 m=5 par=5
XMpar16 a_13894_13428.t66 a_4241_7630.t1 vdd.t17 vdd.t16 pfet_03v3 w=7.75u l=0.6u ad=2.1700e-12 pd=8.3100e-06 as=3.4100e-12 ps=1.2505e-05 nf=1 m=4 par=4
XMpar17 a_8258_19763.t2 a_4241_7630.t1 vdd.t17 vdd.t16 pfet_03v3 w=7.75u l=0.6u ad=2.1700e-12 pd=8.3100e-06 as=3.4100e-12 ps=1.2505e-05 nf=1 m=4 par=4
XMpar18 a_4241_7630.t0 ib.t0 vss.t57 vss.t0 nfet_03v3 w=4.87u l=0.6u ad=2.9220e-12 pd=1.0940e-05 as=1.3636e-12 ps=5.4300e-06 nf=1 m=1
XMpar19 a_13774_11124.t0 a_1483_7630.t11 a_13894_13428.t64 vdd.t2 pfet_03v3 w=5.01u l=0.45u ad=3.0060e-12 pd=1.1220e-05 as=1.4028e-12 ps=5.5700e-06 nf=1 m=2 par=2
XMpar20 out.t0 a_11730_4646.t8 vdd.t0 vdd.t0 pfet_03v3 w=8.86u l=0.5u ad=3.0478e-12 pd=1.1320e-05 as=2.4808e-12 ps=9.4200e-06 nf=1 m=5 par=5
XMpar21 a_6607_1041.t45 a_1483_7630.t11 a_8258_19763.t0 vdd.t2 pfet_03v3 w=5.01u l=0.45u ad=3.0060e-12 pd=1.1220e-05 as=1.4028e-12 ps=5.5700e-06 nf=1 m=2 par=2
XMpar22 ib.t1 ib.t0 vss.t57 vss.t0 nfet_03v3 w=4.87u l=0.6u ad=2.9220e-12 pd=1.0940e-05 as=1.3636e-12 ps=5.4300e-06 nf=1 m=1
X14 out.t13 vss.t133 cap_mim_2f0fF c_width=19.37u c_length=19.37u
X59 out.t13 vss.t133 cap_mim_2f0fF c_width=19.37u c_length=19.37u
X183 out.t13 vss.t133 cap_mim_2f0fF c_width=19.37u c_length=19.37u
X219 out.t13 vss.t133 cap_mim_2f0fF c_width=19.37u c_length=19.37u
Rpar0 a_10728_8019.t0 a_10728_8019.t8 49.0632
Rpar1 a_11730_4646.t0 a_11730_4646.t8 522.9191
Rpar2 a_11730_4646.t0 a_11730_4646.t9 61.7214
Rpar3 a_11730_4646.t8 a_11730_4646.t9 23.3329
Rpar4 a_1288_4394.t0 a_1288_4394.t6 39.1381
Rpar5 a_1288_4394.t0 a_1288_4394.t5 430.0472
Rpar6 a_1288_4394.t6 a_1288_4394.t5 34.4023
Rpar7 a_13774_11124.t0 a_13774_11124.t3 180.0987
Rpar8 a_13774_11124.t0 a_13774_11124.t42 71.4716
Rpar9 a_13774_11124.t0 a_13774_11124.t58 153.2104
Rpar10 a_13774_11124.t2 a_13774_11124.t3 17.7166
Rpar11 a_13774_11124.t2 a_13774_11124.t58 3451.0628
Rpar12 a_13774_11124.t3 a_13774_11124.t42 668.0749
Rpar13 a_13774_11124.t3 a_13774_11124.t58 47.3960
Rpar14 a_13774_11124.t42 a_13774_11124.t58 568.3330
Rpar15 a_13894_13428.t0 a_13894_13428.t64 242.2350
Rpar16 a_13894_13428.t0 a_13894_13428.t66 340.6660
Rpar17 a_13894_13428.t0 a_13894_13428.t70 73.4684
Rpar18 a_13894_13428.t64 a_13894_13428.t66 69.2536
Rpar19 a_13894_13428.t64 a_13894_13428.t70 103.6283
Rpar20 a_13894_13428.t66 a_13894_13428.t70 145.7371
Rpar21 a_1483_7630.t0 a_1483_7630.t1 36.4227
Rpar22 a_1483_7630.t0 a_1483_7630.t10 1154.0414
Rpar23 a_1483_7630.t0 a_1483_7630.t11 4467.0969
Rpar24 a_1483_7630.t1 a_1483_7630.t10 63.4749
Rpar25 a_1483_7630.t1 a_1483_7630.t11 245.7006
Rpar26 a_1483_7630.t10 a_1483_7630.t11 109.7985
Rpar27 a_4241_7630.t0 a_4241_7630.t1 162.8368
Rpar28 a_4241_7630.t0 a_4241_7630.t2 63.3917
Rpar29 a_4241_7630.t1 a_4241_7630.t2 52.8270
Rpar30 a_6399_10867.t0 a_6399_10867.t5 57.5588
Rpar31 a_6607_1041.t0 a_6607_1041.t6 204.7627
Rpar32 a_6607_1041.t0 a_6607_1041.t45 116.6611
Rpar33 a_6607_1041.t0 a_6607_1041.t58 178.1786
Rpar34 a_6607_1041.t6 a_6607_1041.t5 17.7233
Rpar35 a_6607_1041.t6 a_6607_1041.t45 184.5058
Rpar36 a_6607_1041.t6 a_6607_1041.t58 51.5212
Rpar37 a_6607_1041.t5 a_6607_1041.t58 3751.4312
Rpar38 a_6607_1041.t45 a_6607_1041.t58 160.5516
Rpar39 a_6863_10867.t0 a_6863_10867.t64 43.4082
Rpar40 a_8258_19763.t0 a_8258_19763.t6 385.0127
Rpar41 a_8258_19763.t0 a_8258_19763.t2 65.1142
Rpar42 a_8258_19763.t0 a_8258_19763.t70 188.6260
Rpar43 a_8258_19763.t6 a_8258_19763.t2 247.5328
Rpar44 a_8258_19763.t6 a_8258_19763.t70 92.0039
Rpar45 a_8258_19763.t2 a_8258_19763.t70 121.2717
Rpar46 ib ib.t0 19.6046
Rpar47 ib ib.t1 6.3958
Rpar48 inn inn.t0 1.8671
Rpar49 inp inp.t0 1.8671
Rpar50 out out.t0 347.3680
Rpar51 out out.t1 76.9990
Rpar52 out out.t13 18.2681
Rpar53 out.t0 out.t1 80.3683
Rpar54 out.t0 out.t13 1370.4223
Rpar55 out.t1 out.t13 303.7732
Rpar56 vdd vdd.t0 207.8967
Rpar57 vdd vdd.t16 329.9014
Rpar58 vdd vdd.t17 192.4565
Rpar59 vdd vdd.t2 274.1294
Rpar60 vdd vdd.t3 1160.1424
Rpar61 vdd.t0 vdd.t16 88.9596
Rpar62 vdd.t0 vdd.t17 56.2554
Rpar63 vdd.t0 vdd.t2 92.3754
Rpar64 vdd.t0 vdd.t3 86.8721
Rpar65 vdd.t16 vdd.t17 4.7831
Rpar66 vdd.t16 vdd.t2 139.2765
Rpar67 vdd.t16 vdd.t3 238.6098
Rpar68 vdd.t17 vdd.t2 73.7795
Rpar69 vdd.t17 vdd.t3 182.8314
Rpar70 vdd.t2 vdd.t3 515.4896
Rpar71 vss vss.t0 309.4239
Rpar72 vss vss.t2 205.4541
Rpar73 vss vss.t133 134.0217
Rpar74 vss vss.t57 219.6701
Rpar75 vss.t0 vss.t2 39.9020
Rpar76 vss.t0 vss.t133 370.9491
Rpar77 vss.t0 vss.t57 2.3599
Rpar78 vss.t2 vss.t133 246.3062
Rpar79 vss.t2 vss.t57 28.3583
Rpar80 vss.t133 vss.t57 263.3488
Cpar0 a_10728_8019.t0 vss 2.40705e-14
Cpar1 a_10728_8019.t8 vss 2.51230e-15
Cpar2 a_11730_4646.t0 vss 1.27253e-14
Cpar3 a_11730_4646.t8 vss 9.12923e-15
Cpar4 a_11730_4646.t9 vss 1.15467e-14
Cpar5 a_1288_4394.t0 vss 9.87594e-15
Cpar6 a_1288_4394.t5 vss 4.47697e-15
Cpar7 a_1288_4394.t6 vss 1.05999e-14
Cpar8 a_13774_11124.t0 vss 6.61847e-15
Cpar9 a_13774_11124.t2 vss 1.72309e-14
Cpar10 a_13774_11124.t3 vss 2.80927e-14
Cpar11 a_13774_11124.t42 vss 2.59991e-14
Cpar12 a_13774_11124.t58 vss 1.09841e-14
Cpar13 a_13894_13428.t0 vss 3.22518e-14
Cpar14 a_13894_13428.t64 vss 3.58990e-15
Cpar15 a_13894_13428.t66 vss 6.56519e-15
Cpar16 a_13894_13428.t70 vss 2.49455e-14
Cpar17 a_1483_7630.t0 vss 3.92960e-15
Cpar18 a_1483_7630.t1 vss 1.16698e-14
Cpar19 a_1483_7630.t10 vss 4.43419e-15
Cpar20 a_1483_7630.t11 vss 3.78851e-15
Cpar21 a_4241_7630.t0 vss 4.10788e-15
Cpar22 a_4241_7630.t1 vss 1.20655e-14
Cpar23 a_4241_7630.t2 vss 5.41192e-15
Cpar24 a_6399_10867.t0 vss 5.45230e-14
Cpar25 a_6399_10867.t5 vss 7.41122e-15
Cpar26 a_6607_1041.t0 vss 2.78238e-14
Cpar27 a_6607_1041.t45 vss 5.93433e-15
Cpar28 a_6607_1041.t5 vss 1.80689e-14
Cpar29 a_6607_1041.t58 vss 1.18860e-14
Cpar30 a_6607_1041.t6 vss 2.97969e-14
Cpar31 a_6863_10867.t0 vss 7.63039e-14
Cpar32 a_6863_10867.t64 vss 7.38375e-15
Cpar33 a_8258_19763.t0 vss 3.40070e-15
Cpar34 a_8258_19763.t2 vss 7.37188e-15
Cpar35 a_8258_19763.t6 vss 3.35256e-14
Cpar36 a_8258_19763.t70 vss 2.58780e-14
Cpar37 ib vdd 7.82170e-16
Cpar38 ib vss 2.00633e-14
Cpar39 ib.t0 vss 5.57288e-15
Cpar40 ib.t1 vss 4.01320e-16
Cpar41 inn inp 1.00480e-16
Cpar42 inn vdd 4.85000e-17
Cpar43 inn vss 3.03103e-14
Cpar44 inn.t0 vss 1.65641e-14
Cpar45 inp vdd 7.82700e-17
Cpar46 inp vss 3.01897e-14
Cpar47 inp.t0 vss 1.65767e-14
Cpar48 out vdd 1.00403e-14
Cpar49 out vss 3.70073e-14
Cpar50 out.t0 vss 4.95179e-16
Cpar51 out.t1 vss 6.98242e-16
Cpar52 out.t13 vss 2.51486e-14
Cpar53 vdd vss 2.52688e-13
Cpar54 vdd.t0 vss 1.15967e-13
Cpar55 vdd.t16 vss 1.59344e-14
Cpar56 vdd.t17 vss 1.52676e-14
Cpar57 vdd.t2 vss 8.38869e-15
Cpar58 vdd.t3 vss 1.19246e-14
.ends opamp_dut

Vdd vdd 0 3.300000
Vss vss 0 0
Ibias vdd ib 3.593700e-06
Vinp inp 0 DC 2.048300 AC 1 PWL(0 2.048300 1.094360e-08 2.048300 1.203797e-08 2.058300)
Rfb out inn 1m
Cload out 0 2.000000e-12
Xdut vdd vss inp inn out ib opamp_dut
.end
