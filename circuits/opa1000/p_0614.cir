* opa1000[0614]: 200f/pmos_miller_3v3_i2u_weak (pmos_miller, VDD=3.3V, CL=0.2pF, Iref=0.2875uA)
.include "pdk_opa.inc"
.temp 27
.option gmin=1e-12 rshunt=1e12 reltol=1e-3 abstol=1e-12 vntol=1e-5 method=gear
* Post-PEX R+C extracted netlist for pmos_miller_3v3_i2u_weak
.subckt opamp_dut vdd vss inp inn out ib
XMpar0 out.t0 a_1830_5492.t2 vdd.t1 vdd.t0 pfet_03v3 w=1.86u l=3.25u ad=8.7792e-13 pd=3.9200e-06 as=7.5888e-13 ps=3.4200e-06 nf=1 m=10 par=10
XMpar1 a_6576_3831.t9 a_6576_3831.t8 vss.t1 vss.t0 nfet_03v3 w=0.4u l=1.69u ad=1.1200e-13 pd=9.6000e-07 as=1.1200e-13 ps=9.6000e-07 nf=1 m=2 par=2
XMpar2 a_1830_5492.t3 a_1830_5492.t2 vdd.t1 vdd.t0 pfet_03v3 w=1.86u l=3.25u ad=1.1160e-12 pd=4.9200e-06 as=5.2080e-13 ps=2.4200e-06 nf=1 m=2 par=2
XMpar3 a_3242_5700.t1 inn.t0 a_6576_3831.t0 vdd.t14 pfet_03v3 w=1.66u l=2.4u ad=7.3040e-13 pd=3.3700e-06 as=4.6480e-13 ps=2.2200e-06 nf=1 m=8 par=8
XMpar4 a_3242_5700.t1 inp.t0 a_4379_9664.t0 vdd.t14 pfet_03v3 w=1.66u l=2.4u ad=7.3040e-13 pd=3.3700e-06 as=4.6480e-13 ps=2.2200e-06 nf=1 m=8 par=8
XMpar5 out.t2 a_4379_9664.t11 vss.t1 vss.t0 nfet_03v3 w=0.4u l=1.69u ad=1.3760e-13 pd=1.1680e-06 as=1.3760e-13 ps=1.1680e-06 nf=1 m=10 par=10
XMpar6 a_3242_5700.t0 a_1830_5492.t2 vdd.t1 vdd.t0 pfet_03v3 w=1.86u l=3.25u ad=1.1160e-12 pd=4.9200e-06 as=5.2080e-13 ps=2.4200e-06 nf=1 m=4 par=4
XMpar7 ib.t1 ib.t0 vss.t3 vss.t0 nfet_03v3 w=0.47u l=3.25u ad=2.8200e-13 pd=2.1400e-06 as=1.3160e-13 ps=1.0300e-06 nf=1 m=2 par=2
XMpar8 a_4379_9664.t9 a_6576_3831.t8 vss.t1 vss.t0 nfet_03v3 w=0.4u l=1.69u ad=2.4000e-13 pd=2.0000e-06 as=1.1200e-13 ps=9.6000e-07 nf=1 m=2 par=2
XMpar9 a_1830_5492.t0 ib.t0 vss.t3 vss.t0 nfet_03v3 w=0.47u l=3.25u ad=1.3160e-13 pd=1.0300e-06 as=1.3160e-13 ps=1.0300e-06 nf=1 m=2 par=2
X17 a_4379_9664.t8 a_8377_9664.t0 vss.t24 ppolyf_u_1k r_width=1u r_length=19.33u
X23 a_4379_10184.t0 a_8377_9664.t0 vss.t24 ppolyf_u_1k r_width=1u r_length=19.33u
X49 a_8377_10704.t1 out.t17 cap_mim_2f0fF c_width=11.46u c_length=11.46u
X50 a_4379_10184.t0 a_8377_10704.t0 vss.t24 ppolyf_u_1k r_width=1u r_length=19.33u
Rpar0 a_1830_5492.t0 a_1830_5492.t2 141.2431
Rpar1 a_1830_5492.t0 a_1830_5492.t3 79.3987
Rpar2 a_1830_5492.t2 a_1830_5492.t3 13.1763
Rpar3 a_3242_5700.t0 a_3242_5700.t1 51.0236
Rpar4 a_4379_9664.t0 a_4379_9664.t9 64.7616
Rpar5 a_4379_9664.t0 a_4379_9664.t11 178.4883
Rpar6 a_4379_9664.t0 a_4379_9664.t8 1714.4321
Rpar7 a_4379_9664.t9 a_4379_9664.t11 142.0184
Rpar8 a_4379_9664.t9 a_4379_9664.t8 1364.1280
Rpar9 a_4379_9664.t11 a_4379_9664.t8 140.3323
Rpar10 a_6576_3831.t0 a_6576_3831.t8 103.0539
Rpar11 a_6576_3831.t0 a_6576_3831.t9 106.4025
Rpar12 a_6576_3831.t8 a_6576_3831.t9 30.4564
Rpar13 a_8377_10704.t0 a_8377_10704.t1 59.4044
Rpar14 ib ib.t0 16.6449
Rpar15 ib ib.t1 8.7402
Rpar16 ib.t0 ib.t1 90.4219
Rpar17 inn inn.t0 2.4015
Rpar18 inp inp.t0 2.4015
Rpar19 out out.t0 4.5020
Rpar20 out out.t2 181.8566
Rpar21 out out.t17 768.5414
Rpar22 out.t0 out.t2 52.3141
Rpar23 out.t0 out.t17 221.0840
Rpar24 out.t2 out.t17 192.7287
Rpar25 vdd vdd.t0 115.8835
Rpar26 vdd vdd.t1 948.8894
Rpar27 vdd vdd.t14 221.7327
Rpar28 vdd.t0 vdd.t1 12.2974
Rpar29 vdd.t0 vdd.t14 42.9250
Rpar30 vdd.t1 vdd.t14 351.4831
Rpar31 vss vss.t0 172.9592
Rpar32 vss vss.t1 158.6616
Rpar33 vss vss.t24 224.0229
Rpar34 vss vss.t3 2526.0953
Rpar35 vss.t0 vss.t1 6.7703
Rpar36 vss.t0 vss.t24 146.2146
Rpar37 vss.t0 vss.t3 9.8473
Rpar38 vss.t1 vss.t24 161.7936
Rpar39 vss.t1 vss.t3 197.1660
Rpar40 vss.t24 vss.t3 2007.2958
Cpar0 a_1830_5492.t0 vss 3.01146e-15
Cpar1 a_1830_5492.t2 vss 4.21681e-14
Cpar2 a_1830_5492.t3 vss 8.22966e-15
Cpar3 a_3242_5700.t0 vss 1.95070e-14
Cpar4 a_3242_5700.t1 vss 1.63037e-14
Cpar5 a_4379_10184.t0 vss 4.68400e-17
Cpar6 a_4379_9664.t0 vss 4.23030e-15
Cpar7 a_4379_9664.t11 vss 9.84949e-15
Cpar8 a_4379_9664.t8 vss 4.46397e-15
Cpar9 a_4379_9664.t9 vss 2.52418e-15
Cpar10 a_6576_3831.t0 vss 5.76582e-15
Cpar11 a_6576_3831.t8 vss 4.44990e-15
Cpar12 a_6576_3831.t9 vss 1.46928e-15
Cpar13 a_8377_10704.t0 vss 1.97240e-16
Cpar14 a_8377_10704.t1 vss 3.22087e-15
Cpar15 a_8377_9664.t0 vss 3.70800e-17
Cpar16 ib vss 1.09971e-14
Cpar17 ib.t0 vss 1.26282e-15
Cpar18 ib.t1 vss 8.65680e-17
Cpar19 inn inp 1.02790e-16
Cpar20 inn vdd 9.33789e-15
Cpar21 inn vss 3.49719e-15
Cpar22 inn.t0 vss 1.03999e-14
Cpar23 inp vdd 9.39415e-15
Cpar24 inp vss 3.45825e-15
Cpar25 inp.t0 vss 1.04325e-14
Cpar26 out vdd 1.23648e-14
Cpar27 out vss 1.91853e-14
Cpar28 out.t0 vss 1.04207e-14
Cpar29 out.t17 vss 1.01227e-14
Cpar30 out.t2 vss 5.83971e-15
Cpar31 vdd vss 1.65394e-13
Cpar32 vdd.t0 vss 4.50017e-14
Cpar33 vdd.t1 vss 7.50352e-15
Cpar34 vdd.t14 vss 2.81903e-14
.ends opamp_dut

Vdd vdd 0 3.300000
Vss vss 0 0
Ibias vdd ib 2.875000e-07
Vinp inp 0 DC 1.480000 AC 1 PWL(0 1.480000 3.181178e-08 1.480000 3.499296e-08 1.490000)
Rfb out inn 1m
Cload out 0 2.000000e-13
Xdut vdd vss inp inn out ib opamp_dut
.end
