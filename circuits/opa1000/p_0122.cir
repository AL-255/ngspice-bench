* opa1000[0122]: 200f/current_reuse_3v3_i150u_weak (current_reuse, VDD=3.3V, CL=0.2pF, Iref=21.4286uA)
.include "pdk_opa.inc"
.temp 27
.option gmin=1e-12 rshunt=1e12 reltol=1e-3 abstol=1e-12 vntol=1e-5 method=gear
* Post-PEX R+C extracted netlist for current_reuse_3v3_i150u_weak
.subckt opamp_dut vdd vss inp inn out ib
XMpar0 ib.t1 ib.t0 vss.t7 vss.t0 nfet_03v3 w=2.86u l=0.98u ad=8.0080e-13 pd=3.4200e-06 as=1.1059e-12 ps=4.5867e-06 nf=1 m=6 par=6
XMpar1 out.t0 ib.t0 vss.t7 vss.t0 nfet_03v3 w=2.86u l=0.98u ad=9.8384e-13 pd=4.1200e-06 as=9.2283e-13 ps=3.8867e-06 nf=1 m=30 par=30
XMpar2 a_3954_11561.t0 inp.t6 a_997_1041.t3 vdd.t10 pfet_03v3 w=1.88u l=0.45u ad=6.2667e-13 pd=2.8600e-06 as=5.2640e-13 ps=2.4400e-06 nf=1 m=12 par=12
XMpar3 a_3854_11353.t0 inn.t6 a_3954_11561.t0 vdd.t10 pfet_03v3 w=1.88u l=0.45u ad=5.2640e-13 pd=2.4400e-06 as=6.2667e-13 ps=2.8600e-06 nf=1 m=12 par=12
XMpar4 a_6006_7924.t6 ib.t0 vss.t7 vss.t0 nfet_03v3 w=2.86u l=0.98u ad=1.1059e-12 pd=4.5867e-06 as=9.5333e-13 ps=4.0033e-06 nf=1 m=12 par=12
XMpar5 a_6006_7924.t0 inp.t0 a_997_1041.t13 vss.t0 nfet_03v3 w=2.1u l=0.45u ad=8.1200e-13 pd=3.5733e-06 as=5.8800e-13 ps=2.6600e-06 nf=1 m=6 par=6
XMpar6 out.t1 a_997_1041.t22 vdd.t1 vdd.t0 pfet_03v3 w=6.26u l=0.5u ad=1.7528e-12 pd=6.8200e-06 as=1.8863e-12 ps=7.2800e-06 nf=1 m=30 par=30
XMpar7 a_3854_11353.t19 a_3854_11353.t18 vdd.t1 vdd.t0 pfet_03v3 w=6.26u l=0.5u ad=2.4205e-12 pd=9.1200e-06 as=1.7528e-12 ps=6.8200e-06 nf=1 m=3 par=3
XMpar8 a_3854_11353.t12 inn.t0 a_6006_7924.t0 vss.t0 nfet_03v3 w=2.1u l=0.45u ad=5.8800e-13 pd=2.6600e-06 as=8.1200e-13 ps=3.5733e-06 nf=1 m=6 par=6
XMpar9 a_3954_11561.t12 a_3854_11353.t18 vdd.t1 vdd.t0 pfet_03v3 w=6.26u l=0.5u ad=1.7528e-12 pd=6.8200e-06 as=2.4205e-12 ps=9.1200e-06 nf=1 m=6 par=6
XMpar10 a_997_1041.t0 a_3854_11353.t18 vdd.t1 vdd.t0 pfet_03v3 w=6.26u l=0.5u ad=2.4205e-12 pd=9.1200e-06 as=1.7528e-12 ps=6.8200e-06 nf=1 m=3 par=3
X7 a_997_1041.t21 a_8946_1290.t0 vss.t87 ppolyf_u_1k r_width=1u r_length=1.12u
X66 a_8946_1290.t1 out.t53 cap_mim_2f0fF c_width=17.43u c_length=17.43u
Rpar0 a_3854_11353.t0 a_3854_11353.t12 53.6626
Rpar1 a_3854_11353.t0 a_3854_11353.t18 263.4036
Rpar2 a_3854_11353.t0 a_3854_11353.t19 99.6180
Rpar3 a_3854_11353.t12 a_3854_11353.t18 759.7578
Rpar4 a_3854_11353.t12 a_3854_11353.t19 287.3370
Rpar5 a_3854_11353.t18 a_3854_11353.t19 23.8915
Rpar6 a_3954_11561.t0 a_3954_11561.t12 64.5772
Rpar7 a_6006_7924.t0 a_6006_7924.t6 43.6048
Rpar8 a_8946_1290.t0 a_8946_1290.t1 95.4121
Rpar9 a_997_1041.t0 a_997_1041.t3 93.9824
Rpar10 a_997_1041.t0 a_997_1041.t13 121.5813
Rpar11 a_997_1041.t0 a_997_1041.t21 1672.7184
Rpar12 a_997_1041.t0 a_997_1041.t22 345.3520
Rpar13 a_997_1041.t3 a_997_1041.t13 72.3544
Rpar14 a_997_1041.t3 a_997_1041.t21 995.4533
Rpar15 a_997_1041.t3 a_997_1041.t22 205.5228
Rpar16 a_997_1041.t13 a_997_1041.t21 605.1436
Rpar17 a_997_1041.t13 a_997_1041.t22 124.9389
Rpar18 a_997_1041.t21 a_997_1041.t22 85.4648
Rpar19 ib ib.t0 1.9624
Rpar20 ib ib.t1 37.5115
Rpar21 ib.t0 ib.t1 18.1063
Rpar22 inn inn.t0 7.3956
Rpar23 inn inn.t6 42.6485
Rpar24 inp inp.t0 7.4442
Rpar25 inp inp.t6 42.5999
Rpar26 out out.t0 53.7707
Rpar27 out out.t1 51.7262
Rpar28 out out.t53 21.0464
Rpar29 out.t0 out.t1 92.2244
Rpar30 out.t0 out.t53 589.0750
Rpar31 out.t1 out.t53 566.6774
Rpar32 vdd vdd.t0 24.5138
Rpar33 vdd vdd.t1 75.4352
Rpar34 vdd vdd.t10 117.9038
Rpar35 vdd.t0 vdd.t1 1.7925
Rpar36 vdd.t0 vdd.t10 40.5813
Rpar37 vdd.t1 vdd.t10 116.8198
Rpar38 vss vss.t0 16.0074
Rpar39 vss vss.t7 231.3360
Rpar40 vss vss.t87 461.4191
Rpar41 vss.t0 vss.t7 3.2384
Rpar42 vss.t0 vss.t87 8.6116
Rpar43 vss.t7 vss.t87 252.7152
Cpar0 a_3854_11353.t0 vss 8.53697e-15
Cpar1 a_3854_11353.t12 vss 4.91100e-15
Cpar2 a_3854_11353.t18 vss 1.34205e-14
Cpar3 a_3854_11353.t19 vss 9.98512e-15
Cpar4 a_3954_11561.t0 vss 1.72572e-14
Cpar5 a_3954_11561.t12 vss 1.16251e-14
Cpar6 a_6006_7924.t0 vss 5.63993e-15
Cpar7 a_6006_7924.t6 vss 1.28961e-14
Cpar8 a_8946_1290.t0 vss 4.23460e-16
Cpar9 a_8946_1290.t1 vss 6.95617e-15
Cpar10 a_997_1041.t0 vss 6.19310e-15
Cpar11 a_997_1041.t13 vss 5.58298e-15
Cpar12 a_997_1041.t21 vss 3.12896e-15
Cpar13 a_997_1041.t22 vss 2.78411e-14
Cpar14 a_997_1041.t3 vss 6.94938e-15
Cpar15 ib out 4.52865e-15
Cpar16 ib vdd 1.87400e-17
Cpar17 ib vss 4.86899e-14
Cpar18 ib.t0 vss 5.90170e-15
Cpar19 ib.t1 vss 7.20961e-16
Cpar20 inn inp 1.04060e-16
Cpar21 inn vdd 5.16121e-15
Cpar22 inn vss 6.30036e-15
Cpar23 inn.t0 vss 1.12019e-15
Cpar24 inn.t6 vss 5.43197e-15
Cpar25 inp out 1.98500e-17
Cpar26 inp vdd 5.31486e-15
Cpar27 inp vss 6.22288e-15
Cpar28 inp.t0 vss 1.26107e-15
Cpar29 inp.t6 vss 6.06662e-15
Cpar30 out vdd 3.97636e-14
Cpar31 out vss 3.11293e-14
Cpar32 out.t0 vss 2.05599e-14
Cpar33 out.t1 vss 2.54585e-14
Cpar34 out.t53 vss 1.03084e-14
Cpar35 vdd vss 1.33130e-13
Cpar36 vdd.t0 vss 5.54387e-14
Cpar37 vdd.t1 vss 2.69253e-14
Cpar38 vdd.t10 vss 2.12833e-14
.ends opamp_dut

Vdd vdd 0 3.300000
Vss vss 0 0
Ibias vdd ib 2.142860e-05
Vinp inp 0 DC 1.645000 AC 1 PWL(0 1.645000 3.000000e-09 1.645000 3.300000e-09 1.655000)
Rfb out inn 1m
Cload out 0 2.000000e-13
Xdut vdd vss inp inn out ib opamp_dut
.end
