* opa1000[0671]: 200f/rail_to_rail_1v8_i200n_weak (rail_to_rail, VDD=1.8V, CL=0.2pF, Iref=0.0262uA)
.include "pdk_opa.inc"
.temp 27
.option gmin=1e-12 rshunt=1e12 reltol=1e-3 abstol=1e-12 vntol=1e-5 method=gear
* Post-PEX R+C extracted netlist for rail_to_rail_1v8_i200n_weak
.subckt opamp_dut vdd vss inp inn out ib
XMpar0 out.t1 a_994_5706.t7 vdd.t1 vdd.t0 pfet_03v3 w=0.4u l=3.2u ad=1.1200e-13 pd=9.6000e-07 as=1.4400e-13 ps=1.2200e-06 nf=1 m=8 par=8
XMpar1 a_1346_13237.t1 a_1346_13237.t0 vdd.t7 vdd.t6 pfet_03v3 w=0.4u l=5u ad=1.1200e-13 pd=9.6000e-07 as=1.1200e-13 ps=9.6000e-07 nf=1 m=2 par=2
XMpar2 a_1346_13237.t4 ib.t0 vss.t31 vss.t30 nfet_03v3 w=0.4u l=5u ad=2.4000e-13 pd=2.0000e-06 as=1.1200e-13 ps=9.6000e-07 nf=1 m=2 par=2
XMpar3 out.t9 ib.t0 vss.t31 vss.t30 nfet_03v3 w=0.4u l=5u ad=1.1200e-13 pd=9.6000e-07 as=2.0800e-13 ps=1.7400e-06 nf=1 m=8 par=8
XMpar4 a_9230_7177.t5 a_9230_7177.t4 vdd.t1 vdd.t0 pfet_03v3 w=0.4u l=3.2u ad=2.4000e-13 pd=2.0000e-06 as=1.1200e-13 ps=9.6000e-07 nf=1 m=2 par=2
XMpar5 a_1226_13445.t4 a_1346_13237.t0 vdd.t7 vdd.t6 pfet_03v3 w=0.4u l=5u ad=2.4000e-13 pd=2.0000e-06 as=1.1200e-13 ps=9.6000e-07 nf=1 m=2 par=2
XMpar6 a_7840_4269.t3 a_7840_4269.t2 vss.t2 vss.t1 nfet_03v3 w=0.4u l=4.23u ad=2.4000e-13 pd=2.0000e-06 as=1.1200e-13 ps=9.6000e-07 nf=1 m=2 par=2
XMpar7 a_994_5706.t5 a_9230_7177.t4 vdd.t1 vdd.t0 pfet_03v3 w=0.4u l=3.2u ad=2.4000e-13 pd=2.0000e-06 as=1.1200e-13 ps=9.6000e-07 nf=1 m=2 par=2
XMpar8 a_7154_5930.t0 inp.t0 a_994_5706.t0 vss.t5 nfet_03v3 w=0.4u l=5.2u ad=2.4000e-13 pd=2.0000e-06 as=1.1200e-13 ps=9.6000e-07 nf=1 m=2 par=2
XMpar9 a_9024_1041.t3 a_9024_1041.t2 vss.t2 vss.t1 nfet_03v3 w=0.4u l=4.23u ad=2.4000e-13 pd=2.0000e-06 as=1.1200e-13 ps=9.6000e-07 nf=1 m=2 par=2
XMpar10 a_9230_7177.t0 a_7840_4269.t2 vss.t2 vss.t1 nfet_03v3 w=0.4u l=4.23u ad=1.1200e-13 pd=9.6000e-07 as=1.1200e-13 ps=9.6000e-07 nf=1 m=2 par=2
XMpar11 a_1226_13445.t0 inn.t2 a_9024_1041.t0 vdd.t4 pfet_03v3 w=0.4u l=5.2u ad=2.4000e-13 pd=2.0000e-06 as=1.1200e-13 ps=9.6000e-07 nf=1 m=2 par=2
XMpar12 a_1226_13445.t0 inp.t2 a_7840_4269.t0 vdd.t4 pfet_03v3 w=0.4u l=5.2u ad=2.4000e-13 pd=2.0000e-06 as=1.1200e-13 ps=9.6000e-07 nf=1 m=2 par=2
XMpar13 a_7154_5930.t0 inn.t0 a_9230_7177.t1 vss.t5 nfet_03v3 w=0.4u l=5.2u ad=2.4000e-13 pd=2.0000e-06 as=1.1200e-13 ps=9.6000e-07 nf=1 m=2 par=2
XMpar14 a_7154_5930.t4 ib.t0 vss.t31 vss.t30 nfet_03v3 w=0.4u l=5u ad=2.4000e-13 pd=2.0000e-06 as=1.1200e-13 ps=9.6000e-07 nf=1 m=2 par=2
XMpar15 a_994_5706.t2 a_9024_1041.t2 vss.t2 vss.t1 nfet_03v3 w=0.4u l=4.23u ad=2.4000e-13 pd=2.0000e-06 as=1.1200e-13 ps=9.6000e-07 nf=1 m=2 par=2
XMpar16 ib.t1 ib.t0 vss.t31 vss.t30 nfet_03v3 w=0.4u l=5u ad=2.4000e-13 pd=2.0000e-06 as=1.1200e-13 ps=9.6000e-07 nf=1 m=2 par=2
X8 a_994_10386.t0 a_4972_9866.t0 vss.t0 ppolyf_u_1k r_width=1u r_length=19.23u
X9 a_994_9346.t0 a_4972_8826.t0 vss.t0 ppolyf_u_1k r_width=1u r_length=19.23u
X11 a_994_6226.t0 a_4972_5706.t0 vss.t0 ppolyf_u_1k r_width=1u r_length=19.23u
X18 a_994_8306.t0 a_4972_8826.t0 vss.t0 ppolyf_u_1k r_width=1u r_length=19.23u
X21 a_994_5706.t4 a_4972_5706.t0 vss.t0 ppolyf_u_1k r_width=1u r_length=19.23u
X28 a_994_8306.t0 a_4972_7786.t0 vss.t0 ppolyf_u_1k r_width=1u r_length=19.23u
X32 a_994_11426.t0 a_4972_11946.t0 vss.t0 ppolyf_u_1k r_width=1u r_length=19.23u
X40 a_994_11426.t0 a_4972_10906.t0 vss.t0 ppolyf_u_1k r_width=1u r_length=19.23u
X44 a_994_10386.t0 a_4972_10906.t0 vss.t0 ppolyf_u_1k r_width=1u r_length=19.23u
X45 a_994_7266.t0 a_4972_7786.t0 vss.t0 ppolyf_u_1k r_width=1u r_length=19.23u
X49 a_4972_11946.t1 out.t0 cap_mim_2f0fF c_width=13.83u c_length=13.83u
X52 a_994_7266.t0 a_4972_6746.t0 vss.t0 ppolyf_u_1k r_width=1u r_length=19.23u
X56 a_994_9346.t0 a_4972_9866.t0 vss.t0 ppolyf_u_1k r_width=1u r_length=19.23u
X57 a_994_6226.t0 a_4972_6746.t0 vss.t0 ppolyf_u_1k r_width=1u r_length=19.23u
Rpar0 a_1226_13445.t0 a_1226_13445.t4 42.8872
Rpar1 a_1346_13237.t0 a_1346_13237.t1 29.5525
Rpar2 a_1346_13237.t0 a_1346_13237.t4 127.9737
Rpar3 a_1346_13237.t1 a_1346_13237.t4 117.9209
Rpar4 a_4972_11946.t0 a_4972_11946.t1 74.6208
Rpar5 a_7154_5930.t0 a_7154_5930.t4 78.6003
Rpar6 a_7840_4269.t0 a_7840_4269.t2 366.5395
Rpar7 a_7840_4269.t0 a_7840_4269.t3 276.0638
Rpar8 a_7840_4269.t2 a_7840_4269.t3 20.5470
Rpar9 a_9024_1041.t0 a_9024_1041.t2 206.5092
Rpar10 a_9024_1041.t0 a_9024_1041.t3 213.9349
Rpar11 a_9024_1041.t2 a_9024_1041.t3 16.0273
Rpar12 a_9230_7177.t0 a_9230_7177.t1 127.5568
Rpar13 a_9230_7177.t0 a_9230_7177.t4 277.9412
Rpar14 a_9230_7177.t0 a_9230_7177.t5 284.2222
Rpar15 a_9230_7177.t1 a_9230_7177.t4 122.3001
Rpar16 a_9230_7177.t1 a_9230_7177.t5 125.0639
Rpar17 a_9230_7177.t4 a_9230_7177.t5 16.3566
Rpar18 a_994_5706.t0 a_994_5706.t7 274.5091
Rpar19 a_994_5706.t0 a_994_5706.t2 161.6338
Rpar20 a_994_5706.t0 a_994_5706.t4 135.9909
Rpar21 a_994_5706.t0 a_994_5706.t5 125.3619
Rpar22 a_994_5706.t7 a_994_5706.t2 718.1774
Rpar23 a_994_5706.t7 a_994_5706.t4 604.2397
Rpar24 a_994_5706.t7 a_994_5706.t5 125.8715
Rpar25 a_994_5706.t2 a_994_5706.t4 135.9658
Rpar26 a_994_5706.t2 a_994_5706.t5 327.9747
Rpar27 a_994_5706.t4 a_994_5706.t5 275.9420
Rpar28 ib ib.t0 15.6433
Rpar29 ib ib.t1 16.6363
Rpar30 ib.t0 ib.t1 29.4293
Rpar31 inn inn.t0 3.2827
Rpar32 inn inn.t2 60.7766
Rpar33 inp inp.t0 3.3314
Rpar34 inp inp.t2 60.7279
Rpar35 out out.t0 176.9441
Rpar36 out out.t1 166.5112
Rpar37 out out.t9 6.6474
Rpar38 out.t0 out.t1 415.3432
Rpar39 out.t0 out.t9 247.2390
Rpar40 out.t1 out.t9 232.6614
Rpar41 vdd vdd.t0 135.9221
Rpar42 vdd vdd.t1 209.0052
Rpar43 vdd vdd.t4 80.4098
Rpar44 vdd vdd.t6 843.2900
Rpar45 vdd vdd.t7 1787.0651
Rpar46 vdd.t0 vdd.t1 5.6033
Rpar47 vdd.t0 vdd.t4 230.8856
Rpar48 vdd.t0 vdd.t6 208.0414
Rpar49 vdd.t0 vdd.t7 440.8727
Rpar50 vdd.t1 vdd.t4 355.0290
Rpar51 vdd.t1 vdd.t6 169.6818
Rpar52 vdd.t1 vdd.t7 359.5825
Rpar53 vdd.t4 vdd.t6 1432.4639
Rpar54 vdd.t4 vdd.t7 3035.6178
Rpar55 vdd.t6 vdd.t7 13.1979
Rpar56 vss vss.t0 106.4618
Rpar57 vss vss.t1 95.3359
Rpar58 vss vss.t5 198.7433
Rpar59 vss vss.t2 437.8955
Rpar60 vss vss.t30 135.6137
Rpar61 vss vss.t31 409.4720
Rpar62 vss.t0 vss.t1 198.7245
Rpar63 vss.t0 vss.t5 387.7280
Rpar64 vss.t0 vss.t2 990.7800
Rpar65 vss.t0 vss.t30 209.3641
Rpar66 vss.t0 vss.t31 103.6627
Rpar67 vss.t1 vss.t5 2.4712
Rpar68 vss.t1 vss.t2 14.4451
Rpar69 vss.t1 vss.t30 3.9368
Rpar70 vss.t1 vss.t31 47.7818
Rpar71 vss.t5 vss.t2 28.9545
Rpar72 vss.t5 vss.t30 6.9360
Rpar73 vss.t5 vss.t31 79.0730
Rpar74 vss.t2 vss.t30 20.9037
Rpar75 vss.t2 vss.t31 272.6631
Rpar76 vss.t30 vss.t31 22.2818
Cpar0 a_1226_13445.t0 vss 6.78390e-15
Cpar1 a_1226_13445.t4 vss 5.37793e-15
Cpar2 a_1346_13237.t0 vss 1.19001e-14
Cpar3 a_1346_13237.t1 vss 3.27144e-15
Cpar4 a_1346_13237.t4 vss 1.20713e-14
Cpar5 a_4972_10906.t0 vss 3.89200e-17
Cpar6 a_4972_11946.t0 vss 4.16490e-16
Cpar7 a_4972_11946.t1 vss 6.02318e-15
Cpar8 a_4972_5706.t0 vss 3.91600e-17
Cpar9 a_4972_6746.t0 vss 3.43000e-17
Cpar10 a_4972_7786.t0 vss 3.01400e-17
Cpar11 a_4972_8826.t0 vss 3.06200e-17
Cpar12 a_4972_9866.t0 vss 3.00800e-17
Cpar13 a_7154_5930.t0 vss 8.93424e-15
Cpar14 a_7154_5930.t4 vss 1.56651e-14
Cpar15 a_7840_4269.t0 vss 4.87049e-15
Cpar16 a_7840_4269.t2 vss 6.80298e-15
Cpar17 a_7840_4269.t3 vss 4.26254e-15
Cpar18 a_9024_1041.t0 vss 4.30807e-15
Cpar19 a_9024_1041.t2 vss 7.67730e-15
Cpar20 a_9024_1041.t3 vss 3.58820e-15
Cpar21 a_9230_7177.t0 vss 3.55435e-15
Cpar22 a_9230_7177.t1 vss 3.10839e-15
Cpar23 a_9230_7177.t4 vss 9.83924e-15
Cpar24 a_9230_7177.t5 vss 3.76760e-15
Cpar25 a_994_10386.t0 vss 3.93200e-17
Cpar26 a_994_11426.t0 vss 4.08400e-17
Cpar27 a_994_5706.t0 vss 3.78885e-15
Cpar28 a_994_5706.t2 vss 5.76813e-15
Cpar29 a_994_5706.t4 vss 4.04551e-15
Cpar30 a_994_5706.t5 vss 6.43778e-15
Cpar31 a_994_5706.t7 vss 1.48530e-14
Cpar32 a_994_6226.t0 vss 4.26800e-17
Cpar33 a_994_7266.t0 vss 3.85800e-17
Cpar34 a_994_8306.t0 vss 3.85800e-17
Cpar35 a_994_9346.t0 vss 3.85800e-17
Cpar36 ib inn 3.94300e-17
Cpar37 ib out 1.82392e-15
Cpar38 ib vdd 3.64500e-17
Cpar39 ib vss 4.44319e-14
Cpar40 ib.t0 vss 1.44537e-14
Cpar41 ib.t1 vss 1.17089e-15
Cpar42 inn inp 1.03940e-16
Cpar43 inn out 1.80110e-16
Cpar44 inn vdd 5.00272e-15
Cpar45 inn vss 1.62341e-14
Cpar46 inn.t0 vss 8.42431e-16
Cpar47 inn.t2 vss 3.98294e-15
Cpar48 inp out 1.08630e-16
Cpar49 inp vdd 6.06029e-15
Cpar50 inp vss 1.75889e-14
Cpar51 inp.t0 vss 2.12582e-15
Cpar52 inp.t2 vss 9.88727e-15
Cpar53 out vdd 1.00559e-14
Cpar54 out vss 2.98372e-14
Cpar55 out.t0 vss 1.23793e-14
Cpar56 out.t1 vss 7.01796e-15
Cpar57 out.t9 vss 5.95291e-15
Cpar58 vdd vss 1.21272e-13
Cpar59 vdd.t0 vss 2.58673e-14
Cpar60 vdd.t1 vss 1.00285e-14
Cpar61 vdd.t4 vss 1.35954e-14
Cpar62 vdd.t6 vss 1.13633e-14
Cpar63 vdd.t7 vss 4.95352e-15
.ends opamp_dut

Vdd vdd 0 1.800000
Vss vss 0 0
Ibias vdd ib 2.620000e-08
Vinp inp 0 DC 0.895000 AC 1 PWL(0 0.895000 5.307518e-07 0.895000 5.838270e-07 0.905000)
Rfb out inn 1m
Cload out 0 2.000000e-13
Xdut vdd vss inp inn out ib opamp_dut
.end
