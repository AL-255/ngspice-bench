* opa1000[0046]: 2p/cherry_hooper_1v8_0p1u_1u_subth (cherry_hooper, VDD=1.8V, CL=2.0pF, Iref=0.025uA)
.include "pdk_opa.inc"
.temp 27
.option gmin=1e-12 rshunt=1e12 reltol=1e-3 abstol=1e-12 vntol=1e-5 method=gear
* Post-PEX R+C extracted netlist for cherry_hooper_1v8_0p1u_1u_subth
.subckt opamp_dut vdd vss inp inn out ib
XMpar0 a_8334_1294.t3 a_3228_6393.t1 vdd.t10 vdd.t9 pfet_03v3 w=0.83u l=4u ad=4.9800e-13 pd=2.8600e-06 as=4.9800e-13 ps=2.8600e-06 nf=1 m=1
XMpar1 a_7200_11076.t2 a_7200_11076.t1 vdd.t1 vdd.t0 pfet_03v3 w=1.95u l=1.3u ad=7.5400e-13 pd=3.3733e-06 as=5.4600e-13 ps=2.5100e-06 nf=1 m=3 par=3
XMpar2 a_1769_3239.t0 ib.t0 vss.t1 vss.t0 nfet_03v3 w=0.4u l=4u ad=2.4000e-13 pd=2.0000e-06 as=1.7600e-13 ps=1.4800e-06 nf=1 m=4 par=4
XMpar3 a_11157_2896.t0 a_4417_6393.t1 a_4417_6393.t2 vdd.t2 pfet_03v3 w=9.33u l=1u ad=2.8838e-12 pd=1.0796e-05 as=2.8838e-12 ps=1.0796e-05 nf=1 m=11 par=11
XMpar4 out.t1 a_7200_11076.t1 vdd.t1 vdd.t0 pfet_03v3 w=1.95u l=1.3u ad=7.5400e-13 pd=3.3733e-06 as=5.4600e-13 ps=2.5100e-06 nf=1 m=3 par=3
XMpar5 a_2136_8213.t1 ib.t0 vss.t1 vss.t0 nfet_03v3 w=0.4u l=4u ad=1.5467e-13 pd=1.3067e-06 as=1.5467e-13 ps=1.3067e-06 nf=1 m=6 par=6
XMpar6 a_1861_1086.t1 a_1861_1086.t0 vdd.t1 vdd.t0 pfet_03v3 w=1.95u l=1.3u ad=5.4600e-13 pd=2.5100e-06 as=1.1700e-12 ps=5.1000e-06 nf=1 m=2 par=2
XMpar7 a_1769_3239.t4 a_8334_1294.t4 a_8334_3194.t5 vss.t24 nfet_03v3 w=1.35u l=2.4u ad=8.1000e-13 pd=3.9000e-06 as=8.1000e-13 ps=3.9000e-06 nf=1 m=1
XMpar8 a_2136_8213.t0 a_8334_3194.t6 out.t0 vss.t25 nfet_03v3 w=2.02u l=2.4u ad=1.2120e-12 pd=5.2400e-06 as=1.2120e-12 ps=5.2400e-06 nf=1 m=1
XMpar9 ib.t1 ib.t0 vss.t1 vss.t0 nfet_03v3 w=0.4u l=4u ad=2.4000e-13 pd=2.0000e-06 as=1.1200e-13 ps=9.6000e-07 nf=1 m=1
XMpar10 a_8334_3194.t1 a_8334_3194.t0 vdd.t1 vdd.t0 pfet_03v3 w=1.95u l=1.3u ad=5.4600e-13 pd=2.5100e-06 as=1.1700e-12 ps=5.1000e-06 nf=1 m=2 par=2
XMpar11 a_3601_3239.t0 ib.t0 vss.t1 vss.t0 nfet_03v3 w=0.4u l=4u ad=2.4000e-13 pd=2.0000e-06 as=1.1200e-13 ps=9.6000e-07 nf=1 m=2 par=2
XMpar12 a_8334_1294.t2 a_4417_6393.t23 a_8334_3194.t4 vdd.t35 pfet_03v3 w=6.56u l=1u ad=3.9360e-12 pd=1.4320e-05 as=3.9360e-12 ps=1.4320e-05 nf=1 m=1
XMpar13 a_3601_3239.t2 inp.t0 a_7434_7752.t0 vss.t25 nfet_03v3 w=0.4u l=2.4u ad=2.4000e-13 pd=2.0000e-06 as=1.1200e-13 ps=9.6000e-07 nf=1 m=1
XMpar14 a_3601_3239.t2 inn.t0 a_8334_1294.t0 vss.t28 nfet_03v3 w=0.4u l=2.4u ad=2.4000e-13 pd=2.0000e-06 as=1.1200e-13 ps=9.6000e-07 nf=1 m=1
XMpar15 a_4417_6393.t0 ib.t0 vss.t1 vss.t0 nfet_03v3 w=0.4u l=4u ad=2.4000e-13 pd=2.0000e-06 as=2.4000e-13 ps=2.0000e-06 nf=1 m=1
XMpar16 a_3228_6393.t0 ib.t0 vss.t1 vss.t0 nfet_03v3 w=0.4u l=4u ad=2.4000e-13 pd=2.0000e-06 as=1.1200e-13 ps=9.6000e-07 nf=1 m=1
XMpar17 a_3601_3239.t2 inp.t0 a_7434_7752.t0 vss.t28 nfet_03v3 w=0.4u l=2.4u ad=2.4000e-13 pd=2.0000e-06 as=1.1200e-13 ps=9.6000e-07 nf=1 m=1
XMpar18 a_3601_3239.t2 inn.t0 a_8334_1294.t0 vss.t25 nfet_03v3 w=0.4u l=2.4u ad=2.4000e-13 pd=2.0000e-06 as=1.1200e-13 ps=9.6000e-07 nf=1 m=1
XMpar19 a_3228_6393.t2 a_3228_6393.t1 vdd.t10 vdd.t9 pfet_03v3 w=0.83u l=4u ad=4.9800e-13 pd=2.8600e-06 as=4.9800e-13 ps=2.8600e-06 nf=1 m=1
XMpar20 a_1861_1086.t5 a_4417_6393.t23 a_7434_7752.t2 vdd.t35 pfet_03v3 w=6.56u l=1u ad=3.9360e-12 pd=1.4320e-05 as=3.9360e-12 ps=1.4320e-05 nf=1 m=1
XMpar21 a_1769_3239.t4 a_7434_7752.t4 a_1861_1086.t4 vss.t24 nfet_03v3 w=1.35u l=2.4u ad=8.1000e-13 pd=3.9000e-06 as=8.1000e-13 ps=3.9000e-06 nf=1 m=1
XMpar22 a_11157_2896.t10 a_11157_2896.t9 vdd.t1 vdd.t0 pfet_03v3 w=1.95u l=1.3u ad=1.1700e-12 pd=5.1000e-06 as=1.1700e-12 ps=5.1000e-06 nf=1 m=1
XMpar23 a_2136_8213.t0 a_1861_1086.t6 a_7200_11076.t0 vss.t25 nfet_03v3 w=2.02u l=2.4u ad=1.2120e-12 pd=5.2400e-06 as=1.2120e-12 ps=5.2400e-06 nf=1 m=1
XMpar24 a_7434_7752.t3 a_3228_6393.t1 vdd.t10 vdd.t9 pfet_03v3 w=0.83u l=4u ad=4.9800e-13 pd=2.8600e-06 as=4.9800e-13 ps=2.8600e-06 nf=1 m=1
X47 out.t4 vss.t30 cap_mim_2f0fF c_width=15u c_length=15u
Rpar0 a_11157_2896.t0 a_11157_2896.t10 51.5198
Rpar1 a_11157_2896.t0 a_11157_2896.t9 182.3671
Rpar2 a_11157_2896.t10 a_11157_2896.t9 51.0916
Rpar3 a_1769_3239.t0 a_1769_3239.t4 51.2412
Rpar4 a_1861_1086.t0 a_1861_1086.t1 31.4390
Rpar5 a_1861_1086.t0 a_1861_1086.t4 392.6418
Rpar6 a_1861_1086.t0 a_1861_1086.t5 724.5156
Rpar7 a_1861_1086.t0 a_1861_1086.t6 1251.6516
Rpar8 a_1861_1086.t1 a_1861_1086.t4 156.3471
Rpar9 a_1861_1086.t1 a_1861_1086.t5 288.4968
Rpar10 a_1861_1086.t1 a_1861_1086.t6 498.3984
Rpar11 a_1861_1086.t4 a_1861_1086.t5 98.1754
Rpar12 a_1861_1086.t4 a_1861_1086.t6 169.6049
Rpar13 a_1861_1086.t5 a_1861_1086.t6 108.8477
Rpar14 a_2136_8213.t0 a_2136_8213.t1 50.1801
Rpar15 a_3228_6393.t0 a_3228_6393.t1 103.4732
Rpar16 a_3228_6393.t0 a_3228_6393.t2 387.4553
Rpar17 a_3228_6393.t1 a_3228_6393.t2 27.9248
Rpar18 a_3601_3239.t0 a_3601_3239.t2 47.2793
Rpar19 a_4417_6393.t0 a_4417_6393.t1 1779.7195
Rpar20 a_4417_6393.t0 a_4417_6393.t2 256.5019
Rpar21 a_4417_6393.t0 a_4417_6393.t23 151.3434
Rpar22 a_4417_6393.t1 a_4417_6393.t2 18.2167
Rpar23 a_4417_6393.t1 a_4417_6393.t23 924.2749
Rpar24 a_4417_6393.t2 a_4417_6393.t23 133.2110
Rpar25 a_7200_11076.t0 a_7200_11076.t1 158.8963
Rpar26 a_7200_11076.t0 a_7200_11076.t2 56.6417
Rpar27 a_7200_11076.t1 a_7200_11076.t2 18.5900
Rpar28 a_7434_7752.t0 a_7434_7752.t2 101.6548
Rpar29 a_7434_7752.t0 a_7434_7752.t3 371.7340
Rpar30 a_7434_7752.t0 a_7434_7752.t4 217.6259
Rpar31 a_7434_7752.t2 a_7434_7752.t3 215.9944
Rpar32 a_7434_7752.t2 a_7434_7752.t4 126.4505
Rpar33 a_7434_7752.t3 a_7434_7752.t4 69.4367
Rpar34 a_8334_1294.t0 a_8334_1294.t2 91.0935
Rpar35 a_8334_1294.t0 a_8334_1294.t3 241.9075
Rpar36 a_8334_1294.t0 a_8334_1294.t4 212.0353
Rpar37 a_8334_1294.t2 a_8334_1294.t3 130.4325
Rpar38 a_8334_1294.t2 a_8334_1294.t4 114.3259
Rpar39 a_8334_1294.t3 a_8334_1294.t4 78.5549
Rpar40 a_8334_3194.t0 a_8334_3194.t1 31.4355
Rpar41 a_8334_3194.t0 a_8334_3194.t4 668.5908
Rpar42 a_8334_3194.t0 a_8334_3194.t5 391.0647
Rpar43 a_8334_3194.t0 a_8334_3194.t6 1496.2548
Rpar44 a_8334_3194.t1 a_8334_3194.t4 266.2279
Rpar45 a_8334_3194.t1 a_8334_3194.t5 155.7191
Rpar46 a_8334_3194.t1 a_8334_3194.t6 595.7976
Rpar47 a_8334_3194.t4 a_8334_3194.t5 90.5973
Rpar48 a_8334_3194.t4 a_8334_3194.t6 184.9337
Rpar49 a_8334_3194.t5 a_8334_3194.t6 202.7498
Rpar50 ib ib.t0 2.6324
Rpar51 ib ib.t1 1344.2679
Rpar52 ib.t0 ib.t1 25.6234
Rpar53 inn inn.t0 3.8284
Rpar54 inp inp.t0 3.8769
Rpar55 out out.t0 105.2147
Rpar56 out out.t1 51.4769
Rpar57 out out.t4 15.6626
Rpar58 out.t0 out.t1 62.1472
Rpar59 out.t0 out.t4 1006.6375
Rpar60 out.t1 out.t4 492.5035
Rpar61 vdd vdd.t0 71.8514
Rpar62 vdd vdd.t1 77.4149
Rpar63 vdd vdd.t10 2933.3725
Rpar64 vdd vdd.t2 377.3377
Rpar65 vdd vdd.t35 798.3897
Rpar66 vdd.t0 vdd.t1 3.4085
Rpar67 vdd.t0 vdd.t10 93.8182
Rpar68 vdd.t0 vdd.t9 278.6460
Rpar69 vdd.t0 vdd.t2 111.2595
Rpar70 vdd.t0 vdd.t35 104.6089
Rpar71 vdd.t1 vdd.t10 79.5337
Rpar72 vdd.t1 vdd.t9 235.8500
Rpar73 vdd.t1 vdd.t2 87.7094
Rpar74 vdd.t1 vdd.t35 77.9264
Rpar75 vdd.t10 vdd.t9 19.6109
Rpar76 vdd.t10 vdd.t2 399.3058
Rpar77 vdd.t10 vdd.t35 313.3746
Rpar78 vdd.t9 vdd.t2 1145.6223
Rpar79 vdd.t9 vdd.t35 899.0827
Rpar80 vdd.t2 vdd.t35 108.6809
Rpar81 vss vss.t0 336.6697
Rpar82 vss vss.t1 186.5025
Rpar83 vss vss.t24 350.3933
Rpar84 vss vss.t25 288.1360
Rpar85 vss vss.t28 248.4321
Rpar86 vss vss.t30 1135.5794
Rpar87 vss.t0 vss.t1 4.4049
Rpar88 vss.t0 vss.t24 345.8755
Rpar89 vss.t0 vss.t25 122.9945
Rpar90 vss.t0 vss.t28 132.6175
Rpar91 vss.t0 vss.t30 404.0316
Rpar92 vss.t1 vss.t24 228.3348
Rpar93 vss.t1 vss.t25 102.9329
Rpar94 vss.t1 vss.t28 105.5329
Rpar95 vss.t1 vss.t30 339.7579
Rpar96 vss.t24 vss.t25 113.3347
Rpar97 vss.t24 vss.t28 91.9269
Rpar98 vss.t24 vss.t30 486.7747
Rpar99 vss.t25 vss.t28 28.1607
Rpar100 vss.t25 vss.t30 133.2009
Rpar101 vss.t28 vss.t30 145.4353
Cpar0 a_11157_2896.t0 vss 1.85456e-14
Cpar1 a_11157_2896.t10 vss 2.15787e-15
Cpar2 a_11157_2896.t9 vss 1.23135e-15
Cpar3 a_1769_3239.t0 vss 5.67267e-15
Cpar4 a_1769_3239.t4 vss 2.23729e-15
Cpar5 a_1861_1086.t0 vss 2.28436e-15
Cpar6 a_1861_1086.t1 vss 2.59353e-15
Cpar7 a_1861_1086.t4 vss 2.03310e-15
Cpar8 a_1861_1086.t5 vss 3.48317e-15
Cpar9 a_1861_1086.t6 vss 2.85832e-15
Cpar10 a_2136_8213.t0 vss 1.04354e-15
Cpar11 a_2136_8213.t1 vss 1.68762e-15
Cpar12 a_3228_6393.t0 vss 4.65920e-15
Cpar13 a_3228_6393.t1 vss 1.24212e-14
Cpar14 a_3228_6393.t2 vss 2.73376e-15
Cpar15 a_3601_3239.t0 vss 4.97552e-15
Cpar16 a_3601_3239.t2 vss 3.69997e-15
Cpar17 a_4417_6393.t0 vss 3.75738e-15
Cpar18 a_4417_6393.t1 vss 1.62356e-14
Cpar19 a_4417_6393.t2 vss 1.75349e-14
Cpar20 a_4417_6393.t23 vss 4.83469e-15
Cpar21 a_7200_11076.t0 vss 1.78892e-15
Cpar22 a_7200_11076.t1 vss 6.31314e-15
Cpar23 a_7200_11076.t2 vss 3.35151e-15
Cpar24 a_7434_7752.t0 vss 2.17852e-15
Cpar25 a_7434_7752.t2 vss 4.23016e-15
Cpar26 a_7434_7752.t3 vss 1.92799e-15
Cpar27 a_7434_7752.t4 vss 3.07368e-15
Cpar28 a_8334_1294.t0 vss 2.10872e-15
Cpar29 a_8334_1294.t2 vss 4.15247e-15
Cpar30 a_8334_1294.t3 vss 1.96431e-15
Cpar31 a_8334_1294.t4 vss 2.88993e-15
Cpar32 a_8334_3194.t0 vss 2.44387e-15
Cpar33 a_8334_3194.t1 vss 2.76409e-15
Cpar34 a_8334_3194.t4 vss 3.74742e-15
Cpar35 a_8334_3194.t5 vss 2.56721e-15
Cpar36 a_8334_3194.t6 vss 3.30267e-15
Cpar37 ib vdd 1.70000e-17
Cpar38 ib vss 4.46338e-14
Cpar39 ib.t0 vss 6.19844e-15
Cpar40 ib.t1 vss 3.64608e-16
Cpar41 inn inp 5.19700e-17
Cpar42 inn vss 3.04589e-15
Cpar43 inn.t0 vss 2.96654e-16
Cpar44 inp vss 3.07464e-15
Cpar45 inp.t0 vss 2.97216e-16
Cpar46 out vdd 4.46705e-15
Cpar47 out vss 8.15910e-15
Cpar48 out.t0 vss 1.38966e-16
Cpar49 out.t1 vss 2.58755e-16
Cpar50 out.t4 vss 6.52875e-15
Cpar51 vdd vss 1.39874e-13
Cpar52 vdd.t0 vss 1.16194e-14
Cpar53 vdd.t1 vss 1.04578e-14
Cpar54 vdd.t10 vss 6.53312e-15
Cpar55 vdd.t2 vss 1.69942e-14
Cpar56 vdd.t35 vss 6.06076e-15
Cpar57 vdd.t9 vss 3.47708e-15
.ends opamp_dut

Vdd vdd 0 1.800000
Vss vss 0 0
Ibias vdd ib 2.500000e-08
Vinp inp 0 DC 1.199800 AC 1 PWL(0 1.199800 2.791900e-07 1.199800 3.071090e-07 1.209800)
Rfb out inn 1m
Cload out 0 2.000000e-12
Xdut vdd vss inp inn out ib opamp_dut
.end
