* opa1000[0426]: 200f/nmos_miller_1v8_i2u_subth (nmos_miller, VDD=1.8V, CL=0.2pF, Iref=0.2429uA)
.include "pdk_opa.inc"
.temp 27
.option gmin=1e-12 rshunt=1e12 reltol=1e-3 abstol=1e-12 vntol=1e-5 method=gear
* Post-PEX R+C extracted netlist for nmos_miller_1v8_i2u_subth
.subckt opamp_dut vdd vss inp inn out ib
XMpar0 a_1100_2788.t11 a_6128_2743.t10 vdd.t1 vdd.t0 pfet_03v3 w=3.93u l=0.81u ad=2.3580e-12 pd=9.0600e-06 as=1.1004e-12 ps=4.4900e-06 nf=1 m=2 par=2
XMpar1 a_1100_2788.t0 inp.t0 a_2858_1205.t0 vss.t1 nfet_03v3 w=2.08u l=1.14u ad=5.8240e-13 pd=2.6400e-06 as=7.1552e-13 ps=3.1840e-06 nf=1 m=10 par=10
XMpar2 out.t3 a_1100_2788.t13 vdd.t1 vdd.t0 pfet_03v3 w=3.93u l=0.81u ad=1.1004e-12 pd=4.4900e-06 as=1.3519e-12 ps=5.4040e-06 nf=1 m=10 par=10
XMpar3 a_2858_1205.t0 inn.t0 a_6128_2743.t0 vss.t1 nfet_03v3 w=2.08u l=1.14u ad=7.1552e-13 pd=3.1840e-06 as=5.8240e-13 ps=2.6400e-06 nf=1 m=10 par=10
XMpar4 a_2858_1205.t10 ib.t0 vss.t12 vss.t1 nfet_03v3 w=0.51u l=1.56u ad=1.4280e-13 pd=1.0700e-06 as=1.4280e-13 ps=1.0700e-06 nf=1 m=4 par=4
XMpar5 a_6128_2743.t11 a_6128_2743.t10 vdd.t1 vdd.t0 pfet_03v3 w=3.93u l=0.81u ad=1.1004e-12 pd=4.4900e-06 as=1.1004e-12 ps=4.4900e-06 nf=1 m=2 par=2
XMpar6 out.t0 ib.t0 vss.t12 vss.t1 nfet_03v3 w=0.51u l=1.56u ad=1.7544e-13 pd=1.3000e-06 as=1.4280e-13 ps=1.0700e-06 nf=1 m=10 par=10
XMpar7 ib.t1 ib.t0 vss.t12 vss.t1 nfet_03v3 w=0.51u l=1.56u ad=1.4280e-13 pd=1.0700e-06 as=1.4280e-13 ps=1.0700e-06 nf=1 m=2 par=2
X7 a_1100_2788.t10 a_8419_7066.t0 vss.t0 ppolyf_u_1k r_width=1u r_length=16.74u
X24 a_8419_8106.t1 out.t16 cap_mim_2f0fF c_width=11.46u c_length=11.46u
X33 a_4939_7586.t0 a_8419_8106.t0 vss.t0 ppolyf_u_1k r_width=1u r_length=16.74u
X53 a_4939_7586.t0 a_8419_7066.t0 vss.t0 ppolyf_u_1k r_width=1u r_length=16.74u
Rpar0 a_1100_2788.t0 a_1100_2788.t10 252.7672
Rpar1 a_1100_2788.t0 a_1100_2788.t11 199.5585
Rpar2 a_1100_2788.t0 a_1100_2788.t13 42.7994
Rpar3 a_1100_2788.t10 a_1100_2788.t11 140.4380
Rpar4 a_1100_2788.t10 a_1100_2788.t13 238.0300
Rpar5 a_1100_2788.t11 a_1100_2788.t13 187.9235
Rpar6 a_2858_1205.t0 a_2858_1205.t10 72.6255
Rpar7 a_6128_2743.t0 a_6128_2743.t10 162.1634
Rpar8 a_6128_2743.t0 a_6128_2743.t11 53.4550
Rpar9 a_6128_2743.t10 a_6128_2743.t11 29.5392
Rpar10 a_8419_8106.t0 a_8419_8106.t1 68.1709
Rpar11 ib ib.t0 10.9540
Rpar12 ib ib.t1 16.3610
Rpar13 inn inn.t0 1.4832
Rpar14 inp inp.t0 1.8716
Rpar15 out out.t0 3.6242
Rpar16 out out.t3 143.1399
Rpar17 out out.t16 280.0340
Rpar18 out.t3 out.t16 57.2330
Rpar19 vdd vdd.t0 97.0400
Rpar20 vdd vdd.t1 157.8695
Rpar21 vdd.t0 vdd.t1 3.2984
Rpar22 vss vss.t0 283.4383
Rpar23 vss vss.t1 19.1798
Rpar24 vss vss.t12 502.1771
Rpar25 vss.t0 vss.t1 2.2751
Rpar26 vss.t0 vss.t12 37.1299
Rpar27 vss.t1 vss.t12 5.2143
Cpar0 a_1100_2788.t0 vss 5.95266e-15
Cpar1 a_1100_2788.t10 vss 3.34218e-15
Cpar2 a_1100_2788.t11 vss 4.54066e-15
Cpar3 a_1100_2788.t13 vss 9.19472e-15
Cpar4 a_2858_1205.t0 vss 1.34155e-14
Cpar5 a_2858_1205.t10 vss 5.21420e-15
Cpar6 a_4939_7586.t0 vss 4.43800e-17
Cpar7 a_6128_2743.t0 vss 5.67479e-15
Cpar8 a_6128_2743.t10 vss 3.60442e-15
Cpar9 a_6128_2743.t11 vss 3.05881e-15
Cpar10 a_8419_7066.t0 vss 3.65400e-17
Cpar11 a_8419_8106.t0 vss 1.74720e-16
Cpar12 a_8419_8106.t1 vss 2.93320e-15
Cpar13 ib out 8.25320e-16
Cpar14 ib vdd 7.95900e-17
Cpar15 ib vss 2.18989e-14
Cpar16 ib.t0 vss 3.19597e-15
Cpar17 ib.t1 vss 1.69234e-16
Cpar18 inn inp 5.22000e-17
Cpar19 inn vss 8.81463e-15
Cpar20 inn.t0 vss 1.43987e-15
Cpar21 inp vdd 1.17700e-17
Cpar22 inp vss 8.54825e-15
Cpar23 inp.t0 vss 1.67293e-15
Cpar24 out vdd 1.17899e-14
Cpar25 out vss 1.90785e-14
Cpar26 out.t0 vss 1.41398e-15
Cpar27 out.t16 vss 8.03600e-15
Cpar28 out.t3 vss 7.71503e-15
Cpar29 vdd vss 5.21423e-14
Cpar30 vdd.t0 vss 1.47429e-14
Cpar31 vdd.t1 vss 8.87868e-15
.ends opamp_dut

Vdd vdd 0 1.800000
Vss vss 0 0
Ibias vdd ib 2.429000e-07
Vinp inp 0 DC 0.895000 AC 1 PWL(0 0.895000 3.097812e-08 0.895000 3.407594e-08 0.905000)
Rfb out inn 1m
Cload out 0 2.000000e-13
Xdut vdd vss inp inn out ib opamp_dut
.end
