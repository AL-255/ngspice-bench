* opa1000[0865]: 200f/telescopic_nmos_3v3_1u_10u_weak (telescopic_nmos, VDD=3.3V, CL=0.2pF, Iref=1.625uA)
.include "pdk_opa.inc"
.temp 27
.option gmin=1e-12 rshunt=1e12 reltol=1e-3 abstol=1e-12 vntol=1e-5 method=gear
* Post-PEX R+C extracted netlist for telescopic_nmos_3v3_1u_10u_weak
.subckt opamp_dut vdd vss inp inn out ib
XMpar0 a_1086_5039.t0 a_1206_4831.t48 vdd.t1 vdd.t0 pfet_03v3 w=2.05u l=4u ad=7.3800e-13 pd=3.2825e-06 as=5.7400e-13 ps=2.6100e-06 nf=1 m=16 par=16
XMpar1 a_1086_5039.t1 a_1206_4831.t0 a_1206_4831.t1 vdd.t4 pfet_03v3 w=2.04u l=1u ad=7.8880e-13 pd=3.4933e-06 as=5.7120e-13 ps=2.6000e-06 nf=1 m=12 par=12
XMpar2 a_2210_3077.t0 a_1206_4831.t24 out.t0 vss.t1 nfet_03v3 w=1.33u l=1u ad=5.8520e-13 pd=2.8750e-06 as=3.7240e-13 ps=1.8900e-06 nf=1 m=4 par=4
XMpar3 a_1310_3077.t2 inp.t0 a_1708_7141.t0 vss.t4 nfet_03v3 w=2.03u l=1.6u ad=5.6840e-13 pd=2.5900e-06 as=7.1276e-13 ps=3.1833e-06 nf=1 m=9 par=9
XMpar4 a_1708_7141.t0 inn.t0 a_2210_3077.t3 vss.t4 nfet_03v3 w=2.03u l=1.6u ad=6.9832e-13 pd=3.1240e-06 as=5.6840e-13 ps=2.5900e-06 nf=1 m=10 par=10
XMpar5 a_3096_8976.t2 a_1206_4831.t0 out.t1 vdd.t4 pfet_03v3 w=2.04u l=1u ad=6.8000e-13 pd=3.0467e-06 as=5.7120e-13 ps=2.6000e-06 nf=1 m=12 par=12
XMpar6 a_1708_7141.t20 ib.t0 vss.t26 vss.t25 nfet_03v3 w=1.5u l=2u ad=4.2000e-13 pd=2.0600e-06 as=5.4000e-13 ps=2.5950e-06 nf=1 m=8 par=8
XMpar7 a_3096_8976.t0 a_1206_4831.t48 vdd.t1 vdd.t0 pfet_03v3 w=2.05u l=4u ad=6.5600e-13 pd=2.9462e-06 as=5.7400e-13 ps=2.6100e-06 nf=1 m=16 par=16
XMpar8 a_1206_4831.t25 a_1206_4831.t24 a_1310_3077.t0 vss.t1 nfet_03v3 w=1.33u l=1u ad=3.7240e-13 pd=1.8900e-06 as=7.9800e-13 ps=3.8600e-06 nf=1 m=3 par=3
XMpar9 a_1206_4831.t25 a_1206_4831.t24 a_1310_3077.t0 vss.t0 nfet_03v3 w=1.33u l=1u ad=3.7240e-13 pd=1.8900e-06 as=7.9800e-13 ps=3.8600e-06 nf=1 m=1
XMpar10 ib.t1 ib.t0 vss.t26 vss.t25 nfet_03v3 w=1.5u l=2u ad=4.2000e-13 pd=2.0600e-06 as=4.2000e-13 ps=2.0600e-06 nf=1 m=2 par=2
XMpar11 a_1310_3077.t2 inp.t0 a_1708_7141.t0 vss.t0 nfet_03v3 w=2.03u l=1.6u ad=5.6840e-13 pd=2.5900e-06 as=5.6840e-13 ps=2.5900e-06 nf=1 m=1
Rpar0 a_1086_5039.t0 a_1086_5039.t1 65.0233
Rpar1 a_1206_4831.t0 a_1206_4831.t1 15.2890
Rpar2 a_1206_4831.t0 a_1206_4831.t24 1199.4837
Rpar3 a_1206_4831.t0 a_1206_4831.t25 649.5978
Rpar4 a_1206_4831.t0 a_1206_4831.t48 310.3897
Rpar5 a_1206_4831.t1 a_1206_4831.t24 296.5755
Rpar6 a_1206_4831.t1 a_1206_4831.t25 160.6148
Rpar7 a_1206_4831.t1 a_1206_4831.t48 76.7446
Rpar8 a_1206_4831.t24 a_1206_4831.t25 22.5443
Rpar9 a_1206_4831.t24 a_1206_4831.t48 283.4567
Rpar10 a_1206_4831.t25 a_1206_4831.t48 153.5101
Rpar11 a_1310_3077.t0 a_1310_3077.t2 46.4091
Rpar12 a_1708_7141.t0 a_1708_7141.t20 97.6216
Rpar13 a_2210_3077.t0 a_2210_3077.t3 53.4787
Rpar14 a_3096_8976.t0 a_3096_8976.t2 51.2087
Rpar15 ib ib.t0 11.3281
Rpar16 ib ib.t1 11.2621
Rpar17 inn inn.t0 1.0922
Rpar18 inp inp.t0 1.4626
Rpar19 out out.t0 51.0693
Rpar20 out out.t1 4.1952
Rpar21 vdd vdd.t0 304.7558
Rpar22 vdd vdd.t1 54.2586
Rpar23 vdd vdd.t4 66.7757
Rpar24 vdd.t0 vdd.t1 10.6251
Rpar25 vdd.t0 vdd.t4 670.8837
Rpar26 vdd.t1 vdd.t4 119.4439
Rpar27 vss vss.t0 942.1966
Rpar28 vss vss.t1 280.7987
Rpar29 vss vss.t4 93.5584
Rpar30 vss vss.t25 366.2486
Rpar31 vss vss.t26 474.7452
Rpar32 vss.t0 vss.t1 25.1107
Rpar33 vss.t0 vss.t4 13.9514
Rpar34 vss.t1 vss.t4 3.5679
Rpar35 vss.t1 vss.t25 701.6819
Rpar36 vss.t1 vss.t26 909.5894
Rpar37 vss.t4 vss.t25 234.5486
Rpar38 vss.t4 vss.t26 304.0390
Rpar39 vss.t25 vss.t26 6.5052
Cpar0 a_1086_5039.t0 vss 4.11303e-14
Cpar1 a_1086_5039.t1 vss 1.79135e-14
Cpar2 a_1206_4831.t0 vss 1.82297e-14
Cpar3 a_1206_4831.t1 vss 9.09134e-15
Cpar4 a_1206_4831.t24 vss 5.84524e-15
Cpar5 a_1206_4831.t25 vss 2.72867e-15
Cpar6 a_1206_4831.t48 vss 8.74721e-14
Cpar7 a_1310_3077.t0 vss 3.38505e-15
Cpar8 a_1310_3077.t2 vss 6.38169e-15
Cpar9 a_1708_7141.t0 vss 1.19696e-14
Cpar10 a_1708_7141.t20 vss 6.54789e-15
Cpar11 a_2210_3077.t0 vss 4.09466e-15
Cpar12 a_2210_3077.t3 vss 7.98447e-15
Cpar13 a_3096_8976.t0 vss 3.89182e-14
Cpar14 a_3096_8976.t2 vss 1.56197e-14
Cpar15 ib vdd 1.13990e-16
Cpar16 ib vss 1.70708e-14
Cpar17 ib.t0 vss 2.86525e-15
Cpar18 ib.t1 vss 1.24480e-16
Cpar19 inn inp 5.25900e-17
Cpar20 inn vss 1.11450e-14
Cpar21 inn.t0 vss 1.70254e-15
Cpar22 inp vss 1.06227e-14
Cpar23 inp.t0 vss 2.12440e-15
Cpar24 out vdd 5.56706e-15
Cpar25 out vss 1.04979e-14
Cpar26 out.t0 vss 4.80822e-15
Cpar27 out.t1 vss 8.77724e-15
Cpar28 vdd vss 2.45068e-13
Cpar29 vdd.t0 vss 1.00734e-13
Cpar30 vdd.t1 vss 1.08650e-14
Cpar31 vdd.t4 vss 2.87721e-14
.ends opamp_dut

Vdd vdd 0 3.300000
Vss vss 0 0
Ibias vdd ib 1.625000e-06
Vinp inp 0 DC 1.711000 AC 1 PWL(0 1.711000 5.094088e-09 1.711000 5.603497e-09 1.721000)
Rfb out inn 1m
Cload out 0 2.000000e-13
Xdut vdd vss inp inn out ib opamp_dut
.end
