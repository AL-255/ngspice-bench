* opa1000[0434]: 200f/nmos_miller_1v8_10u_100u_weak (nmos_miller, VDD=1.8V, CL=0.2pF, Iref=9.2857uA)
.include "pdk_opa.inc"
.temp 27
.option gmin=1e-12 rshunt=1e12 reltol=1e-3 abstol=1e-12 vntol=1e-5 method=gear
* Post-PEX R+C extracted netlist for nmos_miller_1v8_10u_100u_weak
.subckt opamp_dut vdd vss inp inn out ib
XMpar0 a_6472_996.t7 a_6472_996.t6 vdd.t1 vdd.t0 pfet_03v3 w=10u l=0.75u ad=2.8000e-12 pd=1.0560e-05 as=2.8000e-12 ps=1.0560e-05 nf=1 m=2 par=2
XMpar1 a_4946_6781.t0 ib.t0 vss.t1 vss.t0 nfet_03v3 w=6.56u l=1.5u ad=1.8368e-12 pd=7.1200e-06 as=1.8368e-12 ps=7.1200e-06 nf=1 m=4 par=4
XMpar2 out.t2 ib.t0 vss.t1 vss.t0 nfet_03v3 w=6.56u l=1.5u ad=2.2566e-12 pd=8.5600e-06 as=1.8368e-12 ps=7.1200e-06 nf=1 m=10 par=10
XMpar3 a_1217_8327.t0 inp.t0 a_4946_6781.t4 vss.t0 nfet_03v3 w=1.67u l=0.8u ad=4.6760e-13 pd=2.2300e-06 as=6.4573e-13 ps=3.0000e-06 nf=1 m=6 par=6
XMpar4 out.t0 a_1217_8327.t9 vdd.t1 vdd.t0 pfet_03v3 w=10u l=0.75u ad=2.8000e-12 pd=1.0560e-05 as=3.4400e-12 ps=1.2688e-05 nf=1 m=10 par=10
XMpar5 a_4946_6781.t4 inn.t0 a_6472_996.t0 vss.t0 nfet_03v3 w=1.67u l=0.8u ad=6.4573e-13 pd=3.0000e-06 as=4.6760e-13 ps=2.2300e-06 nf=1 m=6 par=6
XMpar6 a_1217_8327.t6 a_6472_996.t6 vdd.t1 vdd.t0 pfet_03v3 w=10u l=0.75u ad=6.0000e-12 pd=2.1200e-05 as=2.8000e-12 ps=1.0560e-05 nf=1 m=2 par=2
XMpar7 ib.t1 ib.t0 vss.t1 vss.t0 nfet_03v3 w=6.56u l=1.5u ad=1.8368e-12 pd=7.1200e-06 as=1.8368e-12 ps=7.1200e-06 nf=1 m=2 par=2
X5 a_6642_4781.t1 out.t14 cap_mim_2f0fF c_width=19.62u c_length=19.63u
X8 a_1217_8327.t8 a_6642_4781.t0 vss.t44 ppolyf_u_1k r_width=1u r_length=2.16u
Rpar0 a_1217_8327.t0 a_1217_8327.t9 68.2143
Rpar1 a_1217_8327.t0 a_1217_8327.t6 254.1287
Rpar2 a_1217_8327.t0 a_1217_8327.t8 248.7498
Rpar3 a_1217_8327.t9 a_1217_8327.t6 179.5609
Rpar4 a_1217_8327.t9 a_1217_8327.t8 175.7603
Rpar5 a_1217_8327.t6 a_1217_8327.t8 56.8096
Rpar6 a_4946_6781.t0 a_4946_6781.t4 56.1170
Rpar7 a_6472_996.t0 a_6472_996.t6 241.3203
Rpar8 a_6472_996.t0 a_6472_996.t7 49.4659
Rpar9 a_6472_996.t6 a_6472_996.t7 40.2737
Rpar10 a_6642_4781.t0 a_6642_4781.t1 56.5452
Rpar11 ib ib.t0 12.9603
Rpar12 ib ib.t1 9.2956
Rpar13 inn inn.t0 3.1092
Rpar14 inp inp.t0 3.4940
Rpar15 out out.t0 269.1113
Rpar16 out out.t2 2.0795
Rpar17 out out.t14 548.1403
Rpar18 out.t0 out.t2 60.2001
Rpar19 out.t0 out.t14 269.5421
Rpar20 out.t2 out.t14 122.6188
Rpar21 vdd vdd.t0 36.1064
Rpar22 vdd vdd.t1 101.8175
Rpar23 vdd.t0 vdd.t1 3.6407
Rpar24 vss vss.t0 49.6837
Rpar25 vss vss.t1 563.2500
Rpar26 vss vss.t44 163.6508
Rpar27 vss.t0 vss.t1 5.0050
Rpar28 vss.t0 vss.t44 3.3390
Rpar29 vss.t1 vss.t44 47.6000
Cpar0 a_1217_8327.t0 vss 3.80677e-15
Cpar1 a_1217_8327.t6 vss 7.73735e-15
Cpar2 a_1217_8327.t8 vss 2.87377e-15
Cpar3 a_1217_8327.t9 vss 1.54282e-14
Cpar4 a_4946_6781.t0 vss 1.10051e-14
Cpar5 a_4946_6781.t4 vss 6.91137e-15
Cpar6 a_6472_996.t0 vss 2.55088e-15
Cpar7 a_6472_996.t6 vss 5.15242e-15
Cpar8 a_6472_996.t7 vss 5.02434e-15
Cpar9 a_6642_4781.t0 vss 3.43300e-17
Cpar10 a_6642_4781.t1 vss 2.63022e-15
Cpar11 ib out 3.51300e-15
Cpar12 ib vdd 2.93980e-16
Cpar13 ib vss 2.59794e-14
Cpar14 ib.t0 vss 6.91323e-15
Cpar15 ib.t1 vss 5.03860e-16
Cpar16 inn inp 5.23000e-17
Cpar17 inn vss 4.38049e-15
Cpar18 inn.t0 vss 6.08528e-16
Cpar19 inp vss 4.26295e-15
Cpar20 inp.t0 vss 6.57975e-16
Cpar21 out vdd 1.58788e-14
Cpar22 out vss 1.92422e-14
Cpar23 out.t0 vss 1.15274e-14
Cpar24 out.t14 vss 1.21252e-14
Cpar25 out.t2 vss 1.07277e-14
Cpar26 vdd vss 7.52440e-14
Cpar27 vdd.t0 vss 2.10111e-14
Cpar28 vdd.t1 vss 1.17063e-14
.ends opamp_dut

Vdd vdd 0 1.800000
Vss vss 0 0
Ibias vdd ib 9.285700e-06
Vinp inp 0 DC 0.895000 AC 1 PWL(0 0.895000 3.942248e-09 0.895000 4.336473e-09 0.905000)
Rfb out inn 1m
Cload out 0 2.000000e-13
Xdut vdd vss inp inn out ib opamp_dut
.end
