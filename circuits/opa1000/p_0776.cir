* opa1000[0776]: 200f/symmetrical_ota_3v3_0p1u_1u_subth (symmetrical_ota, VDD=3.3V, CL=0.2pF, Iref=0.0958uA)
.include "pdk_opa.inc"
.temp 27
.option gmin=1e-12 rshunt=1e12 reltol=1e-3 abstol=1e-12 vntol=1e-5 method=gear
* Post-PEX R+C extracted netlist for symmetrical_ota_3v3_0p1u_1u_subth
.subckt opamp_dut vdd vss inp inn out ib
XMpar0 ib.t1 ib.t0 vss.t13 vss.t12 nfet_03v3 w=0.45u l=3u ad=1.2600e-13 pd=1.0100e-06 as=1.2600e-13 ps=1.0100e-06 nf=1 m=2 par=2
XMpar1 a_3908_1041.t0 a_7988_4427.t0 vdd.t1 vdd.t0 pfet_03v3 w=2.48u l=3.9u ad=6.9440e-13 pd=3.0400e-06 as=1.0912e-12 ps=4.6000e-06 nf=1 m=4 par=4
XMpar2 a_1332_4427.t0 inp.t0 a_4050_2901.t0 vss.t2 nfet_03v3 w=1.79u l=3.2u ad=5.0120e-13 pd=2.3500e-06 as=7.8760e-13 ps=3.5650e-06 nf=1 m=4 par=4
XMpar3 a_4050_2901.t0 inn.t0 a_7988_4427.t4 vss.t2 nfet_03v3 w=1.79u l=3.2u ad=7.8760e-13 pd=3.5650e-06 as=5.0120e-13 ps=2.3500e-06 nf=1 m=4 par=4
XMpar4 a_4050_2901.t4 ib.t0 vss.t13 vss.t12 nfet_03v3 w=0.45u l=3u ad=1.2600e-13 pd=1.0100e-06 as=1.9800e-13 ps=1.5550e-06 nf=1 m=4 par=4
XMpar5 out.t1 a_1332_4427.t4 vdd.t1 vdd.t0 pfet_03v3 w=2.48u l=3.9u ad=6.9440e-13 pd=3.0400e-06 as=1.0912e-12 ps=4.6000e-06 nf=1 m=4 par=4
XMpar6 out.t0 a_3908_1041.t4 vss.t1 vss.t0 nfet_03v3 w=0.58u l=3.9u ad=1.6240e-13 pd=1.1400e-06 as=2.5520e-13 ps=1.7500e-06 nf=1 m=4 par=4
XMpar7 a_1332_4427.t5 a_1332_4427.t4 vdd.t1 vdd.t0 pfet_03v3 w=2.48u l=3.9u ad=6.9440e-13 pd=3.0400e-06 as=6.9440e-13 ps=3.0400e-06 nf=1 m=2 par=2
XMpar8 a_7988_4427.t1 a_7988_4427.t0 vdd.t1 vdd.t0 pfet_03v3 w=2.48u l=3.9u ad=6.9440e-13 pd=3.0400e-06 as=6.9440e-13 ps=3.0400e-06 nf=1 m=2 par=2
XMpar9 a_3908_1041.t5 a_3908_1041.t4 vss.t1 vss.t0 nfet_03v3 w=0.58u l=3.9u ad=1.6240e-13 pd=1.1400e-06 as=1.6240e-13 ps=1.1400e-06 nf=1 m=4 par=4
X5 out.t8 vss.t24 cap_mim_2f0fF c_width=19.27u c_length=19.27u
Rpar0 a_1332_4427.t0 a_1332_4427.t4 175.7321
Rpar1 a_1332_4427.t0 a_1332_4427.t5 149.9223
Rpar2 a_1332_4427.t4 a_1332_4427.t5 23.3791
Rpar3 a_3908_1041.t0 a_3908_1041.t4 156.6558
Rpar4 a_3908_1041.t0 a_3908_1041.t5 65.8283
Rpar5 a_3908_1041.t4 a_3908_1041.t5 22.4846
Rpar6 a_4050_2901.t0 a_4050_2901.t4 67.2605
Rpar7 a_7988_4427.t0 a_7988_4427.t1 24.2935
Rpar8 a_7988_4427.t0 a_7988_4427.t4 115.2893
Rpar9 a_7988_4427.t1 a_7988_4427.t4 98.3567
Rpar10 ib ib.t0 11.3299
Rpar11 ib ib.t1 15.2591
Rpar12 inn inn.t0 2.1432
Rpar13 inp inp.t0 2.1918
Rpar14 out out.t0 198.6674
Rpar15 out out.t1 58.3176
Rpar16 out out.t8 15.3867
Rpar17 out.t0 out.t1 89.4619
Rpar18 vdd vdd.t0 82.5128
Rpar19 vdd vdd.t1 132.4008
Rpar20 vdd.t0 vdd.t1 3.3809
Rpar21 vss vss.t0 88.2704
Rpar22 vss vss.t1 279.1628
Rpar23 vss vss.t12 1112.2261
Rpar24 vss vss.t13 3182.8835
Rpar25 vss vss.t2 81.6158
Rpar26 vss vss.t24 1229.2993
Rpar27 vss.t0 vss.t1 13.1495
Rpar28 vss.t0 vss.t12 166.3584
Rpar29 vss.t0 vss.t13 477.2880
Rpar30 vss.t0 vss.t2 3.2766
Rpar31 vss.t0 vss.t24 185.4569
Rpar32 vss.t1 vss.t12 736.3186
Rpar33 vss.t1 vss.t2 11.9576
Rpar34 vss.t1 vss.t24 829.6513
Rpar35 vss.t12 vss.t13 7.5406
Rpar36 vss.t12 vss.t2 158.6850
Rpar37 vss.t12 vss.t24 137.4747
Rpar38 vss.t13 vss.t2 455.3236
Rpar39 vss.t13 vss.t24 392.9429
Rpar40 vss.t2 vss.t24 176.9935
Cpar0 a_1332_4427.t0 vss 3.80310e-15
Cpar1 a_1332_4427.t4 vss 1.75457e-14
Cpar2 a_1332_4427.t5 vss 3.45105e-15
Cpar3 a_3908_1041.t0 vss 3.40987e-15
Cpar4 a_3908_1041.t4 vss 8.50236e-15
Cpar5 a_3908_1041.t5 vss 2.27645e-15
Cpar6 a_4050_2901.t0 vss 6.15981e-15
Cpar7 a_4050_2901.t4 vss 3.98042e-15
Cpar8 a_7988_4427.t0 vss 1.94231e-14
Cpar9 a_7988_4427.t1 vss 3.68347e-15
Cpar10 a_7988_4427.t4 vss 3.87302e-15
Cpar11 ib vdd 2.69480e-16
Cpar12 ib vss 1.41988e-14
Cpar13 ib.t0 vss 1.85026e-15
Cpar14 ib.t1 vss 7.88130e-17
Cpar15 inn inp 5.13900e-17
Cpar16 inn vdd 1.30500e-17
Cpar17 inn vss 7.22774e-15
Cpar18 inn.t0 vss 1.10946e-15
Cpar19 inp vdd 1.36200e-17
Cpar20 inp vss 7.46254e-15
Cpar21 inp.t0 vss 1.10595e-15
Cpar22 out vdd 4.29288e-15
Cpar23 out vss 1.80566e-14
Cpar24 out.t0 vss 4.85405e-16
Cpar25 out.t1 vss 5.97536e-16
Cpar26 out.t8 vss 1.18768e-14
Cpar27 vdd vss 9.29853e-14
Cpar28 vdd.t0 vss 2.21795e-14
Cpar29 vdd.t1 vss 1.35778e-14
.ends opamp_dut

Vdd vdd 0 3.300000
Vss vss 0 0
Ibias vdd ib 9.580000e-08
Vinp inp 0 DC 1.645000 AC 1 PWL(0 1.645000 1.468082e-07 1.645000 1.614890e-07 1.655000)
Rfb out inn 1m
Cload out 0 2.000000e-13
Xdut vdd vss inp inn out ib opamp_dut
.end
