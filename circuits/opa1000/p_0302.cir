* opa1000[0302]: 2p/folded_cascode_pmos_1v8_i2u_weak (folded_cascode_pmos, VDD=1.8V, CL=2.0pF, Iref=0.5778uA)
.include "pdk_opa.inc"
.temp 27
.option gmin=1e-12 rshunt=1e12 reltol=1e-3 abstol=1e-12 vntol=1e-5 method=gear
* Post-PEX R+C extracted netlist for folded_cascode_pmos_1v8_i2u_weak
.subckt opamp_dut vdd vss inp inn out ib
XMpar0 a_1466_11526.t0 inn.t0 a_7854_10029.t0 vdd.t4 pfet_03v3 w=1.93u l=4.5u ad=6.8292e-13 pd=3.0831e-06 as=6.3542e-13 ps=2.8854e-06 nf=1 m=26 par=26
XMpar1 a_1295_5862.t4 ib.t0 vss.t5 vss.t4 nfet_03v3 w=0.56u l=2.08u ad=1.5680e-13 pd=1.1200e-06 as=1.5680e-13 ps=1.1200e-06 nf=1 m=2 par=2
XMpar2 a_1466_11526.t0 inp.t0 a_2486_11526.t2 vdd.t4 pfet_03v3 w=1.93u l=4.5u ad=6.8292e-13 pd=3.0831e-06 as=6.3542e-13 ps=2.8854e-06 nf=1 m=26 par=26
XMpar3 a_6810_1250.t3 a_6810_1250.t2 vdd.t1 vdd.t0 pfet_03v3 w=4.9u l=5.1u ad=2.9400e-12 pd=1.1000e-05 as=1.3720e-12 ps=5.4600e-06 nf=1 m=2 par=2
XMpar4 out.t0 a_6810_1250.t2 vdd.t1 vdd.t0 pfet_03v3 w=4.9u l=5.1u ad=2.9400e-12 pd=1.1000e-05 as=1.3720e-12 ps=5.4600e-06 nf=1 m=2 par=2
XMpar5 a_7854_10029.t28 ib.t0 vss.t5 vss.t4 nfet_03v3 w=0.56u l=2.08u ad=1.5680e-13 pd=1.1200e-06 as=2.4640e-13 ps=1.7200e-06 nf=1 m=4 par=4
XMpar6 a_7854_10029.t26 a_1295_5862.t10 out.t2 vss.t0 nfet_03v3 w=0.83u l=1.63u ad=4.9800e-13 pd=2.8600e-06 as=2.3240e-13 ps=1.3900e-06 nf=1 m=2 par=2
XMpar7 a_1295_5862.t1 a_1295_5862.t0 vdd.t1 vdd.t0 pfet_03v3 w=4.9u l=5.1u ad=1.3720e-12 pd=5.4600e-06 as=1.3720e-12 ps=5.4600e-06 nf=1 m=2 par=2
XMpar8 a_1466_11526.t26 a_1295_5862.t0 vdd.t1 vdd.t0 pfet_03v3 w=4.9u l=5.1u ad=1.3720e-12 pd=5.4600e-06 as=2.1560e-12 ps=8.2300e-06 nf=1 m=4 par=4
XMpar9 a_2486_11526.t0 a_1295_5862.t10 a_6810_1250.t0 vss.t0 nfet_03v3 w=0.83u l=1.63u ad=4.9800e-13 pd=2.8600e-06 as=2.3240e-13 ps=1.3900e-06 nf=1 m=2 par=2
XMpar10 a_2486_11526.t28 ib.t0 vss.t5 vss.t4 nfet_03v3 w=0.56u l=2.08u ad=1.5680e-13 pd=1.1200e-06 as=2.4640e-13 ps=1.7200e-06 nf=1 m=4 par=4
XMpar11 ib.t1 ib.t0 vss.t5 vss.t4 nfet_03v3 w=0.56u l=2.08u ad=3.3600e-13 pd=2.3200e-06 as=1.5680e-13 ps=1.1200e-06 nf=1 m=2 par=2
Rpar0 a_1295_5862.t0 a_1295_5862.t1 24.3980
Rpar1 a_1295_5862.t0 a_1295_5862.t10 334.0404
Rpar2 a_1295_5862.t0 a_1295_5862.t4 336.1074
Rpar3 a_1295_5862.t1 a_1295_5862.t10 131.9569
Rpar4 a_1295_5862.t1 a_1295_5862.t4 132.7734
Rpar5 a_1295_5862.t10 a_1295_5862.t4 102.2239
Rpar6 a_1466_11526.t0 a_1466_11526.t26 60.6133
Rpar7 a_2486_11526.t0 a_2486_11526.t2 125.4059
Rpar8 a_2486_11526.t0 a_2486_11526.t28 55.7274
Rpar9 a_2486_11526.t2 a_2486_11526.t28 82.9579
Rpar10 a_6810_1250.t0 a_6810_1250.t2 353.7778
Rpar11 a_6810_1250.t0 a_6810_1250.t3 152.4003
Rpar12 a_6810_1250.t2 a_6810_1250.t3 11.2118
Rpar13 a_7854_10029.t0 a_7854_10029.t26 125.4059
Rpar14 a_7854_10029.t0 a_7854_10029.t28 82.9579
Rpar15 a_7854_10029.t26 a_7854_10029.t28 55.7274
Rpar16 ib ib.t0 11.8238
Rpar17 ib ib.t1 8.0640
Rpar18 ib.t0 ib.t1 116.8426
Rpar19 inn inn.t0 1.9042
Rpar20 inp inp.t0 1.9042
Rpar21 out out.t0 5.5572
Rpar22 out out.t2 65.9537
Rpar23 vdd vdd.t0 317.4921
Rpar24 vdd vdd.t1 630.2010
Rpar25 vdd vdd.t4 20.4016
Rpar26 vdd.t0 vdd.t1 5.3963
Rpar27 vdd.t0 vdd.t4 117.8152
Rpar28 vdd.t1 vdd.t4 233.8555
Rpar29 vss vss.t0 285.3791
Rpar30 vss vss.t4 167.4013
Rpar31 vss vss.t5 457.4885
Rpar32 vss.t0 vss.t4 6.2782
Rpar33 vss.t0 vss.t5 22.2458
Rpar34 vss.t4 vss.t5 5.9473
Cpar0 a_1295_5862.t0 vss 2.26096e-14
Cpar1 a_1295_5862.t1 vss 3.53160e-15
Cpar2 a_1295_5862.t10 vss 3.36068e-15
Cpar3 a_1295_5862.t4 vss 1.66407e-15
Cpar4 a_1466_11526.t0 vss 6.86309e-14
Cpar5 a_1466_11526.t26 vss 1.01770e-14
Cpar6 a_2486_11526.t0 vss 3.60616e-15
Cpar7 a_2486_11526.t2 vss 3.78730e-14
Cpar8 a_2486_11526.t28 vss 4.93575e-15
Cpar9 a_6810_1250.t0 vss 2.86790e-15
Cpar10 a_6810_1250.t2 vss 1.66177e-14
Cpar11 a_6810_1250.t3 vss 7.41725e-15
Cpar12 a_7854_10029.t0 vss 3.70568e-14
Cpar13 a_7854_10029.t26 vss 3.52845e-15
Cpar14 a_7854_10029.t28 vss 4.82935e-15
Cpar15 ib vdd 1.47970e-16
Cpar16 ib vss 2.06445e-14
Cpar17 ib.t0 vss 2.66936e-15
Cpar18 ib.t1 vss 7.01420e-17
Cpar19 inn inp 7.80900e-17
Cpar20 inn out 5.85600e-17
Cpar21 inn vdd 4.26999e-14
Cpar22 inn vss 5.18535e-15
Cpar23 inn.t0 vss 6.13820e-14
Cpar24 inp vdd 4.26022e-14
Cpar25 inp vss 5.25409e-15
Cpar26 inp.t0 vss 6.12561e-14
Cpar27 out vdd 5.25594e-15
Cpar28 out vss 1.08540e-14
Cpar29 out.t0 vss 4.46373e-15
Cpar30 out.t2 vss 2.64619e-15
Cpar31 vdd vss 3.83460e-13
Cpar32 vdd.t0 vss 3.19387e-14
Cpar33 vdd.t1 vss 1.90424e-14
Cpar34 vdd.t4 vss 1.07124e-13
.ends opamp_dut

Vdd vdd 0 1.800000
Vss vss 0 0
Ibias vdd ib 5.778000e-07
Vinp inp 0 DC 0.751000 AC 1 PWL(0 0.751000 1.280136e-07 0.751000 1.408150e-07 0.761000)
Rfb out inn 1m
Cload out 0 2.000000e-12
Xdut vdd vss inp inn out ib opamp_dut
.end
