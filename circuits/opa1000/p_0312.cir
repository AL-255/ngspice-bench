* opa1000[0312]: 2p/folded_cascode_pmos_1v8_i500u_weak (folded_cascode_pmos, VDD=1.8V, CL=2.0pF, Iref=77.7778uA)
.include "pdk_opa.inc"
.temp 27
.option gmin=1e-12 rshunt=1e12 reltol=1e-3 abstol=1e-12 vntol=1e-5 method=gear
* Post-PEX R+C extracted netlist for folded_cascode_pmos_1v8_i500u_weak
.subckt opamp_dut vdd vss inp inn out ib
XMpar0 a_10848_12122.t180 ib.t0 vss.t22 vss.t21 nfet_03v3 w=2.72u l=0.68u ad=7.6160e-13 pd=3.2800e-06 as=8.1600e-13 ps=3.4900e-06 nf=1 m=32 par=32
XMpar1 a_10848_12122.t0 inn.t0 a_1284_3079.t0 vdd.t8 pfet_03v3 w=2.3u l=0.45u ad=6.4400e-13 pd=2.8600e-06 as=6.9000e-13 ps=3.0437e-06 nf=1 m=160 par=160
XMpar2 a_1134_2871.t32 ib.t0 vss.t22 vss.t21 nfet_03v3 w=2.72u l=0.68u ad=8.7040e-13 pd=3.7000e-06 as=7.6160e-13 ps=3.2800e-06 nf=1 m=16 par=16
XMpar3 a_1284_3079.t0 inp.t0 a_2738_1205.t0 vdd.t8 pfet_03v3 w=2.3u l=0.45u ad=6.9000e-13 pd=3.0437e-06 as=6.4400e-13 ps=2.8600e-06 nf=1 m=160 par=160
XMpar4 a_6644_6296.t19 a_6644_6296.t18 vdd.t1 vdd.t0 pfet_03v3 w=9.67u l=0.75u ad=2.7076e-12 pd=1.0230e-05 as=3.0944e-12 ps=1.1519e-05 nf=1 m=16 par=16
XMpar5 a_2738_1205.t180 ib.t0 vss.t22 vss.t21 nfet_03v3 w=2.72u l=0.68u ad=7.6160e-13 pd=3.2800e-06 as=8.1600e-13 ps=3.4900e-06 nf=1 m=32 par=32
XMpar6 a_1284_3079.t320 a_1134_2871.t0 vdd.t1 vdd.t0 pfet_03v3 w=9.67u l=0.75u ad=2.7076e-12 pd=1.0230e-05 as=2.9010e-12 ps=1.0874e-05 nf=1 m=32 par=32
XMpar7 a_1134_2871.t1 a_1134_2871.t0 vdd.t1 vdd.t0 pfet_03v3 w=9.67u l=0.75u ad=2.7076e-12 pd=1.0230e-05 as=2.7076e-12 ps=1.0230e-05 nf=1 m=16 par=16
XMpar8 out.t10 a_6644_6296.t18 vdd.t1 vdd.t0 pfet_03v3 w=9.67u l=0.75u ad=2.7076e-12 pd=1.0230e-05 as=2.7076e-12 ps=1.0230e-05 nf=1 m=16 par=16
XMpar9 ib.t1 ib.t0 vss.t22 vss.t21 nfet_03v3 w=2.72u l=0.68u ad=9.7920e-13 pd=4.1200e-06 as=7.6160e-13 ps=3.2800e-06 nf=1 m=16 par=16
XMpar10 a_2738_1205.t160 a_1134_2871.t80 a_6644_6296.t0 vss.t1 nfet_03v3 w=1.95u l=0.28u ad=9.6330e-13 pd=3.3280e-06 as=9.0090e-13 ps=3.0690e-06 nf=1 m=20 par=20
XMpar11 a_10848_12122.t160 a_1134_2871.t80 out.t0 vss.t1 nfet_03v3 w=1.95u l=0.28u ad=9.6330e-13 pd=3.3280e-06 as=9.0090e-13 ps=3.0690e-06 nf=1 m=20 par=20
X394 out.t36 vss.t0 cap_mim_2f0fF c_width=11.49u c_length=11.49u
Rpar0 a_10848_12122.t0 a_10848_12122.t160 84.6006
Rpar1 a_10848_12122.t0 a_10848_12122.t180 103.7736
Rpar2 a_10848_12122.t160 a_10848_12122.t180 108.6331
Rpar3 a_1134_2871.t0 a_1134_2871.t1 16.4082
Rpar4 a_1134_2871.t1 a_1134_2871.t80 101.6334
Rpar5 a_1134_2871.t1 a_1134_2871.t32 81.5759
Rpar6 a_1134_2871.t80 a_1134_2871.t32 67.6527
Rpar7 a_1284_3079.t0 a_1284_3079.t320 44.4454
Rpar8 a_2738_1205.t0 a_2738_1205.t160 84.6006
Rpar9 a_2738_1205.t0 a_2738_1205.t180 103.7736
Rpar10 a_2738_1205.t160 a_2738_1205.t180 108.6331
Rpar11 a_6644_6296.t0 a_6644_6296.t18 284.0087
Rpar12 a_6644_6296.t0 a_6644_6296.t19 55.2617
Rpar13 a_6644_6296.t18 a_6644_6296.t19 17.0879
Rpar14 ib ib.t0 28.0226
Rpar15 ib ib.t1 3.9693
Rpar16 ib.t0 ib.t1 5.8892
Rpar17 inn inn.t0 1.5931
Rpar18 inp inp.t0 1.5931
Rpar19 out out.t0 554.0038
Rpar20 out out.t10 2.5701
Rpar21 out out.t36 800.9927
Rpar22 out.t0 out.t10 51.2470
Rpar23 out.t0 out.t36 117.0933
Rpar24 out.t10 out.t36 74.0942
Rpar25 vdd vdd.t0 386.8204
Rpar26 vdd vdd.t1 4232.1212
Rpar27 vdd vdd.t8 23.3099
Rpar28 vdd.t0 vdd.t1 2.1050
Rpar29 vdd.t0 vdd.t8 111.7180
Rpar30 vdd.t1 vdd.t8 1222.2832
Rpar31 vss vss.t0 2111.6066
Rpar32 vss vss.t1 901.4799
Rpar33 vss vss.t22 409.6073
Rpar34 vss vss.t21 55.1987
Rpar35 vss.t0 vss.t1 92.6297
Rpar36 vss.t0 vss.t22 147.9149
Rpar37 vss.t0 vss.t21 266.5775
Rpar38 vss.t1 vss.t22 63.0968
Rpar39 vss.t1 vss.t21 108.3898
Rpar40 vss.t22 vss.t21 3.1343
Cpar0 a_10848_12122.t0 vss 1.01367e-13
Cpar1 a_10848_12122.t160 vss 2.07493e-14
Cpar2 a_10848_12122.t180 vss 2.86671e-14
Cpar3 a_1134_2871.t0 vss 5.48360e-14
Cpar4 a_1134_2871.t1 vss 2.30840e-14
Cpar5 a_1134_2871.t32 vss 1.25007e-14
Cpar6 a_1134_2871.t80 vss 1.46997e-14
Cpar7 a_1284_3079.t0 vss 2.14828e-13
Cpar8 a_1284_3079.t320 vss 7.59859e-14
Cpar9 a_2738_1205.t0 vss 1.00520e-13
Cpar10 a_2738_1205.t160 vss 2.05760e-14
Cpar11 a_2738_1205.t180 vss 2.84273e-14
Cpar12 a_6644_6296.t0 vss 1.05284e-14
Cpar13 a_6644_6296.t18 vss 4.04423e-14
Cpar14 a_6644_6296.t19 vss 2.35724e-14
Cpar15 ib vdd 4.26000e-17
Cpar16 ib vss 8.39726e-14
Cpar17 ib.t0 vss 1.24776e-14
Cpar18 ib.t1 vss 3.36778e-15
Cpar19 inn inp 2.59840e-16
Cpar20 inn vdd 5.02704e-14
Cpar21 inn vss 9.57739e-15
Cpar22 inn.t0 vss 8.13151e-14
Cpar23 inp vdd 5.01913e-14
Cpar24 inp vss 9.57663e-15
Cpar25 inp.t0 vss 8.12653e-14
Cpar26 out vdd 2.36042e-14
Cpar27 out vss 1.06156e-14
Cpar28 out.t0 vss 7.36371e-15
Cpar29 out.t10 vss 1.43271e-14
Cpar30 out.t36 vss 2.69600e-14
Cpar31 vdd vss 5.37511e-13
Cpar32 vdd.t0 vss 1.20911e-13
Cpar33 vdd.t1 vss 4.44560e-14
Cpar34 vdd.t8 vss 1.52087e-13
.ends opamp_dut

Vdd vdd 0 1.800000
Vss vss 0 0
Ibias vdd ib 7.777780e-05
Vinp inp 0 DC 0.751000 AC 1 PWL(0 0.751000 3.000000e-09 0.751000 3.300000e-09 0.761000)
Rfb out inn 1m
Cload out 0 2.000000e-12
Xdut vdd vss inp inn out ib opamp_dut
.end
