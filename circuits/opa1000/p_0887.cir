* opa1000[0887]: 2p/telescopic_nmos_1v8_1u_10u_weak (telescopic_nmos, VDD=1.8V, CL=2.0pF, Iref=1.625uA)
.include "pdk_opa.inc"
.temp 27
.option gmin=1e-12 rshunt=1e12 reltol=1e-3 abstol=1e-12 vntol=1e-5 method=gear
* Post-PEX R+C extracted netlist for telescopic_nmos_1v8_1u_10u_weak
.subckt opamp_dut vdd vss inp inn out ib
XMpar0 a_1894_5466.t0 vdd.t54 a_3394_1205.t14 vss.t7 nfet_03v3 w=1.54u l=1.6u ad=4.3120e-13 pd=2.1000e-06 as=5.9547e-13 ps=2.8267e-06 nf=1 m=6 par=6
XMpar1 a_1754_9662.t0 inn.t0 a_7374_1205.t6 vss.t0 nfet_03v3 w=1.87u l=2.5u ad=6.0909e-13 pd=2.7886e-06 as=6.0909e-13 ps=2.7886e-06 nf=1 m=14 par=14
XMpar2 a_2914_5674.t0 a_1894_5466.t72 vdd.t1 vdd.t0 pfet_03v3 w=1.79u l=2u ad=5.0120e-13 pd=2.3500e-06 as=5.7280e-13 ps=2.6537e-06 nf=1 m=8 par=8
XMpar3 a_1894_5466.t7 a_1894_5466.t6 a_2914_5674.t2 vdd.t8 pfet_03v3 w=1.91u l=1.6u ad=5.9036e-13 pd=2.7018e-06 as=8.1262e-13 ps=3.6291e-06 nf=1 m=22 par=22
XMpar4 a_1774_5674.t2 a_1894_5466.t6 out.t0 vdd.t8 pfet_03v3 w=1.91u l=1.6u ad=9.2375e-13 pd=4.0927e-06 as=5.9036e-13 ps=2.7018e-06 nf=1 m=22 par=22
XMpar5 a_1754_9662.t0 inp.t0 a_3394_1205.t0 vss.t0 nfet_03v3 w=1.87u l=2.5u ad=6.0909e-13 pd=2.7886e-06 as=6.0909e-13 ps=2.7886e-06 nf=1 m=14 par=14
XMpar6 a_1754_9662.t14 ib.t0 vss.t20 vss.t19 nfet_03v3 w=0.91u l=1.3u ad=2.5480e-13 pd=1.4700e-06 as=3.2760e-13 ps=1.8575e-06 nf=1 m=8 par=8
XMpar7 a_7374_1205.t0 vdd.t54 out.t16 vss.t7 nfet_03v3 w=1.54u l=1.6u ad=5.9547e-13 pd=2.8267e-06 as=4.3120e-13 ps=2.1000e-06 nf=1 m=6 par=6
XMpar8 a_1774_5674.t0 a_1894_5466.t72 vdd.t1 vdd.t0 pfet_03v3 w=1.79u l=2u ad=5.0120e-13 pd=2.3500e-06 as=5.7280e-13 ps=2.6537e-06 nf=1 m=8 par=8
XMpar9 ib.t1 ib.t0 vss.t20 vss.t19 nfet_03v3 w=0.91u l=1.3u ad=2.5480e-13 pd=1.4700e-06 as=2.5480e-13 ps=1.4700e-06 nf=1 m=2 par=2
Rpar0 a_1754_9662.t0 a_1754_9662.t14 71.1524
Rpar1 a_1774_5674.t0 a_1774_5674.t2 85.5922
Rpar2 a_1894_5466.t0 a_1894_5466.t6 289.1183
Rpar3 a_1894_5466.t0 a_1894_5466.t7 120.6108
Rpar4 a_1894_5466.t0 a_1894_5466.t72 159.1400
Rpar5 a_1894_5466.t6 a_1894_5466.t7 9.0546
Rpar6 a_1894_5466.t6 a_1894_5466.t72 145.1517
Rpar7 a_1894_5466.t7 a_1894_5466.t72 60.5526
Rpar8 a_2914_5674.t0 a_2914_5674.t2 60.2001
Rpar9 a_3394_1205.t0 a_3394_1205.t14 37.3866
Rpar10 a_7374_1205.t0 a_7374_1205.t6 37.3866
Rpar11 ib ib.t0 11.4042
Rpar12 ib ib.t1 14.1046
Rpar13 inn inn.t0 1.7296
Rpar14 inp inp.t0 1.7296
Rpar15 out out.t0 3.8570
Rpar16 out out.t16 37.8328
Rpar17 vdd vdd.t0 31.7289
Rpar18 vdd vdd.t1 101.6176
Rpar19 vdd vdd.t8 195.8843
Rpar20 vdd vdd.t54 2675.7120
Rpar21 vdd.t0 vdd.t1 4.8704
Rpar22 vdd.t0 vdd.t8 92.7022
Rpar23 vdd.t0 vdd.t54 1266.2795
Rpar24 vdd.t1 vdd.t8 296.8958
Rpar25 vdd.t1 vdd.t54 4055.4939
Rpar26 vdd.t8 vdd.t54 110.6711
Rpar27 vss vss.t0 60.7042
Rpar28 vss vss.t7 70.4892
Rpar29 vss vss.t19 748.7126
Rpar30 vss vss.t20 1042.2256
Rpar31 vss.t0 vss.t7 1.5315
Rpar32 vss.t0 vss.t19 249.2370
Rpar33 vss.t0 vss.t20 347.0913
Rpar34 vss.t7 vss.t19 277.5508
Rpar35 vss.t7 vss.t20 386.5094
Rpar36 vss.t19 vss.t20 6.9159
Cpar0 a_1754_9662.t0 vss 2.01591e-14
Cpar1 a_1754_9662.t14 vss 5.30550e-15
Cpar2 a_1774_5674.t0 vss 1.11265e-14
Cpar3 a_1774_5674.t2 vss 3.42403e-14
Cpar4 a_1894_5466.t0 vss 4.55733e-15
Cpar5 a_1894_5466.t6 vss 5.92501e-14
Cpar6 a_1894_5466.t7 vss 2.51351e-14
Cpar7 a_1894_5466.t72 vss 2.67645e-14
Cpar8 a_2914_5674.t0 vss 1.09504e-14
Cpar9 a_2914_5674.t2 vss 4.05695e-14
Cpar10 a_3394_1205.t0 vss 1.22238e-14
Cpar11 a_3394_1205.t14 vss 3.47115e-15
Cpar12 a_7374_1205.t0 vss 3.30575e-15
Cpar13 a_7374_1205.t6 vss 1.16413e-14
Cpar14 ib vdd 5.80300e-17
Cpar15 ib vss 1.28725e-14
Cpar16 ib.t0 vss 2.20719e-15
Cpar17 ib.t1 vss 9.09473e-17
Cpar18 inn inp 1.02880e-16
Cpar19 inn vdd 2.81020e-16
Cpar20 inn vss 1.75717e-14
Cpar21 inn.t0 vss 6.20451e-15
Cpar22 inp vdd 2.75010e-16
Cpar23 inp vss 1.74447e-14
Cpar24 inp.t0 vss 6.20590e-15
Cpar25 out vdd 6.83482e-15
Cpar26 out vss 1.24402e-14
Cpar27 out.t0 vss 2.76668e-14
Cpar28 out.t16 vss 5.11987e-15
Cpar29 vdd vss 2.24938e-13
Cpar30 vdd.t0 vss 1.83574e-14
Cpar31 vdd.t1 vss 6.37657e-15
Cpar32 vdd.t54 vss 5.34023e-15
Cpar33 vdd.t8 vss 7.25471e-14
.ends opamp_dut

Vdd vdd 0 1.800000
Vss vss 0 0
Ibias vdd ib 1.625000e-06
Vinp inp 0 DC 0.931000 AC 1 PWL(0 0.931000 2.574920e-08 0.931000 2.832412e-08 0.941000)
Rfb out inn 1m
Cload out 0 2.000000e-12
Xdut vdd vss inp inn out ib opamp_dut
.end
