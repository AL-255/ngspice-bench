* opa1000[0579]: 2p/pmos_5t_3v3_10u_100u_weak (pmos_5t, VDD=3.3V, CL=2.0pF, Iref=13.0uA)
.include "pdk_opa.inc"
.temp 27
.option gmin=1e-12 rshunt=1e12 reltol=1e-3 abstol=1e-12 vntol=1e-5 method=gear
* Post-PEX R+C extracted netlist for pmos_5t_3v3_10u_100u_weak
.subckt opamp_dut vdd vss inp inn out ib
XMpar0 a_1746_1249.t3 inp.t0 a_2026_1249.t0 vdd.t10 pfet_03v3 w=5.53u l=0.8u ad=1.7696e-12 pd=6.8612e-06 as=1.5484e-12 ps=6.0900e-06 nf=1 m=64 par=64
XMpar1 a_1746_1249.t3 inn.t0 out.t4 vdd.t10 pfet_03v3 w=5.53u l=0.8u ad=1.7696e-12 pd=6.8612e-06 as=1.5484e-12 ps=6.0900e-06 nf=1 m=64 par=64
XMpar2 out.t0 a_2026_1249.t64 vss.t1 vss.t0 nfet_03v3 w=1.77u l=1u ad=4.9560e-13 pd=2.3300e-06 as=4.9560e-13 ps=2.3300e-06 nf=1 m=10 par=10
XMpar3 a_1746_1249.t0 a_1962_11058.t0 vdd.t1 vdd.t0 pfet_03v3 w=10u l=1.25u ad=2.8000e-12 pd=1.0560e-05 as=3.6000e-12 ps=1.3220e-05 nf=1 m=8 par=8
XMpar4 a_2026_1249.t65 a_2026_1249.t64 vss.t1 vss.t0 nfet_03v3 w=1.77u l=1u ad=6.0888e-13 pd=2.8120e-06 as=4.9560e-13 ps=2.3300e-06 nf=1 m=10 par=10
XMpar5 a_1962_11058.t4 ib.t0 vss.t5 vss.t4 nfet_03v3 w=7.15u l=1.25u ad=2.0020e-12 pd=7.7100e-06 as=2.0020e-12 ps=7.7100e-06 nf=1 m=2 par=2
XMpar6 ib.t1 ib.t0 vss.t5 vss.t4 nfet_03v3 w=7.15u l=1.25u ad=4.2900e-12 pd=1.5500e-05 as=2.0020e-12 ps=7.7100e-06 nf=1 m=2 par=2
XMpar7 a_1962_11058.t1 a_1962_11058.t0 vdd.t1 vdd.t0 pfet_03v3 w=10u l=1.25u ad=2.8000e-12 pd=1.0560e-05 as=2.8000e-12 ps=1.0560e-05 nf=1 m=2 par=2
Rpar0 a_1746_1249.t0 a_1746_1249.t3 78.5997
Rpar1 a_1962_11058.t0 a_1962_11058.t1 27.0397
Rpar2 a_1962_11058.t0 a_1962_11058.t4 120.7616
Rpar3 a_1962_11058.t1 a_1962_11058.t4 61.5917
Rpar4 a_2026_1249.t0 a_2026_1249.t64 281.5379
Rpar5 a_2026_1249.t0 a_2026_1249.t65 70.5309
Rpar6 a_2026_1249.t64 a_2026_1249.t65 14.2227
Rpar7 ib ib.t0 18.9345
Rpar8 ib ib.t1 3.3700
Rpar9 inn inn.t0 2.1810
Rpar10 inp inp.t0 2.1810
Rpar11 out out.t0 3.4403
Rpar12 out out.t4 34.9135
Rpar13 vdd vdd.t0 25.9443
Rpar14 vdd vdd.t1 157.8318
Rpar15 vdd vdd.t10 50.6954
Rpar16 vdd.t0 vdd.t1 5.6043
Rpar17 vdd.t0 vdd.t10 195.1088
Rpar18 vdd.t1 vdd.t10 1186.9429
Rpar19 vss vss.t0 157.0556
Rpar20 vss vss.t1 444.8610
Rpar21 vss vss.t4 2689.0580
Rpar22 vss vss.t5 108.8825
Rpar23 vss.t0 vss.t1 4.6018
Rpar24 vss.t0 vss.t4 1669.6154
Rpar25 vss.t0 vss.t5 67.9613
Rpar26 vss.t1 vss.t4 4803.4607
Rpar27 vss.t1 vss.t5 195.1461
Rpar28 vss.t4 vss.t5 157.9346
Cpar0 a_1746_1249.t0 vss 1.67623e-14
Cpar1 a_1746_1249.t3 vss 1.38815e-13
Cpar2 a_1962_11058.t0 vss 1.72379e-14
Cpar3 a_1962_11058.t1 vss 3.98285e-15
Cpar4 a_1962_11058.t4 vss 2.46979e-15
Cpar5 a_2026_1249.t0 vss 6.19877e-14
Cpar6 a_2026_1249.t64 vss 1.47037e-14
Cpar7 a_2026_1249.t65 vss 5.91135e-15
Cpar8 ib vdd 1.45600e-17
Cpar9 ib vss 9.68950e-15
Cpar10 ib.t0 vss 8.38648e-16
Cpar11 ib.t1 vss 4.33040e-16
Cpar12 inn inp 2.09120e-16
Cpar13 inn out 1.88773e-14
Cpar14 inn vdd 3.02823e-14
Cpar15 inn vss 8.45448e-15
Cpar16 inn.t0 vss 5.64245e-14
Cpar17 inp vdd 3.01823e-14
Cpar18 inp vss 8.53672e-15
Cpar19 inp.t0 vss 5.63439e-14
Cpar20 out vdd 9.27807e-15
Cpar21 out vss 1.22129e-14
Cpar22 out.t0 vss 3.08466e-15
Cpar23 out.t4 vss 7.51307e-14
Cpar24 vdd vss 3.21937e-13
Cpar25 vdd.t0 vss 1.48128e-14
Cpar26 vdd.t1 vss 6.17731e-15
Cpar27 vdd.t10 vss 8.78960e-14
.ends opamp_dut

Vdd vdd 0 3.300000
Vss vss 0 0
Ibias vdd ib 1.300000e-05
Vinp inp 0 DC 1.480000 AC 1 PWL(0 1.480000 3.000000e-09 1.480000 3.300000e-09 1.490000)
Rfb out inn 1m
Cload out 0 2.000000e-12
Xdut vdd vss inp inn out ib opamp_dut
.end
