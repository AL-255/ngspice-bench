* opa1000[0471]: 2p/nmos_miller_1v8_i10u_subth (nmos_miller, VDD=1.8V, CL=2.0pF, Iref=1.4286uA)
.include "pdk_opa.inc"
.temp 27
.option gmin=1e-12 rshunt=1e12 reltol=1e-3 abstol=1e-12 vntol=1e-5 method=gear
* Post-PEX R+C extracted netlist for nmos_miller_1v8_i10u_subth
.subckt opamp_dut vdd vss inp inn out ib
XMpar0 ib.t1 ib.t0 vss.t1 vss.t0 nfet_03v3 w=4.44u l=2.25u ad=1.2432e-12 pd=5.0000e-06 as=1.2432e-12 ps=5.0000e-06 nf=1 m=2 par=2
XMpar1 out.t1 ib.t0 vss.t1 vss.t0 nfet_03v3 w=4.44u l=2.25u ad=1.5274e-12 pd=6.0160e-06 as=1.2432e-12 ps=5.0000e-06 nf=1 m=10 par=10
XMpar2 a_3286_3035.t4 inp.t0 a_917_10627.t0 vss.t0 nfet_03v3 w=2.05u l=0.72u ad=7.3800e-13 pd=3.2825e-06 as=5.7400e-13 ps=2.6100e-06 nf=1 m=8 par=8
XMpar3 out.t11 a_917_10627.t11 vdd.t1 vdd.t0 pfet_03v3 w=10u l=1.13u ad=2.8000e-12 pd=1.0560e-05 as=3.4400e-12 ps=1.2688e-05 nf=1 m=10 par=10
XMpar4 a_3286_3035.t0 ib.t0 vss.t1 vss.t0 nfet_03v3 w=4.44u l=2.25u ad=1.2432e-12 pd=5.0000e-06 as=1.2432e-12 ps=5.0000e-06 nf=1 m=4 par=4
XMpar5 a_3286_3035.t4 inn.t0 a_6320_10378.t4 vss.t0 nfet_03v3 w=2.05u l=0.72u ad=7.3800e-13 pd=3.2825e-06 as=5.7400e-13 ps=2.6100e-06 nf=1 m=8 par=8
XMpar6 a_6320_10378.t1 a_6320_10378.t0 vdd.t1 vdd.t0 pfet_03v3 w=10u l=1.13u ad=2.8000e-12 pd=1.0560e-05 as=2.8000e-12 ps=1.0560e-05 nf=1 m=2 par=2
XMpar7 a_917_10627.t8 a_6320_10378.t0 vdd.t1 vdd.t0 pfet_03v3 w=10u l=1.13u ad=6.0000e-12 pd=2.1200e-05 as=2.8000e-12 ps=1.0560e-05 nf=1 m=2 par=2
X1 a_917_10627.t10 a_3611_10627.t0 vss.t40 ppolyf_u_1k r_width=1u r_length=12.81u
X25 a_3611_10627.t1 out.t0 cap_mim_2f0fF c_width=16.58u c_length=16.59u
X30 a_3611_10627.t1 out.t0 cap_mim_2f0fF c_width=16.58u c_length=16.59u
Rpar0 a_3286_3035.t0 a_3286_3035.t4 68.2226
Rpar1 a_3611_10627.t0 a_3611_10627.t1 51.0401
Rpar2 a_6320_10378.t0 a_6320_10378.t1 31.5205
Rpar3 a_6320_10378.t0 a_6320_10378.t4 353.2899
Rpar4 a_6320_10378.t1 a_6320_10378.t4 90.7983
Rpar5 a_917_10627.t0 a_917_10627.t10 563.8901
Rpar6 a_917_10627.t0 a_917_10627.t11 216.8011
Rpar7 a_917_10627.t0 a_917_10627.t8 396.2694
Rpar8 a_917_10627.t10 a_917_10627.t11 243.4047
Rpar9 a_917_10627.t10 a_917_10627.t8 72.8243
Rpar10 a_917_10627.t11 a_917_10627.t8 171.0507
Rpar11 ib ib.t0 11.9672
Rpar12 ib ib.t1 10.7712
Rpar13 inn inn.t0 3.9235
Rpar14 inp inp.t0 3.9721
Rpar15 out out.t0 110.1440
Rpar16 out out.t1 57.7300
Rpar17 out out.t11 2.1360
Rpar18 out.t0 out.t1 104.6628
Rpar19 vdd vdd.t0 44.6685
Rpar20 vdd vdd.t1 134.8194
Rpar21 vdd.t0 vdd.t1 3.3740
Rpar22 vss vss.t0 24.3819
Rpar23 vss vss.t1 257.8667
Rpar24 vss vss.t40 657.3520
Rpar25 vss.t0 vss.t1 4.5372
Rpar26 vss.t0 vss.t40 74.2149
Rpar27 vss.t1 vss.t40 846.8293
Cpar0 a_3286_3035.t0 vss 9.37895e-15
Cpar1 a_3286_3035.t4 vss 1.11428e-14
Cpar2 a_3611_10627.t0 vss 8.31169e-17
Cpar3 a_3611_10627.t1 vss 5.36185e-15
Cpar4 a_6320_10378.t0 vss 7.29161e-15
Cpar5 a_6320_10378.t1 vss 6.22940e-15
Cpar6 a_6320_10378.t4 vss 6.61769e-15
Cpar7 a_917_10627.t0 vss 6.13415e-15
Cpar8 a_917_10627.t10 vss 2.92731e-15
Cpar9 a_917_10627.t11 vss 1.83176e-14
Cpar10 a_917_10627.t8 vss 7.04773e-15
Cpar11 ib out 2.97320e-15
Cpar12 ib vss 3.17041e-14
Cpar13 ib.t0 vss 6.98317e-15
Cpar14 ib.t1 vss 4.34055e-16
Cpar15 inn inp 5.13900e-17
Cpar16 inn vss 5.33919e-15
Cpar17 inn.t0 vss 9.41145e-16
Cpar18 inp vss 5.37249e-15
Cpar19 inp.t0 vss 9.53920e-16
Cpar20 out vdd 1.29985e-14
Cpar21 out vss 2.05707e-14
Cpar22 out.t0 vss 1.46637e-14
Cpar23 out.t1 vss 7.16682e-15
Cpar24 out.t11 vss 7.19219e-15
Cpar25 vdd vss 7.80598e-14
Cpar26 vdd.t0 vss 2.39591e-14
Cpar27 vdd.t1 vss 1.05339e-14
.ends opamp_dut

Vdd vdd 0 1.800000
Vss vss 0 0
Ibias vdd ib 1.428600e-06
Vinp inp 0 DC 0.895000 AC 1 PWL(0 0.895000 2.493895e-08 0.895000 2.743285e-08 0.905000)
Rfb out inn 1m
Cload out 0 2.000000e-12
Xdut vdd vss inp inn out ib opamp_dut
.end
