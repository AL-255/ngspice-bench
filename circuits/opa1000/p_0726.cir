* opa1000[0726]: 2p/rail_to_rail_1v8_i150u_weak (rail_to_rail, VDD=1.8V, CL=2.0pF, Iref=13.125uA)
.include "pdk_opa.inc"
.temp 27
.option gmin=1e-12 rshunt=1e12 reltol=1e-3 abstol=1e-12 vntol=1e-5 method=gear
* Post-PEX R+C extracted netlist for rail_to_rail_1v8_i150u_weak
.subckt opamp_dut vdd vss inp inn out ib
XMpar0 out.t1 a_8044_12656.t17 vdd.t1 vdd.t0 pfet_03v3 w=8.41u l=0.6u ad=2.3548e-12 pd=8.9700e-06 as=2.5791e-12 ps=9.7242e-06 nf=1 m=24 par=24
XMpar1 a_8212_15665.t0 inn.t4 a_8226_19105.t0 vdd.t24 pfet_03v3 w=1.87u l=0.28u ad=8.0410e-13 pd=2.7300e-06 as=1.1033e-12 ps=3.9850e-06 nf=1 m=12 par=12
XMpar2 a_8164_12447.t7 a_8164_12447.t6 vdd.t1 vdd.t0 pfet_03v3 w=8.41u l=0.6u ad=2.3548e-12 pd=8.9700e-06 as=2.3548e-12 ps=8.9700e-06 nf=1 m=6 par=6
XMpar3 a_8092_17444.t13 a_8092_17444.t12 vss.t1 vss.t0 nfet_03v3 w=0.4u l=0.56u ad=1.5467e-13 pd=1.3067e-06 as=1.1200e-13 ps=9.6000e-07 nf=1 m=6 par=6
XMpar4 a_10246_4351.t0 ib.t0 vss.t27 vss.t26 nfet_03v3 w=0.72u l=0.39u ad=2.0160e-13 pd=1.2800e-06 as=2.7840e-13 ps=1.7333e-06 nf=1 m=6 par=6
XMpar5 a_8164_12447.t4 a_8092_17444.t12 vss.t1 vss.t0 nfet_03v3 w=0.4u l=0.56u ad=1.1200e-13 pd=9.6000e-07 as=1.1200e-13 ps=9.6000e-07 nf=1 m=6 par=6
XMpar6 a_8226_10829.t4 ib.t0 vss.t27 vss.t26 nfet_03v3 w=0.72u l=0.39u ad=4.3200e-13 pd=2.6400e-06 as=2.0160e-13 ps=1.2800e-06 nf=1 m=6 par=6
XMpar7 a_8044_12656.t2 a_8212_15665.t12 vss.t1 vss.t0 nfet_03v3 w=0.4u l=0.56u ad=1.5467e-13 pd=1.3067e-06 as=1.1200e-13 ps=9.6000e-07 nf=1 m=6 par=6
XMpar8 out.t0 ib.t0 vss.t27 vss.t26 nfet_03v3 w=0.72u l=0.39u ad=2.0160e-13 pd=1.2800e-06 as=2.0160e-13 ps=1.2800e-06 nf=1 m=24 par=24
XMpar9 a_8212_15665.t13 a_8212_15665.t12 vss.t1 vss.t0 nfet_03v3 w=0.4u l=0.56u ad=1.1200e-13 pd=9.6000e-07 as=1.1200e-13 ps=9.6000e-07 nf=1 m=6 par=6
XMpar10 a_8226_19105.t24 a_10246_4351.t6 vdd.t21 vdd.t20 pfet_03v3 w=2.38u l=0.39u ad=9.2027e-13 pd=3.9467e-06 as=6.6640e-13 ps=2.9400e-06 nf=1 m=6 par=6
XMpar11 a_8164_12447.t0 inn.t0 a_8226_10829.t0 vss.t6 nfet_03v3 w=1.81u l=0.28u ad=7.7830e-13 pd=2.6700e-06 as=1.0679e-12 ps=3.8950e-06 nf=1 m=4 par=4
XMpar12 a_8044_12656.t8 inp.t0 a_8226_10829.t0 vss.t6 nfet_03v3 w=1.81u l=0.28u ad=7.7830e-13 pd=2.6700e-06 as=1.0679e-12 ps=3.8950e-06 nf=1 m=4 par=4
XMpar13 a_8044_12656.t0 a_8164_12447.t6 vdd.t1 vdd.t0 pfet_03v3 w=8.41u l=0.6u ad=3.2519e-12 pd=1.1987e-05 as=2.3548e-12 ps=8.9700e-06 nf=1 m=6 par=6
XMpar14 a_8092_17444.t0 inp.t4 a_8226_19105.t0 vdd.t24 pfet_03v3 w=1.87u l=0.28u ad=8.0410e-13 pd=2.7300e-06 as=1.1033e-12 ps=3.9850e-06 nf=1 m=12 par=12
XMpar15 a_10246_4351.t7 a_10246_4351.t6 vdd.t21 vdd.t20 pfet_03v3 w=2.38u l=0.39u ad=6.6640e-13 pd=2.9400e-06 as=6.6640e-13 ps=2.9400e-06 nf=1 m=6 par=6
XMpar16 ib.t1 ib.t0 vss.t27 vss.t26 nfet_03v3 w=0.72u l=0.39u ad=2.0160e-13 pd=1.2800e-06 as=2.0160e-13 ps=1.2800e-06 nf=1 m=6 par=6
X38 a_17599_1290.t1 out.t12 cap_mim_2f0fF c_width=18.91u c_length=18.91u
X55 a_17599_1290.t1 out.t12 cap_mim_2f0fF c_width=18.91u c_length=18.91u
X61 a_8044_12656.t14 a_17599_1290.t0 vss.t103 ppolyf_u_1k r_width=1u r_length=2.49u
X108 a_17599_1290.t1 out.t12 cap_mim_2f0fF c_width=18.91u c_length=18.91u
X120 a_17599_1290.t1 out.t12 cap_mim_2f0fF c_width=18.91u c_length=18.91u
Rpar0 a_10246_4351.t0 a_10246_4351.t6 186.3943
Rpar1 a_10246_4351.t0 a_10246_4351.t7 44.7193
Rpar2 a_10246_4351.t6 a_10246_4351.t7 19.2794
Rpar3 a_17599_1290.t0 a_17599_1290.t1 148.8279
Rpar4 a_8044_12656.t0 a_8044_12656.t8 170.0266
Rpar5 a_8044_12656.t0 a_8044_12656.t14 1582.6855
Rpar6 a_8044_12656.t0 a_8044_12656.t17 851.7983
Rpar7 a_8044_12656.t0 a_8044_12656.t2 75.9596
Rpar8 a_8044_12656.t8 a_8044_12656.t14 419.2404
Rpar9 a_8044_12656.t8 a_8044_12656.t17 225.6344
Rpar10 a_8044_12656.t8 a_8044_12656.t2 61.1234
Rpar11 a_8044_12656.t14 a_8044_12656.t17 59.8328
Rpar12 a_8044_12656.t14 a_8044_12656.t2 568.9642
Rpar13 a_8044_12656.t17 a_8044_12656.t2 306.2155
Rpar14 a_8092_17444.t0 a_8092_17444.t12 178.0583
Rpar15 a_8092_17444.t0 a_8092_17444.t13 63.2318
Rpar16 a_8092_17444.t12 a_8092_17444.t13 17.4396
Rpar17 a_8164_12447.t0 a_8164_12447.t6 926.3026
Rpar18 a_8164_12447.t0 a_8164_12447.t7 82.1038
Rpar19 a_8164_12447.t0 a_8164_12447.t4 179.7640
Rpar20 a_8164_12447.t6 a_8164_12447.t7 21.4906
Rpar21 a_8164_12447.t6 a_8164_12447.t4 929.1859
Rpar22 a_8164_12447.t7 a_8164_12447.t4 82.3593
Rpar23 a_8212_15665.t0 a_8212_15665.t12 214.9327
Rpar24 a_8212_15665.t0 a_8212_15665.t13 65.7504
Rpar25 a_8212_15665.t12 a_8212_15665.t13 18.9848
Rpar26 a_8226_10829.t0 a_8226_10829.t4 55.5569
Rpar27 a_8226_19105.t0 a_8226_19105.t24 46.7729
Rpar28 ib ib.t0 5.2119
Rpar29 ib ib.t1 160.6117
Rpar30 ib.t0 ib.t1 9.2234
Rpar31 inn inn.t0 14.1136
Rpar32 inn inn.t4 44.0362
Rpar33 inp inp.t0 14.1622
Rpar34 inp inp.t4 43.9876
Rpar35 out out.t0 3.1077
Rpar36 out out.t1 476.2738
Rpar37 out out.t12 1798.6708
Rpar38 out.t0 out.t1 84.0968
Rpar39 out.t0 out.t12 317.5954
Rpar40 out.t1 out.t12 62.8715
Rpar41 vdd vdd.t0 157.5195
Rpar42 vdd vdd.t1 957.4937
Rpar43 vdd vdd.t24 22.1292
Rpar44 vdd.t0 vdd.t1 2.3709
Rpar45 vdd.t0 vdd.t20 51.8893
Rpar46 vdd.t0 vdd.t21 83.3242
Rpar47 vdd.t0 vdd.t24 186.2360
Rpar48 vdd.t1 vdd.t20 483.5001
Rpar49 vdd.t1 vdd.t21 776.4084
Rpar50 vdd.t1 vdd.t24 1132.0490
Rpar51 vdd.t20 vdd.t21 4.5963
Rpar52 vss vss.t0 4383.8272
Rpar53 vss vss.t1 5760.2793
Rpar54 vss vss.t103 121.1074
Rpar55 vss vss.t26 418.3793
Rpar56 vss vss.t27 116.0941
Rpar57 vss vss.t6 834.5002
Rpar58 vss.t0 vss.t1 3.5013
Rpar59 vss.t0 vss.t103 7719.5480
Rpar60 vss.t0 vss.t26 699.1421
Rpar61 vss.t0 vss.t27 411.0976
Rpar62 vss.t0 vss.t6 174.6209
Rpar63 vss.t1 vss.t103 10143.3644
Rpar64 vss.t1 vss.t26 918.9628
Rpar65 vss.t1 vss.t27 540.1765
Rpar66 vss.t1 vss.t6 229.4680
Rpar67 vss.t103 vss.t26 600.1217
Rpar68 vss.t103 vss.t27 202.8826
Rpar69 vss.t103 vss.t6 1453.2182
Rpar70 vss.t26 vss.t27 5.7302
Rpar71 vss.t26 vss.t6 88.3399
Rpar72 vss.t27 vss.t6 61.9598
Cpar0 a_10246_4351.t0 vss 2.33139e-15
Cpar1 a_10246_4351.t6 vss 6.17856e-15
Cpar2 a_10246_4351.t7 vss 5.85222e-15
Cpar3 a_17599_1290.t0 vss 2.14360e-16
Cpar4 a_17599_1290.t1 vss 1.71353e-14
Cpar5 a_8044_12656.t0 vss 1.05561e-14
Cpar6 a_8044_12656.t14 vss 3.59005e-15
Cpar7 a_8044_12656.t17 vss 2.43157e-14
Cpar8 a_8044_12656.t2 vss 5.60800e-15
Cpar9 a_8044_12656.t8 vss 4.80150e-15
Cpar10 a_8092_17444.t0 vss 8.28069e-15
Cpar11 a_8092_17444.t12 vss 4.37496e-15
Cpar12 a_8092_17444.t13 vss 2.92682e-15
Cpar13 a_8164_12447.t0 vss 2.84775e-15
Cpar14 a_8164_12447.t4 vss 3.38143e-15
Cpar15 a_8164_12447.t6 vss 1.29212e-14
Cpar16 a_8164_12447.t7 vss 1.21349e-14
Cpar17 a_8212_15665.t0 vss 9.78430e-15
Cpar18 a_8212_15665.t12 vss 5.06093e-15
Cpar19 a_8212_15665.t13 vss 3.64527e-15
Cpar20 a_8226_10829.t0 vss 3.77462e-15
Cpar21 a_8226_10829.t4 vss 8.15916e-15
Cpar22 a_8226_19105.t0 vss 2.63275e-14
Cpar23 a_8226_19105.t24 vss 1.08534e-14
Cpar24 ib inn 3.04300e-17
Cpar25 ib out 8.85810e-15
Cpar26 ib vdd 2.36166e-15
Cpar27 ib vss 3.75872e-14
Cpar28 ib.t0 vss 9.63399e-15
Cpar29 ib.t1 vss 4.16745e-15
Cpar30 inn inp 2.01210e-16
Cpar31 inn vdd 6.46102e-15
Cpar32 inn vss 1.02833e-14
Cpar33 inn.t0 vss 5.41995e-16
Cpar34 inn.t4 vss 9.88060e-15
Cpar35 inp out 2.25100e-17
Cpar36 inp vdd 6.31321e-15
Cpar37 inp vss 8.90558e-15
Cpar38 inp.t0 vss 5.41442e-16
Cpar39 inp.t4 vss 9.78918e-15
Cpar40 out vdd 3.38023e-14
Cpar41 out vss 2.34338e-14
Cpar42 out.t0 vss 5.44326e-15
Cpar43 out.t1 vss 2.23507e-14
Cpar44 out.t12 vss 3.46099e-14
Cpar45 vdd vss 1.85131e-13
Cpar46 vdd.t0 vss 5.21709e-14
Cpar47 vdd.t1 vss 2.25420e-14
Cpar48 vdd.t20 vss 8.97385e-15
Cpar49 vdd.t21 vss 4.65867e-15
Cpar50 vdd.t24 vss 2.70421e-14
.ends opamp_dut

Vdd vdd 0 1.800000
Vss vss 0 0
Ibias vdd ib 1.312500e-05
Vinp inp 0 DC 0.895000 AC 1 PWL(0 0.895000 8.300097e-09 0.895000 9.130107e-09 0.905000)
Rfb out inn 1m
Cload out 0 2.000000e-12
Xdut vdd vss inp inn out ib opamp_dut
.end
