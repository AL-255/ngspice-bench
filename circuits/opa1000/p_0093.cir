* opa1000[0093]: 200f/current_reuse_1v8_i2u_subth (current_reuse, VDD=1.8V, CL=0.2pF, Iref=0.2429uA)
.include "pdk_opa.inc"
.temp 27
.option gmin=1e-12 rshunt=1e12 reltol=1e-3 abstol=1e-12 vntol=1e-5 method=gear
* Post-PEX R+C extracted netlist for current_reuse_1v8_i2u_subth
.subckt opamp_dut vdd vss inp inn out ib
XMpar0 out.t3 a_762_9115.t22 vdd.t1 vdd.t0 pfet_03v3 w=5.72u l=2.03u ad=1.9677e-12 pd=7.5520e-06 as=1.9677e-12 ps=7.5520e-06 nf=1 m=10 par=10
XMpar1 a_2966_4450.t0 inn.t14 a_3590_6212.t2 vss.t2 nfet_03v3 w=1.63u l=2.85u ad=6.3027e-13 pd=2.9467e-06 as=4.5640e-13 ps=2.1900e-06 nf=1 m=6 par=6
XMpar2 a_2284_1339.t0 a_3590_6212.t0 vdd.t1 vdd.t0 pfet_03v3 w=5.72u l=2.03u ad=1.6016e-12 pd=6.2800e-06 as=3.4320e-12 ps=1.2640e-05 nf=1 m=2 par=2
XMpar3 out.t0 ib.t0 vss.t12 vss.t11 nfet_03v3 w=0.7u l=2.08u ad=2.4080e-13 pd=1.5280e-06 as=1.9600e-13 ps=1.2600e-06 nf=1 m=10 par=10
XMpar4 a_2284_1339.t1 inn.t0 a_3590_6212.t8 vdd.t6 pfet_03v3 w=1.9u l=2.85u ad=6.1886e-13 pd=2.8229e-06 as=6.1886e-13 ps=2.8229e-06 nf=1 m=14 par=14
XMpar5 a_2966_4450.t0 inp.t14 a_762_9115.t0 vss.t2 nfet_03v3 w=1.63u l=2.85u ad=6.3027e-13 pd=2.9467e-06 as=4.5640e-13 ps=2.1900e-06 nf=1 m=6 par=6
XMpar6 a_2284_1339.t1 inp.t0 a_762_9115.t6 vdd.t6 pfet_03v3 w=1.9u l=2.85u ad=6.1886e-13 pd=2.8229e-06 as=6.1886e-13 ps=2.8229e-06 nf=1 m=14 par=14
XMpar7 a_2966_4450.t6 ib.t0 vss.t12 vss.t11 nfet_03v3 w=0.7u l=2.08u ad=1.9600e-13 pd=1.2600e-06 as=1.9600e-13 ps=1.2600e-06 nf=1 m=4 par=4
XMpar8 ib.t1 ib.t0 vss.t12 vss.t11 nfet_03v3 w=0.7u l=2.08u ad=1.9600e-13 pd=1.2600e-06 as=1.9600e-13 ps=1.2600e-06 nf=1 m=2 par=2
XMpar9 a_762_9115.t21 a_3590_6212.t0 vdd.t1 vdd.t0 pfet_03v3 w=5.72u l=2.03u ad=3.4320e-12 pd=1.2640e-05 as=1.6016e-12 ps=6.2800e-06 nf=1 m=1
XMpar10 a_3590_6212.t1 a_3590_6212.t0 vdd.t1 vdd.t0 pfet_03v3 w=5.72u l=2.03u ad=3.4320e-12 pd=1.2640e-05 as=1.6016e-12 ps=6.2800e-06 nf=1 m=1
X23 a_762_9635.t0 a_4406_9115.t0 vss.t0 ppolyf_u_1k r_width=1u r_length=17.56u
X29 a_762_10675.t0 a_4406_11195.t0 vss.t0 ppolyf_u_1k r_width=1u r_length=17.56u
X32 a_762_9115.t20 a_4406_9115.t0 vss.t0 ppolyf_u_1k r_width=1u r_length=17.56u
X35 a_762_10675.t0 a_4406_10155.t0 vss.t0 ppolyf_u_1k r_width=1u r_length=17.56u
X50 a_762_9635.t0 a_4406_10155.t0 vss.t0 ppolyf_u_1k r_width=1u r_length=17.56u
X74 a_4406_11195.t1 out.t12 cap_mim_2f0fF c_width=17.43u c_length=17.43u
Rpar0 a_2284_1339.t0 a_2284_1339.t1 63.6598
Rpar1 a_2966_4450.t0 a_2966_4450.t6 121.0124
Rpar2 a_3590_6212.t0 a_3590_6212.t1 23.9704
Rpar3 a_3590_6212.t0 a_3590_6212.t8 268.3363
Rpar4 a_3590_6212.t0 a_3590_6212.t2 286.7249
Rpar5 a_3590_6212.t1 a_3590_6212.t8 419.3731
Rpar6 a_3590_6212.t1 a_3590_6212.t2 448.1120
Rpar7 a_3590_6212.t8 a_3590_6212.t2 43.0579
Rpar8 a_4406_11195.t0 a_4406_11195.t1 79.3941
Rpar9 a_762_9115.t0 a_762_9115.t6 95.1400
Rpar10 a_762_9115.t0 a_762_9115.t20 277.5976
Rpar11 a_762_9115.t0 a_762_9115.t21 101.1971
Rpar12 a_762_9115.t0 a_762_9115.t22 118.1456
Rpar13 a_762_9115.t6 a_762_9115.t20 1051.6716
Rpar14 a_762_9115.t6 a_762_9115.t21 383.3827
Rpar15 a_762_9115.t6 a_762_9115.t22 447.5916
Rpar16 a_762_9115.t20 a_762_9115.t21 232.5385
Rpar17 a_762_9115.t20 a_762_9115.t22 69.3364
Rpar18 a_762_9115.t21 a_762_9115.t22 98.9684
Rpar19 ib ib.t0 10.9739
Rpar20 ib ib.t1 16.6589
Rpar21 inn inn.t0 41.6168
Rpar22 inn inn.t14 1.5654
Rpar23 inp inp.t0 41.5682
Rpar24 inp inp.t14 1.6140
Rpar25 out out.t0 388.6917
Rpar26 out out.t3 2.7633
Rpar27 out out.t12 653.2718
Rpar28 out.t0 out.t3 49.5497
Rpar29 out.t0 out.t12 153.6990
Rpar30 out.t3 out.t12 83.2779
Rpar31 vdd vdd.t0 469.1594
Rpar32 vdd vdd.t1 84.6750
Rpar33 vdd vdd.t6 153.0270
Rpar34 vdd.t0 vdd.t1 5.0981
Rpar35 vdd.t0 vdd.t6 169.4281
Rpar36 vdd.t1 vdd.t6 84.8077
Rpar37 vss vss.t0 188.6073
Rpar38 vss vss.t11 243.1524
Rpar39 vss vss.t12 597.4377
Rpar40 vss vss.t2 129.5424
Rpar41 vss.t0 vss.t11 154.1399
Rpar42 vss.t0 vss.t12 425.0965
Rpar43 vss.t0 vss.t2 74.9105
Rpar44 vss.t11 vss.t12 10.5330
Rpar45 vss.t11 vss.t2 3.1688
Rpar46 vss.t12 vss.t2 13.7649
Cpar0 a_2284_1339.t0 vss 4.96669e-15
Cpar1 a_2284_1339.t1 vss 2.47504e-14
Cpar2 a_2966_4450.t0 vss 1.16657e-14
Cpar3 a_2966_4450.t6 vss 1.00271e-14
Cpar4 a_3590_6212.t0 vss 1.36605e-14
Cpar5 a_3590_6212.t1 vss 5.11421e-15
Cpar6 a_3590_6212.t2 vss 5.21508e-15
Cpar7 a_3590_6212.t8 vss 1.25382e-14
Cpar8 a_4406_10155.t0 vss 4.18200e-17
Cpar9 a_4406_11195.t0 vss 1.38820e-16
Cpar10 a_4406_11195.t1 vss 3.37741e-15
Cpar11 a_4406_9115.t0 vss 3.82400e-17
Cpar12 a_762_10675.t0 vss 2.87400e-17
Cpar13 a_762_9115.t0 vss 4.13951e-15
Cpar14 a_762_9115.t20 vss 2.41974e-15
Cpar15 a_762_9115.t21 vss 3.46277e-15
Cpar16 a_762_9115.t22 vss 2.55711e-14
Cpar17 a_762_9115.t6 vss 9.99186e-15
Cpar18 a_762_9635.t0 vss 3.34400e-17
Cpar19 ib out 9.32640e-16
Cpar20 ib vdd 2.26130e-16
Cpar21 ib vss 2.68992e-14
Cpar22 ib.t0 vss 4.09279e-15
Cpar23 ib.t1 vss 2.21123e-16
Cpar24 inn inp 1.54400e-16
Cpar25 inn vdd 1.83823e-14
Cpar26 inn vss 1.39126e-14
Cpar27 inn.t0 vss 2.09609e-14
Cpar28 inn.t14 vss 5.02656e-15
Cpar29 inp vdd 1.84450e-14
Cpar30 inp vss 1.40561e-14
Cpar31 inp.t0 vss 2.09962e-14
Cpar32 inp.t14 vss 5.11948e-15
Cpar33 out vdd 1.31730e-14
Cpar34 out vss 1.46534e-14
Cpar35 out.t0 vss 4.28624e-15
Cpar36 out.t12 vss 9.75753e-15
Cpar37 out.t3 vss 9.12624e-15
Cpar38 vdd vss 2.00007e-13
Cpar39 vdd.t0 vss 2.93523e-14
Cpar40 vdd.t1 vss 1.66136e-14
Cpar41 vdd.t6 vss 4.59706e-14
.ends opamp_dut

Vdd vdd 0 1.800000
Vss vss 0 0
Ibias vdd ib 2.429000e-07
Vinp inp 0 DC 0.895000 AC 1 PWL(0 0.895000 4.954629e-08 0.895000 5.450092e-08 0.905000)
Rfb out inn 1m
Cload out 0 2.000000e-13
Xdut vdd vss inp inn out ib opamp_dut
.end
