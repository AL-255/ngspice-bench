* opa1000[0251]: 200f/folded_cascode_pmos_1v8_ulp_lt0p1uw_subth (folded_cascode_pmos, VDD=1.8V, CL=0.2pF, Iref=0.002uA)
.include "pdk_opa.inc"
.temp 27
.option gmin=1e-12 rshunt=1e12 reltol=1e-3 abstol=1e-12 vntol=1e-5 method=gear
* Post-PEX R+C extracted netlist for folded_cascode_pmos_1v8_ulp_lt0p1uw_subth
.subckt opamp_dut vdd vss inp inn out ib
XMpar0 a_2770_10434.t2 inp.t0 a_2990_1250.t4 vdd.t8 pfet_03v3 w=8u l=5u ad=3.5200e-12 pd=1.2880e-05 as=2.2400e-12 ps=8.5600e-06 nf=1 m=8 par=8
XMpar1 ib.t1 ib.t0 vss.t1 vss.t0 nfet_03v3 w=0.4u l=6.5u ad=2.4000e-13 pd=2.0000e-06 as=1.1200e-13 ps=9.6000e-07 nf=1 m=2 par=2
XMpar2 a_2990_1250.t0 ib.t0 vss.t1 vss.t0 nfet_03v3 w=0.4u l=6.5u ad=1.1200e-13 pd=9.6000e-07 as=1.7600e-13 ps=1.4800e-06 nf=1 m=4 par=4
XMpar3 a_2770_10434.t0 a_1300_15552.t2 vdd.t1 vdd.t0 pfet_03v3 w=0.4u l=9.5u ad=1.1200e-13 pd=9.6000e-07 as=1.7600e-13 ps=1.4800e-06 nf=1 m=4 par=4
XMpar4 a_1300_15552.t0 ib.t0 vss.t1 vss.t0 nfet_03v3 w=0.4u l=6.5u ad=1.1200e-13 pd=9.6000e-07 as=1.1200e-13 ps=9.6000e-07 nf=1 m=2 par=2
XMpar5 a_2770_10434.t2 inn.t0 a_7534_7362.t5 vdd.t8 pfet_03v3 w=8u l=5u ad=3.5200e-12 pd=1.2880e-05 as=2.2400e-12 ps=8.5600e-06 nf=1 m=8 par=8
XMpar6 a_7534_7362.t0 ib.t0 vss.t1 vss.t0 nfet_03v3 w=0.4u l=6.5u ad=1.1200e-13 pd=9.6000e-07 as=1.7600e-13 ps=1.4800e-06 nf=1 m=4 par=4
XMpar7 a_2990_1250.t12 a_1300_15552.t6 a_3492_8818.t0 vss.t24 nfet_03v3 w=0.4u l=4u ad=2.4000e-13 pd=2.0000e-06 as=1.1200e-13 ps=9.6000e-07 nf=1 m=2 par=2
XMpar8 a_7534_7362.t4 a_1300_15552.t6 out.t0 vss.t24 nfet_03v3 w=0.4u l=4u ad=2.4000e-13 pd=2.0000e-06 as=1.1200e-13 ps=9.6000e-07 nf=1 m=2 par=2
XMpar9 a_3492_8818.t3 a_3492_8818.t2 vdd.t1 vdd.t0 pfet_03v3 w=0.4u l=9.5u ad=2.4000e-13 pd=2.0000e-06 as=1.1200e-13 ps=9.6000e-07 nf=1 m=2 par=2
XMpar10 out.t1 a_3492_8818.t2 vdd.t1 vdd.t0 pfet_03v3 w=0.4u l=9.5u ad=1.1200e-13 pd=9.6000e-07 as=1.1200e-13 ps=9.6000e-07 nf=1 m=2 par=2
XMpar11 a_1300_15552.t3 a_1300_15552.t2 vdd.t1 vdd.t0 pfet_03v3 w=0.4u l=9.5u ad=1.1200e-13 pd=9.6000e-07 as=1.1200e-13 ps=9.6000e-07 nf=1 m=2 par=2
X22 out.t4 vss.t25 cap_mim_2f0fF c_width=14.82u c_length=14.81u
X33 out.t4 vss.t25 cap_mim_2f0fF c_width=14.82u c_length=14.81u
Rpar0 a_1300_15552.t0 a_1300_15552.t2 173.2770
Rpar1 a_1300_15552.t0 a_1300_15552.t3 278.5744
Rpar2 a_1300_15552.t0 a_1300_15552.t6 75.7666
Rpar3 a_1300_15552.t2 a_1300_15552.t3 35.3043
Rpar4 a_1300_15552.t2 a_1300_15552.t6 128.4173
Rpar5 a_1300_15552.t3 a_1300_15552.t6 206.4543
Rpar6 a_2770_10434.t0 a_2770_10434.t2 51.1920
Rpar7 a_2990_1250.t0 a_2990_1250.t4 125.1506
Rpar8 a_2990_1250.t0 a_2990_1250.t12 93.2061
Rpar9 a_2990_1250.t4 a_2990_1250.t12 81.2625
Rpar10 a_3492_8818.t0 a_3492_8818.t2 116.1275
Rpar11 a_3492_8818.t0 a_3492_8818.t3 88.7636
Rpar12 a_3492_8818.t2 a_3492_8818.t3 22.9186
Rpar13 a_7534_7362.t0 a_7534_7362.t5 125.1506
Rpar14 a_7534_7362.t0 a_7534_7362.t4 93.2061
Rpar15 a_7534_7362.t5 a_7534_7362.t4 81.2625
Rpar16 ib ib.t0 8.9309
Rpar17 ib ib.t1 8.8697
Rpar18 inn inn.t0 2.8782
Rpar19 inp inp.t0 2.8782
Rpar20 out out.t0 150.1336
Rpar21 out out.t1 108.2831
Rpar22 out out.t4 17.2464
Rpar23 out.t0 out.t1 86.5588
Rpar24 out.t0 out.t4 744.9497
Rpar25 out.t1 out.t4 537.2910
Rpar26 vdd vdd.t0 51.4522
Rpar27 vdd vdd.t1 105.6511
Rpar28 vdd vdd.t8 182.9463
Rpar29 vdd.t0 vdd.t1 6.1240
Rpar30 vdd.t0 vdd.t8 42.7280
Rpar31 vdd.t1 vdd.t8 98.6925
Rpar32 vss vss.t0 97.6297
Rpar33 vss vss.t1 73.0273
Rpar34 vss vss.t24 274.8389
Rpar35 vss vss.t25 749.4121
Rpar36 vss.t0 vss.t1 5.7714
Rpar37 vss.t0 vss.t24 2.5942
Rpar38 vss.t0 vss.t25 64.8107
Rpar39 vss.t1 vss.t24 19.1927
Rpar40 vss.t1 vss.t25 289.2490
Rpar41 vss.t24 vss.t25 148.1294
Cpar0 a_1300_15552.t0 vss 4.95445e-15
Cpar1 a_1300_15552.t2 vss 2.67270e-14
Cpar2 a_1300_15552.t3 vss 5.14132e-15
Cpar3 a_1300_15552.t6 vss 1.15501e-14
Cpar4 a_2770_10434.t0 vss 5.98533e-15
Cpar5 a_2770_10434.t2 vss 3.88349e-14
Cpar6 a_2990_1250.t0 vss 5.14799e-15
Cpar7 a_2990_1250.t12 vss 4.19126e-15
Cpar8 a_2990_1250.t4 vss 1.62437e-14
Cpar9 a_3492_8818.t0 vss 3.00491e-15
Cpar10 a_3492_8818.t2 vss 2.16478e-14
Cpar11 a_3492_8818.t3 vss 5.56998e-15
Cpar12 a_7534_7362.t0 vss 4.47197e-15
Cpar13 a_7534_7362.t4 vss 3.64087e-15
Cpar14 a_7534_7362.t5 vss 1.41107e-14
Cpar15 ib vss 4.84182e-14
Cpar16 ib.t0 vss 3.89301e-15
Cpar17 ib.t1 vss 6.73800e-17
Cpar18 inn inp 1.02790e-16
Cpar19 inn out 1.24900e-17
Cpar20 inn vdd 1.71670e-14
Cpar21 inn vss 5.09940e-15
Cpar22 inn.t0 vss 2.52774e-14
Cpar23 inp vdd 1.77702e-14
Cpar24 inp vss 5.21051e-15
Cpar25 inp.t0 vss 2.57322e-14
Cpar26 out vdd 4.84209e-15
Cpar27 out vss 1.69766e-14
Cpar28 out.t0 vss 1.89401e-16
Cpar29 out.t1 vss 2.91703e-16
Cpar30 out.t4 vss 1.06488e-14
Cpar31 vdd vss 2.80799e-13
Cpar32 vdd.t0 vss 3.28105e-14
Cpar33 vdd.t1 vss 1.48382e-14
Cpar34 vdd.t8 vss 6.92647e-14
.ends opamp_dut

Vdd vdd 0 1.800000
Vss vss 0 0
Ibias vdd ib 2.000000e-09
Vinp inp 0 DC 0.751000 AC 1 PWL(0 0.751000 1.242638e-05 0.751000 1.366901e-05 0.761000)
Rfb out inn 1m
Cload out 0 2.000000e-13
Xdut vdd vss inp inn out ib opamp_dut
.end
