* opa1000[0647]: 2p/pmos_miller_3v3_i50n_weak (pmos_miller, VDD=3.3V, CL=2.0pF, Iref=0.0066uA)
.include "pdk_opa.inc"
.temp 27
.option gmin=1e-12 rshunt=1e12 reltol=1e-3 abstol=1e-12 vntol=1e-5 method=gear
* Post-PEX R+C extracted netlist for pmos_miller_3v3_i50n_weak
.subckt opamp_dut vdd vss inp inn out ib
XMpar0 out.t0 a_3831_8985.t2 vdd.t1 vdd.t0 pfet_03v3 w=0.4u l=5u ad=1.8880e-13 pd=1.5840e-06 as=1.6320e-13 ps=1.3760e-06 nf=1 m=10 par=10
XMpar1 out.t1 a_1708_1086.t5 vss.t2 vss.t1 nfet_03v3 w=0.4u l=4u ad=1.3760e-13 pd=1.1680e-06 as=1.3760e-13 ps=1.1680e-06 nf=1 m=10 par=10
XMpar2 ib.t1 ib.t0 vss.t6 vss.t5 nfet_03v3 w=0.4u l=5u ad=2.4000e-13 pd=2.0000e-06 as=1.1200e-13 ps=9.6000e-07 nf=1 m=2 par=2
XMpar3 a_3831_8985.t3 a_3831_8985.t2 vdd.t1 vdd.t0 pfet_03v3 w=0.4u l=5u ad=2.4000e-13 pd=2.0000e-06 as=1.1200e-13 ps=9.6000e-07 nf=1 m=2 par=2
XMpar4 a_6194_10825.t0 a_3831_8985.t2 vdd.t1 vdd.t0 pfet_03v3 w=0.4u l=5u ad=2.4000e-13 pd=2.0000e-06 as=1.1200e-13 ps=9.6000e-07 nf=1 m=4 par=4
XMpar5 a_3831_8985.t0 ib.t0 vss.t6 vss.t5 nfet_03v3 w=0.4u l=5u ad=2.4000e-13 pd=2.0000e-06 as=1.1200e-13 ps=9.6000e-07 nf=1 m=2 par=2
XMpar6 a_1708_1086.t2 a_7092_8866.t0 vss.t2 vss.t1 nfet_03v3 w=0.4u l=4u ad=2.4000e-13 pd=2.0000e-06 as=1.1200e-13 ps=9.6000e-07 nf=1 m=2 par=2
XMpar7 a_7092_8866.t1 a_7092_8866.t0 vss.t2 vss.t1 nfet_03v3 w=0.4u l=4u ad=1.1200e-13 pd=9.6000e-07 as=1.1200e-13 ps=9.6000e-07 nf=1 m=2 par=2
XMpar8 a_6194_10825.t2 inn.t0 a_7092_8866.t4 vdd.t12 pfet_03v3 w=0.4u l=5.2u ad=2.4000e-13 pd=2.0000e-06 as=1.1200e-13 ps=9.6000e-07 nf=1 m=2 par=2
XMpar9 a_1708_1086.t0 inp.t0 a_6194_10825.t2 vdd.t12 pfet_03v3 w=0.4u l=5.2u ad=1.1200e-13 pd=9.6000e-07 as=2.4000e-13 ps=2.0000e-06 nf=1 m=2 par=2
X2 a_8821_1810.t0 a_12799_1290.t0 vss.t0 ppolyf_u_1k r_width=1u r_length=19.23u
X5 a_8821_7010.t0 a_12799_7530.t0 vss.t0 ppolyf_u_1k r_width=1u r_length=19.23u
X8 a_8821_3890.t0 a_12799_4410.t0 vss.t0 ppolyf_u_1k r_width=1u r_length=19.23u
X13 a_8821_7010.t0 a_12799_6490.t0 vss.t0 ppolyf_u_1k r_width=1u r_length=19.23u
X24 a_1708_1086.t4 a_12799_1290.t0 vss.t0 ppolyf_u_1k r_width=1u r_length=19.23u
X26 a_8821_3890.t0 a_12799_3370.t0 vss.t0 ppolyf_u_1k r_width=1u r_length=19.23u
X28 a_12799_7530.t1 out.t8 cap_mim_2f0fF c_width=15.29u c_length=15.29u
X29 a_8821_5970.t0 a_12799_6490.t0 vss.t0 ppolyf_u_1k r_width=1u r_length=19.23u
X35 a_8821_2850.t0 a_12799_3370.t0 vss.t0 ppolyf_u_1k r_width=1u r_length=19.23u
X36 a_12799_7530.t1 out.t8 cap_mim_2f0fF c_width=15.29u c_length=15.29u
X38 a_8821_5970.t0 a_12799_5450.t0 vss.t0 ppolyf_u_1k r_width=1u r_length=19.23u
X39 a_8821_2850.t0 a_12799_2330.t0 vss.t0 ppolyf_u_1k r_width=1u r_length=19.23u
X44 a_8821_4930.t0 a_12799_5450.t0 vss.t0 ppolyf_u_1k r_width=1u r_length=19.23u
X45 a_8821_1810.t0 a_12799_2330.t0 vss.t0 ppolyf_u_1k r_width=1u r_length=19.23u
X52 a_8821_4930.t0 a_12799_4410.t0 vss.t0 ppolyf_u_1k r_width=1u r_length=19.23u
Rpar0 a_12799_7530.t0 a_12799_7530.t1 60.4907
Rpar1 a_1708_1086.t0 a_1708_1086.t5 399.3631
Rpar2 a_1708_1086.t0 a_1708_1086.t2 80.0306
Rpar3 a_1708_1086.t0 a_1708_1086.t4 314.4323
Rpar4 a_1708_1086.t5 a_1708_1086.t2 240.4679
Rpar5 a_1708_1086.t5 a_1708_1086.t4 80.6228
Rpar6 a_1708_1086.t2 a_1708_1086.t4 189.3287
Rpar7 a_3831_8985.t0 a_3831_8985.t2 147.7931
Rpar8 a_3831_8985.t0 a_3831_8985.t3 132.1933
Rpar9 a_3831_8985.t2 a_3831_8985.t3 17.1478
Rpar10 a_6194_10825.t0 a_6194_10825.t2 52.1481
Rpar11 a_7092_8866.t0 a_7092_8866.t1 29.8548
Rpar12 a_7092_8866.t0 a_7092_8866.t4 141.5785
Rpar13 a_7092_8866.t1 a_7092_8866.t4 141.6537
Rpar14 ib ib.t0 9.4989
Rpar15 ib ib.t1 11.8303
Rpar16 ib.t0 ib.t1 43.3729
Rpar17 inn inn.t0 3.2828
Rpar18 inp inp.t0 3.3313
Rpar19 out out.t0 189.8126
Rpar20 out out.t1 52.0555
Rpar21 out out.t8 22.5278
Rpar22 out.t0 out.t1 167.3268
Rpar23 out.t0 out.t8 1196.6582
Rpar24 out.t1 out.t8 328.1795
Rpar25 vdd vdd.t0 25.9693
Rpar26 vdd vdd.t1 286.2471
Rpar27 vdd vdd.t12 54.6314
Rpar28 vdd.t0 vdd.t1 12.9235
Rpar29 vdd.t0 vdd.t12 214.2676
Rpar30 vdd.t1 vdd.t12 2361.7658
Rpar31 vss vss.t0 103.3991
Rpar32 vss vss.t1 57.7177
Rpar33 vss vss.t6 550.2024
Rpar34 vss vss.t2 77.3448
Rpar35 vss vss.t5 919.4164
Rpar36 vss.t0 vss.t1 6.0929
Rpar37 vss.t0 vss.t6 390.8346
Rpar38 vss.t0 vss.t2 35.5290
Rpar39 vss.t0 vss.t5 417.2861
Rpar40 vss.t1 vss.t6 25.3930
Rpar41 vss.t1 vss.t2 7.5967
Rpar42 vss.t1 vss.t5 4.0170
Rpar43 vss.t6 vss.t2 135.9925
Rpar44 vss.t6 vss.t5 57.2173
Rpar45 vss.t2 vss.t5 49.0824
Cpar0 a_12799_1290.t0 vss 2.64400e-17
Cpar1 a_12799_2330.t0 vss 3.00800e-17
Cpar2 a_12799_3370.t0 vss 2.93600e-17
Cpar3 a_12799_4410.t0 vss 2.93600e-17
Cpar4 a_12799_5450.t0 vss 2.93600e-17
Cpar5 a_12799_6490.t0 vss 3.20200e-17
Cpar6 a_12799_7530.t0 vss 8.85430e-17
Cpar7 a_12799_7530.t1 vss 4.49829e-15
Cpar8 a_1708_1086.t0 vss 9.83316e-16
Cpar9 a_1708_1086.t2 vss 1.51077e-15
Cpar10 a_1708_1086.t4 vss 1.34119e-15
Cpar11 a_1708_1086.t5 vss 5.81351e-15
Cpar12 a_3831_8985.t0 vss 1.08414e-14
Cpar13 a_3831_8985.t2 vss 5.06907e-14
Cpar14 a_3831_8985.t3 vss 1.04963e-14
Cpar15 a_6194_10825.t0 vss 2.12883e-14
Cpar16 a_6194_10825.t2 vss 8.29395e-15
Cpar17 a_7092_8866.t0 vss 4.01709e-15
Cpar18 a_7092_8866.t1 vss 9.59420e-16
Cpar19 a_7092_8866.t4 vss 1.19821e-15
Cpar20 a_8821_1810.t0 vss 3.97800e-17
Cpar21 a_8821_2850.t0 vss 3.60800e-17
Cpar22 a_8821_3890.t0 vss 3.73200e-17
Cpar23 a_8821_4930.t0 vss 3.94600e-17
Cpar24 a_8821_5970.t0 vss 4.02000e-17
Cpar25 a_8821_7010.t0 vss 3.75000e-17
Cpar26 ib out 6.84300e-17
Cpar27 ib vss 1.76397e-14
Cpar28 ib.t0 vss 2.64712e-15
Cpar29 ib.t1 vss 3.29903e-16
Cpar30 inn inp 5.19700e-17
Cpar31 inn vdd 4.93991e-15
Cpar32 inn vss 3.28465e-15
Cpar33 inn.t0 vss 2.79939e-15
Cpar34 inp vdd 4.97800e-15
Cpar35 inp vss 3.27060e-15
Cpar36 inp.t0 vss 2.85712e-15
Cpar37 out vdd 1.38834e-14
Cpar38 out vss 3.67430e-14
Cpar39 out.t0 vss 9.37835e-15
Cpar40 out.t1 vss 5.65608e-15
Cpar41 out.t8 vss 1.30643e-14
Cpar42 vdd vss 1.45085e-13
Cpar43 vdd.t0 vss 5.44813e-14
Cpar44 vdd.t1 vss 8.00619e-15
Cpar45 vdd.t12 vss 1.24928e-14
.ends opamp_dut

Vdd vdd 0 3.300000
Vss vss 0 0
Ibias vdd ib 6.600000e-09
Vinp inp 0 DC 1.480000 AC 1 PWL(0 1.480000 4.601383e-06 1.480000 5.061522e-06 1.490000)
Rfb out inn 1m
Cload out 0 2.000000e-12
Xdut vdd vss inp inn out ib opamp_dut
.end
