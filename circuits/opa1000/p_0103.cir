* opa1000[0103]: 200f/current_reuse_1v8_i150u_weak (current_reuse, VDD=1.8V, CL=0.2pF, Iref=27.8571uA)
.include "pdk_opa.inc"
.temp 27
.option gmin=1e-12 rshunt=1e12 reltol=1e-3 abstol=1e-12 vntol=1e-5 method=gear
* Post-PEX R+C extracted netlist for current_reuse_1v8_i150u_weak
.subckt opamp_dut vdd vss inp inn out ib
XMpar0 a_5098_8465.t0 inn.t0 a_5728_10038.t14 vss.t0 nfet_03v3 w=1.81u l=0.28u ad=8.9414e-13 pd=3.1600e-06 as=7.7830e-13 ps=2.6700e-06 nf=1 m=10 par=10
XMpar1 out a_1161_14924.t28 vdd.t1 vdd.t0 pfet_03v3 w=6.62u l=0.4u ad=1.8536e-12 pd=7.1800e-06 as=1.9948e-12 ps=7.6640e-06 nf=1 m=30 par=30
XMpar2 a_1161_14924.t4 inp.t10 a_4186_13081.t2 vdd.t4 pfet_03v3 w=1.91u l=0.28u ad=8.2130e-13 pd=2.7700e-06 as=9.0861e-13 ps=3.1343e-06 nf=1 m=14 par=14
XMpar3 a_1161_14924.t18 inp.t0 a_5098_8465.t0 vss.t0 nfet_03v3 w=1.81u l=0.28u ad=7.7830e-13 pd=2.6700e-06 as=8.9414e-13 ps=3.1600e-06 nf=1 m=10 par=10
XMpar4 a_5098_8465.t20 ib.t0 vss.t22 vss.t0 nfet_03v3 w=1.96u l=0.52u ad=5.4880e-13 pd=2.5200e-06 as=5.4880e-13 ps=2.5200e-06 nf=1 m=12 par=12
XMpar5 out.t26 ib.t0 vss.t22 vss.t0 nfet_03v3 w=1.96u l=0.52u ad=5.4880e-13 pd=2.5200e-06 as=6.7424e-13 ps=3.0400e-06 nf=1 m=30 par=30
XMpar6 a_4186_13081.t2 inn.t10 a_5728_10038.t0 vdd.t4 pfet_03v3 w=1.91u l=0.28u ad=9.0861e-13 pd=3.1343e-06 as=8.2130e-13 ps=2.7700e-06 nf=1 m=14 par=14
XMpar7 a_5728_10038.t25 a_5728_10038.t24 vdd.t1 vdd.t0 pfet_03v3 w=6.62u l=0.4u ad=2.5597e-12 pd=9.6000e-06 as=1.8536e-12 ps=7.1800e-06 nf=1 m=3 par=3
XMpar8 a_1161_14924.t0 a_5728_10038.t24 vdd.t1 vdd.t0 pfet_03v3 w=6.62u l=0.4u ad=2.5597e-12 pd=9.6000e-06 as=1.8536e-12 ps=7.1800e-06 nf=1 m=3 par=3
XMpar9 a_4186_13081.t0 a_5728_10038.t24 vdd.t1 vdd.t0 pfet_03v3 w=6.62u l=0.4u ad=1.8536e-12 pd=7.1800e-06 as=2.5597e-12 ps=9.6000e-06 nf=1 m=6 par=6
XMpar10 ib.t1 ib.t0 vss.t22 vss.t0 nfet_03v3 w=1.96u l=0.52u ad=5.4880e-13 pd=2.5200e-06 as=7.5787e-13 ps=3.3867e-06 nf=1 m=6 par=6
X52 a_1161_14924.t3 a_1493_14924.t0 vss.t10 ppolyf_u_1k r_width=1u r_length=1u
X126 a_1493_14924.t1 out.t10 cap_mim_2f0fF c_width=17.43u c_length=17.43u
Rpar0 a_1161_14924.t0 a_1161_14924.t4 66.0416
Rpar1 a_1161_14924.t0 a_1161_14924.t18 268.5937
Rpar2 a_1161_14924.t0 a_1161_14924.t28 731.2987
Rpar3 a_1161_14924.t0 a_1161_14924.t3 337.8891
Rpar4 a_1161_14924.t4 a_1161_14924.t18 88.3902
Rpar5 a_1161_14924.t4 a_1161_14924.t28 240.6596
Rpar6 a_1161_14924.t4 a_1161_14924.t3 111.1943
Rpar7 a_1161_14924.t18 a_1161_14924.t28 60.1128
Rpar8 a_1161_14924.t18 a_1161_14924.t3 233.3184
Rpar9 a_1161_14924.t28 a_1161_14924.t3 635.2549
Rpar10 a_1493_14924.t0 a_1493_14924.t1 64.4553
Rpar11 a_4186_13081.t0 a_4186_13081.t2 53.9776
Rpar12 a_5098_8465.t0 a_5098_8465.t20 55.4116
Rpar13 a_5728_10038.t0 a_5728_10038.t14 91.3916
Rpar14 a_5728_10038.t0 a_5728_10038.t24 239.2434
Rpar15 a_5728_10038.t0 a_5728_10038.t25 61.5734
Rpar16 a_5728_10038.t14 a_5728_10038.t24 122.5653
Rpar17 a_5728_10038.t14 a_5728_10038.t25 305.3015
Rpar18 a_5728_10038.t24 a_5728_10038.t25 30.5791
Rpar19 ib ib.t0 2.5025
Rpar20 ib ib.t1 420.7299
Rpar21 ib.t0 ib.t1 16.0835
Rpar22 inn inn.t0 5.6273
Rpar23 inn inn.t10 62.1331
Rpar24 inp inp.t0 5.6759
Rpar25 inp inp.t10 45.5533
Rpar26 out out.t10 260.5598
Rpar27 out out.t26 139.6867
Rpar28 out.t10 out.t26 74.1908
Rpar29 vdd vdd.t0 114.9567
Rpar30 vdd vdd.t1 179.1866
Rpar31 vdd vdd.t4 57.7854
Rpar32 vdd.t0 vdd.t1 1.8013
Rpar33 vdd.t0 vdd.t4 4.7200
Rpar34 vdd.t1 vdd.t4 6.0057
Rpar35 vss vss.t0 69.7391
Rpar36 vss vss.t10 2187.9455
Rpar37 vss vss.t22 58.7865
Rpar38 vss.t0 vss.t10 152.8077
Rpar39 vss.t0 vss.t22 3.2542
Rpar40 vss.t10 vss.t22 1006.8443
Cpar0 a_1161_14924.t0 vss 6.43668e-15
Cpar1 a_1161_14924.t18 vss 5.94995e-15
Cpar2 a_1161_14924.t28 vss 2.30006e-14
Cpar3 a_1161_14924.t3 vss 2.08545e-15
Cpar4 a_1161_14924.t4 vss 9.47932e-15
Cpar5 a_1493_14924.t0 vss 7.82300e-17
Cpar6 a_1493_14924.t1 vss 2.19953e-15
Cpar7 a_4186_13081.t0 vss 1.00949e-14
Cpar8 a_4186_13081.t2 vss 1.97140e-14
Cpar9 a_5098_8465.t0 vss 6.71216e-15
Cpar10 a_5098_8465.t20 vss 1.26204e-14
Cpar11 a_5728_10038.t0 vss 1.06575e-14
Cpar12 a_5728_10038.t14 vss 8.07178e-15
Cpar13 a_5728_10038.t24 vss 1.13105e-14
Cpar14 a_5728_10038.t25 vss 7.76002e-15
Cpar15 ib out 5.80545e-15
Cpar16 ib vss 3.68717e-14
Cpar17 ib.t0 vss 5.06237e-15
Cpar18 ib.t1 vss 1.13874e-15
Cpar19 inn inp 9.96400e-17
Cpar20 inn out 1.21900e-17
Cpar21 inn vdd 6.99787e-15
Cpar22 inn vss 1.32375e-14
Cpar23 inn.t0 vss 9.72581e-16
Cpar24 inn.t10 vss 6.63607e-15
Cpar25 inp out 1.05166e-15
Cpar26 inp vdd 6.40837e-15
Cpar27 inp vss 1.02214e-14
Cpar28 inp.t0 vss 1.32432e-15
Cpar29 inp.t10 vss 6.99485e-15
Cpar30 out vdd 4.53566e-14
Cpar31 out vss 6.14686e-14
Cpar32 out.t10 vss 1.50307e-14
Cpar33 out.t26 vss 1.93371e-14
Cpar34 vdd vss 1.36800e-13
Cpar35 vdd.t0 vss 4.94709e-14
Cpar36 vdd.t1 vss 2.73590e-14
Cpar37 vdd.t4 vss 2.64311e-14
.ends opamp_dut

Vdd vdd 0 1.800000
Vss vss 0 0
Ibias vdd ib 2.785710e-05
Vinp inp 0 DC 0.895000 AC 1 PWL(0 0.895000 3.000000e-09 0.895000 3.300000e-09 0.905000)
Rfb out inn 1m
Cload out 0 2.000000e-13
Xdut vdd vss inp inn out ib opamp_dut
.end
