* opa1000[0940]: 200f/telescopic_pmos_3v3_i50n_weak (telescopic_pmos, VDD=3.3V, CL=0.2pF, Iref=0.01uA)
.include "pdk_opa.inc"
.temp 27
.option gmin=1e-12 rshunt=1e12 reltol=1e-3 abstol=1e-12 vntol=1e-5 method=gear
* Post-PEX R+C extracted netlist for telescopic_pmos_3v3_i50n_weak
.subckt opamp_dut vdd vss inp inn out ib
XMpar0 a_1122_2861.t5 a_1122_2861.t4 a_1342_9314.t2 vdd.t0 pfet_03v3 w=0.4u l=3.5u ad=2.4000e-13 pd=2.0000e-06 as=2.4000e-13 ps=2.0000e-06 nf=1 m=2 par=2
XMpar1 a_2615_4730.t2 a_1815_4522.t0 vdd.t4 vdd.t3 pfet_03v3 w=0.4u l=4u ad=1.1200e-13 pd=9.6000e-07 as=2.0800e-13 ps=1.7400e-06 nf=1 m=8 par=8
XMpar2 a_2430_1249.t0 a_1122_2861.t10 vss.t1 vss.t0 nfet_03v3 w=0.4u l=8.13u ad=1.1200e-13 pd=9.6000e-07 as=1.1200e-13 ps=9.6000e-07 nf=1 m=2 par=2
XMpar3 a_1002_3069.t2 a_1122_2861.t0 a_1122_2861.t1 vss.t6 nfet_03v3 w=0.4u l=3.5u ad=2.4000e-13 pd=2.0000e-06 as=2.4000e-13 ps=2.0000e-06 nf=1 m=2 par=2
XMpar4 ib.t1 ib.t0 vss.t8 vss.t7 nfet_03v3 w=0.4u l=4u ad=2.4000e-13 pd=2.0000e-06 as=1.1200e-13 ps=9.6000e-07 nf=1 m=2 par=2
XMpar5 a_1815_4522.t4 ib.t0 vss.t8 vss.t7 nfet_03v3 w=0.4u l=4u ad=2.4000e-13 pd=2.0000e-06 as=1.1200e-13 ps=9.6000e-07 nf=1 m=2 par=2
XMpar6 a_2430_1249.t2 a_1122_2861.t0 out.t1 vss.t6 nfet_03v3 w=0.4u l=3.5u ad=2.4000e-13 pd=2.0000e-06 as=1.1200e-13 ps=9.6000e-07 nf=1 m=2 par=2
XMpar7 a_1815_4522.t1 a_1815_4522.t0 vdd.t4 vdd.t3 pfet_03v3 w=0.4u l=4u ad=2.4000e-13 pd=2.0000e-06 as=1.1200e-13 ps=9.6000e-07 nf=1 m=2 par=2
XMpar8 a_2430_9314.t0 a_1122_2861.t4 out.t0 vdd.t0 pfet_03v3 w=0.4u l=3.5u ad=2.4000e-13 pd=2.0000e-06 as=1.1200e-13 ps=9.6000e-07 nf=1 m=2 par=2
XMpar9 a_2430_9314.t1 inn.t0 a_2615_4730.t0 vdd.t1 pfet_03v3 w=0.72u l=6.5u ad=2.0160e-13 pd=1.2800e-06 as=4.3200e-13 ps=2.6400e-06 nf=1 m=2 par=2
XMpar10 a_1002_3069.t0 a_1122_2861.t10 vss.t1 vss.t0 nfet_03v3 w=0.4u l=8.13u ad=2.4000e-13 pd=2.0000e-06 as=1.1200e-13 ps=9.6000e-07 nf=1 m=2 par=2
XMpar11 a_1342_9314.t0 inp.t0 a_2615_4730.t0 vdd.t1 pfet_03v3 w=0.72u l=6.5u ad=2.0160e-13 pd=1.2800e-06 as=4.3200e-13 ps=2.6400e-06 nf=1 m=2 par=2
Rpar0 a_1002_3069.t0 a_1002_3069.t2 58.0688
Rpar1 a_1122_2861.t0 a_1122_2861.t1 26.2948
Rpar2 a_1122_2861.t0 a_1122_2861.t10 97.3872
Rpar3 a_1122_2861.t0 a_1122_2861.t4 540.3138
Rpar4 a_1122_2861.t0 a_1122_2861.t5 409.8669
Rpar5 a_1122_2861.t1 a_1122_2861.t10 76.3385
Rpar6 a_1122_2861.t1 a_1122_2861.t4 423.5337
Rpar7 a_1122_2861.t1 a_1122_2861.t5 321.2808
Rpar8 a_1122_2861.t10 a_1122_2861.t4 311.3610
Rpar9 a_1122_2861.t10 a_1122_2861.t5 236.1898
Rpar10 a_1122_2861.t4 a_1122_2861.t5 23.4550
Rpar11 a_1342_9314.t0 a_1342_9314.t2 61.9075
Rpar12 a_1815_4522.t0 a_1815_4522.t1 15.5889
Rpar13 a_1815_4522.t0 a_1815_4522.t4 110.6597
Rpar14 a_1815_4522.t1 a_1815_4522.t4 118.5987
Rpar15 a_2430_1249.t0 a_2430_1249.t2 65.8393
Rpar16 a_2430_9314.t0 a_2430_9314.t1 69.9796
Rpar17 a_2615_4730.t0 a_2615_4730.t2 41.6991
Rpar18 ib ib.t0 13.1986
Rpar19 ib ib.t1 15.9676
Rpar20 ib.t0 ib.t1 28.1211
Rpar21 inn inn.t0 3.3085
Rpar22 inp inp.t0 3.3570
Rpar23 out out.t0 108.7190
Rpar24 out out.t1 15.7345
Rpar25 out.t0 out.t1 820.9144
Rpar26 vdd vdd.t0 74.4374
Rpar27 vdd vdd.t1 72.2872
Rpar28 vdd vdd.t3 153.2553
Rpar29 vdd vdd.t4 1136.2860
Rpar30 vdd.t0 vdd.t1 67.3375
Rpar31 vdd.t0 vdd.t3 142.7615
Rpar32 vdd.t0 vdd.t4 1058.4814
Rpar33 vdd.t1 vdd.t3 52.6734
Rpar34 vdd.t1 vdd.t4 390.5384
Rpar35 vdd.t3 vdd.t4 13.4480
Rpar36 vss vss.t0 95.0171
Rpar37 vss vss.t1 325.3886
Rpar38 vss vss.t7 353.2356
Rpar39 vss vss.t8 131.2696
Rpar40 vss vss.t6 79.2587
Rpar41 vss.t0 vss.t1 23.3494
Rpar42 vss.t0 vss.t7 348.1399
Rpar43 vss.t0 vss.t8 147.6890
Rpar44 vss.t0 vss.t6 6.1366
Rpar45 vss.t1 vss.t7 1026.5464
Rpar46 vss.t1 vss.t8 439.3163
Rpar47 vss.t1 vss.t6 25.6684
Rpar48 vss.t7 vss.t8 28.0504
Rpar49 vss.t7 vss.t6 348.6734
Rpar50 vss.t8 vss.t6 145.8741
Cpar0 a_1002_3069.t0 vss 4.67563e-15
Cpar1 a_1002_3069.t2 vss 3.67556e-15
Cpar2 a_1122_2861.t0 vss 4.88063e-15
Cpar3 a_1122_2861.t1 vss 1.96050e-15
Cpar4 a_1122_2861.t10 vss 9.21952e-15
Cpar5 a_1122_2861.t4 vss 4.93797e-15
Cpar6 a_1122_2861.t5 vss 2.11546e-15
Cpar7 a_1342_9314.t0 vss 3.82317e-15
Cpar8 a_1342_9314.t2 vss 5.40731e-15
Cpar9 a_1815_4522.t0 vss 2.70070e-14
Cpar10 a_1815_4522.t1 vss 5.74816e-15
Cpar11 a_1815_4522.t4 vss 6.43335e-15
Cpar12 a_2430_1249.t0 vss 5.36162e-15
Cpar13 a_2430_1249.t2 vss 5.41490e-15
Cpar14 a_2430_9314.t0 vss 6.86563e-15
Cpar15 a_2430_9314.t1 vss 5.55610e-15
Cpar16 a_2615_4730.t0 vss 8.42925e-15
Cpar17 a_2615_4730.t2 vss 1.31801e-14
Cpar18 ib out 1.49120e-16
Cpar19 ib vss 1.51501e-14
Cpar20 ib.t0 vss 2.45728e-15
Cpar21 ib.t1 vss 4.25757e-16
Cpar22 inn inp 5.16000e-17
Cpar23 inn vdd 6.01992e-15
Cpar24 inn vss 3.44600e-15
Cpar25 inn.t0 vss 3.77726e-15
Cpar26 inp vdd 6.15449e-15
Cpar27 inp vss 3.41068e-15
Cpar28 inp.t0 vss 3.93023e-15
Cpar29 out vdd 3.26566e-15
Cpar30 out vss 1.47882e-14
Cpar31 out.t0 vss 3.85272e-15
Cpar32 out.t1 vss 5.94617e-16
Cpar33 vdd vss 1.15929e-13
Cpar34 vdd.t0 vss 1.37706e-14
Cpar35 vdd.t1 vss 1.42064e-14
Cpar36 vdd.t3 vss 2.88916e-14
Cpar37 vdd.t4 vss 5.65801e-15
.ends opamp_dut

Vdd vdd 0 3.300000
Vss vss 0 0
Ibias vdd ib 1.000000e-08
Vinp inp 0 DC 1.480000 AC 1 PWL(0 1.480000 3.981696e-07 1.480000 4.379865e-07 1.490000)
Rfb out inn 1m
Cload out 0 2.000000e-13
Xdut vdd vss inp inn out ib opamp_dut
.end
