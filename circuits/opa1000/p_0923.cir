* opa1000[0923]: 200f/telescopic_pmos_1v8_0p1u_1u_subth (telescopic_pmos, VDD=1.8V, CL=0.2pF, Iref=0.095uA)
.include "pdk_opa.inc"
.temp 27
.option gmin=1e-12 rshunt=1e12 reltol=1e-3 abstol=1e-12 vntol=1e-5 method=gear
* Post-PEX R+C extracted netlist for telescopic_pmos_1v8_0p1u_1u_subth
.subckt opamp_dut vdd vss inp inn out ib
XMpar0 a_11350_17349.t0 inn.t0 a_1458_15797.t0 vdd.t12 pfet_03v3 w=4.23u l=4u ad=1.3113e-12 pd=5.2466e-06 as=1.3536e-12 ps=5.3987e-06 nf=1 m=64 par=64
XMpar1 a_2378_15797.t64 vss.t20 a_6914_12902.t4 vdd.t0 pfet_03v3 w=1.92u l=2.5u ad=6.2537e-13 pd=2.8457e-06 as=6.2537e-13 ps=2.8457e-06 nf=1 m=14 par=14
XMpar2 a_1458_15797.t0 inp.t0 a_2378_15797.t0 vdd.t12 pfet_03v3 w=4.23u l=4u ad=1.3536e-12 pd=5.3987e-06 as=1.3113e-12 ps=5.2466e-06 nf=1 m=64 par=64
XMpar3 a_11083_1086.t0 ib.t0 vss.t5 vss.t4 nfet_03v3 w=0.73u l=5u ad=2.0440e-13 pd=1.2900e-06 as=2.0440e-13 ps=1.2900e-06 nf=1 m=2 par=2
XMpar4 a_11350_17349.t64 vss.t20 out.t0 vdd.t0 pfet_03v3 w=1.92u l=2.5u ad=6.2537e-13 pd=2.8457e-06 as=6.2537e-13 ps=2.8457e-06 nf=1 m=14 par=14
XMpar5 a_6914_12902.t1 a_6914_12902.t0 a_9324_7164.t1 vss.t12 nfet_03v3 w=2.47u l=2.5u ad=1.4820e-12 pd=6.1400e-06 as=1.4820e-12 ps=6.1400e-06 nf=1 m=2 par=2
XMpar6 a_10264_10623.t1 a_6914_12902.t18 vss.t1 vss.t0 nfet_03v3 w=1.5u l=6.5u ad=9.0000e-13 pd=4.2000e-06 as=4.2000e-13 ps=2.0600e-06 nf=1 m=2 par=2
XMpar7 ib.t1 ib.t0 vss.t5 vss.t4 nfet_03v3 w=0.73u l=5u ad=4.3800e-13 pd=2.6600e-06 as=2.0440e-13 ps=1.2900e-06 nf=1 m=2 par=2
XMpar8 a_9324_7164.t0 a_6914_12902.t18 vss.t1 vss.t0 nfet_03v3 w=1.5u l=6.5u ad=9.0000e-13 pd=4.2000e-06 as=4.2000e-13 ps=2.0600e-06 nf=1 m=2 par=2
XMpar9 a_10264_10623.t0 a_6914_12902.t0 out.t14 vss.t12 nfet_03v3 w=2.47u l=2.5u ad=1.4820e-12 pd=6.1400e-06 as=6.9160e-13 ps=3.0300e-06 nf=1 m=2 par=2
XMpar10 a_1458_15797.t128 a_11083_1086.t2 vdd.t2 vdd.t1 pfet_03v3 w=3.1u l=5u ad=8.6800e-13 pd=3.6600e-06 as=1.6120e-12 ps=6.4650e-06 nf=1 m=8 par=8
XMpar11 a_11083_1086.t3 a_11083_1086.t2 vdd.t2 vdd.t1 pfet_03v3 w=3.1u l=5u ad=1.8600e-12 pd=7.4000e-06 as=8.6800e-13 ps=3.6600e-06 nf=1 m=2 par=2
X26 out.t16 vss.t2 cap_mim_2f0fF c_width=19.56u c_length=19.56u
X138 out.t16 vss.t2 cap_mim_2f0fF c_width=19.56u c_length=19.56u
Rpar0 a_10264_10623.t0 a_10264_10623.t1 42.5357
Rpar1 a_11083_1086.t0 a_11083_1086.t2 155.0187
Rpar2 a_11083_1086.t0 a_11083_1086.t3 129.0785
Rpar3 a_11083_1086.t2 a_11083_1086.t3 11.7268
Rpar4 a_11350_17349.t0 a_11350_17349.t64 54.0276
Rpar5 a_1458_15797.t0 a_1458_15797.t128 53.9566
Rpar6 a_2378_15797.t0 a_2378_15797.t64 54.0276
Rpar7 a_6914_12902.t0 a_6914_12902.t1 20.8057
Rpar8 a_6914_12902.t0 a_6914_12902.t4 326.8001
Rpar9 a_6914_12902.t0 a_6914_12902.t18 291.8340
Rpar10 a_6914_12902.t1 a_6914_12902.t4 127.9906
Rpar11 a_6914_12902.t1 a_6914_12902.t18 114.2963
Rpar12 a_6914_12902.t4 a_6914_12902.t18 95.9025
Rpar13 a_9324_7164.t0 a_9324_7164.t1 64.1355
Rpar14 ib ib.t0 19.2334
Rpar15 ib ib.t1 8.4344
Rpar16 ib.t0 ib.t1 65.3024
Rpar17 inn inn.t0 1.6908
Rpar18 inp inp.t0 1.6908
Rpar19 out out.t0 81.6136
Rpar20 out out.t14 9.4968
Rpar21 out out.t16 135.0484
Rpar22 out.t0 out.t14 449.0473
Rpar23 out.t0 out.t16 276.4417
Rpar24 out.t14 out.t16 743.0519
Rpar25 vdd vdd.t0 122.3060
Rpar26 vdd vdd.t12 19.9670
Rpar27 vdd vdd.t2 1452.5985
Rpar28 vdd.t0 vdd.t1 1492.2025
Rpar29 vdd.t0 vdd.t12 361.9356
Rpar30 vdd.t0 vdd.t2 245.8350
Rpar31 vdd.t1 vdd.t2 11.9696
Rpar32 vss vss.t0 266.7084
Rpar33 vss vss.t1 301.5489
Rpar34 vss vss.t4 151.0799
Rpar35 vss vss.t5 682.4408
Rpar36 vss vss.t12 161.2124
Rpar37 vss vss.t2 68.6228
Rpar38 vss vss.t20 115.6999
Rpar39 vss.t0 vss.t1 52.0759
Rpar40 vss.t0 vss.t4 8.7817
Rpar41 vss.t0 vss.t5 51.4018
Rpar42 vss.t0 vss.t12 6.6007
Rpar43 vss.t0 vss.t2 596.5211
Rpar44 vss.t0 vss.t20 409.9409
Rpar45 vss.t1 vss.t4 51.5314
Rpar46 vss.t1 vss.t5 328.8759
Rpar47 vss.t1 vss.t12 35.1989
Rpar48 vss.t1 vss.t2 1524.2514
Rpar49 vss.t1 vss.t20 129.2718
Rpar50 vss.t4 vss.t5 21.3496
Rpar51 vss.t4 vss.t12 4.3448
Rpar52 vss.t4 vss.t2 324.8142
Rpar53 vss.t4 vss.t20 285.5963
Rpar54 vss.t5 vss.t12 29.8598
Rpar55 vss.t5 vss.t2 1396.6975
Rpar56 vss.t5 vss.t20 1841.7636
Rpar57 vss.t12 vss.t2 361.8676
Rpar58 vss.t12 vss.t20 243.7314
Rpar59 vss.t2 vss.t20 799.3563
Cpar0 a_10264_10623.t0 vss 5.08191e-15
Cpar1 a_10264_10623.t1 vss 6.70773e-15
Cpar2 a_11083_1086.t0 vss 4.42859e-15
Cpar3 a_11083_1086.t2 vss 3.84110e-14
Cpar4 a_11083_1086.t3 vss 8.27465e-15
Cpar5 a_11350_17349.t0 vss 9.54727e-14
Cpar6 a_11350_17349.t64 vss 1.57248e-14
Cpar7 a_1458_15797.t0 vss 1.71772e-13
Cpar8 a_1458_15797.t128 vss 1.74139e-14
Cpar9 a_2378_15797.t0 vss 9.60134e-14
Cpar10 a_2378_15797.t64 vss 1.58138e-14
Cpar11 a_6914_12902.t0 vss 4.38680e-15
Cpar12 a_6914_12902.t1 vss 2.46383e-15
Cpar13 a_6914_12902.t18 vss 9.35957e-15
Cpar14 a_6914_12902.t4 vss 6.24551e-15
Cpar15 a_9324_7164.t0 vss 5.66503e-15
Cpar16 a_9324_7164.t1 vss 4.34685e-15
Cpar17 ib out 2.14700e-17
Cpar18 ib vdd 9.76600e-17
Cpar19 ib vss 1.48960e-14
Cpar20 ib.t0 vss 2.16784e-15
Cpar21 ib.t1 vss 1.41939e-16
Cpar22 inn inp 1.12310e-16
Cpar23 inn out 2.51000e-17
Cpar24 inn vdd 8.93394e-14
Cpar25 inn vss 6.16763e-15
Cpar26 inn.t0 vss 1.53912e-13
Cpar27 inp vdd 9.01410e-14
Cpar28 inp vss 6.19948e-15
Cpar29 inp.t0 vss 1.54412e-13
Cpar30 out vdd 5.96505e-15
Cpar31 out vss 2.97390e-14
Cpar32 out.t0 vss 8.03949e-16
Cpar33 out.t14 vss 9.22998e-17
Cpar34 out.t16 vss 1.81292e-14
Cpar35 vdd vss 9.36431e-13
Cpar36 vdd.t0 vss 3.44680e-14
Cpar37 vdd.t1 vss 2.93757e-14
Cpar38 vdd.t12 vss 2.30417e-13
Cpar39 vdd.t2 vss 7.89985e-15
.ends opamp_dut

Vdd vdd 0 1.800000
Vss vss 0 0
Ibias vdd ib 9.500000e-08
Vinp inp 0 DC 0.805000 AC 1 PWL(0 0.805000 2.449735e-07 0.805000 2.694708e-07 0.815000)
Rfb out inn 1m
Cload out 0 2.000000e-13
Xdut vdd vss inp inn out ib opamp_dut
.end
