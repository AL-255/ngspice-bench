* opa1000[0825]: 2p/symmetrical_ota_3v3_i10u_subth (symmetrical_ota, VDD=3.3V, CL=2.0pF, Iref=1.6667uA)
.include "pdk_opa.inc"
.temp 27
.option gmin=1e-12 rshunt=1e12 reltol=1e-3 abstol=1e-12 vntol=1e-5 method=gear
* Post-PEX R+C extracted netlist for symmetrical_ota_3v3_i10u_subth
.subckt opamp_dut vdd vss inp inn out ib
XMpar0 a_3828_9722.t1 a_3828_9722.t0 vss.t13 vss.t12 nfet_03v3 w=3.17u l=1.8u ad=8.8760e-13 pd=3.7300e-06 as=8.8760e-13 ps=3.7300e-06 nf=1 m=4 par=4
XMpar1 a_1517_1204.t0 inn.t0 a_5914_3353.t0 vss.t0 nfet_03v3 w=1.95u l=0.9u ad=6.5000e-13 pd=2.9417e-06 as=5.4600e-13 ps=2.5100e-06 nf=1 m=24 par=24
XMpar2 out.t0 a_1485_6052.t24 vdd.t1 vdd.t0 pfet_03v3 w=10u l=1.8u ad=2.8000e-12 pd=1.0560e-05 as=4.4000e-12 ps=1.5880e-05 nf=1 m=4 par=4
XMpar3 a_1485_6052.t0 inp.t0 a_1517_1204.t0 vss.t0 nfet_03v3 w=1.95u l=0.9u ad=5.4600e-13 pd=2.5100e-06 as=6.5000e-13 ps=2.9417e-06 nf=1 m=24 par=24
XMpar4 out.t3 a_3828_9722.t0 vss.t13 vss.t12 nfet_03v3 w=3.17u l=1.8u ad=8.8760e-13 pd=3.7300e-06 as=1.3948e-12 ps=5.6350e-06 nf=1 m=4 par=4
XMpar5 a_1517_1204.t48 ib.t0 vss.t31 vss.t30 nfet_03v3 w=3.29u l=1.5u ad=9.2120e-13 pd=3.8500e-06 as=1.4476e-12 ps=5.8150e-06 nf=1 m=4 par=4
XMpar6 ib.t1 ib.t0 vss.t31 vss.t30 nfet_03v3 w=3.29u l=1.5u ad=9.2120e-13 pd=3.8500e-06 as=9.2120e-13 ps=3.8500e-06 nf=1 m=2 par=2
XMpar7 a_3828_9722.t8 a_5914_3353.t24 vdd.t1 vdd.t0 pfet_03v3 w=10u l=1.8u ad=2.8000e-12 pd=1.0560e-05 as=4.4000e-12 ps=1.5880e-05 nf=1 m=4 par=4
XMpar8 a_1485_6052.t25 a_1485_6052.t24 vdd.t1 vdd.t0 pfet_03v3 w=10u l=1.8u ad=2.8000e-12 pd=1.0560e-05 as=2.8000e-12 ps=1.0560e-05 nf=1 m=2 par=2
XMpar9 a_5914_3353.t25 a_5914_3353.t24 vdd.t1 vdd.t0 pfet_03v3 w=10u l=1.8u ad=2.8000e-12 pd=1.0560e-05 as=2.8000e-12 ps=1.0560e-05 nf=1 m=2 par=2
Rpar0 a_1485_6052.t0 a_1485_6052.t24 122.2265
Rpar1 a_1485_6052.t0 a_1485_6052.t25 57.0740
Rpar2 a_1485_6052.t24 a_1485_6052.t25 27.5390
Rpar3 a_1517_1204.t0 a_1517_1204.t48 46.1805
Rpar4 a_3828_9722.t0 a_3828_9722.t1 18.3390
Rpar5 a_3828_9722.t0 a_3828_9722.t8 265.9268
Rpar6 a_3828_9722.t1 a_3828_9722.t8 60.0565
Rpar7 a_5914_3353.t0 a_5914_3353.t24 122.2265
Rpar8 a_5914_3353.t0 a_5914_3353.t25 57.0740
Rpar9 a_5914_3353.t24 a_5914_3353.t25 27.5390
Rpar10 ib ib.t0 18.2309
Rpar11 ib ib.t1 8.5229
Rpar12 ib.t0 ib.t1 105.5865
Rpar13 inn inn.t0 1.9420
Rpar14 inp inp.t0 1.9420
Rpar15 out out.t0 3.8951
Rpar16 out out.t3 71.3165
Rpar17 out.t0 out.t3 144.1172
Rpar18 vdd vdd.t0 66.5803
Rpar19 vdd vdd.t1 225.8417
Rpar20 vdd.t0 vdd.t1 3.1282
Rpar21 vss vss.t0 54.0802
Rpar22 vss vss.t12 559.2437
Rpar23 vss vss.t13 920.9036
Rpar24 vss vss.t30 154.4565
Rpar25 vss vss.t31 213.3197
Rpar26 vss.t0 vss.t12 52.1636
Rpar27 vss.t0 vss.t13 86.0701
Rpar28 vss.t0 vss.t30 1.9455
Rpar29 vss.t0 vss.t31 7.2060
Rpar30 vss.t12 vss.t13 5.5627
Rpar31 vss.t12 vss.t30 209.6820
Rpar32 vss.t12 vss.t31 608.0384
Rpar33 vss.t13 vss.t30 345.9896
Rpar34 vss.t13 vss.t31 1003.6125
Rpar35 vss.t30 vss.t31 15.3723
Cpar0 a_1485_6052.t0 vss 9.53150e-15
Cpar1 a_1485_6052.t24 vss 1.64561e-14
Cpar2 a_1485_6052.t25 vss 4.60315e-15
Cpar3 a_1517_1204.t0 vss 2.54156e-14
Cpar4 a_1517_1204.t48 vss 4.03419e-15
Cpar5 a_3828_9722.t0 vss 5.45932e-15
Cpar6 a_3828_9722.t1 vss 2.06258e-15
Cpar7 a_3828_9722.t8 vss 3.30814e-15
Cpar8 a_5914_3353.t0 vss 9.45776e-15
Cpar9 a_5914_3353.t24 vss 1.63291e-14
Cpar10 a_5914_3353.t25 vss 4.56764e-15
Cpar11 ib inp 1.49100e-17
Cpar12 ib vss 1.01272e-14
Cpar13 ib.t0 vss 1.57812e-15
Cpar14 ib.t1 vss 2.09997e-16
Cpar15 inn inp 1.02520e-16
Cpar16 inn vss 1.49480e-14
Cpar17 inn.t0 vss 5.78098e-15
Cpar18 inp vss 1.51679e-14
Cpar19 inp.t0 vss 5.83100e-15
Cpar20 out vdd 6.41794e-15
Cpar21 out vss 6.60076e-15
Cpar22 out.t0 vss 5.81812e-15
Cpar23 out.t3 vss 4.83179e-15
Cpar24 vdd vss 9.05458e-14
Cpar25 vdd.t0 vss 2.26154e-14
Cpar26 vdd.t1 vss 9.52112e-15
.ends opamp_dut

Vdd vdd 0 3.300000
Vss vss 0 0
Ibias vdd ib 1.666700e-06
Vinp inp 0 DC 1.645000 AC 1 PWL(0 1.645000 1.706865e-08 1.645000 1.877551e-08 1.655000)
Rfb out inn 1m
Cload out 0 2.000000e-12
Xdut vdd vss inp inn out ib opamp_dut
.end
