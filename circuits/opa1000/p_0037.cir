* opa1000[0037]: 200f/cherry_hooper_3v3_i150u_subth (cherry_hooper, VDD=3.3V, CL=0.2pF, Iref=7.9687uA)
.include "pdk_opa.inc"
.temp 27
.option gmin=1e-12 rshunt=1e12 reltol=1e-3 abstol=1e-12 vntol=1e-5 method=gear
* Post-PEX R+C extracted netlist for cherry_hooper_3v3_i150u_subth
.subckt opamp_dut vdd vss inp inn out ib
XMpar0 a_11746_11693.t6 inp.t0 a_7760_8226.t0 vss.t14 nfet_03v3 w=8u l=0.44u ad=2.2400e-12 pd=8.5600e-06 as=2.4000e-12 ps=9.1000e-06 nf=1 m=64 par=64
XMpar1 a_1217_21446.t0 a_1328_8316.t108 out.t0 vss.t0 nfet_03v3 w=10u l=0.44u ad=3.6000e-12 pd=1.3220e-05 as=2.8000e-12 ps=1.0560e-05 nf=1 m=16 par=16
XMpar2 a_1328_8316.t5 a_1328_8316.t4 vdd.t3 vdd.t2 pfet_03v3 w=9.37u l=0.6u ad=2.7599e-12 pd=1.0385e-05 as=2.8962e-12 ps=1.0840e-05 nf=1 m=44 par=44
XMpar3 a_1328_8316.t92 a_18374_4464.t76 a_7328_8226.t0 vss.t0 nfet_03v3 w=10u l=0.44u ad=2.8000e-12 pd=1.0560e-05 as=3.2000e-12 ps=1.1890e-05 nf=1 m=16 par=16
XMpar4 a_14946_4672.t0 a_11746_11693.t76 a_7328_8226.t0 vss.t0 nfet_03v3 w=10u l=0.44u ad=2.8000e-12 pd=1.0560e-05 as=3.2000e-12 ps=1.1890e-05 nf=1 m=16 par=16
XMpar5 a_18374_4464.t10 inn.t0 a_7760_8226.t0 vss.t14 nfet_03v3 w=8u l=0.44u ad=2.2400e-12 pd=8.5600e-06 as=2.4000e-12 ps=9.1000e-06 nf=1 m=64 par=64
XMpar6 a_7328_8226.t11 ib.t0 vss.t63 vss.t62 nfet_03v3 w=9.21u l=0.52u ad=2.5788e-12 pd=9.7700e-06 as=3.3156e-12 ps=1.2232e-05 nf=1 m=8 par=8
XMpar7 a_14946_4672.t21 a_14946_4672.t20 vdd.t3 vdd.t2 pfet_03v3 w=9.37u l=0.6u ad=2.7599e-12 pd=1.0385e-05 as=2.8962e-12 ps=1.0840e-05 nf=1 m=44 par=44
XMpar8 a_1217_21446.t0 a_14946_4672.t108 a_15666_7973.t0 vss.t0 nfet_03v3 w=10u l=0.44u ad=3.6000e-12 pd=1.3220e-05 as=2.8000e-12 ps=1.0560e-05 nf=1 m=16 par=16
XMpar9 a_4128_17730.t12 a_4128_17730.t11 vdd.t3 vdd.t2 pfet_03v3 w=9.37u l=0.6u ad=2.8962e-12 pd=1.0840e-05 as=2.8962e-12 ps=1.0840e-05 nf=1 m=11 par=11
XMpar10 a_2311_17775.t1 a_2311_17775.t0 a_4128_17730.t0 vdd.t25 pfet_03v3 w=9.84u l=0.45u ad=3.0415e-12 pd=1.1353e-05 as=3.0415e-12 ps=1.1353e-05 nf=1 m=11 par=11
XMpar11 out.t3 a_15666_7973.t4 vdd.t3 vdd.t2 pfet_03v3 w=9.37u l=0.6u ad=2.8962e-12 pd=1.0840e-05 as=2.8962e-12 ps=1.0840e-05 nf=1 m=11 par=11
XMpar12 a_1818_17775.t1 a_1818_17775.t0 vdd.t1 vdd.t0 pfet_03v3 w=9.11u l=0.52u ad=2.5508e-12 pd=9.6700e-06 as=4.0084e-12 ps=1.4545e-05 nf=1 m=4 par=4
XMpar13 a_1818_17775.t8 ib.t0 vss.t63 vss.t62 nfet_03v3 w=9.21u l=0.52u ad=5.5260e-12 pd=1.9620e-05 as=2.5788e-12 ps=9.7700e-06 nf=1 m=1
XMpar14 a_18374_4464.t0 a_1818_17775.t0 vdd.t1 vdd.t0 pfet_03v3 w=9.11u l=0.52u ad=2.5508e-12 pd=9.6700e-06 as=3.2796e-12 ps=1.2107e-05 nf=1 m=8 par=8
XMpar15 a_11746_11693.t0 a_2311_17775.t23 a_14946_4672.t16 vdd.t24 pfet_03v3 w=7.78u l=0.45u ad=2.1784e-12 pd=8.3400e-06 as=3.4232e-12 ps=1.2550e-05 nf=1 m=4 par=4
XMpar16 a_11746_11693.t1 a_1818_17775.t0 vdd.t1 vdd.t0 pfet_03v3 w=9.11u l=0.52u ad=2.5508e-12 pd=9.6700e-06 as=3.2796e-12 ps=1.2107e-05 nf=1 m=8 par=8
XMpar17 a_15666_7973.t5 a_15666_7973.t4 vdd.t3 vdd.t2 pfet_03v3 w=9.37u l=0.6u ad=2.8962e-12 pd=1.0840e-05 as=2.8962e-12 ps=1.0840e-05 nf=1 m=11 par=11
XMpar18 ib.t1 ib.t0 vss.t63 vss.t62 nfet_03v3 w=9.21u l=0.52u ad=5.5260e-12 pd=1.9620e-05 as=2.5788e-12 ps=9.7700e-06 nf=1 m=1
XMpar19 a_1217_21446.t16 ib.t0 vss.t63 vss.t62 nfet_03v3 w=9.21u l=0.52u ad=2.5788e-12 pd=9.7700e-06 as=5.5260e-12 ps=1.9620e-05 nf=1 m=2 par=2
XMpar20 a_1328_8316.t0 a_2311_17775.t23 a_18374_4464.t1 vdd.t24 pfet_03v3 w=7.78u l=0.45u ad=3.4232e-12 pd=1.2550e-05 as=2.1784e-12 ps=8.3400e-06 nf=1 m=4 par=4
XMpar21 a_7760_8226.t64 ib.t0 vss.t63 vss.t62 nfet_03v3 w=9.21u l=0.52u ad=2.5788e-12 pd=9.7700e-06 as=2.5788e-12 ps=9.7700e-06 nf=1 m=4 par=4
XMpar22 a_2311_17775.t22 ib.t0 vss.t63 vss.t62 nfet_03v3 w=9.21u l=0.52u ad=5.5260e-12 pd=1.9620e-05 as=5.5260e-12 ps=1.9620e-05 nf=1 m=1
X44 out.t27 vss.t4 cap_mim_2f0fF c_width=19.69u c_length=19.69u
X72 out.t27 vss.t4 cap_mim_2f0fF c_width=19.69u c_length=19.69u
X131 out.t27 vss.t4 cap_mim_2f0fF c_width=19.69u c_length=19.69u
X161 out.t27 vss.t4 cap_mim_2f0fF c_width=19.69u c_length=19.69u
X179 out.t27 vss.t4 cap_mim_2f0fF c_width=19.69u c_length=19.69u
X283 out.t27 vss.t4 cap_mim_2f0fF c_width=19.69u c_length=19.69u
X287 out.t27 vss.t4 cap_mim_2f0fF c_width=19.69u c_length=19.69u
X333 out.t27 vss.t4 cap_mim_2f0fF c_width=19.69u c_length=19.69u
Rpar0 a_11746_11693.t0 a_11746_11693.t1 636.1196
Rpar1 a_11746_11693.t0 a_11746_11693.t6 86.6689
Rpar2 a_11746_11693.t0 a_11746_11693.t76 457.0989
Rpar3 a_11746_11693.t1 a_11746_11693.t6 193.3218
Rpar4 a_11746_11693.t1 a_11746_11693.t76 46.0430
Rpar5 a_11746_11693.t6 a_11746_11693.t76 138.9160
Rpar6 a_1217_21446.t0 a_1217_21446.t16 58.7234
Rpar7 a_1328_8316.t0 a_1328_8316.t4 1256.2280
Rpar8 a_1328_8316.t0 a_1328_8316.t92 166.7951
Rpar9 a_1328_8316.t0 a_1328_8316.t108 83.5420
Rpar10 a_1328_8316.t0 a_1328_8316.t5 144.8089
Rpar11 a_1328_8316.t4 a_1328_8316.t92 4115.0223
Rpar12 a_1328_8316.t4 a_1328_8316.t108 3556.3609
Rpar13 a_1328_8316.t4 a_1328_8316.t5 6.3092
Rpar14 a_1328_8316.t92 a_1328_8316.t108 472.1943
Rpar15 a_1328_8316.t92 a_1328_8316.t5 474.3500
Rpar16 a_1328_8316.t108 a_1328_8316.t5 409.9516
Rpar17 a_14946_4672.t0 a_14946_4672.t20 6542.5797
Rpar18 a_14946_4672.t0 a_14946_4672.t21 754.1813
Rpar19 a_14946_4672.t0 a_14946_4672.t108 203.8498
Rpar20 a_14946_4672.t0 a_14946_4672.t16 136.3598
Rpar21 a_14946_4672.t20 a_14946_4672.t21 6.2996
Rpar22 a_14946_4672.t20 a_14946_4672.t108 2865.1813
Rpar23 a_14946_4672.t20 a_14946_4672.t16 1821.5922
Rpar24 a_14946_4672.t21 a_14946_4672.t108 330.2774
Rpar25 a_14946_4672.t21 a_14946_4672.t16 209.9800
Rpar26 a_14946_4672.t108 a_14946_4672.t16 59.7158
Rpar27 a_15666_7973.t0 a_15666_7973.t4 740.1262
Rpar28 a_15666_7973.t0 a_15666_7973.t5 119.1738
Rpar29 a_15666_7973.t4 a_15666_7973.t5 18.1700
Rpar30 a_1818_17775.t0 a_1818_17775.t1 30.7392
Rpar31 a_1818_17775.t0 a_1818_17775.t8 333.7748
Rpar32 a_1818_17775.t1 a_1818_17775.t8 111.9087
Rpar33 a_18374_4464.t0 a_18374_4464.t1 735.7880
Rpar34 a_18374_4464.t0 a_18374_4464.t10 168.2257
Rpar35 a_18374_4464.t0 a_18374_4464.t76 59.6774
Rpar36 a_18374_4464.t1 a_18374_4464.t10 71.0844
Rpar37 a_18374_4464.t1 a_18374_4464.t76 581.9160
Rpar38 a_18374_4464.t10 a_18374_4464.t76 133.0454
Rpar39 a_2311_17775.t0 a_2311_17775.t1 24.0114
Rpar40 a_2311_17775.t0 a_2311_17775.t22 820.0494
Rpar41 a_2311_17775.t0 a_2311_17775.t23 1670.3540
Rpar42 a_2311_17775.t1 a_2311_17775.t22 75.3384
Rpar43 a_2311_17775.t1 a_2311_17775.t23 153.4563
Rpar44 a_2311_17775.t22 a_2311_17775.t23 356.0286
Rpar45 a_4128_17730.t0 a_4128_17730.t11 1123.9248
Rpar46 a_4128_17730.t0 a_4128_17730.t12 121.5493
Rpar47 a_4128_17730.t11 a_4128_17730.t12 21.0695
Rpar48 a_7328_8226.t0 a_7328_8226.t11 56.5368
Rpar49 a_7760_8226.t0 a_7760_8226.t64 38.1026
Rpar50 ib ib.t0 43.3761
Rpar51 ib ib.t1 111.6376
Rpar52 ib.t0 ib.t1 36.5486
Rpar53 inn inn.t0 2.8548
Rpar54 inp inp.t0 2.8548
Rpar55 out out.t0 2.0617
Rpar56 out out.t3 84.7911
Rpar57 out out.t27 82.6572
Rpar58 out.t3 out.t27 572.2614
Rpar59 vdd vdd.t0 404.5378
Rpar60 vdd vdd.t1 638.5516
Rpar61 vdd vdd.t2 105.9456
Rpar62 vdd vdd.t3 566.7016
Rpar63 vdd vdd.t24 382.6356
Rpar64 vdd vdd.t25 5285.6767
Rpar65 vdd.t0 vdd.t1 3.4213
Rpar66 vdd.t0 vdd.t2 60.4952
Rpar67 vdd.t0 vdd.t3 562.7054
Rpar68 vdd.t0 vdd.t24 168.3050
Rpar69 vdd.t0 vdd.t25 2324.9431
Rpar70 vdd.t1 vdd.t2 140.8567
Rpar71 vdd.t1 vdd.t24 254.9249
Rpar72 vdd.t1 vdd.t25 3521.4983
Rpar73 vdd.t2 vdd.t3 1.7075
Rpar74 vdd.t2 vdd.t24 60.4354
Rpar75 vdd.t2 vdd.t25 66.4295
Rpar76 vdd.t3 vdd.t24 766.6351
Rpar77 vdd.t3 vdd.t25 6836.9397
Rpar78 vdd.t24 vdd.t25 135.6837
Rpar79 vss vss.t0 73.6797
Rpar80 vss vss.t14 62.1742
Rpar81 vss vss.t4 4188.0267
Rpar82 vss vss.t62 139.9337
Rpar83 vss vss.t63 372.7780
Rpar84 vss.t0 vss.t14 43.9351
Rpar85 vss.t0 vss.t4 104.3002
Rpar86 vss.t0 vss.t62 148.7696
Rpar87 vss.t0 vss.t63 401.4537
Rpar88 vss.t14 vss.t4 457.3083
Rpar89 vss.t14 vss.t62 82.0235
Rpar90 vss.t14 vss.t63 232.3215
Rpar91 vss.t4 vss.t62 6736.2610
Rpar92 vss.t62 vss.t63 2.7031
Cpar0 a_11746_11693.t0 vss 9.75278e-15
Cpar1 a_11746_11693.t1 vss 1.73547e-14
Cpar2 a_11746_11693.t6 vss 9.75763e-14
Cpar3 a_11746_11693.t76 vss 2.14288e-14
Cpar4 a_1217_21446.t0 vss 6.19879e-14
Cpar5 a_1217_21446.t16 vss 6.55978e-15
Cpar6 a_1328_8316.t0 vss 1.28317e-14
Cpar7 a_1328_8316.t108 vss 1.77809e-14
Cpar8 a_1328_8316.t4 vss 4.48060e-14
Cpar9 a_1328_8316.t5 vss 6.94121e-14
Cpar10 a_1328_8316.t92 vss 2.79290e-14
Cpar11 a_14946_4672.t0 vss 2.55415e-14
Cpar12 a_14946_4672.t108 vss 1.89359e-14
Cpar13 a_14946_4672.t16 vss 1.30806e-14
Cpar14 a_14946_4672.t20 vss 4.53399e-14
Cpar15 a_14946_4672.t21 vss 7.05213e-14
Cpar16 a_15666_7973.t0 vss 3.06531e-14
Cpar17 a_15666_7973.t4 vss 2.56813e-14
Cpar18 a_15666_7973.t5 vss 2.43059e-14
Cpar19 a_1818_17775.t0 vss 2.47002e-14
Cpar20 a_1818_17775.t1 vss 1.43917e-14
Cpar21 a_1818_17775.t8 vss 8.47961e-15
Cpar22 a_18374_4464.t0 vss 1.70521e-14
Cpar23 a_18374_4464.t1 vss 9.21327e-15
Cpar24 a_18374_4464.t10 vss 9.94881e-14
Cpar25 a_18374_4464.t76 vss 2.15156e-14
Cpar26 a_2311_17775.t0 vss 8.56117e-15
Cpar27 a_2311_17775.t1 vss 2.07363e-14
Cpar28 a_2311_17775.t22 vss 5.21387e-15
Cpar29 a_2311_17775.t23 vss 9.24092e-15
Cpar30 a_4128_17730.t0 vss 2.22502e-14
Cpar31 a_4128_17730.t11 vss 1.28025e-14
Cpar32 a_4128_17730.t12 vss 2.41301e-14
Cpar33 a_7328_8226.t0 vss 5.39874e-14
Cpar34 a_7328_8226.t11 vss 1.36596e-14
Cpar35 a_7760_8226.t0 vss 2.05528e-13
Cpar36 a_7760_8226.t64 vss 9.72116e-15
Cpar37 ib vdd 2.23122e-15
Cpar38 ib vss 2.48065e-14
Cpar39 ib.t0 vss 5.95289e-15
Cpar40 ib.t1 vss 2.51719e-15
Cpar41 inn inp 1.05180e-16
Cpar42 inn vdd 9.38900e-17
Cpar43 inn vss 3.03984e-14
Cpar44 inn.t0 vss 2.01229e-14
Cpar45 inp vdd 4.39500e-17
Cpar46 inp vss 3.03088e-14
Cpar47 inp.t0 vss 2.02388e-14
Cpar48 out vdd 1.98637e-14
Cpar49 out vss 7.63626e-14
Cpar50 out.t0 vss 1.29807e-15
Cpar51 out.t27 vss 6.11377e-14
Cpar52 out.t3 vss 1.46691e-15
Cpar53 vdd vss 5.14013e-13
Cpar54 vdd.t0 vss 2.94635e-14
Cpar55 vdd.t1 vss 1.88099e-14
Cpar56 vdd.t2 vss 2.00277e-13
Cpar57 vdd.t24 vss 1.51727e-14
Cpar58 vdd.t25 vss 1.83104e-14
Cpar59 vdd.t3 vss 7.07056e-14
.ends opamp_dut

Vdd vdd 0 3.300000
Vss vss 0 0
Ibias vdd ib 7.968700e-06
Vinp inp 0 DC 2.024300 AC 1 PWL(0 2.024300 8.223531e-09 2.024300 9.045884e-09 2.034300)
Rfb out inn 1m
Cload out 0 2.000000e-13
Xdut vdd vss inp inn out ib opamp_dut
.end
