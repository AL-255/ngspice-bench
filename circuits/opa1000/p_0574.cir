* opa1000[0574]: 2p/pmos_5t_3v3_1u_10u_weak (pmos_5t, VDD=3.3V, CL=2.0pF, Iref=1.3uA)
.include "pdk_opa.inc"
.temp 27
.option gmin=1e-12 rshunt=1e12 reltol=1e-3 abstol=1e-12 vntol=1e-5 method=gear
* Post-PEX R+C extracted netlist for pmos_5t_3v3_1u_10u_weak
.subckt opamp_dut vdd vss inp inn out ib
XMpar0 a_1682_7030.t0 inn.t0 out.t0 vdd.t8 pfet_03v3 w=1.98u l=2.5u ad=7.1280e-13 pd=3.1950e-06 as=5.5440e-13 ps=2.5400e-06 nf=1 m=48 par=48
XMpar1 a_4906_2675.t0 ib.t0 vss.t12 vss.t11 nfet_03v3 w=0.72u l=1.3u ad=2.0160e-13 pd=1.2800e-06 as=2.0160e-13 ps=1.2800e-06 nf=1 m=2 par=2
XMpar2 a_1682_7030.t0 inp.t0 a_2302_7030.t0 vdd.t8 pfet_03v3 w=1.98u l=2.5u ad=7.1280e-13 pd=3.1950e-06 as=5.5440e-13 ps=2.5400e-06 nf=1 m=48 par=48
XMpar3 a_2302_7030.t49 a_2302_7030.t48 vss.t1 vss.t0 nfet_03v3 w=1.26u l=3.2u ad=3.5280e-13 pd=1.8200e-06 as=5.5440e-13 ps=2.7700e-06 nf=1 m=4 par=4
XMpar4 ib.t1 ib.t0 vss.t12 vss.t11 nfet_03v3 w=0.72u l=1.3u ad=4.3200e-13 pd=2.6400e-06 as=2.0160e-13 ps=1.2800e-06 nf=1 m=2 par=2
XMpar5 out.t4 a_2302_7030.t48 vss.t1 vss.t0 nfet_03v3 w=1.26u l=3.2u ad=3.5280e-13 pd=1.8200e-06 as=3.5280e-13 ps=1.8200e-06 nf=1 m=4 par=4
XMpar6 a_1682_7030.t96 a_4906_2675.t2 vdd.t1 vdd.t0 pfet_03v3 w=3.17u l=1.3u ad=8.8760e-13 pd=3.7300e-06 as=1.1412e-12 ps=4.6825e-06 nf=1 m=8 par=8
XMpar7 a_4906_2675.t3 a_4906_2675.t2 vdd.t1 vdd.t0 pfet_03v3 w=3.17u l=1.3u ad=8.8760e-13 pd=3.7300e-06 as=8.8760e-13 ps=3.7300e-06 nf=1 m=2 par=2
X4 out.t52 vss.t2 cap_mim_2f0fF c_width=11.49u c_length=11.49u
Rpar0 a_1682_7030.t0 a_1682_7030.t96 61.8094
Rpar1 a_2302_7030.t0 a_2302_7030.t48 101.5130
Rpar2 a_2302_7030.t0 a_2302_7030.t49 71.9905
Rpar3 a_2302_7030.t48 a_2302_7030.t49 21.1299
Rpar4 a_4906_2675.t0 a_4906_2675.t2 117.6857
Rpar5 a_4906_2675.t0 a_4906_2675.t3 82.4383
Rpar6 a_4906_2675.t2 a_4906_2675.t3 23.2761
Rpar7 ib ib.t0 12.9837
Rpar8 ib ib.t1 7.1322
Rpar9 inn inn.t0 1.4557
Rpar10 inp inp.t0 1.4557
Rpar11 out out.t0 158.1557
Rpar12 out out.t4 61.3229
Rpar13 out out.t52 15.1847
Rpar14 out.t0 out.t4 96.4485
Rpar15 out.t0 out.t52 1835.0074
Rpar16 out.t4 out.t52 711.5010
Rpar17 vdd vdd.t0 221.9593
Rpar18 vdd vdd.t1 513.6148
Rpar19 vdd vdd.t8 20.7468
Rpar20 vdd.t0 vdd.t1 5.1306
Rpar21 vdd.t0 vdd.t8 235.3572
Rpar22 vdd.t1 vdd.t8 544.6176
Rpar23 vss vss.t0 158.4668
Rpar24 vss vss.t1 278.0462
Rpar25 vss vss.t11 187.5049
Rpar26 vss vss.t12 170.8053
Rpar27 vss vss.t2 84.7486
Rpar28 vss.t0 vss.t1 7.7695
Rpar29 vss.t0 vss.t11 780.2031
Rpar30 vss.t0 vss.t12 710.8375
Rpar31 vss.t0 vss.t2 413.4371
Rpar32 vss.t1 vss.t11 1439.5846
Rpar33 vss.t1 vss.t12 1311.5175
Rpar34 vss.t1 vss.t2 726.3023
Rpar35 vss.t11 vss.t12 18.0965
Rpar36 vss.t11 vss.t2 220.1149
Rpar37 vss.t12 vss.t2 200.5110
Cpar0 a_1682_7030.t0 vss 8.21788e-14
Cpar1 a_1682_7030.t96 vss 9.73062e-15
Cpar2 a_2302_7030.t0 vss 3.59018e-14
Cpar3 a_2302_7030.t48 vss 1.61261e-14
Cpar4 a_2302_7030.t49 vss 3.81227e-15
Cpar5 a_4906_2675.t0 vss 1.69242e-15
Cpar6 a_4906_2675.t2 vss 1.26098e-14
Cpar7 a_4906_2675.t3 vss 3.17706e-15
Cpar8 ib vss 6.42794e-15
Cpar9 ib.t0 vss 6.34550e-16
Cpar10 ib.t1 vss 6.55300e-17
Cpar11 inn inp 3.10050e-16
Cpar12 inn out 1.79113e-14
Cpar13 inn vdd 4.62196e-14
Cpar14 inn vss 5.19881e-15
Cpar15 inn.t0 vss 7.19111e-14
Cpar16 inp vdd 4.64493e-14
Cpar17 inp vss 5.24069e-15
Cpar18 inp.t0 vss 7.21148e-14
Cpar19 out vdd 1.15579e-14
Cpar20 out vss 1.57789e-14
Cpar21 out.t0 vss 2.19769e-14
Cpar22 out.t4 vss 3.56038e-15
Cpar23 out.t52 vss 2.94549e-14
Cpar24 vdd vss 3.10461e-13
Cpar25 vdd.t0 vss 1.20858e-14
Cpar26 vdd.t1 vss 6.48530e-15
Cpar27 vdd.t8 vss 1.18151e-13
.ends opamp_dut

Vdd vdd 0 3.300000
Vss vss 0 0
Ibias vdd ib 1.300000e-06
Vinp inp 0 DC 1.480000 AC 1 PWL(0 1.480000 3.083980e-08 1.480000 3.392378e-08 1.490000)
Rfb out inn 1m
Cload out 0 2.000000e-12
Xdut vdd vss inp inn out ib opamp_dut
.end
