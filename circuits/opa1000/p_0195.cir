* opa1000[0195]: 200f/folded_cascode_nmos_3v3_i2u_subth (folded_cascode_nmos, VDD=3.3V, CL=0.2pF, Iref=0.3111uA)
.include "pdk_opa.inc"
.temp 27
.option gmin=1e-12 rshunt=1e12 reltol=1e-3 abstol=1e-12 vntol=1e-5 method=gear
* Post-PEX R+C extracted netlist for folded_cascode_nmos_3v3_i2u_subth
.subckt opamp_dut vdd vss inp inn out ib
XMpar0 a_6094_4262.t6 ib.t10 out.t2 vdd.t14 pfet_03v3 w=1.99u l=0.78u ad=7.6947e-13 pd=3.4267e-06 as=5.5720e-13 ps=2.5500e-06 nf=1 m=6 par=6
XMpar1 a_2786_1249.t0 inn.t0 a_6094_4262.t1 vss.t0 nfet_03v3 w=1.59u l=1.14u ad=6.9960e-13 pd=3.2650e-06 as=4.4520e-13 ps=2.1500e-06 nf=1 m=4 par=4
XMpar2 a_2786_1249.t8 ib.t0 vss.t9 vss.t8 nfet_03v3 w=1.48u l=3.25u ad=4.1440e-13 pd=2.0400e-06 as=4.1440e-13 ps=2.0400e-06 nf=1 m=4 par=4
XMpar3 a_3634_9218.t1 a_3634_9218.t0 vdd.t1 vdd.t0 pfet_03v3 w=8.63u l=5.1u ad=2.4164e-12 pd=9.1900e-06 as=5.1780e-12 ps=1.8460e-05 nf=1 m=2 par=2
XMpar4 a_4170_4262.t4 a_3634_9218.t0 vdd.t1 vdd.t0 pfet_03v3 w=8.63u l=5.1u ad=2.4164e-12 pd=9.1900e-06 as=5.1780e-12 ps=1.8460e-05 nf=1 m=4 par=4
XMpar5 a_6094_4262.t0 a_3634_9218.t0 vdd.t1 vdd.t0 pfet_03v3 w=8.63u l=5.1u ad=2.4164e-12 pd=9.1900e-06 as=5.1780e-12 ps=1.8460e-05 nf=1 m=4 par=4
XMpar6 a_2786_1249.t0 inp.t0 a_4170_4262.t0 vss.t0 nfet_03v3 w=1.59u l=1.14u ad=6.9960e-13 pd=3.2650e-06 as=4.4520e-13 ps=2.1500e-06 nf=1 m=4 par=4
XMpar7 ib.t1 ib.t0 vss.t9 vss.t8 nfet_03v3 w=1.48u l=3.25u ad=8.8800e-13 pd=4.1600e-06 as=4.1440e-13 ps=2.0400e-06 nf=1 m=2 par=2
XMpar8 a_4170_4262.t8 ib.t10 a_4446_4262.t0 vdd.t14 pfet_03v3 w=1.99u l=0.78u ad=7.6947e-13 pd=3.4267e-06 as=5.5720e-13 ps=2.5500e-06 nf=1 m=6 par=6
XMpar9 a_4446_4262.t7 a_4446_4262.t6 vss.t9 vss.t8 nfet_03v3 w=1.48u l=3.25u ad=8.8800e-13 pd=4.1600e-06 as=4.1440e-13 ps=2.0400e-06 nf=1 m=2 par=2
XMpar10 out.t0 a_4446_4262.t6 vss.t9 vss.t8 nfet_03v3 w=1.48u l=3.25u ad=4.1440e-13 pd=2.0400e-06 as=4.1440e-13 ps=2.0400e-06 nf=1 m=2 par=2
XMpar11 a_3634_9218.t4 ib.t0 vss.t9 vss.t8 nfet_03v3 w=1.48u l=3.25u ad=4.1440e-13 pd=2.0400e-06 as=4.1440e-13 ps=2.0400e-06 nf=1 m=2 par=2
Rpar0 a_2786_1249.t0 a_2786_1249.t8 178.3622
Rpar1 a_3634_9218.t0 a_3634_9218.t1 24.5162
Rpar2 a_3634_9218.t0 a_3634_9218.t4 105.3688
Rpar3 a_3634_9218.t1 a_3634_9218.t4 112.1539
Rpar4 a_4170_4262.t0 a_4170_4262.t8 64.0597
Rpar5 a_4170_4262.t0 a_4170_4262.t4 101.0039
Rpar6 a_4170_4262.t8 a_4170_4262.t4 104.5448
Rpar7 a_4446_4262.t0 a_4446_4262.t6 76.4247
Rpar8 a_4446_4262.t0 a_4446_4262.t7 43.9168
Rpar9 a_4446_4262.t6 a_4446_4262.t7 22.1966
Rpar10 a_6094_4262.t0 a_6094_4262.t1 101.0039
Rpar11 a_6094_4262.t0 a_6094_4262.t6 104.5448
Rpar12 a_6094_4262.t1 a_6094_4262.t6 64.0597
Rpar13 ib ib.t0 11.2485
Rpar14 ib ib.t1 7.5288
Rpar15 ib ib.t10 92.1359
Rpar16 ib.t1 ib.t10 208.9325
Rpar17 inn inn.t0 4.1001
Rpar18 inp inp.t0 4.1487
Rpar19 out out.t0 62.4968
Rpar20 out out.t2 3.4103
Rpar21 vdd vdd.t0 32.0962
Rpar22 vdd vdd.t1 64.1108
Rpar23 vdd vdd.t14 272.4190
Rpar24 vdd.t0 vdd.t1 5.6090
Rpar25 vdd.t0 vdd.t14 74.4625
Rpar26 vdd.t1 vdd.t14 71.5449
Rpar27 vss vss.t0 507.3003
Rpar28 vss vss.t8 50.7222
Rpar29 vss vss.t9 200.0699
Rpar30 vss.t0 vss.t8 2.3541
Rpar31 vss.t0 vss.t9 20.2157
Rpar32 vss.t8 vss.t9 5.2734
Cpar0 a_2786_1249.t0 vss 1.14462e-14
Cpar1 a_2786_1249.t8 vss 1.03429e-14
Cpar2 a_3634_9218.t0 vss 5.05665e-14
Cpar3 a_3634_9218.t1 vss 4.27934e-15
Cpar4 a_3634_9218.t4 vss 3.72606e-15
Cpar5 a_4170_4262.t0 vss 3.64565e-15
Cpar6 a_4170_4262.t4 vss 1.23134e-14
Cpar7 a_4170_4262.t8 vss 6.01339e-15
Cpar8 a_4446_4262.t0 vss 1.88252e-15
Cpar9 a_4446_4262.t6 vss 4.37996e-15
Cpar10 a_4446_4262.t7 vss 1.14378e-15
Cpar11 a_6094_4262.t0 vss 1.13954e-14
Cpar12 a_6094_4262.t1 vss 3.37385e-15
Cpar13 a_6094_4262.t6 vss 5.56506e-15
Cpar14 ib out 5.76670e-16
Cpar15 ib vdd 7.35988e-15
Cpar16 ib vss 2.68611e-14
Cpar17 ib.t0 vss 8.59811e-15
Cpar18 ib.t1 vss 1.07982e-15
Cpar19 ib.t10 vss 6.09133e-15
Cpar20 inn inp 5.18200e-17
Cpar21 inn vss 3.56747e-15
Cpar22 inn.t0 vss 5.71865e-16
Cpar23 inp vss 3.57196e-15
Cpar24 inp.t0 vss 5.63631e-16
Cpar25 out vdd 1.48876e-15
Cpar26 out vss 6.65030e-15
Cpar27 out.t0 vss 2.93524e-15
Cpar28 out.t2 vss 1.95276e-15
Cpar29 vdd vss 1.76950e-13
Cpar30 vdd.t0 vss 3.35147e-14
Cpar31 vdd.t1 vss 2.57714e-14
Cpar32 vdd.t14 vss 1.04733e-14
.ends opamp_dut

Vdd vdd 0 3.300000
Vss vss 0 0
Ibias vdd ib 3.111000e-07
Vinp inp 0 DC 1.810000 AC 1 PWL(0 1.810000 2.032607e-08 1.810000 2.235868e-08 1.820000)
Rfb out inn 1m
Cload out 0 2.000000e-13
Xdut vdd vss inp inn out ib opamp_dut
.end
