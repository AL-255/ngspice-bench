* opa1000[0740]: 2p/rail_to_rail_3v3_1u_10u_weak (rail_to_rail, VDD=3.3V, CL=2.0pF, Iref=0.7188uA)
.include "pdk_opa.inc"
.temp 27
.option gmin=1e-12 rshunt=1e12 reltol=1e-3 abstol=1e-12 vntol=1e-5 method=gear
* Post-PEX R+C extracted netlist for rail_to_rail_3v3_1u_10u_weak
.subckt opamp_dut vdd vss inp inn out ib
XMpar0 out.t10 ib.t0 vss.t20 vss.t19 nfet_03v3 w=1.15u l=3u ad=3.2200e-13 pd=1.7100e-06 as=5.9800e-13 ps=3.0525e-06 nf=1 m=8 par=8
XMpar1 a_7972_13037.t2 a_6890_7637.t0 vss.t1 vss.t0 nfet_03v3 w=0.4u l=1.63u ad=1.1200e-13 pd=9.6000e-07 as=1.1200e-13 ps=9.6000e-07 nf=1 m=2 par=2
XMpar2 a_7720_1041.t0 inn.t0 a_976_7226.t0 vdd.t6 pfet_03v3 w=1.52u l=1.6u ad=4.2560e-13 pd=2.0800e-06 as=6.6880e-13 ps=3.1600e-06 nf=1 m=4 par=4
XMpar3 out.t0 a_878_1291.t7 vdd.t1 vdd.t0 pfet_03v3 w=2.68u l=1u ad=7.5040e-13 pd=3.2400e-06 as=9.6480e-13 ps=4.0700e-06 nf=1 m=8 par=8
XMpar4 a_6890_7637.t4 inp.t0 a_976_7226.t0 vdd.t6 pfet_03v3 w=1.52u l=1.6u ad=4.2560e-13 pd=2.0800e-06 as=6.6880e-13 ps=3.1600e-06 nf=1 m=4 par=4
XMpar5 ib.t1 ib.t0 vss.t20 vss.t19 nfet_03v3 w=1.15u l=3u ad=6.9000e-13 pd=3.5000e-06 as=3.2200e-13 ps=1.7100e-06 nf=1 m=2 par=2
XMpar6 a_7720_1041.t5 a_7720_1041.t4 vss.t1 vss.t0 nfet_03v3 w=0.4u l=1.63u ad=1.1200e-13 pd=9.6000e-07 as=1.1200e-13 ps=9.6000e-07 nf=1 m=2 par=2
XMpar7 a_1096_7017.t4 ib.t0 vss.t20 vss.t19 nfet_03v3 w=1.15u l=3u ad=6.9000e-13 pd=3.5000e-06 as=3.2200e-13 ps=1.7100e-06 nf=1 m=2 par=2
XMpar8 a_4062_3311.t0 inn.t4 a_7972_13037.t0 vss.t4 nfet_03v3 w=0.69u l=1.6u ad=4.1400e-13 pd=2.5800e-06 as=4.1400e-13 ps=2.5800e-06 nf=1 m=2 par=2
XMpar9 a_6890_7637.t1 a_6890_7637.t0 vss.t1 vss.t0 nfet_03v3 w=0.4u l=1.63u ad=2.4000e-13 pd=2.0000e-06 as=1.1200e-13 ps=9.6000e-07 nf=1 m=2 par=2
XMpar10 a_4062_3311.t0 inp.t4 a_878_1291.t4 vss.t4 nfet_03v3 w=0.69u l=1.6u ad=4.1400e-13 pd=2.5800e-06 as=4.1400e-13 ps=2.5800e-06 nf=1 m=2 par=2
XMpar11 a_878_1291.t1 a_7720_1041.t4 vss.t1 vss.t0 nfet_03v3 w=0.4u l=1.63u ad=2.4000e-13 pd=2.0000e-06 as=1.1200e-13 ps=9.6000e-07 nf=1 m=2 par=2
XMpar12 a_976_7226.t4 a_1096_7017.t0 vdd.t5 vdd.t4 pfet_03v3 w=4.58u l=3u ad=2.7480e-12 pd=1.0360e-05 as=1.2824e-12 ps=5.1400e-06 nf=1 m=2 par=2
XMpar13 a_7972_13037.t5 a_7972_13037.t4 vdd.t1 vdd.t0 pfet_03v3 w=2.68u l=1u ad=7.5040e-13 pd=3.2400e-06 as=7.5040e-13 ps=3.2400e-06 nf=1 m=2 par=2
XMpar14 a_4062_3311.t4 ib.t0 vss.t20 vss.t19 nfet_03v3 w=1.15u l=3u ad=6.9000e-13 pd=3.5000e-06 as=3.2200e-13 ps=1.7100e-06 nf=1 m=2 par=2
XMpar15 a_1096_7017.t1 a_1096_7017.t0 vdd.t5 vdd.t4 pfet_03v3 w=4.58u l=3u ad=1.2824e-12 pd=5.1400e-06 as=1.2824e-12 ps=5.1400e-06 nf=1 m=2 par=2
XMpar16 a_878_1291.t0 a_7972_13037.t4 vdd.t1 vdd.t0 pfet_03v3 w=2.68u l=1u ad=1.6080e-12 pd=6.5600e-06 as=7.5040e-13 ps=3.2400e-06 nf=1 m=2 par=2
X7 a_878_1811.t0 a_4646_1291.t0 vss.t16 ppolyf_u_1k r_width=1u r_length=18.18u
X28 a_878_1291.t6 a_4646_1291.t0 vss.t16 ppolyf_u_1k r_width=1u r_length=18.18u
X29 a_878_1811.t1 out.t1 cap_mim_2f0fF c_width=15.62u c_length=15.61u
X45 a_878_1811.t1 out.t1 cap_mim_2f0fF c_width=15.62u c_length=15.61u
Rpar0 a_1096_7017.t0 a_1096_7017.t1 24.0441
Rpar1 a_1096_7017.t0 a_1096_7017.t4 126.0105
Rpar2 a_1096_7017.t1 a_1096_7017.t4 72.4086
Rpar3 a_4062_3311.t0 a_4062_3311.t4 71.3867
Rpar4 a_6890_7637.t0 a_6890_7637.t1 22.8841
Rpar5 a_6890_7637.t0 a_6890_7637.t4 104.1382
Rpar6 a_6890_7637.t1 a_6890_7637.t4 70.2955
Rpar7 a_7720_1041.t0 a_7720_1041.t4 150.1866
Rpar8 a_7720_1041.t0 a_7720_1041.t5 152.3379
Rpar9 a_7720_1041.t4 a_7720_1041.t5 29.4321
Rpar10 a_7972_13037.t0 a_7972_13037.t2 72.8142
Rpar11 a_7972_13037.t0 a_7972_13037.t4 373.2465
Rpar12 a_7972_13037.t0 a_7972_13037.t5 152.6968
Rpar13 a_7972_13037.t2 a_7972_13037.t4 303.4278
Rpar14 a_7972_13037.t2 a_7972_13037.t5 124.1337
Rpar15 a_7972_13037.t4 a_7972_13037.t5 26.3310
Rpar16 a_878_1291.t0 a_878_1291.t1 791.9684
Rpar17 a_878_1291.t0 a_878_1291.t7 189.2419
Rpar18 a_878_1291.t0 a_878_1291.t4 56.3092
Rpar19 a_878_1291.t0 a_878_1291.t6 735.4658
Rpar20 a_878_1291.t1 a_878_1291.t7 418.5538
Rpar21 a_878_1291.t1 a_878_1291.t4 585.2841
Rpar22 a_878_1291.t1 a_878_1291.t6 90.2145
Rpar23 a_878_1291.t7 a_878_1291.t4 139.8544
Rpar24 a_878_1291.t7 a_878_1291.t6 388.6923
Rpar25 a_878_1291.t4 a_878_1291.t6 543.5273
Rpar26 a_878_1811.t0 a_878_1811.t1 94.2495
Rpar27 a_976_7226.t0 a_976_7226.t4 44.9418
Rpar28 ib ib.t0 14.1241
Rpar29 ib ib.t1 13.0618
Rpar30 ib.t0 ib.t1 27.2002
Rpar31 inn inn.t0 51.6976
Rpar32 inn inn.t4 11.1983
Rpar33 inp inp.t0 42.6490
Rpar34 inp inp.t4 11.1983
Rpar35 out out.t0 419.6190
Rpar36 out out.t1 152.3468
Rpar37 out out.t10 7.8798
Rpar38 out.t0 out.t1 373.4920
Rpar39 out.t0 out.t10 382.4510
Rpar40 out.t1 out.t10 138.8526
Rpar41 vdd vdd.t0 54.2661
Rpar42 vdd vdd.t1 53.2077
Rpar43 vdd vdd.t4 254.8768
Rpar44 vdd vdd.t5 421.0902
Rpar45 vdd vdd.t6 195.0605
Rpar46 vdd.t0 vdd.t1 4.5823
Rpar47 vdd.t0 vdd.t4 669.1027
Rpar48 vdd.t0 vdd.t5 1105.4460
Rpar49 vdd.t0 vdd.t6 512.0729
Rpar50 vdd.t1 vdd.t4 656.0528
Rpar51 vdd.t1 vdd.t5 1083.8859
Rpar52 vdd.t1 vdd.t6 502.0857
Rpar53 vdd.t4 vdd.t5 9.5368
Rpar54 vdd.t4 vdd.t6 115.3654
Rpar55 vdd.t5 vdd.t6 190.5989
Rpar56 vss vss.t0 109.5522
Rpar57 vss vss.t1 311.0148
Rpar58 vss vss.t16 179.3879
Rpar59 vss vss.t19 50.6681
Rpar60 vss vss.t20 752.0666
Rpar61 vss.t0 vss.t1 7.6128
Rpar62 vss.t0 vss.t4 8.4317
Rpar63 vss.t0 vss.t16 39.7935
Rpar64 vss.t0 vss.t19 8.7893
Rpar65 vss.t0 vss.t20 109.3147
Rpar66 vss.t1 vss.t4 99.4673
Rpar67 vss.t1 vss.t16 131.8442
Rpar68 vss.t1 vss.t19 27.2682
Rpar69 vss.t1 vss.t20 365.3170
Rpar70 vss.t4 vss.t19 564.8610
Rpar71 vss.t16 vss.t19 5.1658
Rpar72 vss.t16 vss.t20 57.2391
Rpar73 vss.t19 vss.t20 18.3195
Cpar0 a_1096_7017.t0 vss 1.11242e-14
Cpar1 a_1096_7017.t1 vss 3.43876e-15
Cpar2 a_1096_7017.t4 vss 5.84281e-15
Cpar3 a_4062_3311.t0 vss 8.47307e-15
Cpar4 a_4062_3311.t4 vss 1.12214e-14
Cpar5 a_4646_1291.t0 vss 3.13000e-17
Cpar6 a_6890_7637.t0 vss 2.94972e-15
Cpar7 a_6890_7637.t1 vss 1.42350e-15
Cpar8 a_6890_7637.t4 vss 2.26638e-15
Cpar9 a_7720_1041.t0 vss 3.52311e-15
Cpar10 a_7720_1041.t4 vss 3.57236e-15
Cpar11 a_7720_1041.t5 vss 1.91014e-15
Cpar12 a_7972_13037.t0 vss 2.75841e-15
Cpar13 a_7972_13037.t2 vss 1.89380e-15
Cpar14 a_7972_13037.t4 vss 4.01900e-15
Cpar15 a_7972_13037.t5 vss 2.79611e-15
Cpar16 a_878_1291.t0 vss 4.03887e-15
Cpar17 a_878_1291.t1 vss 3.68108e-15
Cpar18 a_878_1291.t4 vss 3.89734e-15
Cpar19 a_878_1291.t6 vss 4.02815e-15
Cpar20 a_878_1291.t7 vss 7.82424e-15
Cpar21 a_878_1811.t0 vss 1.98464e-16
Cpar22 a_878_1811.t1 vss 7.69274e-15
Cpar23 a_976_7226.t0 vss 5.48751e-15
Cpar24 a_976_7226.t4 vss 7.21409e-15
Cpar25 ib out 2.17189e-15
Cpar26 ib vdd 1.20000e-17
Cpar27 ib vss 3.08236e-14
Cpar28 ib.t0 vss 1.10854e-14
Cpar29 ib.t1 vss 9.90300e-16
Cpar30 inn inp 1.54750e-16
Cpar31 inn out 4.58800e-17
Cpar32 inn vdd 3.83479e-15
Cpar33 inn vss 6.37418e-15
Cpar34 inn.t0 vss 3.86370e-15
Cpar35 inn.t4 vss 8.43390e-16
Cpar36 inp out 3.20870e-16
Cpar37 inp vdd 3.89104e-15
Cpar38 inp vss 6.60088e-15
Cpar39 inp.t0 vss 4.37226e-15
Cpar40 inp.t4 vss 9.59740e-16
Cpar41 out vdd 1.44066e-14
Cpar42 out vss 2.30491e-14
Cpar43 out.t0 vss 6.86289e-15
Cpar44 out.t1 vss 1.84875e-14
Cpar45 out.t10 vss 4.85380e-15
Cpar46 vdd vss 1.01999e-13
Cpar47 vdd.t0 vss 1.03401e-14
Cpar48 vdd.t1 vss 9.84497e-15
Cpar49 vdd.t4 vss 1.00314e-14
Cpar50 vdd.t5 vss 5.89738e-15
Cpar51 vdd.t6 vss 1.22970e-14
.ends opamp_dut

Vdd vdd 0 3.300000
Vss vss 0 0
Ibias vdd ib 7.188000e-07
Vinp inp 0 DC 1.645000 AC 1 PWL(0 1.645000 5.635535e-08 1.645000 6.199088e-08 1.655000)
Rfb out inn 1m
Cload out 0 2.000000e-12
Xdut vdd vss inp inn out ib opamp_dut
.end
