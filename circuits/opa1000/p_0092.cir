* opa1000[0092]: 200f/current_reuse_1v8_i1u_weak (current_reuse, VDD=1.8V, CL=0.2pF, Iref=0.1429uA)
.include "pdk_opa.inc"
.temp 27
.option gmin=1e-12 rshunt=1e12 reltol=1e-3 abstol=1e-12 vntol=1e-5 method=gear
* Post-PEX R+C extracted netlist for current_reuse_1v8_i1u_weak
.subckt opamp_dut vdd vss inp inn out ib
XMpar0 out.t0 a_1289_1290.t6 vdd.t1 vdd.t0 pfet_03v3 w=1.02u l=1.8u ad=3.5088e-13 pd=1.9120e-06 as=4.1616e-13 ps=2.2440e-06 nf=1 m=10 par=10
XMpar1 out.t10 ib.t0 vss.t14 vss.t13 nfet_03v3 w=0.4u l=2.1u ad=1.8880e-13 pd=1.5840e-06 as=1.6320e-13 ps=1.3760e-06 nf=1 m=10 par=10
XMpar2 a_5714_12693.t0 inn.t2 a_957_7217.t2 vss.t1 nfet_03v3 w=0.54u l=2.4u ad=3.2400e-13 pd=2.2800e-06 as=1.5120e-13 ps=1.1000e-06 nf=1 m=2 par=2
XMpar3 a_1289_1290.t1 inp.t0 a_1317_7425.t0 vdd.t7 pfet_03v3 w=1.25u l=2.4u ad=3.5000e-13 pd=1.8100e-06 as=7.5000e-13 ps=3.7000e-06 nf=1 m=2 par=2
XMpar4 a_1317_7425.t0 inn.t0 a_957_7217.t0 vdd.t7 pfet_03v3 w=1.25u l=2.4u ad=7.5000e-13 pd=3.7000e-06 as=3.5000e-13 ps=1.8100e-06 nf=1 m=2 par=2
XMpar5 ib.t1 ib.t0 vss.t14 vss.t13 nfet_03v3 w=0.4u l=2.1u ad=2.4000e-13 pd=2.0000e-06 as=1.1200e-13 ps=9.6000e-07 nf=1 m=2 par=2
XMpar6 a_5714_12693.t4 ib.t0 vss.t14 vss.t13 nfet_03v3 w=0.4u l=2.1u ad=2.4000e-13 pd=2.0000e-06 as=1.1200e-13 ps=9.6000e-07 nf=1 m=4 par=4
XMpar7 a_1289_1290.t0 a_957_7217.t4 vdd.t1 vdd.t0 pfet_03v3 w=1.02u l=1.8u ad=6.1200e-13 pd=3.2400e-06 as=2.8560e-13 ps=1.5800e-06 nf=1 m=1
XMpar8 a_1289_1290.t3 inp.t2 a_5714_12693.t0 vss.t1 nfet_03v3 w=0.54u l=2.4u ad=1.5120e-13 pd=1.1000e-06 as=3.2400e-13 ps=2.2800e-06 nf=1 m=2 par=2
XMpar9 a_1317_7425.t2 a_957_7217.t4 vdd.t1 vdd.t0 pfet_03v3 w=1.02u l=1.8u ad=2.8560e-13 pd=1.5800e-06 as=6.1200e-13 ps=3.2400e-06 nf=1 m=2 par=2
XMpar10 a_957_7217.t5 a_957_7217.t4 vdd.t1 vdd.t0 pfet_03v3 w=1.02u l=1.8u ad=6.1200e-13 pd=3.2400e-06 as=2.8560e-13 ps=1.5800e-06 nf=1 m=1
X1 a_1289_2850.t0 a_5079_2330.t0 vss.t0 ppolyf_u_1k r_width=1u r_length=18.29u
X6 a_1289_4930.t0 a_5079_5450.t0 vss.t0 ppolyf_u_1k r_width=1u r_length=18.29u
X9 a_1289_1810.t0 a_5079_2330.t0 vss.t0 ppolyf_u_1k r_width=1u r_length=18.29u
X15 a_1289_4930.t0 a_5079_4410.t0 vss.t0 ppolyf_u_1k r_width=1u r_length=18.29u
X18 a_1289_1810.t0 a_5079_1290.t0 vss.t0 ppolyf_u_1k r_width=1u r_length=18.29u
X24 a_1289_3890.t0 a_5079_4410.t0 vss.t0 ppolyf_u_1k r_width=1u r_length=18.29u
X26 a_1289_5970.t1 out.t20 cap_mim_2f0fF c_width=15u c_length=15u
X35 a_1289_1290.t5 a_5079_1290.t0 vss.t0 ppolyf_u_1k r_width=1u r_length=18.29u
X39 a_1289_3890.t0 a_5079_3370.t0 vss.t0 ppolyf_u_1k r_width=1u r_length=18.29u
X46 a_1289_2850.t0 a_5079_3370.t0 vss.t0 ppolyf_u_1k r_width=1u r_length=18.29u
X48 a_1289_5970.t0 a_5079_5450.t0 vss.t0 ppolyf_u_1k r_width=1u r_length=18.29u
Rpar0 a_1289_1290.t0 a_1289_1290.t1 126.9480
Rpar1 a_1289_1290.t0 a_1289_1290.t6 204.4403
Rpar2 a_1289_1290.t0 a_1289_1290.t3 137.4507
Rpar3 a_1289_1290.t0 a_1289_1290.t5 661.1251
Rpar4 a_1289_1290.t1 a_1289_1290.t6 86.3058
Rpar5 a_1289_1290.t1 a_1289_1290.t3 178.4557
Rpar6 a_1289_1290.t1 a_1289_1290.t5 279.0982
Rpar7 a_1289_1290.t6 a_1289_1290.t3 287.3896
Rpar8 a_1289_1290.t6 a_1289_1290.t5 161.9335
Rpar9 a_1289_1290.t3 a_1289_1290.t5 929.3689
Rpar10 a_1289_5970.t0 a_1289_5970.t1 59.4798
Rpar11 a_1317_7425.t0 a_1317_7425.t2 56.0612
Rpar12 a_5714_12693.t0 a_5714_12693.t4 99.3273
Rpar13 a_957_7217.t0 a_957_7217.t2 114.4181
Rpar14 a_957_7217.t0 a_957_7217.t4 209.2126
Rpar15 a_957_7217.t0 a_957_7217.t5 448.2597
Rpar16 a_957_7217.t2 a_957_7217.t4 122.1156
Rpar17 a_957_7217.t2 a_957_7217.t5 261.6454
Rpar18 a_957_7217.t4 a_957_7217.t5 28.5158
Rpar19 ib ib.t0 12.8739
Rpar20 ib ib.t1 14.0368
Rpar21 ib.t0 ib.t1 34.9852
Rpar22 inn inn.t0 54.8284
Rpar23 inn inn.t2 3.9349
Rpar24 inp inp.t0 44.8708
Rpar25 inp inp.t2 3.9835
Rpar26 out out.t0 414.6482
Rpar27 out out.t10 4.2265
Rpar28 out out.t20 628.4948
Rpar29 out.t0 out.t10 94.1576
Rpar30 out.t0 out.t20 169.6175
Rpar31 out.t10 out.t20 142.7174
Rpar32 vdd vdd.t0 173.8539
Rpar33 vdd vdd.t1 80.2679
Rpar34 vdd vdd.t7 155.3040
Rpar35 vdd.t0 vdd.t1 5.8915
Rpar36 vdd.t0 vdd.t7 104.3177
Rpar37 vdd.t1 vdd.t7 67.2228
Rpar38 vss vss.t0 44.6661
Rpar39 vss vss.t1 296.9374
Rpar40 vss vss.t13 789.9463
Rpar41 vss vss.t14 73.6610
Rpar42 vss.t0 vss.t1 414.5069
Rpar43 vss.t0 vss.t13 23.4303
Rpar44 vss.t0 vss.t14 16.4971
Rpar45 vss.t1 vss.t13 3699.2143
Rpar46 vss.t1 vss.t14 103.5075
Rpar47 vss.t13 vss.t14 172.2546
Cpar0 a_1289_1290.t0 vss 2.79910e-15
Cpar1 a_1289_1290.t1 vss 3.33723e-15
Cpar2 a_1289_1290.t3 vss 2.79316e-15
Cpar3 a_1289_1290.t5 vss 5.40421e-15
Cpar4 a_1289_1290.t6 vss 1.67152e-14
Cpar5 a_1289_1810.t0 vss 3.20200e-17
Cpar6 a_1289_2850.t0 vss 2.93600e-17
Cpar7 a_1289_3890.t0 vss 2.93600e-17
Cpar8 a_1289_4930.t0 vss 3.20200e-17
Cpar9 a_1289_5970.t0 vss 9.88500e-17
Cpar10 a_1289_5970.t1 vss 2.71238e-15
Cpar11 a_1317_7425.t0 vss 5.48675e-15
Cpar12 a_1317_7425.t2 vss 2.96565e-15
Cpar13 a_5079_1290.t0 vss 3.81000e-17
Cpar14 a_5079_2330.t0 vss 4.12600e-17
Cpar15 a_5079_3370.t0 vss 4.05400e-17
Cpar16 a_5079_4410.t0 vss 4.04400e-17
Cpar17 a_5079_5450.t0 vss 3.78200e-17
Cpar18 a_5714_12693.t0 vss 7.10783e-15
Cpar19 a_5714_12693.t4 vss 1.35408e-14
Cpar20 a_957_7217.t0 vss 3.26424e-15
Cpar21 a_957_7217.t2 vss 3.63028e-15
Cpar22 a_957_7217.t4 vss 9.72396e-15
Cpar23 a_957_7217.t5 vss 2.58098e-15
Cpar24 ib inn 1.13400e-17
Cpar25 ib out 2.11714e-15
Cpar26 ib vss 3.11614e-14
Cpar27 ib.t0 vss 5.37744e-15
Cpar28 ib.t1 vss 5.40268e-16
Cpar29 inn inp 1.03940e-16
Cpar30 inn vdd 2.70658e-15
Cpar31 inn vss 6.55091e-15
Cpar32 inn.t0 vss 2.42882e-15
Cpar33 inn.t2 vss 6.71376e-16
Cpar34 inp out 2.13600e-17
Cpar35 inp vdd 3.16196e-15
Cpar36 inp vss 5.91872e-15
Cpar37 inp.t0 vss 3.27901e-15
Cpar38 inp.t2 vss 9.98609e-16
Cpar39 out vdd 1.30165e-14
Cpar40 out vss 2.02695e-14
Cpar41 out.t0 vss 7.33199e-15
Cpar42 out.t10 vss 5.72101e-15
Cpar43 out.t20 vss 1.21421e-14
Cpar44 vdd vss 8.23190e-14
Cpar45 vdd.t0 vss 2.53614e-14
Cpar46 vdd.t1 vss 9.18757e-15
Cpar47 vdd.t7 vss 8.25702e-15
.ends opamp_dut

Vdd vdd 0 1.800000
Vss vss 0 0
Ibias vdd ib 1.429000e-07
Vinp inp 0 DC 0.895000 AC 1 PWL(0 0.895000 7.799729e-08 0.895000 8.579702e-08 0.905000)
Rfb out inn 1m
Cload out 0 2.000000e-13
Xdut vdd vss inp inn out ib opamp_dut
.end
