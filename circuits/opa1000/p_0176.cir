* opa1000[0176]: 200f/folded_cascode_nmos_1v8_i2u_weak (folded_cascode_nmos, VDD=1.8V, CL=0.2pF, Iref=0.4444uA)
.include "pdk_opa.inc"
.temp 27
.option gmin=1e-12 rshunt=1e12 reltol=1e-3 abstol=1e-12 vntol=1e-5 method=gear
* Post-PEX R+C extracted netlist for folded_cascode_nmos_1v8_i2u_weak
.subckt opamp_dut vdd vss inp inn out ib
XMpar0 a_1970_4834.t0 inn.t0 a_5134_6559.t0 vss.t0 nfet_03v3 w=1.52u l=3u ad=6.6880e-13 pd=3.1600e-06 as=4.2560e-13 ps=2.0800e-06 nf=1 m=4 par=4
XMpar1 a_5134_6559.t4 a_1303_6396.t2 vdd.t1 vdd.t0 pfet_03v3 w=2.14u l=2.72u ad=5.9920e-13 pd=2.7000e-06 as=9.4160e-13 ps=4.0900e-06 nf=1 m=4 par=4
XMpar2 out.t2 a_3852_1249.t2 vss.t9 vss.t8 nfet_03v3 w=0.55u l=2.6u ad=1.5400e-13 pd=1.1100e-06 as=1.5400e-13 ps=1.1100e-06 nf=1 m=2 par=2
XMpar3 a_1970_4834.t8 ib.t0 vss.t9 vss.t8 nfet_03v3 w=0.55u l=2.6u ad=1.5400e-13 pd=1.1100e-06 as=1.5400e-13 ps=1.1100e-06 nf=1 m=4 par=4
XMpar4 a_1970_4834.t0 inp.t0 a_2690_4834.t0 vss.t0 nfet_03v3 w=1.52u l=3u ad=6.6880e-13 pd=3.1600e-06 as=4.2560e-13 ps=2.0800e-06 nf=1 m=4 par=4
XMpar5 a_3852_1249.t3 a_3852_1249.t2 vss.t9 vss.t8 nfet_03v3 w=0.55u l=2.6u ad=3.3000e-13 pd=2.3000e-06 as=1.5400e-13 ps=1.1100e-06 nf=1 m=2 par=2
XMpar6 a_2690_4834.t4 a_1303_6396.t2 vdd.t1 vdd.t0 pfet_03v3 w=2.14u l=2.72u ad=5.9920e-13 pd=2.7000e-06 as=9.4160e-13 ps=4.0900e-06 nf=1 m=4 par=4
XMpar7 a_5134_6559.t5 ib.t10 out.t0 vdd.t4 pfet_03v3 w=1.75u l=1.04u ad=1.0500e-12 pd=4.7000e-06 as=4.9000e-13 ps=2.3100e-06 nf=1 m=2 par=2
XMpar8 a_2690_4834.t5 ib.t10 a_3852_1249.t0 vdd.t4 pfet_03v3 w=1.75u l=1.04u ad=1.0500e-12 pd=4.7000e-06 as=4.9000e-13 ps=2.3100e-06 nf=1 m=2 par=2
XMpar9 a_1303_6396.t3 a_1303_6396.t2 vdd.t1 vdd.t0 pfet_03v3 w=2.14u l=2.72u ad=5.9920e-13 pd=2.7000e-06 as=1.2840e-12 ps=5.4800e-06 nf=1 m=2 par=2
XMpar10 ib.t1 ib.t0 vss.t9 vss.t8 nfet_03v3 w=0.55u l=2.6u ad=3.3000e-13 pd=2.3000e-06 as=1.5400e-13 ps=1.1100e-06 nf=1 m=2 par=2
XMpar11 a_1303_6396.t0 ib.t0 vss.t9 vss.t8 nfet_03v3 w=0.55u l=2.6u ad=1.5400e-13 pd=1.1100e-06 as=1.5400e-13 ps=1.1100e-06 nf=1 m=2 par=2
Rpar0 a_1303_6396.t0 a_1303_6396.t2 112.2721
Rpar1 a_1303_6396.t0 a_1303_6396.t3 612.5288
Rpar2 a_1303_6396.t2 a_1303_6396.t3 19.2921
Rpar3 a_1970_4834.t0 a_1970_4834.t8 51.0943
Rpar4 a_2690_4834.t0 a_2690_4834.t4 68.4917
Rpar5 a_2690_4834.t0 a_2690_4834.t5 64.0242
Rpar6 a_2690_4834.t4 a_2690_4834.t5 160.9107
Rpar7 a_3852_1249.t0 a_3852_1249.t2 200.6918
Rpar8 a_3852_1249.t0 a_3852_1249.t3 132.7702
Rpar9 a_3852_1249.t2 a_3852_1249.t3 20.5594
Rpar10 a_5134_6559.t0 a_5134_6559.t4 68.4917
Rpar11 a_5134_6559.t0 a_5134_6559.t5 64.0242
Rpar12 a_5134_6559.t4 a_5134_6559.t5 160.9107
Rpar13 ib ib.t0 19.1583
Rpar14 ib ib.t1 9.0984
Rpar15 ib ib.t10 67.8017
Rpar16 ib.t0 ib.t1 60.4810
Rpar17 inn inn.t0 2.1602
Rpar18 inp inp.t0 2.2088
Rpar19 out out.t0 8.6034
Rpar20 out out.t2 69.0403
Rpar21 vdd vdd.t0 42.4448
Rpar22 vdd vdd.t1 65.8550
Rpar23 vdd vdd.t4 107.8223
Rpar24 vdd.t0 vdd.t1 5.5401
Rpar25 vdd.t0 vdd.t4 48.2677
Rpar26 vdd.t1 vdd.t4 53.3030
Rpar27 vss vss.t0 89.4846
Rpar28 vss vss.t8 138.8182
Rpar29 vss vss.t9 187.2898
Rpar30 vss.t0 vss.t8 4.0798
Rpar31 vss.t0 vss.t9 7.2996
Rpar32 vss.t8 vss.t9 11.3482
Cpar0 a_1303_6396.t0 vss 5.74464e-15
Cpar1 a_1303_6396.t2 vss 2.33018e-14
Cpar2 a_1303_6396.t3 vss 2.81851e-15
Cpar3 a_1970_4834.t0 vss 6.69348e-15
Cpar4 a_1970_4834.t8 vss 4.97394e-15
Cpar5 a_2690_4834.t0 vss 4.52276e-15
Cpar6 a_2690_4834.t4 vss 5.51254e-15
Cpar7 a_2690_4834.t5 vss 2.82055e-15
Cpar8 a_3852_1249.t0 vss 2.05811e-15
Cpar9 a_3852_1249.t2 vss 3.82219e-15
Cpar10 a_3852_1249.t3 vss 2.17377e-15
Cpar11 a_5134_6559.t0 vss 4.17030e-15
Cpar12 a_5134_6559.t4 vss 5.08293e-15
Cpar13 a_5134_6559.t5 vss 2.60073e-15
Cpar14 ib inn 5.47000e-17
Cpar15 ib inp 2.40000e-17
Cpar16 ib out 2.10563e-15
Cpar17 ib vdd 3.16239e-15
Cpar18 ib vss 2.11926e-14
Cpar19 ib.t0 vss 5.27247e-15
Cpar20 ib.t1 vss 3.08915e-16
Cpar21 ib.t10 vss 2.84411e-15
Cpar22 inn inp 5.13900e-17
Cpar23 inn vss 7.00430e-15
Cpar24 inn.t0 vss 1.04180e-15
Cpar25 inp vss 6.92676e-15
Cpar26 inp.t0 vss 1.03584e-15
Cpar27 out vdd 9.29750e-16
Cpar28 out vss 8.04766e-15
Cpar29 out.t0 vss 2.04156e-16
Cpar30 out.t2 vss 3.10800e-15
Cpar31 vdd vss 6.39632e-14
Cpar32 vdd.t0 vss 1.30897e-14
Cpar33 vdd.t1 vss 1.06788e-14
Cpar34 vdd.t4 vss 7.14089e-15
.ends opamp_dut

Vdd vdd 0 1.800000
Vss vss 0 0
Ibias vdd ib 4.444000e-07
Vinp inp 0 DC 0.985000 AC 1 PWL(0 0.985000 1.783349e-08 0.985000 1.961684e-08 0.995000)
Rfb out inn 1m
Cload out 0 2.000000e-13
Xdut vdd vss inp inn out ib opamp_dut
.end
