* opa1000[0697]: 200f/rail_to_rail_3v3_1u_10u_subth (rail_to_rail, VDD=3.3V, CL=0.2pF, Iref=0.7188uA)
.include "pdk_opa.inc"
.temp 27
.option gmin=1e-12 rshunt=1e12 reltol=1e-3 abstol=1e-12 vntol=1e-5 method=gear
* Post-PEX R+C extracted netlist for rail_to_rail_3v3_1u_10u_subth
.subckt opamp_dut vdd vss inp inn out ib
XMpar0 a_4978_1249.t1 inn.t0 a_9692_8218.t4 vdd.t20 pfet_03v3 w=1.93u l=2u ad=6.6392e-13 pd=3.0040e-06 as=5.4040e-13 ps=2.4900e-06 nf=1 m=30 par=30
XMpar1 a_9692_8218.t1 a_9692_8218.t0 vss.t1 vss.t0 nfet_03v3 w=0.51u l=1.5u ad=1.4280e-13 pd=1.0700e-06 as=1.4280e-13 ps=1.0700e-06 nf=1 m=2 par=2
XMpar2 a_966_6625.t8 a_9792_9811.t0 vdd.t1 vdd.t0 pfet_03v3 w=10u l=1.25u ad=6.0000e-12 pd=2.1200e-05 as=2.8000e-12 ps=1.0560e-05 nf=1 m=2 par=2
XMpar3 out.t0 ib.t0 vss.t11 vss.t10 nfet_03v3 w=1.54u l=1.6u ad=4.3120e-13 pd=2.1000e-06 as=5.5440e-13 ps=2.6450e-06 nf=1 m=8 par=8
XMpar4 a_7026_6789.t0 inn a_9792_9811.t4 vss.t2 nfet_03v3 w=1.53u l=2u ad=5.9160e-13 pd=2.8133e-06 as=4.2840e-13 ps=2.0900e-06 nf=1 m=6 par=6
XMpar5 a_4978_1249.t1 inp.t0 a_5498_1249.t0 vdd.t20 pfet_03v3 w=1.93u l=2u ad=6.6392e-13 pd=3.0040e-06 as=5.4040e-13 ps=2.4900e-06 nf=1 m=30 par=30
XMpar6 a_5498_1249.t31 a_5498_1249.t30 vss.t1 vss.t0 nfet_03v3 w=0.51u l=1.5u ad=3.0600e-13 pd=2.2200e-06 as=1.4280e-13 ps=1.0700e-06 nf=1 m=2 par=2
XMpar7 out.t1 a_966_6625.t11 vdd.t1 vdd.t0 pfet_03v3 w=10u l=1.25u ad=2.8000e-12 pd=1.0560e-05 as=3.6000e-12 ps=1.3220e-05 nf=1 m=8 par=8
XMpar8 a_4978_1249.t0 a_5447_8262.t2 vdd.t3 vdd.t2 pfet_03v3 w=7.29u l=1.6u ad=4.3740e-12 pd=1.5780e-05 as=2.0412e-12 ps=7.8500e-06 nf=1 m=2 par=2
XMpar9 a_7026_6789.t6 ib.t0 vss.t11 vss.t10 nfet_03v3 w=1.54u l=1.6u ad=9.2400e-13 pd=4.2800e-06 as=4.3120e-13 ps=2.1000e-06 nf=1 m=2 par=2
XMpar10 a_966_6625.t0 a_9692_8218.t0 vss.t1 vss.t0 nfet_03v3 w=0.51u l=1.5u ad=3.0600e-13 pd=2.2200e-06 as=1.4280e-13 ps=1.0700e-06 nf=1 m=2 par=2
XMpar11 ib.t1 ib.t0 vss.t11 vss.t10 nfet_03v3 w=1.54u l=1.6u ad=9.2400e-13 pd=4.2800e-06 as=4.3120e-13 ps=2.1000e-06 nf=1 m=2 par=2
XMpar12 a_9792_9811.t1 a_9792_9811.t0 vdd.t1 vdd.t0 pfet_03v3 w=10u l=1.25u ad=2.8000e-12 pd=1.0560e-05 as=2.8000e-12 ps=1.0560e-05 nf=1 m=2 par=2
XMpar13 a_7026_6789.t0 inp.t30 a_966_6625.t2 vss.t2 nfet_03v3 w=1.53u l=2u ad=5.9160e-13 pd=2.8133e-06 as=4.2840e-13 ps=2.0900e-06 nf=1 m=6 par=6
XMpar14 a_5447_8262.t0 ib.t0 vss.t11 vss.t10 nfet_03v3 w=1.54u l=1.6u ad=4.3120e-13 pd=2.1000e-06 as=4.3120e-13 ps=2.1000e-06 nf=1 m=2 par=2
XMpar15 a_9792_9811.t10 a_5498_1249.t30 vss.t1 vss.t0 nfet_03v3 w=0.51u l=1.5u ad=1.4280e-13 pd=1.0700e-06 as=1.4280e-13 ps=1.0700e-06 nf=1 m=2 par=2
XMpar16 a_5447_8262.t3 a_5447_8262.t2 vdd.t3 vdd.t2 pfet_03v3 w=7.29u l=1.6u ad=2.0412e-12 pd=7.8500e-06 as=2.0412e-12 ps=7.8500e-06 nf=1 m=2 par=2
X20 a_16255_7395.t0 a_19071_6875.t0 vss.t38 ppolyf_u_1k r_width=1u r_length=13.42u
X38 a_966_6625.t10 a_19071_6875.t0 vss.t38 ppolyf_u_1k r_width=1u r_length=13.42u
X98 a_16255_7395.t1 out.t14 cap_mim_2f0fF c_width=17.43u c_length=17.43u
Rpar0 a_16255_7395.t0 a_16255_7395.t1 69.1683
Rpar1 a_4978_1249.t0 a_4978_1249.t1 65.9553
Rpar2 a_5447_8262.t0 a_5447_8262.t2 281.0303
Rpar3 a_5447_8262.t0 a_5447_8262.t3 91.2699
Rpar4 a_5447_8262.t2 a_5447_8262.t3 26.1534
Rpar5 a_5498_1249.t0 a_5498_1249.t30 107.8335
Rpar6 a_5498_1249.t0 a_5498_1249.t31 68.4277
Rpar7 a_5498_1249.t30 a_5498_1249.t31 22.2187
Rpar8 a_7026_6789.t0 a_7026_6789.t6 100.7535
Rpar9 a_966_6625.t0 a_966_6625.t10 488.9150
Rpar10 a_966_6625.t0 a_966_6625.t11 333.0095
Rpar11 a_966_6625.t0 a_966_6625.t2 114.2465
Rpar12 a_966_6625.t0 a_966_6625.t8 78.4049
Rpar13 a_966_6625.t10 a_966_6625.t11 2995.7636
Rpar14 a_966_6625.t10 a_966_6625.t2 1027.7653
Rpar15 a_966_6625.t10 a_966_6625.t8 208.2651
Rpar16 a_966_6625.t11 a_966_6625.t2 99.4989
Rpar17 a_966_6625.t11 a_966_6625.t8 480.4161
Rpar18 a_966_6625.t2 a_966_6625.t8 164.8178
Rpar19 a_9692_8218.t0 a_9692_8218.t1 29.2213
Rpar20 a_9692_8218.t0 a_9692_8218.t4 133.0093
Rpar21 a_9692_8218.t1 a_9692_8218.t4 130.7863
Rpar22 a_9792_9811.t0 a_9792_9811.t1 31.4288
Rpar23 a_9792_9811.t0 a_9792_9811.t10 1037.1232
Rpar24 a_9792_9811.t0 a_9792_9811.t4 307.9699
Rpar25 a_9792_9811.t1 a_9792_9811.t10 278.1048
Rpar26 a_9792_9811.t1 a_9792_9811.t4 82.5822
Rpar27 a_9792_9811.t10 a_9792_9811.t4 74.6408
Rpar28 ib ib.t0 27.3575
Rpar29 ib ib.t1 7.7223
Rpar30 ib.t0 ib.t1 39.9856
Rpar31 inn inn.t0 44.7346
Rpar32 inp inp.t0 44.6860
Rpar33 inp inp.t30 1.8266
Rpar34 out out.t0 148.9605
Rpar35 out out.t1 2.4067
Rpar36 out out.t14 510.5033
Rpar37 out.t0 out.t1 134.5247
Rpar38 out.t0 out.t14 150.4489
Rpar39 out.t1 out.t14 461.0303
Rpar40 vdd vdd.t0 99.7788
Rpar41 vdd vdd.t1 312.9089
Rpar42 vdd vdd.t2 81.6860
Rpar43 vdd vdd.t3 185.0599
Rpar44 vdd vdd.t20 1003.9835
Rpar45 vdd.t0 vdd.t1 3.7041
Rpar46 vdd.t0 vdd.t2 70.5990
Rpar47 vdd.t0 vdd.t3 159.9423
Rpar48 vdd.t0 vdd.t20 108.3718
Rpar49 vdd.t1 vdd.t2 218.8011
Rpar50 vdd.t1 vdd.t3 495.6946
Rpar51 vdd.t1 vdd.t20 326.5509
Rpar52 vdd.t2 vdd.t3 9.8594
Rpar53 vdd.t2 vdd.t20 335.0984
Rpar54 vdd.t3 vdd.t20 759.1667
Rpar55 vss vss.t0 550.1190
Rpar56 vss vss.t1 1041.3890
Rpar57 vss vss.t10 318.2497
Rpar58 vss vss.t11 1595.8746
Rpar59 vss vss.t2 296.7078
Rpar60 vss vss.t38 105.2900
Rpar61 vss.t0 vss.t1 15.4240
Rpar62 vss.t0 vss.t10 8.3315
Rpar63 vss.t0 vss.t11 65.9583
Rpar64 vss.t0 vss.t2 4.2371
Rpar65 vss.t0 vss.t38 236.7153
Rpar66 vss.t1 vss.t10 18.6724
Rpar67 vss.t1 vss.t11 135.4922
Rpar68 vss.t1 vss.t2 12.4212
Rpar69 vss.t1 vss.t38 450.1559
Rpar70 vss.t10 vss.t11 6.3417
Rpar71 vss.t10 vss.t2 2.1461
Rpar72 vss.t10 vss.t38 106.8921
Rpar73 vss.t11 vss.t2 14.7829
Rpar74 vss.t11 vss.t38 480.3832
Rpar75 vss.t2 vss.t38 118.3888
Cpar0 a_16255_7395.t0 vss 1.29840e-16
Cpar1 a_16255_7395.t1 vss 3.88462e-15
Cpar2 a_19071_6875.t0 vss 4.07600e-17
Cpar3 a_4978_1249.t0 vss 9.90792e-15
Cpar4 a_4978_1249.t1 vss 4.34694e-14
Cpar5 a_5447_8262.t0 vss 3.50415e-15
Cpar6 a_5447_8262.t2 vss 8.17026e-15
Cpar7 a_5447_8262.t3 vss 4.33018e-15
Cpar8 a_5498_1249.t0 vss 2.45503e-14
Cpar9 a_5498_1249.t30 vss 4.89572e-15
Cpar10 a_5498_1249.t31 vss 2.80540e-15
Cpar11 a_7026_6789.t0 vss 1.31792e-14
Cpar12 a_7026_6789.t6 vss 1.35405e-14
Cpar13 a_966_6625.t0 vss 4.07440e-15
Cpar14 a_966_6625.t10 vss 7.09726e-15
Cpar15 a_966_6625.t11 vss 1.78290e-14
Cpar16 a_966_6625.t2 vss 4.50299e-15
Cpar17 a_966_6625.t8 vss 1.04480e-14
Cpar18 a_9692_8218.t0 vss 5.37638e-15
Cpar19 a_9692_8218.t1 vss 2.34755e-15
Cpar20 a_9692_8218.t4 vss 2.46109e-14
Cpar21 a_9792_9811.t0 vss 6.33854e-15
Cpar22 a_9792_9811.t1 vss 3.99578e-15
Cpar23 a_9792_9811.t10 vss 1.61098e-15
Cpar24 a_9792_9811.t4 vss 3.28635e-15
Cpar25 ib out 1.30084e-15
Cpar26 ib vdd 1.28400e-16
Cpar27 ib vss 1.84364e-14
Cpar28 ib.t0 vss 6.85976e-15
Cpar29 ib.t1 vss 6.86858e-16
Cpar30 inn inp 2.10040e-16
Cpar31 inn vdd 2.63001e-14
Cpar32 inn vss 1.92019e-14
Cpar33 inn.t0 vss 3.64011e-14
Cpar34 inp vdd 2.66706e-14
Cpar35 inp vss 1.33879e-14
Cpar36 inp.t0 vss 3.79921e-14
Cpar37 inp.t30 vss 3.94491e-15
Cpar38 out vdd 1.17324e-14
Cpar39 out vss 1.76935e-14
Cpar40 out.t0 vss 7.54016e-15
Cpar41 out.t1 vss 1.05697e-14
Cpar42 out.t14 vss 1.45237e-14
Cpar43 vdd vss 2.54894e-13
Cpar44 vdd.t0 vss 2.43892e-14
Cpar45 vdd.t1 vss 1.19674e-14
Cpar46 vdd.t2 vss 8.60826e-15
Cpar47 vdd.t20 vss 6.58722e-14
Cpar48 vdd.t3 vss 4.75986e-15
.ends opamp_dut

Vdd vdd 0 3.300000
Vss vss 0 0
Ibias vdd ib 7.188000e-07
Vinp inp 0 DC 1.645000 AC 1 PWL(0 1.645000 2.485252e-08 1.645000 2.733777e-08 1.655000)
Rfb out inn 1m
Cload out 0 2.000000e-13
Xdut vdd vss inp inn out ib opamp_dut
.end
