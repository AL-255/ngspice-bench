* opa1000[0474]: 2p/nmos_miller_1v8_10u_100u_weak (nmos_miller, VDD=1.8V, CL=2.0pF, Iref=5.0uA)
.include "pdk_opa.inc"
.temp 27
.option gmin=1e-12 rshunt=1e12 reltol=1e-3 abstol=1e-12 vntol=1e-5 method=gear
* Post-PEX R+C extracted netlist for nmos_miller_1v8_10u_100u_weak
.subckt opamp_dut vdd vss inp inn out ib
XMpar0 out.t1 a_1002_5812.t9 vdd.t1 vdd.t0 pfet_03v3 w=8.55u l=0.75u ad=2.3940e-12 pd=9.1100e-06 as=2.9412e-12 ps=1.0948e-05 nf=1 m=10 par=10
XMpar1 a_3986_8173.t0 inn.t0 a_5512_9701.t0 vss.t0 nfet_03v3 w=1.81u l=0.8u ad=6.9987e-13 pd=3.1867e-06 as=5.0680e-13 ps=2.3700e-06 nf=1 m=6 par=6
XMpar2 a_1002_5812.t6 a_5512_9701.t6 vdd.t1 vdd.t0 pfet_03v3 w=8.55u l=0.75u ad=5.1300e-12 pd=1.8300e-05 as=2.3940e-12 ps=9.1100e-06 nf=1 m=2 par=2
XMpar3 a_1002_5812.t0 inp.t0 a_3986_8173.t0 vss.t0 nfet_03v3 w=1.81u l=0.8u ad=5.0680e-13 pd=2.3700e-06 as=6.9987e-13 ps=3.1867e-06 nf=1 m=6 par=6
XMpar4 out.t8 ib.t0 vss.t13 vss.t0 nfet_03v3 w=3.53u l=1.5u ad=1.2143e-12 pd=4.9240e-06 as=9.8840e-13 ps=4.0900e-06 nf=1 m=10 par=10
XMpar5 a_3986_8173.t12 ib.t0 vss.t13 vss.t0 nfet_03v3 w=3.53u l=1.5u ad=9.8840e-13 pd=4.0900e-06 as=9.8840e-13 ps=4.0900e-06 nf=1 m=4 par=4
XMpar6 ib.t1 ib.t0 vss.t13 vss.t0 nfet_03v3 w=3.53u l=1.5u ad=9.8840e-13 pd=4.0900e-06 as=9.8840e-13 ps=4.0900e-06 nf=1 m=2 par=2
XMpar7 a_5512_9701.t7 a_5512_9701.t6 vdd.t1 vdd.t0 pfet_03v3 w=8.55u l=0.75u ad=2.3940e-12 pd=9.1100e-06 as=2.3940e-12 ps=9.1100e-06 nf=1 m=2 par=2
X23 a_1002_5812.t8 a_2246_5812.t0 vss.t44 ppolyf_u_1k r_width=1u r_length=5.56u
X25 a_2246_5812.t1 out.t0 cap_mim_2f0fF c_width=14.37u c_length=14.36u
X33 a_2246_5812.t1 out.t0 cap_mim_2f0fF c_width=14.37u c_length=14.36u
Rpar0 a_1002_5812.t0 a_1002_5812.t9 203.0654
Rpar1 a_1002_5812.t0 a_1002_5812.t6 232.3607
Rpar2 a_1002_5812.t0 a_1002_5812.t8 77.2249
Rpar3 a_1002_5812.t9 a_1002_5812.t6 70.6929
Rpar4 a_1002_5812.t9 a_1002_5812.t8 214.5153
Rpar5 a_1002_5812.t6 a_1002_5812.t8 245.4625
Rpar6 a_2246_5812.t0 a_2246_5812.t1 58.5710
Rpar7 a_3986_8173.t0 a_3986_8173.t12 85.5031
Rpar8 a_5512_9701.t0 a_5512_9701.t6 225.3045
Rpar9 a_5512_9701.t0 a_5512_9701.t7 49.3894
Rpar10 a_5512_9701.t6 a_5512_9701.t7 37.9440
Rpar11 ib ib.t0 24.8135
Rpar12 ib ib.t1 11.1274
Rpar13 ib.t0 ib.t1 55.2146
Rpar14 inn inn.t0 3.2207
Rpar15 inp inp.t0 3.6055
Rpar16 out out.t0 264.4097
Rpar17 out out.t1 1.6501
Rpar18 out out.t8 65.5249
Rpar19 out.t0 out.t8 136.8844
Rpar20 vdd vdd.t0 50.5307
Rpar21 vdd vdd.t1 110.2001
Rpar22 vdd.t0 vdd.t1 3.5401
Rpar23 vss vss.t0 65.0979
Rpar24 vss vss.t13 611.8161
Rpar25 vss vss.t44 135.0582
Rpar26 vss.t0 vss.t13 4.1049
Rpar27 vss.t0 vss.t44 31.5543
Rpar28 vss.t13 vss.t44 386.8350
Cpar0 a_1002_5812.t0 vss 3.08139e-15
Cpar1 a_1002_5812.t6 vss 7.03142e-15
Cpar2 a_1002_5812.t8 vss 2.49013e-15
Cpar3 a_1002_5812.t9 vss 1.29207e-14
Cpar4 a_2246_5812.t0 vss 7.66522e-17
Cpar5 a_2246_5812.t1 vss 4.73461e-15
Cpar6 a_3986_8173.t0 vss 7.03606e-15
Cpar7 a_3986_8173.t12 vss 8.62111e-15
Cpar8 a_5512_9701.t0 vss 2.62787e-15
Cpar9 a_5512_9701.t6 vss 5.07222e-15
Cpar10 a_5512_9701.t7 vss 4.87597e-15
Cpar11 ib inn 1.15100e-17
Cpar12 ib inp 1.12800e-17
Cpar13 ib out 2.26812e-15
Cpar14 ib vss 2.35408e-14
Cpar15 ib.t0 vss 5.21685e-15
Cpar16 ib.t1 vss 4.09274e-16
Cpar17 inn inp 5.23000e-17
Cpar18 inn vss 4.35096e-15
Cpar19 inn.t0 vss 6.27102e-16
Cpar20 inp vss 4.36740e-15
Cpar21 inp.t0 vss 7.11155e-16
Cpar22 out vdd 1.29651e-14
Cpar23 out vss 2.09492e-14
Cpar24 out.t0 vss 1.32824e-14
Cpar25 out.t1 vss 5.72049e-15
Cpar26 out.t8 vss 6.57855e-15
Cpar27 vdd vss 6.10014e-14
Cpar28 vdd.t0 vss 1.86235e-14
Cpar29 vdd.t1 vss 1.08050e-14
.ends opamp_dut

Vdd vdd 0 1.800000
Vss vss 0 0
Ibias vdd ib 5.000000e-06
Vinp inp 0 DC 0.895000 AC 1 PWL(0 0.895000 7.243494e-09 0.895000 7.967843e-09 0.905000)
Rfb out inn 1m
Cload out 0 2.000000e-12
Xdut vdd vss inp inn out ib opamp_dut
.end
