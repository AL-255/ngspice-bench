* opa1000[0388]: 2p/nmos_5t_1v8_i10u_weak (nmos_5t, VDD=1.8V, CL=2.0pF, Iref=2.5uA)
.include "pdk_opa.inc"
.temp 27
.option gmin=1e-12 rshunt=1e12 reltol=1e-3 abstol=1e-12 vntol=1e-5 method=gear
* Post-PEX R+C extracted netlist for nmos_5t_1v8_i10u_weak
.subckt opamp_dut vdd vss inp inn out ib
XMpar0 out.t0 a_1952_5453.t16 vdd.t1 vdd.t0 pfet_03v3 w=2.01u l=2.25u ad=5.6280e-13 pd=2.5700e-06 as=5.6280e-13 ps=2.5700e-06 nf=1 m=12 par=12
XMpar1 a_1442_5453.t8 inp.t0 a_1952_5453.t0 vss.t20 nfet_03v3 w=1.87u l=1.95u ad=6.7320e-13 pd=3.0575e-06 as=5.2360e-13 ps=2.4300e-06 nf=1 m=16 par=16
XMpar2 a_1952_5453.t17 a_1952_5453.t16 vdd.t1 vdd.t0 pfet_03v3 w=2.01u l=2.25u ad=7.7720e-13 pd=3.4533e-06 as=5.6280e-13 ps=2.5700e-06 nf=1 m=12 par=12
XMpar3 a_1442_5453.t8 inn.t0 out.t9 vss.t20 nfet_03v3 w=1.87u l=1.95u ad=6.7320e-13 pd=3.0575e-06 as=5.2360e-13 ps=2.4300e-06 nf=1 m=16 par=16
XMpar4 ib.t1 ib.t0 vss.t1 vss.t0 nfet_03v3 w=2.1u l=1.88u ad=5.8800e-13 pd=2.6600e-06 as=5.8800e-13 ps=2.6600e-06 nf=1 m=2 par=2
XMpar5 a_1442_5453.t0 ib.t0 vss.t1 vss.t0 nfet_03v3 w=2.1u l=1.88u ad=5.8800e-13 pd=2.6600e-06 as=7.5600e-13 ps=3.3450e-06 nf=1 m=8 par=8
X34 out.t28 vss.t36 cap_mim_2f0fF c_width=12.99u c_length=12.99u
Rpar0 a_1442_5453.t0 a_1442_5453.t8 38.9931
Rpar1 a_1952_5453.t0 a_1952_5453.t16 160.7110
Rpar2 a_1952_5453.t0 a_1952_5453.t17 46.2205
Rpar3 a_1952_5453.t16 a_1952_5453.t17 7.3177
Rpar4 ib ib.t0 20.3202
Rpar5 ib ib.t1 11.1822
Rpar6 ib.t0 ib.t1 69.1419
Rpar7 inn inn.t0 1.6948
Rpar8 inp inp.t0 1.6948
Rpar9 out out.t0 4.0105
Rpar10 out out.t9 405.2831
Rpar11 out out.t28 1924.5778
Rpar12 out.t0 out.t9 50.9971
Rpar13 out.t0 out.t28 242.1709
Rpar14 out.t9 out.t28 102.6896
Rpar15 vdd vdd.t0 21.0421
Rpar16 vdd vdd.t1 304.2351
Rpar17 vdd.t0 vdd.t1 11.2304
Rpar18 vss vss.t0 116.9390
Rpar19 vss vss.t1 306.5869
Rpar20 vss vss.t20 66.1818
Rpar21 vss vss.t36 102.0364
Rpar22 vss.t0 vss.t1 11.1026
Rpar23 vss.t0 vss.t20 1.9462
Rpar24 vss.t0 vss.t36 170.6113
Rpar25 vss.t1 vss.t20 6.6966
Rpar26 vss.t1 vss.t36 447.3030
Rpar27 vss.t20 vss.t36 96.5577
Cpar0 a_1442_5453.t0 vss 5.93622e-15
Cpar1 a_1442_5453.t8 vss 2.00890e-14
Cpar2 a_1952_5453.t0 vss 1.12010e-14
Cpar3 a_1952_5453.t16 vss 4.12472e-14
Cpar4 a_1952_5453.t17 vss 1.45057e-14
Cpar5 ib out 1.43600e-17
Cpar6 ib vss 1.69684e-14
Cpar7 ib.t0 vss 2.75740e-15
Cpar8 ib.t1 vss 2.09334e-16
Cpar9 inn inp 1.04880e-16
Cpar10 inn out 3.87191e-15
Cpar11 inn vdd 1.70600e-17
Cpar12 inn vss 1.65681e-14
Cpar13 inn.t0 vss 6.13486e-15
Cpar14 inp out 1.05180e-16
Cpar15 inp vdd 1.62700e-17
Cpar16 inp vss 1.66018e-14
Cpar17 inp.t0 vss 6.05659e-15
Cpar18 out vdd 1.05466e-14
Cpar19 out vss 1.70857e-14
Cpar20 out.t0 vss 3.96772e-15
Cpar21 out.t28 vss 2.34047e-14
Cpar22 out.t9 vss 4.75978e-15
Cpar23 vdd vss 9.18696e-14
Cpar24 vdd.t0 vss 4.25384e-14
Cpar25 vdd.t1 vss 7.09447e-15
.ends opamp_dut

Vdd vdd 0 1.800000
Vss vss 0 0
Ibias vdd ib 2.500000e-06
Vinp inp 0 DC 0.895000 AC 1 PWL(0 0.895000 1.808527e-08 0.895000 1.989379e-08 0.905000)
Rfb out inn 1m
Cload out 0 2.000000e-12
Xdut vdd vss inp inn out ib opamp_dut
.end
