* opa1000[0014]: 200f/cherry_hooper_1v8_i20u_subth (cherry_hooper, VDD=1.8V, CL=0.2pF, Iref=1.5833uA)
.include "pdk_opa.inc"
.temp 27
.option gmin=1e-12 rshunt=1e12 reltol=1e-3 abstol=1e-12 vntol=1e-5 method=gear
* Post-PEX R+C extracted netlist for cherry_hooper_1v8_i20u_subth
.subckt opamp_dut vdd vss inp inn out ib
XMpar0 a_2551_13976.t0 inp.t0 a_8564_18156.t4 vss.t3 nfet_03v3 w=1.94u l=0.65u ad=6.4667e-13 pd=2.9300e-06 as=5.4320e-13 ps=2.5000e-06 nf=1 m=12 par=12
XMpar1 a_3413_8098.t0 a_11534_1294.t28 out.t0 vss.t0 nfet_03v3 w=9.61u l=0.5u ad=5.7660e-12 pd=2.0420e-05 as=2.6908e-12 ps=1.0170e-05 nf=1 m=2 par=2
XMpar2 a_11654_14472.t4 inn.t0 a_2551_13976.t0 vss.t3 nfet_03v3 w=1.94u l=0.65u ad=5.4320e-13 pd=2.5000e-06 as=6.4667e-13 ps=2.9300e-06 nf=1 m=12 par=12
XMpar3 a_11534_1294.t0 a_1564_4381.t33 a_11654_14472.t0 vdd.t2 pfet_03v3 w=6.84u l=1u ad=3.0096e-12 pd=1.1140e-05 as=1.9152e-12 ps=7.4000e-06 nf=1 m=4 par=4
XMpar4 a_1323_1086.t10 a_1323_1086.t9 vdd.t1 vdd.t0 pfet_03v3 w=8.7u l=0.6u ad=2.7453e-12 pd=1.0298e-05 as=2.7453e-12 ps=1.0298e-05 nf=1 m=9 par=9
XMpar5 a_11534_1294.t10 a_11534_1294.t9 vdd.t1 vdd.t0 pfet_03v3 w=8.7u l=0.6u ad=2.7453e-12 pd=1.0298e-05 as=2.7453e-12 ps=1.0298e-05 nf=1 m=9 par=9
XMpar6 a_1135_13976.t0 a_8564_18156.t18 a_1323_1086.t0 vss.t0 nfet_03v3 w=9.61u l=0.5u ad=3.7159e-12 pd=1.3587e-05 as=2.6908e-12 ps=1.0170e-05 nf=1 m=6 par=6
XMpar7 a_1234_7890.t0 a_1564_4381.t0 a_1564_4381.t1 vdd.t6 pfet_03v3 w=10u l=0.6u ad=3.2000e-12 pd=1.1890e-05 as=2.8000e-12 ps=1.0560e-05 nf=1 m=16 par=16
XMpar8 a_1564_4381.t32 ib.t0 vss.t22 vss.t21 nfet_03v3 w=4.67u l=1.2u ad=2.8020e-12 pd=1.0540e-05 as=2.8020e-12 ps=1.0540e-05 nf=1 m=1
XMpar9 a_1323_1086.t2 a_1564_4381.t33 a_8564_18156.t0 vdd.t2 pfet_03v3 w=6.84u l=1u ad=3.0096e-12 pd=1.1140e-05 as=1.9152e-12 ps=7.4000e-06 nf=1 m=4 par=4
XMpar10 a_2551_13976.t12 ib.t0 vss.t22 vss.t21 nfet_03v3 w=4.67u l=1.2u ad=1.3076e-12 pd=5.2300e-06 as=1.3076e-12 ps=5.2300e-06 nf=1 m=2 par=2
XMpar11 a_1135_13976.t6 ib.t0 vss.t22 vss.t21 nfet_03v3 w=4.67u l=1.2u ad=1.8057e-12 pd=7.0000e-06 as=1.3076e-12 ps=5.2300e-06 nf=1 m=6 par=6
XMpar12 a_1135_13976.t0 a_11654_14472.t18 a_11534_1294.t4 vss.t0 nfet_03v3 w=9.61u l=0.5u ad=3.7159e-12 pd=1.3587e-05 as=2.6908e-12 ps=1.0170e-05 nf=1 m=6 par=6
XMpar13 out.t2 a_10820_8065.t2 vdd.t1 vdd.t0 pfet_03v3 w=8.7u l=0.6u ad=3.3640e-12 pd=1.2373e-05 as=2.4360e-12 ps=9.2600e-06 nf=1 m=3 par=3
XMpar14 a_10820_8065.t3 a_10820_8065.t2 vdd.t1 vdd.t0 pfet_03v3 w=8.7u l=0.6u ad=3.3640e-12 pd=1.2373e-05 as=2.4360e-12 ps=9.2600e-06 nf=1 m=3 par=3
XMpar15 a_11654_14472.t16 a_1947_11258.t1 vdd.t51 vdd.t50 pfet_03v3 w=8.25u l=1.2u ad=2.3100e-12 pd=8.8100e-06 as=4.9500e-12 ps=1.7700e-05 nf=1 m=2 par=2
XMpar16 a_1234_7890.t10 a_1234_7890.t9 vdd.t1 vdd.t0 pfet_03v3 w=8.7u l=0.6u ad=3.3640e-12 pd=1.2373e-05 as=3.3640e-12 ps=1.2373e-05 nf=1 m=3 par=3
XMpar17 a_3413_8098.t3 ib.t0 vss.t22 vss.t21 nfet_03v3 w=4.67u l=1.2u ad=1.3076e-12 pd=5.2300e-06 as=2.8020e-12 ps=1.0540e-05 nf=1 m=2 par=2
XMpar18 a_10820_8065.t0 a_1323_1086.t28 a_3413_8098.t0 vss.t0 nfet_03v3 w=9.61u l=0.5u ad=2.6908e-12 pd=1.0170e-05 as=5.7660e-12 ps=2.0420e-05 nf=1 m=2 par=2
XMpar19 ib.t1 ib.t0 vss.t22 vss.t21 nfet_03v3 w=4.67u l=1.2u ad=2.8020e-12 pd=1.0540e-05 as=1.3076e-12 ps=5.2300e-06 nf=1 m=1
XMpar20 a_1947_11258.t2 a_1947_11258.t1 vdd.t51 vdd.t50 pfet_03v3 w=8.25u l=1.2u ad=2.3100e-12 pd=8.8100e-06 as=4.9500e-12 ps=1.7700e-05 nf=1 m=2 par=2
XMpar21 a_8564_18156.t16 a_1947_11258.t1 vdd.t51 vdd.t50 pfet_03v3 w=8.25u l=1.2u ad=2.3100e-12 pd=8.8100e-06 as=4.9500e-12 ps=1.7700e-05 nf=1 m=2 par=2
XMpar22 a_1947_11258.t0 ib.t0 vss.t22 vss.t21 nfet_03v3 w=4.67u l=1.2u ad=2.8020e-12 pd=1.0540e-05 as=1.3076e-12 ps=5.2300e-06 nf=1 m=1
X6 out.t5 vss.t64 cap_mim_2f0fF c_width=19.69u c_length=19.69u
X69 out.t5 vss.t64 cap_mim_2f0fF c_width=19.69u c_length=19.69u
X73 out.t5 vss.t64 cap_mim_2f0fF c_width=19.69u c_length=19.69u
X88 out.t5 vss.t64 cap_mim_2f0fF c_width=19.69u c_length=19.69u
X91 out.t5 vss.t64 cap_mim_2f0fF c_width=19.69u c_length=19.69u
X98 out.t5 vss.t64 cap_mim_2f0fF c_width=19.69u c_length=19.69u
X105 out.t5 vss.t64 cap_mim_2f0fF c_width=19.69u c_length=19.69u
X115 out.t5 vss.t64 cap_mim_2f0fF c_width=19.69u c_length=19.69u
Rpar0 a_10820_8065.t0 a_10820_8065.t2 339.4717
Rpar1 a_10820_8065.t0 a_10820_8065.t3 45.1643
Rpar2 a_10820_8065.t2 a_10820_8065.t3 29.1731
Rpar3 a_1135_13976.t0 a_1135_13976.t6 75.1881
Rpar4 a_11534_1294.t0 a_11534_1294.t10 71.4183
Rpar5 a_11534_1294.t0 a_11534_1294.t9 655.0269
Rpar6 a_11534_1294.t0 a_11534_1294.t4 130.0771
Rpar7 a_11534_1294.t0 a_11534_1294.t28 197.5329
Rpar8 a_11534_1294.t10 a_11534_1294.t9 22.5580
Rpar9 a_11534_1294.t10 a_11534_1294.t4 299.9335
Rpar10 a_11534_1294.t10 a_11534_1294.t28 455.4739
Rpar11 a_11534_1294.t9 a_11534_1294.t4 2750.8970
Rpar12 a_11534_1294.t9 a_11534_1294.t28 4177.4655
Rpar13 a_11534_1294.t4 a_11534_1294.t28 210.6760
Rpar14 a_11654_14472.t0 a_11654_14472.t4 149.9231
Rpar15 a_11654_14472.t0 a_11654_14472.t16 81.0416
Rpar16 a_11654_14472.t0 a_11654_14472.t18 85.7142
Rpar17 a_11654_14472.t4 a_11654_14472.t16 169.2710
Rpar18 a_11654_14472.t4 a_11654_14472.t18 160.8031
Rpar19 a_11654_14472.t16 a_11654_14472.t18 96.7758
Rpar20 a_1234_7890.t0 a_1234_7890.t10 40.1820
Rpar21 a_1234_7890.t0 a_1234_7890.t9 410.9842
Rpar22 a_1234_7890.t10 a_1234_7890.t9 44.3156
Rpar23 a_1323_1086.t0 a_1323_1086.t10 299.9335
Rpar24 a_1323_1086.t0 a_1323_1086.t9 2750.8970
Rpar25 a_1323_1086.t0 a_1323_1086.t2 130.0771
Rpar26 a_1323_1086.t0 a_1323_1086.t28 210.6760
Rpar27 a_1323_1086.t10 a_1323_1086.t9 22.5580
Rpar28 a_1323_1086.t10 a_1323_1086.t2 71.4183
Rpar29 a_1323_1086.t10 a_1323_1086.t28 455.4739
Rpar30 a_1323_1086.t9 a_1323_1086.t2 655.0269
Rpar31 a_1323_1086.t9 a_1323_1086.t28 4177.4655
Rpar32 a_1323_1086.t2 a_1323_1086.t28 197.5329
Rpar33 a_1564_4381.t0 a_1564_4381.t1 18.8157
Rpar34 a_1564_4381.t0 a_1564_4381.t32 3877.8168
Rpar35 a_1564_4381.t0 a_1564_4381.t33 3492.4887
Rpar36 a_1564_4381.t1 a_1564_4381.t32 80.8789
Rpar37 a_1564_4381.t1 a_1564_4381.t33 72.8422
Rpar38 a_1564_4381.t32 a_1564_4381.t33 361.8931
Rpar39 a_1947_11258.t0 a_1947_11258.t1 109.3425
Rpar40 a_1947_11258.t0 a_1947_11258.t2 107.2683
Rpar41 a_1947_11258.t1 a_1947_11258.t2 31.3517
Rpar42 a_2551_13976.t0 a_2551_13976.t12 88.5449
Rpar43 a_3413_8098.t0 a_3413_8098.t3 62.6253
Rpar44 a_8564_18156.t0 a_8564_18156.t4 149.9229
Rpar45 a_8564_18156.t0 a_8564_18156.t16 81.0415
Rpar46 a_8564_18156.t0 a_8564_18156.t18 85.7141
Rpar47 a_8564_18156.t4 a_8564_18156.t16 169.2711
Rpar48 a_8564_18156.t4 a_8564_18156.t18 160.8032
Rpar49 a_8564_18156.t16 a_8564_18156.t18 96.7759
Rpar50 ib ib.t0 2.7662
Rpar51 ib ib.t1 129.0748
Rpar52 ib.t0 ib.t1 23.5302
Rpar53 inn inn.t0 2.4225
Rpar54 inp inp.t0 2.8037
Rpar55 out out.t0 55.1770
Rpar56 out out.t5 162.2358
Rpar57 out out.t2 3.8164
Rpar58 out.t0 out.t5 324.0797
Rpar59 out.t0 out.t2 181.3735
Rpar60 out.t5 out.t2 533.2887
Rpar61 vdd vdd.t0 439.5877
Rpar62 vdd vdd.t1 1048.4337
Rpar63 vdd vdd.t2 2911.8693
Rpar64 vdd vdd.t6 4490.9699
Rpar65 vdd vdd.t50 310.0141
Rpar66 vdd vdd.t51 130.0230
Rpar67 vdd.t0 vdd.t1 1.7998
Rpar68 vdd.t0 vdd.t2 65.3925
Rpar69 vdd.t0 vdd.t6 84.3094
Rpar70 vdd.t0 vdd.t50 136.7822
Rpar71 vdd.t0 vdd.t51 63.1649
Rpar72 vdd.t1 vdd.t2 189.9481
Rpar73 vdd.t1 vdd.t6 244.6608
Rpar74 vdd.t1 vdd.t50 271.0392
Rpar75 vdd.t1 vdd.t51 145.0928
Rpar76 vdd.t2 vdd.t6 85.3900
Rpar77 vdd.t2 vdd.t50 1411.5511
Rpar78 vdd.t2 vdd.t51 448.6329
Rpar79 vdd.t6 vdd.t50 2177.0322
Rpar80 vdd.t6 vdd.t51 691.9256
Rpar81 vdd.t50 vdd.t51 5.0285
Rpar82 vss vss.t0 35.6083
Rpar83 vss vss.t3 626.2730
Rpar84 vss vss.t21 3338.3694
Rpar85 vss vss.t22 6180.3483
Rpar86 vss vss.t64 7058.7877
Rpar87 vss.t0 vss.t3 8.8821
Rpar88 vss.t0 vss.t21 160.3961
Rpar89 vss.t0 vss.t22 296.5801
Rpar90 vss.t0 vss.t64 342.1373
Rpar91 vss.t3 vss.t21 214.3483
Rpar92 vss.t3 vss.t22 439.6290
Rpar93 vss.t3 vss.t64 559.7295
Rpar94 vss.t21 vss.t22 2.8369
Rpar95 vss.t21 vss.t64 137.0478
Rpar96 vss.t22 vss.t64 253.8759
Cpar0 a_10820_8065.t0 vss 3.60006e-15
Cpar1 a_10820_8065.t2 vss 6.02502e-15
Cpar2 a_10820_8065.t3 vss 7.76301e-15
Cpar3 a_1135_13976.t0 vss 2.11572e-14
Cpar4 a_1135_13976.t6 vss 7.74617e-15
Cpar5 a_11534_1294.t0 vss 8.87943e-15
Cpar6 a_11534_1294.t10 vss 1.51442e-14
Cpar7 a_11534_1294.t28 vss 2.58869e-15
Cpar8 a_11534_1294.t4 vss 1.10774e-14
Cpar9 a_11534_1294.t9 vss 8.34388e-15
Cpar10 a_11654_14472.t0 vss 6.43090e-15
Cpar11 a_11654_14472.t16 vss 4.08562e-15
Cpar12 a_11654_14472.t18 vss 5.81456e-15
Cpar13 a_11654_14472.t4 vss 6.04597e-15
Cpar14 a_1234_7890.t0 vss 2.89773e-14
Cpar15 a_1234_7890.t10 vss 8.43753e-15
Cpar16 a_1234_7890.t9 vss 3.33230e-15
Cpar17 a_1323_1086.t0 vss 1.15127e-14
Cpar18 a_1323_1086.t10 vss 1.57392e-14
Cpar19 a_1323_1086.t2 vss 9.22829e-15
Cpar20 a_1323_1086.t28 vss 2.69039e-15
Cpar21 a_1323_1086.t9 vss 8.67158e-15
Cpar22 a_1564_4381.t0 vss 1.49251e-14
Cpar23 a_1564_4381.t1 vss 2.42377e-14
Cpar24 a_1564_4381.t32 vss 4.04196e-15
Cpar25 a_1564_4381.t33 vss 1.13768e-14
Cpar26 a_1947_11258.t0 vss 3.00941e-15
Cpar27 a_1947_11258.t1 vss 9.96044e-15
Cpar28 a_1947_11258.t2 vss 4.17859e-15
Cpar29 a_2551_13976.t0 vss 1.35078e-14
Cpar30 a_2551_13976.t12 vss 4.49204e-15
Cpar31 a_3413_8098.t0 vss 7.01777e-15
Cpar32 a_3413_8098.t3 vss 1.94126e-15
Cpar33 a_8564_18156.t0 vss 7.49330e-15
Cpar34 a_8564_18156.t16 vss 4.76054e-15
Cpar35 a_8564_18156.t18 vss 6.77513e-15
Cpar36 a_8564_18156.t4 vss 7.04479e-15
Cpar37 ib vdd 8.16360e-16
Cpar38 ib vss 2.42679e-14
Cpar39 ib.t0 vss 3.13778e-15
Cpar40 ib.t1 vss 9.74974e-16
Cpar41 inn inp 5.23500e-17
Cpar42 inn vss 7.66356e-15
Cpar43 inn.t0 vss 1.08065e-15
Cpar44 inp vdd 1.15300e-17
Cpar45 inp vss 7.55806e-15
Cpar46 inp.t0 vss 1.25414e-15
Cpar47 out vdd 7.86111e-15
Cpar48 out vss 6.98550e-14
Cpar49 out.t0 vss 6.77098e-17
Cpar50 out.t2 vss 7.15159e-17
Cpar51 out.t5 vss 1.33129e-14
Cpar52 vdd vss 2.45724e-13
Cpar53 vdd.t0 vss 3.62942e-14
Cpar54 vdd.t1 vss 2.03299e-14
Cpar55 vdd.t2 vss 1.31278e-14
Cpar56 vdd.t50 vss 1.16912e-14
Cpar57 vdd.t51 vss 1.21970e-14
Cpar58 vdd.t6 vss 2.10016e-14
.ends opamp_dut

Vdd vdd 0 1.800000
Vss vss 0 0
Ibias vdd ib 1.583300e-06
Vinp inp 0 DC 1.175600 AC 1 PWL(0 1.175600 2.524085e-08 1.175600 2.776493e-08 1.185600)
Rfb out inn 1m
Cload out 0 2.000000e-13
Xdut vdd vss inp inn out ib opamp_dut
.end
