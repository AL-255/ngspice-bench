* opa1000[0829]: 2p/symmetrical_ota_3v3_10u_100u_weak (symmetrical_ota, VDD=3.3V, CL=2.0pF, Iref=9.5833uA)
.include "pdk_opa.inc"
.temp 27
.option gmin=1e-12 rshunt=1e12 reltol=1e-3 abstol=1e-12 vntol=1e-5 method=gear
* Post-PEX R+C extracted netlist for symmetrical_ota_3v3_10u_100u_weak
.subckt opamp_dut vdd vss inp inn out ib
XMpar0 ib.t1 ib.t0 vss.t31 vss.t30 nfet_03v3 w=2.34u l=0.65u ad=6.5520e-13 pd=2.9000e-06 as=6.5520e-13 ps=2.9000e-06 nf=1 m=2 par=2
XMpar1 a_1185_996.t4 inp.t0 a_1314_6615.t0 vss.t0 nfet_03v3 w=2.02u l=0.6u ad=5.6560e-13 pd=2.5800e-06 as=6.9488e-13 ps=3.1120e-06 nf=1 m=10 par=10
XMpar2 a_4108_6452.t8 a_5694_4836.t10 vdd.t1 vdd.t0 pfet_03v3 w=10u l=1.25u ad=2.8000e-12 pd=1.0560e-05 as=4.4000e-12 ps=1.5880e-05 nf=1 m=4 par=4
XMpar3 a_5694_4836.t11 a_5694_4836.t10 vdd.t1 vdd.t0 pfet_03v3 w=10u l=1.25u ad=2.8000e-12 pd=1.0560e-05 as=2.8000e-12 ps=1.0560e-05 nf=1 m=2 par=2
XMpar4 a_1314_6615.t20 ib.t0 vss.t31 vss.t30 nfet_03v3 w=2.34u l=0.65u ad=6.5520e-13 pd=2.9000e-06 as=1.0296e-12 ps=4.3900e-06 nf=1 m=4 par=4
XMpar5 a_1314_6615.t0 inn.t0 a_5694_4836.t0 vss.t0 nfet_03v3 w=2.02u l=0.6u ad=6.9488e-13 pd=3.1120e-06 as=5.6560e-13 ps=2.5800e-06 nf=1 m=10 par=10
XMpar6 a_4108_6452.t1 a_4108_6452.t0 vss.t1 vss.t0 nfet_03v3 w=2.94u l=1.25u ad=8.2320e-13 pd=3.5000e-06 as=8.2320e-13 ps=3.5000e-06 nf=1 m=4 par=4
XMpar7 a_1185_996.t1 a_1185_996.t0 vdd.t1 vdd.t0 pfet_03v3 w=10u l=1.25u ad=2.8000e-12 pd=1.0560e-05 as=2.8000e-12 ps=1.0560e-05 nf=1 m=2 par=2
XMpar8 out.t1 a_4108_6452.t0 vss.t1 vss.t0 nfet_03v3 w=2.94u l=1.25u ad=8.2320e-13 pd=3.5000e-06 as=1.2936e-12 ps=5.2900e-06 nf=1 m=4 par=4
XMpar9 out.t0 a_1185_996.t0 vdd.t1 vdd.t0 pfet_03v3 w=10u l=1.25u ad=2.8000e-12 pd=1.0560e-05 as=4.4000e-12 ps=1.5880e-05 nf=1 m=4 par=4
X36 out.t8 vss.t44 cap_mim_2f0fF c_width=9.69u c_length=9.68u
Rpar0 a_1185_996.t0 a_1185_996.t1 29.4257
Rpar1 a_1185_996.t0 a_1185_996.t4 136.7926
Rpar2 a_1185_996.t1 a_1185_996.t4 54.8506
Rpar3 a_1314_6615.t0 a_1314_6615.t20 68.2956
Rpar4 a_4108_6452.t0 a_4108_6452.t1 18.4694
Rpar5 a_4108_6452.t0 a_4108_6452.t8 312.6826
Rpar6 a_4108_6452.t1 a_4108_6452.t8 74.7140
Rpar7 a_5694_4836.t0 a_5694_4836.t10 136.7926
Rpar8 a_5694_4836.t0 a_5694_4836.t11 54.8506
Rpar9 a_5694_4836.t10 a_5694_4836.t11 29.4257
Rpar10 ib ib.t0 15.9635
Rpar11 ib ib.t1 8.4257
Rpar12 inn inn.t0 3.5882
Rpar13 inp inp.t0 3.6368
Rpar14 out out.t0 114.7403
Rpar15 out out.t1 4.3591
Rpar16 out out.t8 299.0149
Rpar17 out.t0 out.t1 281.0732
Rpar18 out.t0 out.t8 55.5894
Rpar19 out.t1 out.t8 732.4807
Rpar20 vdd vdd.t0 75.7644
Rpar21 vdd vdd.t1 218.7052
Rpar22 vdd.t0 vdd.t1 3.2196
Rpar23 vss vss.t0 60.6903
Rpar24 vss vss.t1 341.9419
Rpar25 vss vss.t30 375.4070
Rpar26 vss vss.t31 388.5369
Rpar27 vss vss.t44 44.3032
Rpar28 vss.t0 vss.t1 3.8197
Rpar29 vss.t0 vss.t30 43.1567
Rpar30 vss.t0 vss.t31 49.2747
Rpar31 vss.t0 vss.t44 384.1857
Rpar32 vss.t1 vss.t30 323.5482
Rpar33 vss.t1 vss.t31 370.3190
Rpar34 vss.t1 vss.t44 2164.5843
Rpar35 vss.t30 vss.t31 7.9955
Rpar36 vss.t30 vss.t44 2376.4273
Rpar37 vss.t31 vss.t44 2459.5431
Cpar0 a_1185_996.t0 vss 1.19008e-14
Cpar1 a_1185_996.t1 vss 4.66381e-15
Cpar2 a_1185_996.t4 vss 4.51500e-15
Cpar3 a_1314_6615.t0 vss 1.13892e-14
Cpar4 a_1314_6615.t20 vss 4.62087e-15
Cpar5 a_4108_6452.t0 vss 4.41116e-15
Cpar6 a_4108_6452.t1 vss 2.33520e-15
Cpar7 a_4108_6452.t8 vss 4.09440e-15
Cpar8 a_5694_4836.t0 vss 4.32233e-15
Cpar9 a_5694_4836.t10 vss 1.13930e-14
Cpar10 a_5694_4836.t11 vss 4.46481e-15
Cpar11 ib out 2.23700e-17
Cpar12 ib vss 6.92388e-15
Cpar13 ib.t0 vss 7.43659e-16
Cpar14 ib.t1 vss 1.54839e-16
Cpar15 inn inp 5.18200e-17
Cpar16 inn out 1.67800e-17
Cpar17 inn vdd 1.18500e-17
Cpar18 inn vss 6.17469e-15
Cpar19 inn.t0 vss 9.88127e-16
Cpar20 inp out 2.71300e-17
Cpar21 inp vdd 1.08800e-17
Cpar22 inp vss 6.11638e-15
Cpar23 inp.t0 vss 9.97111e-16
Cpar24 out vdd 5.76081e-15
Cpar25 out vss 1.21167e-14
Cpar26 out.t0 vss 2.64009e-15
Cpar27 out.t1 vss 7.58934e-16
Cpar28 out.t8 vss 1.00218e-14
Cpar29 vdd vss 8.34440e-14
Cpar30 vdd.t0 vss 1.94101e-14
Cpar31 vdd.t1 vss 9.43651e-15
.ends opamp_dut

Vdd vdd 0 3.300000
Vss vss 0 0
Ibias vdd ib 9.583300e-06
Vinp inp 0 DC 1.645000 AC 1 PWL(0 1.645000 4.202637e-09 1.645000 4.622900e-09 1.655000)
Rfb out inn 1m
Cload out 0 2.000000e-12
Xdut vdd vss inp inn out ib opamp_dut
.end
