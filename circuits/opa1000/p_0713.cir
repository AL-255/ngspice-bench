* opa1000[0713]: 2p/rail_to_rail_1v8_0p1u_1u_subth (rail_to_rail, VDD=1.8V, CL=2.0pF, Iref=0.0656uA)
.include "pdk_opa.inc"
.temp 27
.option gmin=1e-12 rshunt=1e12 reltol=1e-3 abstol=1e-12 vntol=1e-5 method=gear
* Post-PEX R+C extracted netlist for rail_to_rail_1v8_0p1u_1u_subth
.subckt opamp_dut vdd vss inp inn out ib
XMpar0 a_1251_10437.t0 inp.t2 a_5594_14061.t4 vdd.t6 pfet_03v3 w=1.87u l=3.2u ad=6.4328e-13 pd=2.9320e-06 as=5.8344e-13 ps=2.6810e-06 nf=1 m=20 par=20
XMpar1 a_1251_10437.t20 a_1371_10229.t2 vdd.t5 vdd.t4 pfet_03v3 w=2.14u l=5u ad=1.2840e-12 pd=5.4800e-06 as=5.9920e-13 ps=2.7000e-06 nf=1 m=2 par=2
XMpar2 a_1251_10437.t0 inn.t2 a_7692_10139.t4 vdd.t6 pfet_03v3 w=1.87u l=3.2u ad=6.4328e-13 pd=2.9320e-06 as=5.8344e-13 ps=2.6810e-06 nf=1 m=20 par=20
XMpar3 a_1091_6060.t0 inp.t0 a_5492_1294.t0 vss.t0 nfet_03v3 w=2.42u l=3.2u ad=6.7760e-13 pd=2.9800e-06 as=1.4520e-12 ps=6.0400e-06 nf=1 m=2 par=2
XMpar4 a_1371_10229.t3 a_1371_10229.t2 vdd.t5 vdd.t4 pfet_03v3 w=2.14u l=5u ad=5.9920e-13 pd=2.7000e-06 as=5.9920e-13 ps=2.7000e-06 nf=1 m=2 par=2
XMpar5 out.t5 ib.t0 vss.t8 vss.t7 nfet_03v3 w=0.5u l=5u ad=1.4000e-13 pd=1.0600e-06 as=2.6000e-13 ps=1.9150e-06 nf=1 m=8 par=8
XMpar6 a_5492_1294.t2 ib.t0 vss.t8 vss.t7 nfet_03v3 w=0.5u l=5u ad=3.0000e-13 pd=2.2000e-06 as=1.4000e-13 ps=1.0600e-06 nf=1 m=2 par=2
XMpar7 a_1371_10229.t0 ib.t0 vss.t8 vss.t7 nfet_03v3 w=0.5u l=5u ad=3.0000e-13 pd=2.2000e-06 as=1.4000e-13 ps=1.0600e-06 nf=1 m=2 par=2
XMpar8 out.t0 a_1091_6060.t7 vdd.t1 vdd.t0 pfet_03v3 w=2.97u l=2.5u ad=8.3160e-13 pd=3.5300e-06 as=1.0692e-12 ps=4.4325e-06 nf=1 m=8 par=8
XMpar9 a_1091_6060.t3 a_9292_6015.t2 vdd.t1 vdd.t0 pfet_03v3 w=2.97u l=2.5u ad=1.7820e-12 pd=7.1400e-06 as=8.3160e-13 ps=3.5300e-06 nf=1 m=2 par=2
XMpar10 ib.t1 ib.t0 vss.t8 vss.t7 nfet_03v3 w=0.5u l=5u ad=3.0000e-13 pd=2.2000e-06 as=1.4000e-13 ps=1.0600e-06 nf=1 m=2 par=2
XMpar11 a_5594_14061.t1 a_5594_14061.t0 vss.t3 vss.t2 nfet_03v3 w=0.4u l=6.5u ad=2.4000e-13 pd=2.0000e-06 as=1.1200e-13 ps=9.6000e-07 nf=1 m=2 par=2
XMpar12 a_1091_6060.t2 a_7692_10139.t0 vss.t3 vss.t2 nfet_03v3 w=0.4u l=6.5u ad=2.4000e-13 pd=2.0000e-06 as=1.1200e-13 ps=9.6000e-07 nf=1 m=2 par=2
XMpar13 a_5492_1294.t0 inn.t0 a_9292_6015.t0 vss.t0 nfet_03v3 w=2.42u l=3.2u ad=1.4520e-12 pd=6.0400e-06 as=6.7760e-13 ps=2.9800e-06 nf=1 m=2 par=2
XMpar14 a_9292_6015.t3 a_9292_6015.t2 vdd.t1 vdd.t0 pfet_03v3 w=2.97u l=2.5u ad=8.3160e-13 pd=3.5300e-06 as=8.3160e-13 ps=3.5300e-06 nf=1 m=2 par=2
XMpar15 a_9292_6015.t6 a_5594_14061.t0 vss.t3 vss.t2 nfet_03v3 w=0.4u l=6.5u ad=1.1200e-13 pd=9.6000e-07 as=1.1200e-13 ps=9.6000e-07 nf=1 m=2 par=2
XMpar16 a_7692_10139.t1 a_7692_10139.t0 vss.t3 vss.t2 nfet_03v3 w=0.4u l=6.5u ad=1.1200e-13 pd=9.6000e-07 as=1.1200e-13 ps=9.6000e-07 nf=1 m=2 par=2
X1 a_14625_10944.t0 a_18713_11464.t0 vss.t6 ppolyf_u_1k r_width=1u r_length=19.78u
X4 a_18713_12504.t1 out.t3 cap_mim_2f0fF c_width=16.62u c_length=16.62u
X7 a_14625_6784.t0 a_18713_6264.t0 vss.t6 ppolyf_u_1k r_width=1u r_length=19.78u
X11 a_14625_10944.t0 a_18713_10424.t0 vss.t6 ppolyf_u_1k r_width=1u r_length=19.78u
X17 a_14625_8864.t0 a_18713_9384.t0 vss.t6 ppolyf_u_1k r_width=1u r_length=19.78u
X19 a_18713_12504.t1 out.t3 cap_mim_2f0fF c_width=16.62u c_length=16.62u
X21 a_1091_6060.t6 a_18713_6264.t0 vss.t6 ppolyf_u_1k r_width=1u r_length=19.78u
X27 a_14625_9904.t0 a_18713_10424.t0 vss.t6 ppolyf_u_1k r_width=1u r_length=19.78u
X28 a_14625_8864.t0 a_18713_8344.t0 vss.t6 ppolyf_u_1k r_width=1u r_length=19.78u
X38 a_14625_7824.t0 a_18713_8344.t0 vss.t6 ppolyf_u_1k r_width=1u r_length=19.78u
X43 a_14625_11984.t0 a_18713_12504.t0 vss.t6 ppolyf_u_1k r_width=1u r_length=19.78u
X51 a_14625_7824.t0 a_18713_7304.t0 vss.t6 ppolyf_u_1k r_width=1u r_length=19.78u
X66 a_14625_6784.t0 a_18713_7304.t0 vss.t6 ppolyf_u_1k r_width=1u r_length=19.78u
X79 a_14625_9904.t0 a_18713_9384.t0 vss.t6 ppolyf_u_1k r_width=1u r_length=19.78u
X87 a_14625_11984.t0 a_18713_11464.t0 vss.t6 ppolyf_u_1k r_width=1u r_length=19.78u
Rpar0 a_1091_6060.t0 a_1091_6060.t7 180.9486
Rpar1 a_1091_6060.t0 a_1091_6060.t2 112.1342
Rpar2 a_1091_6060.t0 a_1091_6060.t3 99.6771
Rpar3 a_1091_6060.t0 a_1091_6060.t6 406.6368
Rpar4 a_1091_6060.t7 a_1091_6060.t2 198.5299
Rpar5 a_1091_6060.t7 a_1091_6060.t3 138.9861
Rpar6 a_1091_6060.t7 a_1091_6060.t6 154.9366
Rpar7 a_1091_6060.t2 a_1091_6060.t3 109.3619
Rpar8 a_1091_6060.t2 a_1091_6060.t6 446.1465
Rpar9 a_1091_6060.t3 a_1091_6060.t6 312.3367
Rpar10 a_1251_10437.t0 a_1251_10437.t20 50.8787
Rpar11 a_1371_10229.t0 a_1371_10229.t2 139.6896
Rpar12 a_1371_10229.t0 a_1371_10229.t3 111.4410
Rpar13 a_1371_10229.t2 a_1371_10229.t3 23.8479
Rpar14 a_18713_12504.t0 a_18713_12504.t1 64.2201
Rpar15 a_5492_1294.t0 a_5492_1294.t2 82.3894
Rpar16 a_5594_14061.t0 a_5594_14061.t1 22.0524
Rpar17 a_5594_14061.t0 a_5594_14061.t4 140.4159
Rpar18 a_5594_14061.t1 a_5594_14061.t4 109.3138
Rpar19 a_7692_10139.t0 a_7692_10139.t1 30.3436
Rpar20 a_7692_10139.t0 a_7692_10139.t4 178.0170
Rpar21 a_7692_10139.t1 a_7692_10139.t4 167.1479
Rpar22 a_9292_6015.t0 a_9292_6015.t2 207.5767
Rpar23 a_9292_6015.t0 a_9292_6015.t3 98.5848
Rpar24 a_9292_6015.t0 a_9292_6015.t6 114.9754
Rpar25 a_9292_6015.t2 a_9292_6015.t3 23.6971
Rpar26 a_9292_6015.t2 a_9292_6015.t6 481.4022
Rpar27 a_9292_6015.t3 a_9292_6015.t6 228.6333
Rpar28 ib ib.t0 15.9207
Rpar29 ib ib.t1 15.9194
Rpar30 ib.t0 ib.t1 28.3476
Rpar31 inn inn.t0 4.4875
Rpar32 inn inn.t2 60.6481
Rpar33 inp inp.t0 4.5361
Rpar34 inp inp.t2 171.1542
Rpar35 out out.t0 160.1595
Rpar36 out out.t5 9.3639
Rpar37 out out.t3 174.7465
Rpar38 out.t0 out.t5 112.5984
Rpar39 out.t0 out.t3 196.3383
Rpar40 out.t5 out.t3 122.8536
Rpar41 vdd vdd.t0 696.3506
Rpar42 vdd vdd.t1 888.5666
Rpar43 vdd vdd.t6 34.7847
Rpar44 vdd vdd.t4 415.6972
Rpar45 vdd vdd.t5 755.1094
Rpar46 vdd.t0 vdd.t1 3.9907
Rpar47 vdd.t0 vdd.t6 769.3492
Rpar48 vdd.t0 vdd.t4 146.6652
Rpar49 vdd.t0 vdd.t5 266.4158
Rpar50 vdd.t1 vdd.t6 981.7153
Rpar51 vdd.t1 vdd.t4 187.1498
Rpar52 vdd.t1 vdd.t5 339.9555
Rpar53 vdd.t6 vdd.t4 459.2748
Rpar54 vdd.t6 vdd.t5 834.2677
Rpar55 vdd.t4 vdd.t5 10.1205
Rpar56 vss vss.t0 820.6359
Rpar57 vss vss.t8 71.6879
Rpar58 vss vss.t7 1131.3696
Rpar59 vss vss.t2 478.8861
Rpar60 vss vss.t6 134.3983
Rpar61 vss vss.t3 868.0130
Rpar62 vss.t0 vss.t8 635.9614
Rpar63 vss.t0 vss.t2 12.2553
Rpar64 vss.t0 vss.t6 10.1541
Rpar65 vss.t0 vss.t3 31.8701
Rpar66 vss.t8 vss.t7 13.8271
Rpar67 vss.t8 vss.t2 371.1104
Rpar68 vss.t8 vss.t6 103.4833
Rpar69 vss.t8 vss.t3 672.6086
Rpar70 vss.t7 vss.t6 814.4341
Rpar71 vss.t2 vss.t6 4.6556
Rpar72 vss.t2 vss.t3 18.4509
Rpar73 vss.t6 vss.t3 10.4005
Cpar0 a_1091_6060.t0 vss 2.51321e-15
Cpar1 a_1091_6060.t2 vss 3.30720e-15
Cpar2 a_1091_6060.t3 vss 4.00694e-15
Cpar3 a_1091_6060.t6 vss 3.63759e-15
Cpar4 a_1091_6060.t7 vss 1.47546e-14
Cpar5 a_1251_10437.t0 vss 4.21217e-14
Cpar6 a_1251_10437.t20 vss 7.18539e-15
Cpar7 a_1371_10229.t0 vss 9.72318e-15
Cpar8 a_1371_10229.t2 vss 1.45912e-14
Cpar9 a_1371_10229.t3 vss 4.22153e-15
Cpar10 a_14625_10944.t0 vss 4.12600e-17
Cpar11 a_14625_11984.t0 vss 4.19000e-17
Cpar12 a_14625_6784.t0 vss 3.71200e-17
Cpar13 a_14625_7824.t0 vss 3.88400e-17
Cpar14 a_14625_8864.t0 vss 3.85200e-17
Cpar15 a_14625_9904.t0 vss 3.89600e-17
Cpar16 a_18713_10424.t0 vss 3.71600e-17
Cpar17 a_18713_11464.t0 vss 3.98400e-17
Cpar18 a_18713_12504.t0 vss 1.17744e-16
Cpar19 a_18713_12504.t1 vss 4.35739e-15
Cpar20 a_18713_6264.t0 vss 3.71200e-17
Cpar21 a_18713_7304.t0 vss 3.79000e-17
Cpar22 a_18713_8344.t0 vss 3.71600e-17
Cpar23 a_18713_9384.t0 vss 3.71600e-17
Cpar24 a_5492_1294.t0 vss 1.07199e-14
Cpar25 a_5492_1294.t2 vss 1.35739e-14
Cpar26 a_5594_14061.t0 vss 1.11841e-14
Cpar27 a_5594_14061.t1 vss 3.48092e-15
Cpar28 a_5594_14061.t4 vss 1.70375e-14
Cpar29 a_7692_10139.t0 vss 1.19130e-14
Cpar30 a_7692_10139.t1 vss 2.86347e-15
Cpar31 a_7692_10139.t4 vss 1.84392e-14
Cpar32 a_9292_6015.t0 vss 3.07698e-15
Cpar33 a_9292_6015.t2 vss 8.39720e-15
Cpar34 a_9292_6015.t3 vss 3.09175e-15
Cpar35 a_9292_6015.t6 vss 3.35547e-15
Cpar36 ib out 1.88044e-15
Cpar37 ib vss 4.44570e-14
Cpar38 ib.t0 vss 1.44127e-14
Cpar39 ib.t1 vss 1.19278e-15
Cpar40 inn inp 1.66330e-16
Cpar41 inn vdd 2.57882e-14
Cpar42 inn vss 1.23465e-14
Cpar43 inn.t0 vss 2.48745e-15
Cpar44 inn.t2 vss 3.82171e-14
Cpar45 inp out 8.17200e-17
Cpar46 inp vdd 2.68327e-14
Cpar47 inp vss 1.45198e-14
Cpar48 inp.t0 vss 2.32616e-15
Cpar49 inp.t2 vss 3.63212e-14
Cpar50 out vdd 7.27365e-15
Cpar51 out vss 2.61188e-14
Cpar52 out.t0 vss 4.04396e-15
Cpar53 out.t3 vss 1.36507e-14
Cpar54 out.t5 vss 3.75339e-15
Cpar55 vdd vss 2.54078e-13
Cpar56 vdd.t0 vss 1.73695e-14
Cpar57 vdd.t1 vss 1.27144e-14
Cpar58 vdd.t4 vss 1.09792e-14
Cpar59 vdd.t5 vss 5.84810e-15
Cpar60 vdd.t6 vss 6.81978e-14
.ends opamp_dut

Vdd vdd 0 1.800000
Vss vss 0 0
Ibias vdd ib 6.560000e-08
Vinp inp 0 DC 0.895000 AC 1 PWL(0 0.895000 5.043220e-07 0.895000 5.547542e-07 0.905000)
Rfb out inn 1m
Cload out 0 2.000000e-12
Xdut vdd vss inp inn out ib opamp_dut
.end
