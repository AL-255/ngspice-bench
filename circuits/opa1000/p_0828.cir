* opa1000[0828]: 2p/symmetrical_ota_3v3_10u_100u_subth (symmetrical_ota, VDD=3.3V, CL=2.0pF, Iref=8.3333uA)
.include "pdk_opa.inc"
.temp 27
.option gmin=1e-12 rshunt=1e12 reltol=1e-3 abstol=1e-12 vntol=1e-5 method=gear
* Post-PEX R+C extracted netlist for symmetrical_ota_3v3_10u_100u_subth
.subckt opamp_dut vdd vss inp inn out ib
XMpar0 a_2630_1250.t56 ib.t0 vss.t24 vss.t23 nfet_03v3 w=10u l=1u ad=2.8000e-12 pd=1.0560e-05 as=4.4000e-12 ps=1.5880e-05 nf=1 m=4 par=4
XMpar1 a_4628_9819.t0 a_5984_1250.t56 vdd.t1 vdd.t0 pfet_03v3 w=10u l=1u ad=2.8000e-12 pd=1.0560e-05 as=4.4000e-12 ps=1.5880e-05 nf=1 m=4 par=4
XMpar2 a_1305_9864.t0 inp.t0 a_2630_1250.t0 vss.t2 nfet_03v3 w=1.98u l=0.45u ad=5.5440e-13 pd=2.5400e-06 as=6.4491e-13 ps=2.9143e-06 nf=1 m=56 par=56
XMpar3 out.t4 a_1305_9864.t56 vdd.t1 vdd.t0 pfet_03v3 w=10u l=1u ad=2.8000e-12 pd=1.0560e-05 as=4.4000e-12 ps=1.5880e-05 nf=1 m=4 par=4
XMpar4 a_1305_9864.t57 a_1305_9864.t56 vdd.t1 vdd.t0 pfet_03v3 w=10u l=1u ad=2.8000e-12 pd=1.0560e-05 as=2.8000e-12 ps=1.0560e-05 nf=1 m=2 par=2
XMpar5 out.t0 a_4628_9819.t4 vss.t1 vss.t0 nfet_03v3 w=7.67u l=1u ad=2.1476e-12 pd=8.2300e-06 as=3.3748e-12 ps=1.2385e-05 nf=1 m=4 par=4
XMpar6 a_2630_1250.t0 inn.t0 a_5984_1250.t0 vss.t2 nfet_03v3 w=1.98u l=0.45u ad=6.4491e-13 pd=2.9143e-06 as=5.5440e-13 ps=2.5400e-06 nf=1 m=56 par=56
XMpar7 a_5984_1250.t57 a_5984_1250.t56 vdd.t1 vdd.t0 pfet_03v3 w=10u l=1u ad=2.8000e-12 pd=1.0560e-05 as=2.8000e-12 ps=1.0560e-05 nf=1 m=2 par=2
XMpar8 ib.t1 ib.t0 vss.t24 vss.t23 nfet_03v3 w=10u l=1u ad=2.8000e-12 pd=1.0560e-05 as=2.8000e-12 ps=1.0560e-05 nf=1 m=2 par=2
XMpar9 a_4628_9819.t5 a_4628_9819.t4 vss.t1 vss.t0 nfet_03v3 w=7.67u l=1u ad=2.1476e-12 pd=8.2300e-06 as=2.1476e-12 ps=8.2300e-06 nf=1 m=4 par=4
X26 out.t8 vss.t20 cap_mim_2f0fF c_width=10.25u c_length=10.25u
Rpar0 a_1305_9864.t0 a_1305_9864.t56 198.7158
Rpar1 a_1305_9864.t0 a_1305_9864.t57 72.2558
Rpar2 a_1305_9864.t56 a_1305_9864.t57 29.8322
Rpar3 a_2630_1250.t0 a_2630_1250.t56 49.4539
Rpar4 a_4628_9819.t0 a_4628_9819.t4 252.7842
Rpar5 a_4628_9819.t0 a_4628_9819.t5 41.6183
Rpar6 a_4628_9819.t4 a_4628_9819.t5 21.9988
Rpar7 a_5984_1250.t0 a_5984_1250.t56 197.6357
Rpar8 a_5984_1250.t0 a_5984_1250.t57 71.8631
Rpar9 a_5984_1250.t56 a_5984_1250.t57 29.8502
Rpar10 ib ib.t0 24.8658
Rpar11 ib ib.t1 7.2409
Rpar12 ib.t0 ib.t1 167.0428
Rpar13 inn inn.t0 2.4758
Rpar14 inp inp.t0 2.4758
Rpar15 out out.t0 55.4340
Rpar16 out out.t4 93.5821
Rpar17 out out.t8 15.1611
Rpar18 out.t0 out.t4 48.3844
Rpar19 out.t0 out.t8 703.4879
Rpar20 out.t4 out.t8 1187.6083
Rpar21 vdd vdd.t0 103.2856
Rpar22 vdd vdd.t1 189.5378
Rpar23 vdd.t0 vdd.t1 3.6890
Rpar24 vss vss.t0 773.4833
Rpar25 vss vss.t1 715.9378
Rpar26 vss vss.t2 72.4637
Rpar27 vss vss.t20 325.7946
Rpar28 vss vss.t23 630.0796
Rpar29 vss vss.t24 1927.0330
Rpar30 vss.t0 vss.t1 9.8672
Rpar31 vss.t0 vss.t2 17.4732
Rpar32 vss.t0 vss.t20 615.8480
Rpar33 vss.t0 vss.t23 98.6095
Rpar34 vss.t0 vss.t24 209.2221
Rpar35 vss.t1 vss.t2 26.4769
Rpar36 vss.t1 vss.t20 570.0302
Rpar37 vss.t1 vss.t23 193.0409
Rpar38 vss.t1 vss.t24 333.1602
Rpar39 vss.t2 vss.t20 57.6957
Rpar40 vss.t2 vss.t23 1.6854
Rpar41 vss.t2 vss.t24 6.5149
Rpar42 vss.t20 vss.t23 501.6699
Rpar43 vss.t20 vss.t24 1534.3052
Rpar44 vss.t23 vss.t24 47.2412
Cpar0 a_1305_9864.t0 vss 3.25567e-14
Cpar1 a_1305_9864.t56 vss 1.52720e-14
Cpar2 a_1305_9864.t57 vss 8.42782e-15
Cpar3 a_2630_1250.t0 vss 6.62180e-14
Cpar4 a_2630_1250.t56 vss 1.11401e-14
Cpar5 a_4628_9819.t0 vss 2.63597e-15
Cpar6 a_4628_9819.t4 vss 5.02459e-15
Cpar7 a_4628_9819.t5 vss 2.77969e-15
Cpar8 a_5984_1250.t0 vss 3.12175e-14
Cpar9 a_5984_1250.t56 vss 1.47397e-14
Cpar10 a_5984_1250.t57 vss 8.15208e-15
Cpar11 ib out 2.19600e-17
Cpar12 ib vss 1.12825e-14
Cpar13 ib.t0 vss 1.66737e-15
Cpar14 ib.t1 vss 4.39381e-16
Cpar15 inn inp 2.06280e-16
Cpar16 inn vdd 1.45350e-16
Cpar17 inn vss 2.26971e-14
Cpar18 inn.t0 vss 1.20624e-14
Cpar19 inp vdd 9.52600e-17
Cpar20 inp vss 2.28079e-14
Cpar21 inp.t0 vss 1.19905e-14
Cpar22 out vdd 6.70632e-15
Cpar23 out vss 1.06723e-14
Cpar24 out.t0 vss 1.48950e-15
Cpar25 out.t4 vss 1.64838e-15
Cpar26 out.t8 vss 8.36382e-15
Cpar27 vdd vss 8.30770e-14
Cpar28 vdd.t0 vss 1.87204e-14
Cpar29 vdd.t1 vss 1.25129e-14
.ends opamp_dut

Vdd vdd 0 3.300000
Vss vss 0 0
Ibias vdd ib 8.333300e-06
Vinp inp 0 DC 1.645000 AC 1 PWL(0 1.645000 3.875601e-09 1.645000 4.263161e-09 1.655000)
Rfb out inn 1m
Cload out 0 2.000000e-12
Xdut vdd vss inp inn out ib opamp_dut
.end
