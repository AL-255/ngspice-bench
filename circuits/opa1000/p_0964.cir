* opa1000[0964]: 2p/telescopic_pmos_1v8_0p1u_1u_subth (telescopic_pmos, VDD=1.8V, CL=2.0pF, Iref=0.1uA)
.include "pdk_opa.inc"
.temp 27
.option gmin=1e-12 rshunt=1e12 reltol=1e-3 abstol=1e-12 vntol=1e-5 method=gear
* Post-PEX R+C extracted netlist for telescopic_pmos_1v8_0p1u_1u_subth
.subckt opamp_dut vdd vss inp inn out ib
XMpar0 a_1662_11221.t8 inn.t0 a_9934_5183.t0 vdd.t9 pfet_03v3 w=8u l=2.5u ad=2.4800e-12 pd=9.3700e-06 as=2.4000e-12 ps=9.1000e-06 nf=1 m=64 par=64
XMpar1 a_1662_11221.t8 inp.t0 a_2282_11221.t0 vdd.t9 pfet_03v3 w=8u l=2.5u ad=2.4800e-12 pd=9.3700e-06 as=2.4000e-12 ps=9.1000e-06 nf=1 m=64 par=64
XMpar2 a_9934_5183.t64 vss.t22 out.t3 vdd.t6 pfet_03v3 w=1.99u l=3.2u ad=7.6947e-13 pd=3.4267e-06 as=5.5720e-13 ps=2.5500e-06 nf=1 m=18 par=18
XMpar3 a_1662_11221.t0 a_3587_1294.t0 vdd.t1 vdd.t0 pfet_03v3 w=2.6u l=4u ad=7.2800e-13 pd=3.1600e-06 as=9.3600e-13 ps=3.9700e-06 nf=1 m=8 par=8
XMpar4 a_5866_5183.t1 a_5866_5183.t0 a_6632_3087.t0 vss.t0 nfet_03v3 w=1.78u l=3.2u ad=4.9840e-13 pd=2.3400e-06 as=1.0680e-12 ps=4.7600e-06 nf=1 m=4 par=4
XMpar5 a_3587_1294.t4 ib.t0 vss.t17 vss.t16 nfet_03v3 w=0.6u l=4u ad=3.6000e-13 pd=2.4000e-06 as=1.6800e-13 ps=1.1600e-06 nf=1 m=2 par=2
XMpar6 a_2282_11221.t64 vss.t22 a_5866_5183.t8 vdd.t6 pfet_03v3 w=1.99u l=3.2u ad=7.6947e-13 pd=3.4267e-06 as=5.5720e-13 ps=2.5500e-06 nf=1 m=18 par=18
XMpar7 a_6632_3087.t3 a_5866_5183.t26 vss.t3 vss.t2 nfet_03v3 w=1.29u l=6.5u ad=7.7400e-13 pd=3.7800e-06 as=3.6120e-13 ps=1.8500e-06 nf=1 m=2 par=2
XMpar8 a_8412_3087.t1 a_5866_5183.t26 vss.t3 vss.t2 nfet_03v3 w=1.29u l=6.5u ad=3.6120e-13 pd=1.8500e-06 as=3.6120e-13 ps=1.8500e-06 nf=1 m=2 par=2
XMpar9 a_8412_3087.t0 a_5866_5183.t0 out.t0 vss.t0 nfet_03v3 w=1.78u l=3.2u ad=7.8320e-13 pd=3.5500e-06 as=4.9840e-13 ps=2.3400e-06 nf=1 m=4 par=4
XMpar10 ib.t1 ib.t0 vss.t17 vss.t16 nfet_03v3 w=0.6u l=4u ad=3.6000e-13 pd=2.4000e-06 as=1.6800e-13 ps=1.1600e-06 nf=1 m=2 par=2
XMpar11 a_3587_1294.t1 a_3587_1294.t0 vdd.t1 vdd.t0 pfet_03v3 w=2.6u l=4u ad=7.2800e-13 pd=3.1600e-06 as=7.2800e-13 ps=3.1600e-06 nf=1 m=2 par=2
Rpar0 a_1662_11221.t0 a_1662_11221.t8 63.4096
Rpar1 a_2282_11221.t0 a_2282_11221.t64 55.8054
Rpar2 a_3587_1294.t0 a_3587_1294.t1 24.4090
Rpar3 a_3587_1294.t0 a_3587_1294.t4 157.4644
Rpar4 a_3587_1294.t1 a_3587_1294.t4 156.7460
Rpar5 a_5866_5183.t0 a_5866_5183.t1 20.5238
Rpar6 a_5866_5183.t0 a_5866_5183.t8 227.6378
Rpar7 a_5866_5183.t0 a_5866_5183.t26 161.5302
Rpar8 a_5866_5183.t1 a_5866_5183.t8 122.1516
Rpar9 a_5866_5183.t1 a_5866_5183.t26 86.6779
Rpar10 a_5866_5183.t8 a_5866_5183.t26 188.0253
Rpar11 a_6632_3087.t0 a_6632_3087.t3 47.0208
Rpar12 a_8412_3087.t0 a_8412_3087.t1 70.0155
Rpar13 a_9934_5183.t0 a_9934_5183.t64 55.8054
Rpar14 ib ib.t0 9.8080
Rpar15 ib ib.t1 10.8284
Rpar16 ib.t0 ib.t1 41.0417
Rpar17 inn inn.t0 1.6730
Rpar18 inp inp.t0 1.6730
Rpar19 out out.t0 58.0212
Rpar20 out out.t3 3.4045
Rpar21 vdd vdd.t0 342.2628
Rpar22 vdd vdd.t1 901.6323
Rpar23 vdd vdd.t9 20.1676
Rpar24 vdd vdd.t6 1436.6366
Rpar25 vdd.t0 vdd.t1 5.6741
Rpar26 vdd.t0 vdd.t9 120.1223
Rpar27 vdd.t0 vdd.t6 62.7717
Rpar28 vdd.t1 vdd.t9 316.4414
Rpar29 vdd.t1 vdd.t6 165.3613
Rpar30 vdd.t9 vdd.t6 504.2092
Rpar31 vss vss.t0 59.6957
Rpar32 vss vss.t2 140.1020
Rpar33 vss vss.t3 321.7768
Rpar34 vss vss.t16 411.8228
Rpar35 vss vss.t17 133.1182
Rpar36 vss vss.t22 123.0415
Rpar37 vss.t0 vss.t2 5.7178
Rpar38 vss.t0 vss.t3 14.7630
Rpar39 vss.t0 vss.t16 814.5280
Rpar40 vss.t0 vss.t17 299.7691
Rpar41 vss.t0 vss.t22 287.9625
Rpar42 vss.t2 vss.t3 34.9296
Rpar43 vss.t2 vss.t16 1908.5216
Rpar44 vss.t2 vss.t17 703.2462
Rpar45 vss.t2 vss.t22 675.8147
Rpar46 vss.t3 vss.t16 4447.9490
Rpar47 vss.t3 vss.t17 1621.1678
Rpar48 vss.t3 vss.t22 1552.4796
Rpar49 vss.t16 vss.t17 31.6258
Rpar50 vss.t16 vss.t22 439.4400
Rpar51 vss.t17 vss.t22 141.3004
Cpar0 a_1662_11221.t0 vss 8.99859e-15
Cpar1 a_1662_11221.t8 vss 1.81577e-13
Cpar2 a_2282_11221.t0 vss 9.95392e-14
Cpar3 a_2282_11221.t64 vss 1.79276e-14
Cpar4 a_3587_1294.t0 vss 3.03026e-14
Cpar5 a_3587_1294.t1 vss 4.73726e-15
Cpar6 a_3587_1294.t4 vss 5.72037e-15
Cpar7 a_5866_5183.t0 vss 9.57396e-15
Cpar8 a_5866_5183.t1 vss 2.60511e-15
Cpar9 a_5866_5183.t26 vss 8.30112e-15
Cpar10 a_5866_5183.t8 vss 8.54001e-15
Cpar11 a_6632_3087.t0 vss 5.49856e-15
Cpar12 a_6632_3087.t3 vss 4.20793e-15
Cpar13 a_8412_3087.t0 vss 7.80726e-15
Cpar14 a_8412_3087.t1 vss 4.97174e-15
Cpar15 a_9934_5183.t0 vss 1.03981e-13
Cpar16 a_9934_5183.t64 vss 1.87276e-14
Cpar17 ib vss 1.54042e-14
Cpar18 ib.t0 vss 2.28111e-15
Cpar19 ib.t1 vss 3.18189e-16
Cpar20 inn inp 2.19720e-16
Cpar21 inn vdd 6.40387e-14
Cpar22 inn vss 1.13150e-14
Cpar23 inn.t0 vss 1.34688e-13
Cpar24 inp vdd 6.34708e-14
Cpar25 inp vss 1.13270e-14
Cpar26 inp.t0 vss 1.34237e-13
Cpar27 out vdd 5.53102e-15
Cpar28 out vss 1.73991e-14
Cpar29 out.t0 vss 4.92357e-15
Cpar30 out.t3 vss 1.05056e-14
Cpar31 vdd vss 9.08502e-13
Cpar32 vdd.t0 vss 1.28095e-14
Cpar33 vdd.t1 vss 5.75884e-15
Cpar34 vdd.t6 vss 3.50000e-14
Cpar35 vdd.t9 vss 1.67207e-13
.ends opamp_dut

Vdd vdd 0 1.800000
Vss vss 0 0
Ibias vdd ib 1.000000e-07
Vinp inp 0 DC 0.805000 AC 1 PWL(0 0.805000 2.523173e-07 0.805000 2.775490e-07 0.815000)
Rfb out inn 1m
Cload out 0 2.000000e-12
Xdut vdd vss inp inn out ib opamp_dut
.end
