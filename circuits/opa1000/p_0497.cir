* opa1000[0497]: 2p/nmos_miller_3v3_i150u_subth (nmos_miller, VDD=3.3V, CL=2.0pF, Iref=21.4286uA)
.include "pdk_opa.inc"
.temp 27
.option gmin=1e-12 rshunt=1e12 reltol=1e-3 abstol=1e-12 vntol=1e-5 method=gear
* Post-PEX R+C extracted netlist for nmos_miller_3v3_i150u_subth
.subckt opamp_dut vdd vss inp inn out ib
XMpar0 a_1679_9112.t0 inp.t0 a_3028_1249.t1 vss.t1 nfet_03v3 w=5.28u l=0.53u ad=1.5840e-12 pd=6.2100e-06 as=1.4784e-12 ps=5.8400e-06 nf=1 m=64 par=64
XMpar1 a_9044_5280.t65 a_9044_5280.t64 vdd.t1 vdd.t0 pfet_03v3 w=10u l=0.4u ad=2.8000e-12 pd=1.0560e-05 as=2.8000e-12 ps=1.0560e-05 nf=1 m=6 par=6
XMpar2 a_1679_9112.t64 ib.t0 vss.t34 vss.t33 nfet_03v3 w=5.18u l=0.65u ad=1.4504e-12 pd=5.7400e-06 as=1.4504e-12 ps=5.7400e-06 nf=1 m=12 par=12
XMpar3 out.t0 ib.t0 vss.t34 vss.t33 nfet_03v3 w=5.18u l=0.65u ad=1.5609e-12 pd=6.1280e-06 as=1.4504e-12 ps=5.7400e-06 nf=1 m=30 par=30
XMpar4 a_1679_9112.t0 inn.t0 a_9044_5280.t0 vss.t1 nfet_03v3 w=5.28u l=0.53u ad=1.5840e-12 pd=6.2100e-06 as=1.4784e-12 ps=5.8400e-06 nf=1 m=64 par=64
XMpar5 out.t3 a_3028_1249.t71 vdd.t1 vdd.t0 pfet_03v3 w=10u l=0.4u ad=2.8000e-12 pd=1.0560e-05 as=3.0133e-12 ps=1.1269e-05 nf=1 m=30 par=30
XMpar6 a_3028_1249.t65 a_9044_5280.t64 vdd.t1 vdd.t0 pfet_03v3 w=10u l=0.4u ad=3.8667e-12 pd=1.4107e-05 as=2.8000e-12 ps=1.0560e-05 nf=1 m=6 par=6
XMpar7 ib.t1 ib.t0 vss.t34 vss.t33 nfet_03v3 w=5.18u l=0.65u ad=1.4504e-12 pd=5.7400e-06 as=2.0029e-12 ps=7.6800e-06 nf=1 m=6 par=6
X58 a_3028_1249.t0 a_10758_11814.t0 vss.t0 ppolyf_u_1k r_width=1u r_length=1u
X136 a_10758_11814.t1 out.t9 cap_mim_2f0fF c_width=19.27u c_length=19.27u
X211 a_10758_11814.t1 out.t9 cap_mim_2f0fF c_width=19.27u c_length=19.27u
Rpar0 a_10758_11814.t0 a_10758_11814.t1 70.6717
Rpar1 a_1679_9112.t0 a_1679_9112.t64 57.9830
Rpar2 a_3028_1249.t0 a_3028_1249.t1 189.2661
Rpar3 a_3028_1249.t0 a_3028_1249.t71 810.0496
Rpar4 a_3028_1249.t0 a_3028_1249.t65 164.7172
Rpar5 a_3028_1249.t1 a_3028_1249.t71 333.2962
Rpar6 a_3028_1249.t1 a_3028_1249.t65 67.7731
Rpar7 a_3028_1249.t71 a_3028_1249.t65 91.3725
Rpar8 a_9044_5280.t0 a_9044_5280.t64 883.9245
Rpar9 a_9044_5280.t0 a_9044_5280.t65 67.3026
Rpar10 a_9044_5280.t64 a_9044_5280.t65 25.1377
Rpar11 ib ib.t0 19.1373
Rpar12 ib ib.t1 2.2627
Rpar13 ib.t0 ib.t1 85.1547
Rpar14 inn inn.t0 2.2039
Rpar15 inp inp.t0 2.2039
Rpar16 out out.t0 1.7076
Rpar17 out out.t3 4223.7673
Rpar18 out out.t9 7366.9265
Rpar19 out.t0 out.t3 64.1372
Rpar20 out.t0 out.t9 111.8656
Rpar21 out.t3 out.t9 166.8896
Rpar22 vdd vdd.t0 68.3235
Rpar23 vdd vdd.t1 310.9053
Rpar24 vdd.t0 vdd.t1 2.0387
Rpar25 vss vss.t1 86.7416
Rpar26 vss vss.t34 4774.1719
Rpar27 vss vss.t33 885.8729
Rpar28 vss.t0 vss.t1 1595.3196
Rpar29 vss.t0 vss.t34 335.3095
Rpar30 vss.t0 vss.t33 16.2963
Rpar31 vss.t1 vss.t34 175.2292
Rpar32 vss.t1 vss.t33 15.1883
Rpar33 vss.t34 vss.t33 2.2560
Cpar0 a_10758_11814.t0 vss 7.52935e-17
Cpar1 a_10758_11814.t1 vss 7.21583e-15
Cpar2 a_1679_9112.t0 vss 1.30567e-13
Cpar3 a_1679_9112.t64 vss 1.79544e-14
Cpar4 a_3028_1249.t0 vss 4.95942e-15
Cpar5 a_3028_1249.t1 vss 6.36338e-14
Cpar6 a_3028_1249.t65 vss 2.01956e-14
Cpar7 a_3028_1249.t71 vss 3.17476e-14
Cpar8 a_9044_5280.t0 vss 6.79718e-14
Cpar9 a_9044_5280.t64 vss 1.18593e-14
Cpar10 a_9044_5280.t65 vss 1.77724e-14
Cpar11 ib out 5.79278e-15
Cpar12 ib vdd 4.81900e-16
Cpar13 ib vss 4.54585e-14
Cpar14 ib.t0 vss 9.45412e-15
Cpar15 ib.t1 vss 1.07241e-15
Cpar16 inn inp 1.03350e-16
Cpar17 inn vdd 1.22500e-17
Cpar18 inn vss 3.03245e-14
Cpar19 inn.t0 vss 1.80532e-14
Cpar20 inp vss 3.06019e-14
Cpar21 inp.t0 vss 1.80267e-14
Cpar22 out vdd 6.17148e-14
Cpar23 out vss 4.18339e-14
Cpar24 out.t0 vss 2.27554e-14
Cpar25 out.t3 vss 3.58798e-14
Cpar26 out.t9 vss 2.59255e-14
Cpar27 vdd vss 1.29019e-13
Cpar28 vdd.t0 vss 6.83216e-14
Cpar29 vdd.t1 vss 3.56064e-14
.ends opamp_dut

Vdd vdd 0 3.300000
Vss vss 0 0
Ibias vdd ib 2.142860e-05
Vinp inp 0 DC 1.645000 AC 1 PWL(0 1.645000 3.000000e-09 1.645000 3.300000e-09 1.655000)
Rfb out inn 1m
Cload out 0 2.000000e-12
Xdut vdd vss inp inn out ib opamp_dut
.end
