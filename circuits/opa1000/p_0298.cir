* opa1000[0298]: 2p/folded_cascode_pmos_1v8_0p1u_1u_weak (folded_cascode_pmos, VDD=1.8V, CL=2.0pF, Iref=0.1444uA)
.include "pdk_opa.inc"
.temp 27
.option gmin=1e-12 rshunt=1e12 reltol=1e-3 abstol=1e-12 vntol=1e-5 method=gear
* Post-PEX R+C extracted netlist for folded_cascode_pmos_1v8_0p1u_1u_weak
.subckt opamp_dut vdd vss inp inn out ib
XMpar0 a_7214_3168.t4 a_1840_10652.t6 out.t2 vss.t0 nfet_03v3 w=0.5u l=3.2u ad=3.0000e-13 pd=2.2000e-06 as=1.4000e-13 ps=1.0600e-06 nf=1 m=2 par=2
XMpar1 a_1720_10860.t0 a_1840_10652.t2 vdd.t1 vdd.t0 pfet_03v3 w=2.14u l=9.75u ad=1.2840e-12 pd=5.4800e-06 as=9.4160e-13 ps=4.0900e-06 nf=1 m=4 par=4
XMpar2 a_1840_10652.t0 ib vss.t2 vss.t1 nfet_03v3 w=0.49u l=6.25u ad=1.3720e-13 pd=1.0500e-06 as=1.3720e-13 ps=1.0500e-06 nf=1 m=2 par=2
XMpar3 a_7214_3168.t0 ib vss.t2 vss.t1 nfet_03v3 w=0.49u l=6.25u ad=1.3720e-13 pd=1.0500e-06 as=2.1560e-13 ps=1.6150e-06 nf=1 m=4 par=4
XMpar4 a_2820_4690.t1 ib vss.t2 vss.t1 nfet_03v3 w=0.49u l=6.25u ad=1.3720e-13 pd=1.0500e-06 as=2.1560e-13 ps=1.6150e-06 nf=1 m=4 par=4
XMpar5 a_1720_10860.t1 inn.t0 a_7214_3168.t5 vdd.t8 pfet_03v3 w=2.12u l=8u ad=8.1973e-13 pd=3.6000e-06 as=8.1973e-13 ps=3.6000e-06 nf=1 m=6 par=6
XMpar6 a_1720_10860.t1 inp.t0 a_2820_4690.t6 vdd.t8 pfet_03v3 w=2.12u l=8u ad=8.1973e-13 pd=3.6000e-06 as=8.1973e-13 ps=3.6000e-06 nf=1 m=6 par=6
XMpar7 a_3072_1204.t3 a_3072_1204.t2 vdd.t1 vdd.t0 pfet_03v3 w=2.14u l=9.75u ad=1.2840e-12 pd=5.4800e-06 as=5.9920e-13 ps=2.7000e-06 nf=1 m=2 par=2
XMpar8 a_1840_10652.t3 a_1840_10652.t2 vdd.t1 vdd.t0 pfet_03v3 w=2.14u l=9.75u ad=1.2840e-12 pd=5.4800e-06 as=5.9920e-13 ps=2.7000e-06 nf=1 m=2 par=2
XMpar9 a_2820_4690.t0 a_1840_10652.t6 a_3072_1204.t0 vss.t0 nfet_03v3 w=0.5u l=3.2u ad=3.0000e-13 pd=2.2000e-06 as=1.4000e-13 ps=1.0600e-06 nf=1 m=2 par=2
XMpar10 out.t0 a_3072_1204.t2 vdd.t1 vdd.t0 pfet_03v3 w=2.14u l=9.75u ad=5.9920e-13 pd=2.7000e-06 as=5.9920e-13 ps=2.7000e-06 nf=1 m=2 par=2
XMpar11 ib.t1 ib vss.t2 vss.t1 nfet_03v3 w=0.49u l=6.25u ad=2.9400e-13 pd=2.1800e-06 as=1.3720e-13 ps=1.0500e-06 nf=1 m=2 par=2
Rpar0 a_1720_10860.t0 a_1720_10860.t1 57.1695
Rpar1 a_1840_10652.t0 a_1840_10652.t2 489.7259
Rpar2 a_1840_10652.t0 a_1840_10652.t3 227.5543
Rpar3 a_1840_10652.t0 a_1840_10652.t6 107.0949
Rpar4 a_1840_10652.t2 a_1840_10652.t3 12.8413
Rpar5 a_1840_10652.t2 a_1840_10652.t6 356.4871
Rpar6 a_1840_10652.t3 a_1840_10652.t6 165.6440
Rpar7 a_2820_4690.t0 a_2820_4690.t1 132.2992
Rpar8 a_2820_4690.t0 a_2820_4690.t6 191.3576
Rpar9 a_2820_4690.t1 a_2820_4690.t6 67.0516
Rpar10 a_3072_1204.t0 a_3072_1204.t2 197.7087
Rpar11 a_3072_1204.t0 a_3072_1204.t3 82.5078
Rpar12 a_3072_1204.t2 a_3072_1204.t3 18.3819
Rpar13 a_7214_3168.t0 a_7214_3168.t5 86.6776
Rpar14 a_7214_3168.t0 a_7214_3168.t4 72.9461
Rpar15 a_7214_3168.t5 a_7214_3168.t4 190.8834
Rpar16 ib ib.t1 16.6853
Rpar17 inn inn.t0 2.4928
Rpar18 inp inp.t0 2.4928
Rpar19 out out.t0 51.4853
Rpar20 out out.t2 13.8144
Rpar21 vdd vdd.t0 267.5795
Rpar22 vdd vdd.t1 51.9572
Rpar23 vdd vdd.t8 53.2847
Rpar24 vdd.t0 vdd.t1 6.1920
Rpar25 vdd.t0 vdd.t8 100.3938
Rpar26 vdd.t1 vdd.t8 80.4511
Rpar27 vss vss.t0 135.8304
Rpar28 vss vss.t1 68.7906
Rpar29 vss vss.t2 383.1923
Rpar30 vss.t0 vss.t1 3.4193
Rpar31 vss.t0 vss.t2 14.6878
Rpar32 vss.t1 vss.t2 6.4911
Cpar0 a_1720_10860.t0 vss 1.61870e-14
Cpar1 a_1720_10860.t1 vss 2.50705e-14
Cpar2 a_1840_10652.t0 vss 4.44759e-15
Cpar3 a_1840_10652.t2 vss 3.40124e-14
Cpar4 a_1840_10652.t3 vss 8.21400e-15
Cpar5 a_1840_10652.t6 vss 8.51891e-15
Cpar6 a_2820_4690.t0 vss 4.27398e-15
Cpar7 a_2820_4690.t1 vss 5.99773e-15
Cpar8 a_2820_4690.t6 vss 1.23538e-14
Cpar9 a_3072_1204.t0 vss 1.87248e-15
Cpar10 a_3072_1204.t2 vss 2.43608e-14
Cpar11 a_3072_1204.t3 vss 5.82242e-15
Cpar12 a_7214_3168.t0 vss 5.10344e-15
Cpar13 a_7214_3168.t4 vss 3.01054e-15
Cpar14 a_7214_3168.t5 vss 1.08623e-14
Cpar15 ib inp 4.59600e-17
Cpar16 ib vdd 9.77650e-16
Cpar17 ib vss 4.95181e-14
Cpar18 ib.t1 vss 3.99094e-16
Cpar19 inn inp 1.04860e-16
Cpar20 inn vdd 1.87656e-14
Cpar21 inn vss 4.97642e-15
Cpar22 inn.t0 vss 2.06928e-14
Cpar23 inp vdd 1.89164e-14
Cpar24 inp vss 4.88519e-15
Cpar25 inp.t0 vss 2.07357e-14
Cpar26 out vdd 4.62677e-15
Cpar27 out vss 6.65219e-15
Cpar28 out.t0 vss 6.87271e-15
Cpar29 out.t2 vss 2.08472e-16
Cpar30 vdd vss 2.54952e-13
Cpar31 vdd.t0 vss 5.89717e-14
Cpar32 vdd.t1 vss 1.80025e-14
Cpar33 vdd.t8 vss 5.10921e-14
.ends opamp_dut

Vdd vdd 0 1.800000
Vss vss 0 0
Ibias vdd ib 1.444000e-07
Vinp inp 0 DC 0.751000 AC 1 PWL(0 0.751000 5.405769e-07 0.751000 5.946346e-07 0.761000)
Rfb out inn 1m
Cload out 0 2.000000e-12
Xdut vdd vss inp inn out ib opamp_dut
.end
