* opa1000[0004]: 200f/cherry_hooper_1v8_0p1u_1u_subth (cherry_hooper, VDD=1.8V, CL=0.2pF, Iref=0.0287uA)
.include "pdk_opa.inc"
.temp 27
.option gmin=1e-12 rshunt=1e12 reltol=1e-3 abstol=1e-12 vntol=1e-5 method=gear
* Post-PEX R+C extracted netlist for cherry_hooper_1v8_0p1u_1u_subth
.subckt opamp_dut vdd vss inp inn out ib
XMpar0 a_1250_11265.t0 a_1370_11056.t0 a_1370_11056.t1 vdd.t2 pfet_03v3 w=9.83u l=1u ad=3.2767e-12 pd=1.2135e-05 as=2.7524e-12 ps=1.0390e-05 nf=1 m=12 par=12
XMpar1 a_10674_11560.t0 inn.t0 a_12294_13063.t0 vss.t1 nfet_03v3 w=0.78u l=2.4u ad=4.6800e-13 pd=2.7600e-06 as=2.1840e-13 ps=1.3400e-06 nf=1 m=1
XMpar2 a_10339_15082.t7 a_1370_11056.t25 a_11154_17204.t2 vdd.t0 pfet_03v3 w=5.72u l=1u ad=3.4320e-12 pd=1.2640e-05 as=1.6016e-12 ps=6.2800e-06 nf=1 m=2 par=2
XMpar3 a_11154_17204.t4 a_10554_16996.t1 vdd.t4 vdd.t3 pfet_03v3 w=0.79u l=3u ad=2.2120e-13 pd=1.3500e-06 as=4.7400e-13 ps=2.7800e-06 nf=1 m=2 par=2
XMpar4 a_10674_11560.t0 inn.t0 a_12294_13063.t0 vss.t0 nfet_03v3 w=0.78u l=2.4u ad=4.6800e-13 pd=2.7600e-06 as=2.1840e-13 ps=1.3400e-06 nf=1 m=1
XMpar5 a_11266_13271.t1 ib vss.t9 vss.t8 nfet_03v3 w=0.4u l=3u ad=1.1200e-13 pd=9.6000e-07 as=1.5467e-13 ps=1.3067e-06 nf=1 m=6 par=6
XMpar6 a_10674_11560.t4 ib vss.t9 vss.t8 nfet_03v3 w=0.4u l=3u ad=1.1200e-13 pd=9.6000e-07 as=1.1200e-13 ps=9.6000e-07 nf=1 m=4 par=4
XMpar7 a_11266_6867.t2 ib vss.t9 vss.t8 nfet_03v3 w=0.4u l=3u ad=1.4400e-13 pd=1.2200e-06 as=1.7600e-13 ps=1.4800e-06 nf=1 m=8 par=8
XMpar8 a_11518_1294.t2 a_11518_1294.t1 vdd.t6 vdd.t5 pfet_03v3 w=2.24u l=1.3u ad=1.3440e-12 pd=5.6800e-06 as=6.2720e-13 ps=2.8000e-06 nf=1 m=4 par=4
XMpar9 a_12174_8951.t4 a_12174_8951.t3 vdd.t6 vdd.t5 pfet_03v3 w=2.24u l=1.3u ad=8.6613e-13 pd=3.7600e-06 as=8.6613e-13 ps=3.7600e-06 nf=1 m=3 par=3
XMpar10 a_11266_6867.t0 a_10339_15082.t9 a_11518_1294.t0 vss.t2 nfet_03v3 w=3.09u l=2.4u ad=1.8540e-12 pd=7.3800e-06 as=1.8540e-12 ps=7.3800e-06 nf=1 m=1
XMpar11 out.t0 a_11518_1294.t1 vdd.t6 vdd.t5 pfet_03v3 w=2.24u l=1.3u ad=9.8560e-13 pd=4.2400e-06 as=6.2720e-13 ps=2.8000e-06 nf=1 m=4 par=4
XMpar12 a_10339_15082.t1 a_10339_15082.t0 vdd.t6 vdd.t5 pfet_03v3 w=2.24u l=1.3u ad=8.6613e-13 pd=3.7600e-06 as=8.6613e-13 ps=3.7600e-06 nf=1 m=3 par=3
XMpar13 a_1370_11056.t24 ib vss.t9 vss.t8 nfet_03v3 w=0.4u l=3u ad=2.4000e-13 pd=2.0000e-06 as=2.4000e-13 ps=2.0000e-06 nf=1 m=1
XMpar14 ib.t1 ib vss.t9 vss.t8 nfet_03v3 w=0.4u l=3u ad=2.4000e-13 pd=2.0000e-06 as=1.1200e-13 ps=9.6000e-07 nf=1 m=1
XMpar15 a_10339_15082.t6 a_11154_17204.t6 a_11266_13271.t0 vss.t1 nfet_03v3 w=2.32u l=2.4u ad=1.3920e-12 pd=5.8400e-06 as=1.3920e-12 ps=5.8400e-06 nf=1 m=1
XMpar16 a_1250_11265.t4 a_1250_11265.t3 vdd.t6 vdd.t5 pfet_03v3 w=2.24u l=1.3u ad=1.3440e-12 pd=5.6800e-06 as=1.3440e-12 ps=5.6800e-06 nf=1 m=1
XMpar17 a_12174_8951.t0 a_1370_11056.t25 a_12294_13063.t2 vdd.t0 pfet_03v3 w=5.72u l=1u ad=3.4320e-12 pd=1.2640e-05 as=1.6016e-12 ps=6.2800e-06 nf=1 m=2 par=2
XMpar18 a_10554_16996.t0 ib vss.t9 vss.t8 nfet_03v3 w=0.4u l=3u ad=2.4000e-13 pd=2.0000e-06 as=1.1200e-13 ps=9.6000e-07 nf=1 m=1
XMpar19 a_10674_11560.t0 inp.t0 a_11154_17204.t0 vss.t0 nfet_03v3 w=0.78u l=2.4u ad=4.6800e-13 pd=2.7600e-06 as=2.1840e-13 ps=1.3400e-06 nf=1 m=1
XMpar20 a_10674_11560.t0 inp.t0 a_11154_17204.t0 vss.t1 nfet_03v3 w=0.78u l=2.4u ad=4.6800e-13 pd=2.7600e-06 as=2.1840e-13 ps=1.3400e-06 nf=1 m=1
XMpar21 a_10554_16996.t2 a_10554_16996.t1 vdd.t4 vdd.t3 pfet_03v3 w=0.79u l=3u ad=4.7400e-13 pd=2.7800e-06 as=4.7400e-13 ps=2.7800e-06 nf=1 m=1
XMpar22 a_11266_6867.t0 a_12174_8951.t9 out.t1 vss.t2 nfet_03v3 w=3.09u l=2.4u ad=1.8540e-12 pd=7.3800e-06 as=1.8540e-12 ps=7.3800e-06 nf=1 m=1
XMpar23 a_12294_13063.t4 a_10554_16996.t1 vdd.t4 vdd.t3 pfet_03v3 w=0.79u l=3u ad=2.2120e-13 pd=1.3500e-06 as=4.7400e-13 ps=2.7800e-06 nf=1 m=2 par=2
XMpar24 a_11266_13271.t0 a_12294_13063.t6 a_12174_8951.t2 vss.t1 nfet_03v3 w=2.32u l=2.4u ad=1.3920e-12 pd=5.8400e-06 as=1.3920e-12 ps=5.8400e-06 nf=1 m=1
X36 out.t5 vss.t6 cap_mim_2f0fF c_width=20u c_length=20u
X37 out.t5 vss.t6 cap_mim_2f0fF c_width=20u c_length=20u
X61 out.t5 vss.t6 cap_mim_2f0fF c_width=20u c_length=20u
X65 out.t5 vss.t6 cap_mim_2f0fF c_width=20u c_length=20u
Rpar0 a_10339_15082.t0 a_10339_15082.t1 22.6018
Rpar1 a_10339_15082.t0 a_10339_15082.t6 332.8196
Rpar2 a_10339_15082.t0 a_10339_15082.t7 498.1718
Rpar3 a_10339_15082.t0 a_10339_15082.t9 1682.5919
Rpar4 a_10339_15082.t1 a_10339_15082.t6 93.0474
Rpar5 a_10339_15082.t1 a_10339_15082.t7 139.2754
Rpar6 a_10339_15082.t1 a_10339_15082.t9 470.4072
Rpar7 a_10339_15082.t6 a_10339_15082.t7 128.2302
Rpar8 a_10339_15082.t6 a_10339_15082.t9 433.1017
Rpar9 a_10339_15082.t7 a_10339_15082.t9 71.7678
Rpar10 a_10554_16996.t0 a_10554_16996.t1 54.6304
Rpar11 a_10554_16996.t0 a_10554_16996.t2 162.5744
Rpar12 a_10554_16996.t1 a_10554_16996.t2 28.5956
Rpar13 a_10674_11560.t0 a_10674_11560.t4 53.0104
Rpar14 a_11154_17204.t0 a_11154_17204.t2 91.5937
Rpar15 a_11154_17204.t0 a_11154_17204.t4 198.7608
Rpar16 a_11154_17204.t0 a_11154_17204.t6 91.4665
Rpar17 a_11154_17204.t2 a_11154_17204.t4 317.9495
Rpar18 a_11154_17204.t2 a_11154_17204.t6 146.3152
Rpar19 a_11154_17204.t4 a_11154_17204.t6 105.4160
Rpar20 a_11266_13271.t0 a_11266_13271.t1 60.8168
Rpar21 a_11266_6867.t0 a_11266_6867.t2 47.9368
Rpar22 a_11518_1294.t0 a_11518_1294.t1 224.0214
Rpar23 a_11518_1294.t0 a_11518_1294.t2 83.4070
Rpar24 a_11518_1294.t1 a_11518_1294.t2 8.1424
Rpar25 a_12174_8951.t0 a_12174_8951.t2 128.2302
Rpar26 a_12174_8951.t0 a_12174_8951.t3 498.1718
Rpar27 a_12174_8951.t0 a_12174_8951.t4 139.2754
Rpar28 a_12174_8951.t0 a_12174_8951.t9 71.7678
Rpar29 a_12174_8951.t2 a_12174_8951.t3 332.8196
Rpar30 a_12174_8951.t2 a_12174_8951.t4 93.0474
Rpar31 a_12174_8951.t2 a_12174_8951.t9 433.1017
Rpar32 a_12174_8951.t3 a_12174_8951.t4 22.6018
Rpar33 a_12174_8951.t3 a_12174_8951.t9 1682.5919
Rpar34 a_12174_8951.t4 a_12174_8951.t9 470.4072
Rpar35 a_12294_13063.t0 a_12294_13063.t2 91.5937
Rpar36 a_12294_13063.t0 a_12294_13063.t4 198.7608
Rpar37 a_12294_13063.t0 a_12294_13063.t6 91.4665
Rpar38 a_12294_13063.t2 a_12294_13063.t4 317.9495
Rpar39 a_12294_13063.t2 a_12294_13063.t6 146.3152
Rpar40 a_12294_13063.t4 a_12294_13063.t6 105.4160
Rpar41 a_1250_11265.t0 a_1250_11265.t3 188.3897
Rpar42 a_1250_11265.t0 a_1250_11265.t4 46.4513
Rpar43 a_1250_11265.t3 a_1250_11265.t4 50.8524
Rpar44 a_1370_11056.t0 a_1370_11056.t1 17.8063
Rpar45 a_1370_11056.t0 a_1370_11056.t24 4167.5069
Rpar46 a_1370_11056.t0 a_1370_11056.t25 3996.5547
Rpar47 a_1370_11056.t1 a_1370_11056.t24 145.4133
Rpar48 a_1370_11056.t1 a_1370_11056.t25 139.4484
Rpar49 a_1370_11056.t24 a_1370_11056.t25 205.0604
Rpar50 ib ib.t1 25.5795
Rpar51 inn inn.t0 4.1176
Rpar52 inp inp.t0 4.1662
Rpar53 out out.t0 5.6252
Rpar54 out out.t1 58.6436
Rpar55 out out.t5 72.7079
Rpar56 out.t1 out.t5 245.5608
Rpar57 vdd vdd.t0 4347.2645
Rpar58 vdd vdd.t5 264.9200
Rpar59 vdd vdd.t6 196.9308
Rpar60 vdd vdd.t2 3972.2976
Rpar61 vdd vdd.t3 96.0358
Rpar62 vdd vdd.t4 83.7102
Rpar63 vdd.t0 vdd.t5 65.7298
Rpar64 vdd.t0 vdd.t6 136.1052
Rpar65 vdd.t0 vdd.t2 197.8610
Rpar66 vdd.t0 vdd.t3 2343.6713
Rpar67 vdd.t0 vdd.t4 2104.8447
Rpar68 vdd.t5 vdd.t6 3.8189
Rpar69 vdd.t5 vdd.t2 150.7620
Rpar70 vdd.t5 vdd.t3 142.8221
Rpar71 vdd.t5 vdd.t4 128.2681
Rpar72 vdd.t6 vdd.t2 137.0544
Rpar73 vdd.t6 vdd.t3 106.1682
Rpar74 vdd.t6 vdd.t4 95.3493
Rpar75 vdd.t2 vdd.t3 2141.5213
Rpar76 vdd.t2 vdd.t4 1923.2944
Rpar77 vdd.t3 vdd.t4 11.6586
Rpar78 vss vss.t0 606.4242
Rpar79 vss vss.t1 489.5541
Rpar80 vss vss.t8 168.7651
Rpar81 vss vss.t9 118.5801
Rpar82 vss vss.t2 212.1975
Rpar83 vss vss.t6 84.9399
Rpar84 vss.t0 vss.t1 21.3135
Rpar85 vss.t0 vss.t8 101.0920
Rpar86 vss.t0 vss.t9 370.1947
Rpar87 vss.t0 vss.t2 581.0005
Rpar88 vss.t0 vss.t6 1614.7752
Rpar89 vss.t1 vss.t8 82.2663
Rpar90 vss.t1 vss.t9 299.9984
Rpar91 vss.t1 vss.t2 469.0371
Rpar92 vss.t1 vss.t6 1303.5758
Rpar93 vss.t8 vss.t9 2.7486
Rpar94 vss.t8 vss.t2 211.4313
Rpar95 vss.t8 vss.t6 449.3845
Rpar96 vss.t9 vss.t2 215.2682
Rpar97 vss.t9 vss.t6 315.7530
Rpar98 vss.t2 vss.t6 565.0356
Cpar0 a_10339_15082.t0 vss 3.60925e-15
Cpar1 a_10339_15082.t1 vss 4.19391e-15
Cpar2 a_10339_15082.t6 vss 2.70613e-15
Cpar3 a_10339_15082.t7 vss 5.99408e-15
Cpar4 a_10339_15082.t9 vss 3.16490e-15
Cpar5 a_10554_16996.t0 vss 2.80425e-15
Cpar6 a_10554_16996.t1 vss 1.33531e-14
Cpar7 a_10554_16996.t2 vss 1.99717e-15
Cpar8 a_10674_11560.t0 vss 3.68121e-15
Cpar9 a_10674_11560.t4 vss 4.64697e-15
Cpar10 a_11154_17204.t0 vss 2.10153e-15
Cpar11 a_11154_17204.t2 vss 3.48065e-15
Cpar12 a_11154_17204.t4 vss 2.56097e-15
Cpar13 a_11154_17204.t6 vss 3.42933e-15
Cpar14 a_11266_13271.t0 vss 3.30644e-15
Cpar15 a_11266_13271.t1 vss 4.38777e-15
Cpar16 a_11266_6867.t0 vss 1.22160e-15
Cpar17 a_11266_6867.t2 vss 2.15312e-15
Cpar18 a_11518_1294.t0 vss 3.05120e-15
Cpar19 a_11518_1294.t1 vss 1.11213e-14
Cpar20 a_11518_1294.t2 vss 1.03534e-14
Cpar21 a_12174_8951.t0 vss 5.17185e-15
Cpar22 a_12174_8951.t2 vss 2.33492e-15
Cpar23 a_12174_8951.t3 vss 3.11416e-15
Cpar24 a_12174_8951.t4 vss 3.61861e-15
Cpar25 a_12174_8951.t9 vss 2.73075e-15
Cpar26 a_12294_13063.t0 vss 2.37494e-15
Cpar27 a_12294_13063.t2 vss 3.93349e-15
Cpar28 a_12294_13063.t4 vss 2.89414e-15
Cpar29 a_12294_13063.t6 vss 3.87549e-15
Cpar30 a_1250_11265.t0 vss 1.96816e-14
Cpar31 a_1250_11265.t3 vss 1.05606e-15
Cpar32 a_1250_11265.t4 vss 1.76007e-15
Cpar33 a_1370_11056.t0 vss 1.68130e-14
Cpar34 a_1370_11056.t1 vss 1.73750e-14
Cpar35 a_1370_11056.t24 vss 4.04486e-15
Cpar36 a_1370_11056.t25 vss 6.46979e-15
Cpar37 ib vdd 1.03600e-17
Cpar38 ib vss 4.99727e-14
Cpar39 ib.t1 vss 2.53861e-16
Cpar40 inn inp 5.19700e-17
Cpar41 inn vdd 1.23100e-17
Cpar42 inn vss 3.09101e-15
Cpar43 inn.t0 vss 3.40572e-16
Cpar44 inp vdd 5.51600e-17
Cpar45 inp vss 3.03737e-15
Cpar46 inp.t0 vss 3.60535e-16
Cpar47 out vdd 7.90208e-15
Cpar48 out vss 3.37683e-14
Cpar49 out.t0 vss 1.40482e-16
Cpar50 out.t1 vss 9.56304e-17
Cpar51 out.t5 vss 1.80483e-14
Cpar52 vdd vss 1.84324e-13
Cpar53 vdd.t0 vss 7.90001e-15
Cpar54 vdd.t2 vss 1.89326e-14
Cpar55 vdd.t3 vss 5.39633e-15
Cpar56 vdd.t4 vss 5.89133e-15
Cpar57 vdd.t5 vss 2.41514e-14
Cpar58 vdd.t6 vss 1.16728e-14
.ends opamp_dut

Vdd vdd 0 1.800000
Vss vss 0 0
Ibias vdd ib 2.870000e-08
Vinp inp 0 DC 1.203400 AC 1 PWL(0 1.203400 2.168798e-07 1.203400 2.385678e-07 1.213400)
Rfb out inn 1m
Cload out 0 2.000000e-13
Xdut vdd vss inp inn out ib opamp_dut
.end
