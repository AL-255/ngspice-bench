* opa1000[0918]: 200f/telescopic_pmos_1v8_ulp_lt0p1uw_weak (telescopic_pmos, VDD=1.8V, CL=0.2pF, Iref=0.0013uA)
.include "pdk_opa.inc"
.temp 27
.option gmin=1e-12 rshunt=1e12 reltol=1e-3 abstol=1e-12 vntol=1e-5 method=gear
* Post-PEX R+C extracted netlist for telescopic_pmos_1v8_ulp_lt0p1uw_weak
.subckt opamp_dut vdd vss inp inn out ib
XMpar0 a_2392_3069.t1 a_2512_2861.t0 a_2512_2861.t1 vss.t2 nfet_03v3 w=0.4u l=4u ad=2.4000e-13 pd=2.0000e-06 as=2.4000e-13 ps=2.0000e-06 nf=1 m=2 par=2
XMpar1 a_3069_12254.t0 a_1769_12046.t0 vdd.t3 vdd.t2 pfet_03v3 w=0.4u l=6.5u ad=1.1200e-13 pd=9.6000e-07 as=2.0800e-13 ps=1.7400e-06 nf=1 m=8 par=8
XMpar2 a_2392_3069.t0 a_2512_2861.t8 vss.t1 vss.t0 nfet_03v3 w=0.4u l=9.5u ad=2.4000e-13 pd=2.0000e-06 as=1.1200e-13 ps=9.6000e-07 nf=1 m=2 par=2
XMpar3 a_5644_1249.t0 a_2512_2861.t8 vss.t1 vss.t0 nfet_03v3 w=0.4u l=9.5u ad=1.1200e-13 pd=9.6000e-07 as=1.1200e-13 ps=9.6000e-07 nf=1 m=2 par=2
XMpar4 a_1769_12046.t1 a_1769_12046.t0 vdd.t3 vdd.t2 pfet_03v3 w=0.4u l=6.5u ad=2.4000e-13 pd=2.0000e-06 as=1.1200e-13 ps=9.6000e-07 nf=1 m=2 par=2
XMpar5 a_3069_12254.t3 inn.t0 a_6574_9342.t0 vdd.t7 pfet_03v3 w=0.4u l=5u ad=2.4000e-13 pd=2.0000e-06 as=1.1200e-13 ps=9.6000e-07 nf=1 m=2 par=2
XMpar6 a_1769_12046.t4 ib.t0 vss.t14 vss.t13 nfet_03v3 w=0.4u l=6.5u ad=2.4000e-13 pd=2.0000e-06 as=1.1200e-13 ps=9.6000e-07 nf=1 m=2 par=2
XMpar7 a_3069_12254.t3 inp.t0 a_4434_9342.t0 vdd.t7 pfet_03v3 w=0.4u l=5u ad=2.4000e-13 pd=2.0000e-06 as=1.1200e-13 ps=9.6000e-07 nf=1 m=2 par=2
XMpar8 a_2512_2861.t4 vss.t20 a_4434_9342.t2 vdd.t0 pfet_03v3 w=0.4u l=4u ad=1.1200e-13 pd=9.6000e-07 as=2.4000e-13 ps=2.0000e-06 nf=1 m=2 par=2
XMpar9 ib.t1 ib.t0 vss.t14 vss.t13 nfet_03v3 w=0.4u l=6.5u ad=2.4000e-13 pd=2.0000e-06 as=1.1200e-13 ps=9.6000e-07 nf=1 m=2 par=2
XMpar10 a_5644_1249.t1 a_2512_2861.t0 out.t1 vss.t2 nfet_03v3 w=0.4u l=4u ad=2.4000e-13 pd=2.0000e-06 as=1.1200e-13 ps=9.6000e-07 nf=1 m=2 par=2
XMpar11 a_6574_9342.t2 vss.t20 out.t0 vdd.t0 pfet_03v3 w=0.4u l=4u ad=2.4000e-13 pd=2.0000e-06 as=1.1200e-13 ps=9.6000e-07 nf=1 m=2 par=2
X23 out.t4 vss.t7 cap_mim_2f0fF c_width=14.82u c_length=14.81u
X31 out.t4 vss.t7 cap_mim_2f0fF c_width=14.82u c_length=14.81u
Rpar0 a_1769_12046.t0 a_1769_12046.t1 16.4517
Rpar1 a_1769_12046.t0 a_1769_12046.t4 84.4214
Rpar2 a_1769_12046.t1 a_1769_12046.t4 141.6920
Rpar3 a_2392_3069.t0 a_2392_3069.t1 68.7464
Rpar4 a_2512_2861.t0 a_2512_2861.t1 24.7772
Rpar5 a_2512_2861.t0 a_2512_2861.t8 121.4253
Rpar6 a_2512_2861.t0 a_2512_2861.t4 663.1514
Rpar7 a_2512_2861.t1 a_2512_2861.t8 96.3199
Rpar8 a_2512_2861.t1 a_2512_2861.t4 526.0410
Rpar9 a_2512_2861.t8 a_2512_2861.t4 92.3124
Rpar10 a_3069_12254.t0 a_3069_12254.t3 43.8895
Rpar11 a_4434_9342.t0 a_4434_9342.t2 61.1128
Rpar12 a_5644_1249.t0 a_5644_1249.t1 76.9610
Rpar13 a_6574_9342.t0 a_6574_9342.t2 61.1128
Rpar14 ib ib.t0 9.5730
Rpar15 ib ib.t1 11.8178
Rpar16 ib.t0 ib.t1 43.6383
Rpar17 inn inn.t0 3.1042
Rpar18 inp inp.t0 3.1527
Rpar19 out out.t0 52.1752
Rpar20 out out.t1 74.3533
Rpar21 out out.t4 16.4813
Rpar22 out.t0 out.t1 297.3704
Rpar23 vdd vdd.t0 136.2176
Rpar24 vdd vdd.t3 178.4942
Rpar25 vdd vdd.t7 58.5505
Rpar26 vdd vdd.t2 28.2318
Rpar27 vdd.t0 vdd.t3 3662.9641
Rpar28 vdd.t0 vdd.t7 70.8948
Rpar29 vdd.t0 vdd.t2 579.3581
Rpar30 vdd.t3 vdd.t7 1574.4552
Rpar31 vdd.t3 vdd.t2 14.2451
Rpar32 vdd.t7 vdd.t2 249.0260
Rpar33 vss vss.t0 177.3776
Rpar34 vss vss.t1 670.7730
Rpar35 vss vss.t2 106.3063
Rpar36 vss vss.t13 229.5004
Rpar37 vss vss.t14 755.7012
Rpar38 vss vss.t20 1070.8953
Rpar39 vss vss.t7 1153.4776
Rpar40 vss.t0 vss.t1 39.1150
Rpar41 vss.t0 vss.t2 7.2029
Rpar42 vss.t0 vss.t13 12.4790
Rpar43 vss.t0 vss.t14 70.4172
Rpar44 vss.t0 vss.t20 193.5504
Rpar45 vss.t0 vss.t7 220.2500
Rpar46 vss.t1 vss.t2 25.6850
Rpar47 vss.t1 vss.t13 49.5899
Rpar48 vss.t1 vss.t14 284.6154
Rpar49 vss.t1 vss.t20 749.7014
Rpar50 vss.t1 vss.t7 848.9957
Rpar51 vss.t2 vss.t13 9.4415
Rpar52 vss.t2 vss.t14 51.8815
Rpar53 vss.t2 vss.t20 129.2330
Rpar54 vss.t2 vss.t7 145.4702
Rpar55 vss.t13 vss.t14 45.8987
Rpar56 vss.t13 vss.t20 191.8558
Rpar57 vss.t13 vss.t7 232.4326
Rpar58 vss.t14 vss.t20 130.5486
Rpar59 vss.t14 vss.t7 196.5011
Rpar60 vss.t20 vss.t7 187.3923
Cpar0 a_1769_12046.t0 vss 4.11519e-14
Cpar1 a_1769_12046.t1 vss 7.82141e-15
Cpar2 a_1769_12046.t4 vss 8.39709e-15
Cpar3 a_2392_3069.t0 vss 5.47387e-15
Cpar4 a_2392_3069.t1 vss 4.09385e-15
Cpar5 a_2512_2861.t0 vss 2.49315e-15
Cpar6 a_2512_2861.t1 vss 9.57877e-16
Cpar7 a_2512_2861.t4 vss 1.15914e-15
Cpar8 a_2512_2861.t8 vss 5.67271e-15
Cpar9 a_3069_12254.t0 vss 1.82023e-14
Cpar10 a_3069_12254.t3 vss 7.95046e-15
Cpar11 a_4434_9342.t0 vss 2.84078e-15
Cpar12 a_4434_9342.t2 vss 3.33548e-15
Cpar13 a_5644_1249.t0 vss 5.88132e-15
Cpar14 a_5644_1249.t1 vss 5.73126e-15
Cpar15 a_6574_9342.t0 vss 2.76068e-15
Cpar16 a_6574_9342.t2 vss 3.24142e-15
Cpar17 ib out 1.16100e-17
Cpar18 ib vss 2.12780e-14
Cpar19 ib.t0 vss 3.00242e-15
Cpar20 ib.t1 vss 3.41015e-16
Cpar21 inn inp 5.12600e-17
Cpar22 inn vdd 4.83879e-15
Cpar23 inn vss 3.00229e-15
Cpar24 inn.t0 vss 2.83007e-15
Cpar25 inp vdd 4.94645e-15
Cpar26 inp vss 3.00576e-15
Cpar27 inp.t0 vss 2.90951e-15
Cpar28 out vdd 1.84591e-15
Cpar29 out vss 2.02341e-14
Cpar30 out.t0 vss 1.05341e-16
Cpar31 out.t1 vss 1.50066e-16
Cpar32 out.t4 vss 6.67406e-15
Cpar33 vdd vss 1.34820e-13
Cpar34 vdd.t0 vss 1.18875e-14
Cpar35 vdd.t2 vss 3.44765e-14
Cpar36 vdd.t3 vss 7.63471e-15
Cpar37 vdd.t7 vss 9.70958e-15
.ends opamp_dut

Vdd vdd 0 1.800000
Vss vss 0 0
Ibias vdd ib 1.300000e-09
Vinp inp 0 DC 0.805000 AC 1 PWL(0 0.805000 1.247247e-05 0.805000 1.371972e-05 0.815000)
Rfb out inn 1m
Cload out 0 2.000000e-13
Xdut vdd vss inp inn out ib opamp_dut
.end
