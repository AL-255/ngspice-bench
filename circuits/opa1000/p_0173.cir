* opa1000[0173]: 200f/folded_cascode_nmos_1v8_i1u_subth (folded_cascode_nmos, VDD=1.8V, CL=0.2pF, Iref=0.2556uA)
.include "pdk_opa.inc"
.temp 27
.option gmin=1e-12 rshunt=1e12 reltol=1e-3 abstol=1e-12 vntol=1e-5 method=gear
* Post-PEX R+C extracted netlist for folded_cascode_nmos_1v8_i1u_subth
.subckt opamp_dut vdd vss inp inn out ib
XMpar0 a_8814_5239.t0 a_2770_12995.t2 vdd.t1 vdd.t0 pfet_03v3 w=9.42u l=6.75u ad=2.6376e-12 pd=9.9800e-06 as=4.1448e-12 ps=1.5010e-05 nf=1 m=4 par=4
XMpar1 a_4120_13203.t12 a_2770_12995.t2 vdd.t1 vdd.t0 pfet_03v3 w=9.42u l=6.75u ad=2.6376e-12 pd=9.9800e-06 as=4.1448e-12 ps=1.5010e-05 nf=1 m=4 par=4
XMpar2 a_8814_5239.t15 ib out.t0 vdd.t10 pfet_03v3 w=1.92u l=2.13u ad=6.9120e-13 pd=3.1200e-06 as=5.3760e-13 ps=2.4800e-06 nf=1 m=16 par=16
XMpar3 a_3484_3119.t0 inp.t0 a_4120_13203.t0 vss.t0 nfet_03v3 w=1.8u l=2.08u ad=6.9600e-13 pd=3.1733e-06 as=6.9600e-13 ps=3.1733e-06 nf=1 m=12 par=12
XMpar4 a_3484_3119.t24 ib.t0 vss.t4 vss.t3 nfet_03v3 w=1.67u l=4.38u ad=4.6760e-13 pd=2.2300e-06 as=4.6760e-13 ps=2.2300e-06 nf=1 m=4 par=4
XMpar5 a_4740_10264.t1 a_4740_10264.t0 vss.t4 vss.t3 nfet_03v3 w=1.67u l=4.38u ad=1.0020e-12 pd=4.5400e-06 as=4.6760e-13 ps=2.2300e-06 nf=1 m=2 par=2
XMpar6 a_3484_3119.t0 inn.t0 a_8814_5239.t3 vss.t0 nfet_03v3 w=1.8u l=2.08u ad=6.9600e-13 pd=3.1733e-06 as=6.9600e-13 ps=3.1733e-06 nf=1 m=12 par=12
XMpar7 a_2770_12995.t3 a_2770_12995.t2 vdd.t1 vdd.t0 pfet_03v3 w=9.42u l=6.75u ad=2.6376e-12 pd=9.9800e-06 as=5.6520e-12 ps=2.0040e-05 nf=1 m=2 par=2
XMpar8 a_4120_13203.t13 ib a_4740_10264.t4 vdd.t10 pfet_03v3 w=1.92u l=2.13u ad=6.9120e-13 pd=3.1200e-06 as=5.3760e-13 ps=2.4800e-06 nf=1 m=16 par=16
XMpar9 ib.t1 ib.t0 vss.t4 vss.t3 nfet_03v3 w=1.67u l=4.38u ad=1.0020e-12 pd=4.5400e-06 as=4.6760e-13 ps=2.2300e-06 nf=1 m=2 par=2
XMpar10 out.t3 a_4740_10264.t0 vss.t4 vss.t3 nfet_03v3 w=1.67u l=4.38u ad=4.6760e-13 pd=2.2300e-06 as=4.6760e-13 ps=2.2300e-06 nf=1 m=2 par=2
XMpar11 a_2770_12995.t0 ib.t0 vss.t4 vss.t3 nfet_03v3 w=1.67u l=4.38u ad=4.6760e-13 pd=2.2300e-06 as=4.6760e-13 ps=2.2300e-06 nf=1 m=2 par=2
X11 out.t18 vss.t26 cap_mim_2f0fF c_width=14.37u c_length=14.36u
Rpar0 a_2770_12995.t0 a_2770_12995.t2 180.1080
Rpar1 a_2770_12995.t0 a_2770_12995.t3 199.6056
Rpar2 a_2770_12995.t2 a_2770_12995.t3 20.5872
Rpar3 a_3484_3119.t0 a_3484_3119.t24 42.1693
Rpar4 a_4120_13203.t0 a_4120_13203.t12 185.5397
Rpar5 a_4120_13203.t0 a_4120_13203.t13 61.1427
Rpar6 a_4120_13203.t12 a_4120_13203.t13 61.1578
Rpar7 a_4740_10264.t0 a_4740_10264.t1 18.1169
Rpar8 a_4740_10264.t0 a_4740_10264.t4 224.0643
Rpar9 a_4740_10264.t1 a_4740_10264.t4 101.0167
Rpar10 a_8814_5239.t0 a_8814_5239.t3 185.5397
Rpar11 a_8814_5239.t0 a_8814_5239.t15 61.1578
Rpar12 a_8814_5239.t3 a_8814_5239.t15 61.1427
Rpar13 ib ib.t0 145.3183
Rpar14 ib ib.t1 77.2857
Rpar15 ib.t0 ib.t1 18.2945
Rpar16 inn inn.t0 2.7332
Rpar17 inp inp.t0 2.7332
Rpar18 out out.t0 3.2660
Rpar19 out out.t18 83.8883
Rpar20 out out.t3 191.0468
Rpar21 out.t18 out.t3 110.9678
Rpar22 vdd vdd.t0 27.4052
Rpar23 vdd vdd.t1 96.8840
Rpar24 vdd vdd.t10 188.3834
Rpar25 vdd.t0 vdd.t1 4.7956
Rpar26 vdd.t0 vdd.t10 63.4585
Rpar27 vdd.t1 vdd.t10 95.6168
Rpar28 vss vss.t0 96.4631
Rpar29 vss vss.t3 64.0572
Rpar30 vss vss.t4 348.0449
Rpar31 vss vss.t26 1140.3502
Rpar32 vss.t0 vss.t3 1.7122
Rpar33 vss.t0 vss.t4 9.9099
Rpar34 vss.t0 vss.t26 118.4132
Rpar35 vss.t3 vss.t4 5.1462
Rpar36 vss.t3 vss.t26 78.3574
Rpar37 vss.t4 vss.t26 447.6280
Cpar0 a_2770_12995.t0 vss 3.62416e-15
Cpar1 a_2770_12995.t2 vss 6.00761e-14
Cpar2 a_2770_12995.t3 vss 4.42548e-15
Cpar3 a_3484_3119.t0 vss 2.13810e-14
Cpar4 a_3484_3119.t24 vss 7.11155e-15
Cpar5 a_4120_13203.t0 vss 1.15800e-14
Cpar6 a_4120_13203.t12 vss 1.19869e-14
Cpar7 a_4120_13203.t13 vss 1.58706e-14
Cpar8 a_4740_10264.t0 vss 9.05767e-15
Cpar9 a_4740_10264.t1 vss 4.26120e-15
Cpar10 a_4740_10264.t4 vss 1.00242e-14
Cpar11 a_8814_5239.t0 vss 1.24608e-14
Cpar12 a_8814_5239.t15 vss 1.64980e-14
Cpar13 a_8814_5239.t3 vss 1.20379e-14
Cpar14 ib inn 1.57400e-17
Cpar15 ib inp 1.65100e-17
Cpar16 ib out 4.01322e-15
Cpar17 ib vdd 3.19514e-14
Cpar18 ib vss 6.46091e-14
Cpar19 ib.t0 vss 1.54882e-14
Cpar20 ib.t1 vss 3.26861e-15
Cpar21 inn inp 2.05080e-16
Cpar22 inn vss 1.40694e-14
Cpar23 inn.t0 vss 6.82353e-15
Cpar24 inp vss 1.39627e-14
Cpar25 inp.t0 vss 6.75270e-15
Cpar26 out vdd 7.76717e-15
Cpar27 out vss 1.37924e-14
Cpar28 out.t0 vss 2.07263e-15
Cpar29 out.t18 vss 2.08913e-14
Cpar30 out.t3 vss 1.15298e-15
Cpar31 vdd vss 2.56936e-13
Cpar32 vdd.t0 vss 4.38328e-14
Cpar33 vdd.t1 vss 2.36783e-14
Cpar34 vdd.t10 vss 3.79949e-14
.ends opamp_dut

Vdd vdd 0 1.800000
Vss vss 0 0
Ibias vdd ib 2.556000e-07
Vinp inp 0 DC 0.985000 AC 1 PWL(0 0.985000 7.240682e-08 0.985000 7.964751e-08 0.995000)
Rfb out inn 1m
Cload out 0 2.000000e-13
Xdut vdd vss inp inn out ib opamp_dut
.end
