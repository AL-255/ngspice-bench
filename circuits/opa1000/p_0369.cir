* opa1000[0369]: 200f/nmos_5t_3v3_i20u_weak (nmos_5t, VDD=3.3V, CL=0.2pF, Iref=5.75uA)
.include "pdk_opa.inc"
.temp 27
.option gmin=1e-12 rshunt=1e12 reltol=1e-3 abstol=1e-12 vntol=1e-5 method=gear
* Post-PEX R+C extracted netlist for nmos_5t_3v3_i20u_weak
.subckt opamp_dut vdd vss inp inn out ib
XMpar0 out.t0 a_1685_5679.t14 vdd.t1 vdd.t0 pfet_03v3 w=2.04u l=0.81u ad=6.6446e-13 pd=2.9829e-06 as=6.6446e-13 ps=2.9829e-06 nf=1 m=14 par=14
XMpar1 a_1263_1204.t0 inp.t0 a_1685_5679.t0 vss.t0 nfet_03v3 w=2.06u l=0.72u ad=6.7097e-13 pd=3.0057e-06 as=6.7097e-13 ps=3.0057e-06 nf=1 m=14 par=14
XMpar2 a_1263_1204.t0 inn.t0 out.t10 vss.t0 nfet_03v3 w=2.06u l=0.72u ad=6.7097e-13 pd=3.0057e-06 as=6.7097e-13 ps=3.0057e-06 nf=1 m=14 par=14
XMpar3 a_1263_1204.t28 ib.t0 vss.t15 vss.t14 nfet_03v3 w=1.66u l=0.72u ad=4.6480e-13 pd=2.2200e-06 as=5.9760e-13 ps=2.7950e-06 nf=1 m=8 par=8
XMpar4 ib.t1 ib.t0 vss.t15 vss.t14 nfet_03v3 w=1.66u l=0.72u ad=4.6480e-13 pd=2.2200e-06 as=4.6480e-13 ps=2.2200e-06 nf=1 m=2 par=2
XMpar5 a_1685_5679.t15 a_1685_5679.t14 vdd.t1 vdd.t0 pfet_03v3 w=2.04u l=0.81u ad=6.6446e-13 pd=2.9829e-06 as=6.6446e-13 ps=2.9829e-06 nf=1 m=14 par=14
Rpar0 a_1263_1204.t0 a_1263_1204.t28 26.5295
Rpar1 a_1685_5679.t0 a_1685_5679.t14 161.6460
Rpar2 a_1685_5679.t0 a_1685_5679.t15 44.0148
Rpar3 a_1685_5679.t14 a_1685_5679.t15 7.8837
Rpar4 ib ib.t0 13.0800
Rpar5 ib ib.t1 10.0275
Rpar6 inn inn.t0 3.6098
Rpar7 inp inp.t0 3.6098
Rpar8 out out.t0 3.1694
Rpar9 out out.t10 378.5623
Rpar10 out.t0 out.t10 40.9528
Rpar11 vdd vdd.t0 20.8175
Rpar12 vdd vdd.t1 372.4507
Rpar13 vdd.t0 vdd.t1 10.6366
Rpar14 vss vss.t0 38.4456
Rpar15 vss vss.t14 41.8580
Rpar16 vss vss.t15 150.6777
Rpar17 vss.t0 vss.t14 2.0262
Rpar18 vss.t0 vss.t15 10.1512
Rpar19 vss.t14 vss.t15 7.6037
Cpar0 a_1263_1204.t0 vss 1.70054e-14
Cpar1 a_1263_1204.t28 vss 3.29380e-15
Cpar2 a_1685_5679.t0 vss 1.09217e-14
Cpar3 a_1685_5679.t14 vss 2.34969e-14
Cpar4 a_1685_5679.t15 vss 1.44023e-14
Cpar5 ib inp 1.44600e-17
Cpar6 ib vss 1.00016e-14
Cpar7 ib.t0 vss 1.45277e-15
Cpar8 ib.t1 vss 9.41220e-17
Cpar9 inn inp 1.04540e-16
Cpar10 inn out 2.22396e-15
Cpar11 inn vss 9.09229e-15
Cpar12 inn.t0 vss 2.80259e-15
Cpar13 inp vss 9.07345e-15
Cpar14 inp.t0 vss 2.83853e-15
Cpar15 out vdd 1.07669e-14
Cpar16 out vss 8.81898e-15
Cpar17 out.t0 vss 1.29091e-14
Cpar18 out.t10 vss 1.20205e-14
Cpar19 vdd vss 6.10471e-14
Cpar20 vdd.t0 vss 3.09410e-14
Cpar21 vdd.t1 vss 6.17352e-15
.ends opamp_dut

Vdd vdd 0 3.300000
Vss vss 0 0
Ibias vdd ib 5.750000e-06
Vinp inp 0 DC 1.645000 AC 1 PWL(0 1.645000 3.000000e-09 1.645000 3.300000e-09 1.655000)
Rfb out inn 1m
Cload out 0 2.000000e-13
Xdut vdd vss inp inn out ib opamp_dut
.end
