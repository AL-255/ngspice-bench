* opa1000[0836]: 200f/telescopic_nmos_1v8_i50n_weak (telescopic_nmos, VDD=1.8V, CL=0.2pF, Iref=0.0144uA)
.include "pdk_opa.inc"
.temp 27
.option gmin=1e-12 rshunt=1e12 reltol=1e-3 abstol=1e-12 vntol=1e-5 method=gear
* Post-PEX R+C extracted netlist for telescopic_nmos_1v8_i50n_weak
.subckt opamp_dut vdd vss inp inn out ib
XMpar0 a_4654_6123.t2 vdd.t12 out.t0 vss.t2 nfet_03v3 w=0.4u l=5.25u ad=2.4000e-13 pd=2.0000e-06 as=1.1200e-13 ps=9.6000e-07 nf=1 m=2 par=2
XMpar1 a_3474_2775.t1 a_1792_4344.t8 vdd.t3 vdd.t2 pfet_03v3 w=0.4u l=6.5u ad=1.1200e-13 pd=9.6000e-07 as=1.1200e-13 ps=9.6000e-07 nf=1 m=2 par=2
XMpar2 a_1792_4344.t0 vdd.t12 a_2014_6123.t0 vss.t2 nfet_03v3 w=0.4u l=5.25u ad=1.1200e-13 pd=9.6000e-07 as=2.4000e-13 ps=2.0000e-06 nf=1 m=2 par=2
XMpar3 a_1514_7534.t0 inn.t0 a_4654_6123.t0 vss.t0 nfet_03v3 w=0.4u l=6.5u ad=2.4000e-13 pd=2.0000e-06 as=1.1200e-13 ps=9.6000e-07 nf=1 m=2 par=2
XMpar4 a_1514_7534.t4 ib.t0 vss.t9 vss.t8 nfet_03v3 w=0.4u l=3u ad=1.1200e-13 pd=9.6000e-07 as=1.4400e-13 ps=1.2200e-06 nf=1 m=8 par=8
XMpar5 a_1672_4552.t0 a_1792_4344.t2 a_1792_4344.t3 vdd.t0 pfet_03v3 w=0.63u l=5.25u ad=3.7800e-13 pd=2.4600e-06 as=3.7800e-13 ps=2.4600e-06 nf=1 m=2 par=2
XMpar6 a_3474_2775.t0 a_1792_4344.t2 out.t1 vdd.t0 pfet_03v3 w=0.63u l=5.25u ad=3.7800e-13 pd=2.4600e-06 as=1.7640e-13 ps=1.1900e-06 nf=1 m=2 par=2
XMpar7 ib.t1 ib.t0 vss.t9 vss.t8 nfet_03v3 w=0.4u l=3u ad=1.1200e-13 pd=9.6000e-07 as=1.1200e-13 ps=9.6000e-07 nf=1 m=2 par=2
XMpar8 a_1514_7534.t0 inp.t0 a_2014_6123.t2 vss.t0 nfet_03v3 w=0.4u l=6.5u ad=2.4000e-13 pd=2.0000e-06 as=1.1200e-13 ps=9.6000e-07 nf=1 m=2 par=2
XMpar9 a_1672_4552.t1 a_1792_4344.t8 vdd.t3 vdd.t2 pfet_03v3 w=0.4u l=6.5u ad=2.4000e-13 pd=2.0000e-06 as=1.1200e-13 ps=9.6000e-07 nf=1 m=2 par=2
Rpar0 a_1514_7534.t0 a_1514_7534.t4 44.6806
Rpar1 a_1672_4552.t0 a_1672_4552.t1 56.9886
Rpar2 a_1792_4344.t0 a_1792_4344.t8 123.7736
Rpar3 a_1792_4344.t0 a_1792_4344.t2 364.4279
Rpar4 a_1792_4344.t0 a_1792_4344.t3 260.5239
Rpar5 a_1792_4344.t8 a_1792_4344.t2 98.1408
Rpar6 a_1792_4344.t8 a_1792_4344.t3 70.1593
Rpar7 a_1792_4344.t2 a_1792_4344.t3 25.1756
Rpar8 a_2014_6123.t0 a_2014_6123.t2 62.8461
Rpar9 a_3474_2775.t0 a_3474_2775.t1 63.9019
Rpar10 a_4654_6123.t0 a_4654_6123.t2 62.8461
Rpar11 ib ib.t0 10.8675
Rpar12 ib ib.t1 16.8213
Rpar13 inn inn.t0 3.2172
Rpar14 inp inp.t0 3.2658
Rpar15 out out.t0 64.9102
Rpar16 out out.t1 14.3383
Rpar17 vdd vdd.t0 203.1334
Rpar18 vdd vdd.t2 114.5098
Rpar19 vdd vdd.t3 213.3167
Rpar20 vdd vdd.t12 77.3104
Rpar21 vdd.t0 vdd.t2 242.9647
Rpar22 vdd.t0 vdd.t3 452.6112
Rpar23 vdd.t0 vdd.t12 182.8442
Rpar24 vdd.t2 vdd.t3 15.2674
Rpar25 vdd.t2 vdd.t12 103.0724
Rpar26 vdd.t3 vdd.t12 192.0103
Rpar27 vss vss.t0 484.1167
Rpar28 vss vss.t8 80.0406
Rpar29 vss vss.t9 194.4513
Rpar30 vss vss.t2 565.0328
Rpar31 vss.t0 vss.t8 104.0728
Rpar32 vss.t0 vss.t9 252.6358
Rpar33 vss.t0 vss.t2 10.2631
Rpar34 vss.t8 vss.t9 7.2633
Rpar35 vss.t8 vss.t2 121.4678
Rpar36 vss.t9 vss.t2 294.8619
Cpar0 a_1514_7534.t0 vss 6.08405e-15
Cpar1 a_1514_7534.t4 vss 6.40143e-15
Cpar2 a_1672_4552.t0 vss 6.23201e-15
Cpar3 a_1672_4552.t1 vss 6.62271e-15
Cpar4 a_1792_4344.t0 vss 3.20802e-15
Cpar5 a_1792_4344.t2 vss 1.37274e-14
Cpar6 a_1792_4344.t3 vss 4.26219e-15
Cpar7 a_1792_4344.t8 vss 1.53762e-14
Cpar8 a_2014_6123.t0 vss 3.56118e-15
Cpar9 a_2014_6123.t2 vss 3.03036e-15
Cpar10 a_3474_2775.t0 vss 7.74844e-15
Cpar11 a_3474_2775.t1 vss 6.29763e-15
Cpar12 a_4654_6123.t0 vss 2.01014e-15
Cpar13 a_4654_6123.t2 vss 2.38218e-15
Cpar14 ib vdd 2.56000e-17
Cpar15 ib vss 2.29774e-14
Cpar16 ib.t0 vss 2.99620e-15
Cpar17 ib.t1 vss 1.54986e-16
Cpar18 inn inp 5.16000e-17
Cpar19 inn vdd 5.41000e-17
Cpar20 inn vss 6.86594e-15
Cpar21 inn.t0 vss 4.90241e-16
Cpar22 inp vdd 4.52400e-17
Cpar23 inp vss 6.77850e-15
Cpar24 inp.t0 vss 4.97891e-16
Cpar25 out vdd 3.19762e-15
Cpar26 out vss 1.00362e-14
Cpar27 out.t0 vss 2.85076e-15
Cpar28 out.t1 vss 6.44203e-16
Cpar29 vdd vss 8.25936e-14
Cpar30 vdd.t0 vss 1.61982e-14
Cpar31 vdd.t12 vss 4.24474e-15
Cpar32 vdd.t2 vss 1.07917e-14
Cpar33 vdd.t3 vss 5.54146e-15
.ends opamp_dut

Vdd vdd 0 1.800000
Vss vss 0 0
Ibias vdd ib 1.440000e-08
Vinp inp 0 DC 0.931000 AC 1 PWL(0 0.931000 3.068466e-07 0.931000 3.375313e-07 0.941000)
Rfb out inn 1m
Cload out 0 2.000000e-13
Xdut vdd vss inp inn out ib opamp_dut
.end
