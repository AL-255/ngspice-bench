* opa1000[0643]: 2p/pmos_miller_1v8_10u_100u_subth (pmos_miller, VDD=1.8V, CL=2.0pF, Iref=8.125uA)
.include "pdk_opa.inc"
.temp 27
.option gmin=1e-12 rshunt=1e12 reltol=1e-3 abstol=1e-12 vntol=1e-5 method=gear
* Post-PEX R+C extracted netlist for pmos_miller_1v8_10u_100u_subth
.subckt opamp_dut vdd vss inp inn out ib
XMpar0 a_2194_1249.t2 inn.t0 a_9512_6368.t4 vdd.t10 pfet_03v3 w=8u l=0.6u ad=2.4000e-12 pd=9.1000e-06 as=2.2400e-12 ps=8.5600e-06 nf=1 m=64 par=64
XMpar1 a_11161_10200.t3 a_11161_10200.t2 vdd.t1 vdd.t0 pfet_03v3 w=10u l=0.8u ad=2.8000e-12 pd=1.0560e-05 as=2.8000e-12 ps=1.0560e-05 nf=1 m=2 par=2
XMpar2 a_2194_1249.t2 inp.t0 a_2434_1249.t0 vdd.t10 pfet_03v3 w=8u l=0.6u ad=2.4000e-12 pd=9.1000e-06 as=2.2400e-12 ps=8.5600e-06 nf=1 m=64 par=64
XMpar3 a_2434_1249.t64 a_9512_6368.t0 vss.t9 vss.t8 nfet_03v3 w=10u l=0.75u ad=6.0000e-12 pd=2.1200e-05 as=2.8000e-12 ps=1.0560e-05 nf=1 m=2 par=2
XMpar4 out.t9 a_2434_1249.t67 vss.t9 vss.t8 nfet_03v3 w=10u l=0.75u ad=2.8000e-12 pd=1.0560e-05 as=3.4400e-12 ps=1.2688e-05 nf=1 m=10 par=10
XMpar5 out.t0 a_11161_10200.t2 vdd.t1 vdd.t0 pfet_03v3 w=10u l=0.8u ad=3.4400e-12 pd=1.2688e-05 as=2.8000e-12 ps=1.0560e-05 nf=1 m=10 par=10
XMpar6 a_11161_10200.t0 ib.t0 vss.t1 vss.t0 nfet_03v3 w=7.56u l=0.8u ad=2.1168e-12 pd=8.1200e-06 as=2.1168e-12 ps=8.1200e-06 nf=1 m=2 par=2
XMpar7 a_2194_1249.t0 a_11161_10200.t2 vdd.t1 vdd.t0 pfet_03v3 w=10u l=0.8u ad=2.8000e-12 pd=1.0560e-05 as=2.8000e-12 ps=1.0560e-05 nf=1 m=4 par=4
XMpar8 ib.t1 ib.t0 vss.t1 vss.t0 nfet_03v3 w=7.56u l=0.8u ad=4.5360e-12 pd=1.6320e-05 as=2.1168e-12 ps=8.1200e-06 nf=1 m=2 par=2
XMpar9 a_9512_6368.t1 a_9512_6368.t0 vss.t9 vss.t8 nfet_03v3 w=10u l=0.75u ad=2.8000e-12 pd=1.0560e-05 as=2.8000e-12 ps=1.0560e-05 nf=1 m=2 par=2
X32 a_13476_6617.t1 out.t2 cap_mim_2f0fF c_width=17.92u c_length=17.91u
X79 a_2434_1249.t66 a_13476_6617.t0 vss.t22 ppolyf_u_1k r_width=1u r_length=1.47u
X97 a_13476_6617.t1 out.t2 cap_mim_2f0fF c_width=17.92u c_length=17.91u
X119 a_13476_6617.t1 out.t2 cap_mim_2f0fF c_width=17.92u c_length=17.91u
Rpar0 a_11161_10200.t0 a_11161_10200.t2 118.3334
Rpar1 a_11161_10200.t0 a_11161_10200.t3 64.6829
Rpar2 a_11161_10200.t2 a_11161_10200.t3 27.4584
Rpar3 a_13476_6617.t0 a_13476_6617.t1 90.4580
Rpar4 a_2194_1249.t0 a_2194_1249.t2 48.9902
Rpar5 a_2434_1249.t0 a_2434_1249.t64 93.9930
Rpar6 a_2434_1249.t0 a_2434_1249.t66 1900.9647
Rpar7 a_2434_1249.t0 a_2434_1249.t67 300.4805
Rpar8 a_2434_1249.t64 a_2434_1249.t66 423.1485
Rpar9 a_2434_1249.t64 a_2434_1249.t67 66.8860
Rpar10 a_2434_1249.t66 a_2434_1249.t67 168.7639
Rpar11 a_9512_6368.t0 a_9512_6368.t1 37.7025
Rpar12 a_9512_6368.t0 a_9512_6368.t4 486.9355
Rpar13 a_9512_6368.t1 a_9512_6368.t4 100.7244
Rpar14 ib ib.t0 23.7039
Rpar15 ib ib.t1 3.2871
Rpar16 inn inn.t0 2.4374
Rpar17 inp inp.t0 2.4374
Rpar18 out out.t0 1.7836
Rpar19 out out.t9 128.7488
Rpar20 out out.t2 148.4572
Rpar21 out.t9 out.t2 102.6949
Rpar22 vdd vdd.t0 107.9382
Rpar23 vdd vdd.t1 630.1336
Rpar24 vdd vdd.t10 156.3492
Rpar25 vdd.t0 vdd.t1 5.1635
Rpar26 vdd.t0 vdd.t10 92.2510
Rpar27 vdd.t1 vdd.t10 538.5532
Rpar28 vss vss.t0 344.7000
Rpar29 vss vss.t1 1664.3303
Rpar30 vss vss.t8 112.5118
Rpar31 vss vss.t9 417.2103
Rpar32 vss vss.t22 1532.9068
Rpar33 vss.t0 vss.t1 26.1835
Rpar34 vss.t0 vss.t8 1.9743
Rpar35 vss.t0 vss.t9 15.9968
Rpar36 vss.t0 vss.t22 150.6572
Rpar37 vss.t1 vss.t8 10.1189
Rpar38 vss.t1 vss.t9 84.8391
Rpar39 vss.t1 vss.t22 975.8785
Rpar40 vss.t8 vss.t9 4.2297
Rpar41 vss.t8 vss.t22 34.0608
Rpar42 vss.t9 vss.t22 178.9023
Cpar0 a_11161_10200.t0 vss 3.06131e-15
Cpar1 a_11161_10200.t2 vss 2.09259e-14
Cpar2 a_11161_10200.t3 vss 4.90415e-15
Cpar3 a_13476_6617.t0 vss 2.28480e-16
Cpar4 a_13476_6617.t1 vss 1.35392e-14
Cpar5 a_2194_1249.t0 vss 1.07222e-14
Cpar6 a_2194_1249.t2 vss 1.89844e-13
Cpar7 a_2434_1249.t0 vss 7.85255e-14
Cpar8 a_2434_1249.t64 vss 1.11780e-14
Cpar9 a_2434_1249.t66 vss 4.96508e-15
Cpar10 a_2434_1249.t67 vss 2.01475e-14
Cpar11 a_9512_6368.t0 vss 7.20627e-15
Cpar12 a_9512_6368.t1 vss 8.58631e-15
Cpar13 a_9512_6368.t4 vss 8.98722e-14
Cpar14 ib out 1.15770e-16
Cpar15 ib vss 9.00887e-15
Cpar16 ib.t0 vss 5.87991e-16
Cpar17 ib.t1 vss 4.95320e-16
Cpar18 inn inp 1.03940e-16
Cpar19 inn vdd 2.68380e-14
Cpar20 inn vss 1.20317e-14
Cpar21 inn.t0 vss 4.77270e-14
Cpar22 inp vdd 2.68175e-14
Cpar23 inp vss 1.19106e-14
Cpar24 inp.t0 vss 4.77035e-14
Cpar25 out vdd 1.61486e-14
Cpar26 out vss 2.80945e-14
Cpar27 out.t0 vss 7.73190e-15
Cpar28 out.t2 vss 1.85587e-14
Cpar29 out.t9 vss 8.44384e-15
Cpar30 vdd vss 3.48581e-13
Cpar31 vdd.t0 vss 1.98172e-14
Cpar32 vdd.t1 vss 7.27651e-15
Cpar33 vdd.t10 vss 9.40172e-14
.ends opamp_dut

Vdd vdd 0 1.800000
Vss vss 0 0
Ibias vdd ib 8.125000e-06
Vinp inp 0 DC 0.805000 AC 1 PWL(0 0.805000 7.383032e-09 0.805000 8.121335e-09 0.815000)
Rfb out inn 1m
Cload out 0 2.000000e-12
Xdut vdd vss inp inn out ib opamp_dut
.end
