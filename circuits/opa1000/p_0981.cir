* opa1000[0981]: 2p/telescopic_pmos_3v3_i50n_subth (telescopic_pmos, VDD=3.3V, CL=2.0pF, Iref=0.013uA)
.include "pdk_opa.inc"
.temp 27
.option gmin=1e-12 rshunt=1e12 reltol=1e-3 abstol=1e-12 vntol=1e-5 method=gear
* Post-PEX R+C extracted netlist for telescopic_pmos_3v3_i50n_subth
.subckt opamp_dut vdd vss inp inn out ib
XMpar0 a_5332_1204.t1 a_5452_996.t4 a_5452_996.t5 vss.t2 nfet_03v3 w=0.4u l=2.8u ad=2.4000e-13 pd=2.0000e-06 as=2.4000e-13 ps=2.0000e-06 nf=1 m=2 par=2
XMpar1 a_3346_5413.t0 inp.t0 a_4842_5413.t2 vdd.t3 pfet_03v3 w=7.81u l=6.88u ad=3.4364e-12 pd=1.2595e-05 as=2.1868e-12 ps=8.3700e-06 nf=1 m=8 par=8
XMpar2 a_3346_5413.t8 a_4407_10664.t2 vdd.t8 vdd.t7 pfet_03v3 w=0.53u l=6.25u ad=1.4840e-13 pd=1.0900e-06 as=2.7560e-13 ps=1.9675e-06 nf=1 m=8 par=8
XMpar3 ib.t1 ib.t0 vss.t4 vss.t3 nfet_03v3 w=0.4u l=6.25u ad=2.4000e-13 pd=2.0000e-06 as=1.1200e-13 ps=9.6000e-07 nf=1 m=2 par=2
XMpar4 a_3346_5413.t0 inn.t0 a_8924_3044.t2 vdd.t3 pfet_03v3 w=7.81u l=6.88u ad=3.4364e-12 pd=1.2595e-05 as=2.1868e-12 ps=8.3700e-06 nf=1 m=8 par=8
XMpar5 a_8924_3044.t0 a_5452_996.t0 out.t0 vdd.t0 pfet_03v3 w=2.02u l=2.8u ad=1.2120e-12 pd=5.2400e-06 as=5.6560e-13 ps=2.5800e-06 nf=1 m=2 par=2
XMpar6 a_4407_10664.t0 ib.t0 vss.t4 vss.t3 nfet_03v3 w=0.4u l=6.25u ad=2.4000e-13 pd=2.0000e-06 as=1.1200e-13 ps=9.6000e-07 nf=1 m=2 par=2
XMpar7 a_9464_1204.t0 a_5452_996.t8 vss.t1 vss.t0 nfet_03v3 w=0.4u l=9.75u ad=1.1200e-13 pd=9.6000e-07 as=1.1200e-13 ps=9.6000e-07 nf=1 m=2 par=2
XMpar8 a_4842_5413.t0 a_5452_996.t0 a_5452_996.t1 vdd.t0 pfet_03v3 w=2.02u l=2.8u ad=1.2120e-12 pd=5.2400e-06 as=1.2120e-12 ps=5.2400e-06 nf=1 m=2 par=2
XMpar9 a_5332_1204.t0 a_5452_996.t8 vss.t1 vss.t0 nfet_03v3 w=0.4u l=9.75u ad=2.4000e-13 pd=2.0000e-06 as=1.1200e-13 ps=9.6000e-07 nf=1 m=2 par=2
XMpar10 a_9464_1204.t2 a_5452_996.t4 out.t1 vss.t2 nfet_03v3 w=0.4u l=2.8u ad=2.4000e-13 pd=2.0000e-06 as=2.4000e-13 ps=2.0000e-06 nf=1 m=2 par=2
XMpar11 a_4407_10664.t3 a_4407_10664.t2 vdd.t8 vdd.t7 pfet_03v3 w=0.53u l=6.25u ad=3.1800e-13 pd=2.2600e-06 as=1.4840e-13 ps=1.0900e-06 nf=1 m=2 par=2
X12 out.t4 vss.t14 cap_mim_2f0fF c_width=14.79u c_length=14.79u
Rpar0 a_3346_5413.t0 a_3346_5413.t8 60.0944
Rpar1 a_4407_10664.t0 a_4407_10664.t2 75.0270
Rpar2 a_4407_10664.t0 a_4407_10664.t3 118.2100
Rpar3 a_4407_10664.t2 a_4407_10664.t3 15.8252
Rpar4 a_4842_5413.t0 a_4842_5413.t2 65.9399
Rpar5 a_5332_1204.t0 a_5332_1204.t1 98.7702
Rpar6 a_5452_996.t0 a_5452_996.t1 20.0357
Rpar7 a_5452_996.t0 a_5452_996.t8 201.5078
Rpar8 a_5452_996.t0 a_5452_996.t4 953.8374
Rpar9 a_5452_996.t0 a_5452_996.t5 1191.0986
Rpar10 a_5452_996.t1 a_5452_996.t8 83.3645
Rpar11 a_5452_996.t1 a_5452_996.t4 394.6060
Rpar12 a_5452_996.t1 a_5452_996.t5 492.7618
Rpar13 a_5452_996.t8 a_5452_996.t4 174.7929
Rpar14 a_5452_996.t8 a_5452_996.t5 218.2715
Rpar15 a_5452_996.t4 a_5452_996.t5 15.9546
Rpar16 a_8924_3044.t0 a_8924_3044.t2 67.1186
Rpar17 a_9464_1204.t0 a_9464_1204.t2 106.3971
Rpar18 ib ib.t0 14.6634
Rpar19 ib ib.t1 17.7611
Rpar20 ib.t0 ib.t1 25.6121
Rpar21 inn inn.t0 2.6765
Rpar22 inp inp.t0 2.6765
Rpar23 out out.t0 256.1087
Rpar24 out out.t1 87.9496
Rpar25 out out.t4 15.3303
Rpar26 out.t0 out.t1 146.8615
Rpar27 out.t0 out.t4 2479.6905
Rpar28 out.t1 out.t4 851.5437
Rpar29 vdd vdd.t0 555.5359
Rpar30 vdd vdd.t8 872.5735
Rpar31 vdd vdd.t7 83.8473
Rpar32 vdd vdd.t3 115.7113
Rpar33 vdd.t0 vdd.t8 5807.1286
Rpar34 vdd.t0 vdd.t7 558.0185
Rpar35 vdd.t0 vdd.t3 73.8049
Rpar36 vdd.t8 vdd.t7 12.6518
Rpar37 vdd.t8 vdd.t3 1209.5537
Rpar38 vdd.t7 vdd.t3 116.2284
Rpar39 vss vss.t0 107.5885
Rpar40 vss vss.t1 211.1248
Rpar41 vss vss.t2 863.5564
Rpar42 vss vss.t14 4203.5650
Rpar43 vss vss.t3 2859.2215
Rpar44 vss vss.t4 1458.2886
Rpar45 vss.t0 vss.t1 16.9016
Rpar46 vss.t0 vss.t2 348.9761
Rpar47 vss.t0 vss.t14 1707.2987
Rpar48 vss.t0 vss.t3 1108.2171
Rpar49 vss.t0 vss.t4 589.1076
Rpar50 vss.t1 vss.t2 684.8102
Rpar51 vss.t1 vss.t14 3350.2980
Rpar52 vss.t1 vss.t3 2174.7266
Rpar53 vss.t1 vss.t4 1156.0304
Rpar54 vss.t2 vss.t14 91.0366
Rpar55 vss.t2 vss.t3 220.2885
Rpar56 vss.t2 vss.t4 115.9136
Rpar57 vss.t14 vss.t3 1105.4159
Rpar58 vss.t14 vss.t4 566.5000
Rpar59 vss.t3 vss.t4 24.0142
Cpar0 a_3346_5413.t0 vss 4.45285e-14
Cpar1 a_3346_5413.t8 vss 1.07564e-14
Cpar2 a_4407_10664.t0 vss 6.90301e-15
Cpar3 a_4407_10664.t2 vss 4.09140e-14
Cpar4 a_4407_10664.t3 vss 7.13538e-15
Cpar5 a_4842_5413.t0 vss 6.39943e-15
Cpar6 a_4842_5413.t2 vss 2.04957e-14
Cpar7 a_5332_1204.t0 vss 9.76880e-15
Cpar8 a_5332_1204.t1 vss 9.27468e-15
Cpar9 a_5452_996.t0 vss 5.09565e-15
Cpar10 a_5452_996.t1 vss 3.10548e-15
Cpar11 a_5452_996.t4 vss 5.42616e-15
Cpar12 a_5452_996.t5 vss 2.57103e-15
Cpar13 a_5452_996.t8 vss 1.07763e-14
Cpar14 a_8924_3044.t0 vss 6.74162e-15
Cpar15 a_8924_3044.t2 vss 2.09854e-14
Cpar16 a_9464_1204.t0 vss 9.29688e-15
Cpar17 a_9464_1204.t2 vss 1.01779e-14
Cpar18 ib vdd 3.46300e-17
Cpar19 ib vss 2.03250e-14
Cpar20 ib.t0 vss 3.28683e-15
Cpar21 ib.t1 vss 5.09977e-16
Cpar22 inn inp 1.04540e-16
Cpar23 inn out 1.38510e-16
Cpar24 inn vdd 2.25673e-14
Cpar25 inn vss 5.75829e-15
Cpar26 inn.t0 vss 3.17520e-14
Cpar27 inp out 3.09250e-16
Cpar28 inp vdd 2.21260e-14
Cpar29 inp vss 5.84655e-15
Cpar30 inp.t0 vss 3.15893e-14
Cpar31 out vdd 7.52659e-15
Cpar32 out vss 2.26944e-14
Cpar33 out.t0 vss 1.87763e-15
Cpar34 out.t1 vss 1.99447e-15
Cpar35 out.t4 vss 1.45245e-14
Cpar36 vdd vss 3.37879e-13
Cpar37 vdd.t0 vss 1.15793e-14
Cpar38 vdd.t3 vss 7.98068e-14
Cpar39 vdd.t7 vss 2.93741e-14
Cpar40 vdd.t8 vss 4.56572e-15
.ends opamp_dut

Vdd vdd 0 3.300000
Vss vss 0 0
Ibias vdd ib 1.300000e-08
Vinp inp 0 DC 1.480000 AC 1 PWL(0 1.480000 2.222090e-06 1.480000 2.444299e-06 1.490000)
Rfb out inn 1m
Cload out 0 2.000000e-12
Xdut vdd vss inp inn out ib opamp_dut
.end
