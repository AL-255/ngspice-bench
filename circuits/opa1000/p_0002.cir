* opa1000[0002]: 200f/cherry_hooper_1v8_i200n_weak (cherry_hooper, VDD=1.8V, CL=0.2pF, Iref=0.0125uA)
.include "pdk_opa.inc"
.temp 27
.option gmin=1e-12 rshunt=1e12 reltol=1e-3 abstol=1e-12 vntol=1e-5 method=gear
* Post-PEX R+C extracted netlist for cherry_hooper_1v8_i200n_weak
.subckt opamp_dut vdd vss inp inn out ib
XMpar0 ib.t1 ib.t0 vss.t8 vss.t7 nfet_03v3 w=0.4u l=3u ad=2.4000e-13 pd=2.0000e-06 as=1.1200e-13 ps=9.6000e-07 nf=1 m=1
XMpar1 a_9188_11609.t2 a_9188_11609.t1 vdd.t1 vdd.t0 pfet_03v3 w=0.4u l=1.3u ad=1.1200e-13 pd=9.6000e-07 as=1.7600e-13 ps=1.4800e-06 nf=1 m=4 par=4
XMpar2 a_1216_2752.t0 a_1411_8542.t0 a_1411_8542.t1 vdd.t2 pfet_03v3 w=10u l=1u ad=3.2000e-12 pd=1.1890e-05 as=2.8000e-12 ps=1.0560e-05 nf=1 m=16 par=16
XMpar3 a_3261_12259.t0 inp.t0 a_9114_8705.t0 vss.t3 nfet_03v3 w=0.4u l=5.2u ad=2.4000e-13 pd=2.0000e-06 as=1.1200e-13 ps=9.6000e-07 nf=1 m=1
XMpar4 a_9106_1250.t2 ib.t0 vss.t8 vss.t7 nfet_03v3 w=0.4u l=3u ad=1.1200e-13 pd=9.6000e-07 as=1.7600e-13 ps=1.4800e-06 nf=1 m=8 par=8
XMpar5 a_10574_3005.t0 a_1411_8542.t33 a_10574_5384.t0 vdd.t8 pfet_03v3 w=4.57u l=1u ad=2.7420e-12 pd=1.0340e-05 as=1.2796e-12 ps=5.1300e-06 nf=1 m=2 par=2
XMpar6 a_1216_2752.t14 a_1216_2752.t13 vdd.t1 vdd.t0 pfet_03v3 w=0.4u l=1.3u ad=2.4000e-13 pd=2.0000e-06 as=2.4000e-13 ps=2.0000e-06 nf=1 m=1
XMpar7 out.t0 a_9188_11609.t1 vdd.t1 vdd.t0 pfet_03v3 w=0.4u l=1.3u ad=1.1200e-13 pd=9.6000e-07 as=1.1200e-13 ps=9.6000e-07 nf=1 m=4 par=4
XMpar8 a_10574_5384.t2 inn.t0 a_3261_12259.t0 vss.t3 nfet_03v3 w=0.4u l=5.2u ad=1.1200e-13 pd=9.6000e-07 as=2.4000e-13 ps=2.0000e-06 nf=1 m=1
XMpar9 a_9201_6997.t4 a_9201_6997.t3 vdd.t1 vdd.t0 pfet_03v3 w=0.4u l=1.3u ad=1.1200e-13 pd=9.6000e-07 as=2.4000e-13 ps=2.0000e-06 nf=1 m=2 par=2
XMpar10 a_1411_8542.t32 ib.t0 vss.t8 vss.t7 nfet_03v3 w=0.4u l=3u ad=2.4000e-13 pd=2.0000e-06 as=2.4000e-13 ps=2.0000e-06 nf=1 m=1
XMpar11 a_10574_3005.t3 a_10574_3005.t2 vdd.t1 vdd.t0 pfet_03v3 w=0.4u l=1.3u ad=1.1200e-13 pd=9.6000e-07 as=2.4000e-13 ps=2.0000e-06 nf=1 m=2 par=2
XMpar12 a_1837_12259.t1 ib.t0 vss.t8 vss.t7 nfet_03v3 w=0.4u l=3u ad=1.1200e-13 pd=9.6000e-07 as=1.7600e-13 ps=1.4800e-06 nf=1 m=4 par=4
XMpar13 a_9114_8705.t2 a_1411_8542.t33 a_9201_6997.t1 vdd.t8 pfet_03v3 w=4.57u l=1u ad=1.2796e-12 pd=5.1300e-06 as=2.7420e-12 ps=1.0340e-05 nf=1 m=2 par=2
XMpar14 a_9114_8705.t4 a_4485_5385.t1 vdd.t24 vdd.t23 pfet_03v3 w=0.4u l=3u ad=2.4000e-13 pd=2.0000e-06 as=2.4000e-13 ps=2.0000e-06 nf=1 m=1
XMpar15 a_4485_5385.t0 ib.t0 vss.t8 vss.t7 nfet_03v3 w=0.4u l=3u ad=2.4000e-13 pd=2.0000e-06 as=1.1200e-13 ps=9.6000e-07 nf=1 m=1
XMpar16 a_10574_3005.t1 a_10574_5384.t5 a_1837_12259.t0 vss.t3 nfet_03v3 w=0.73u l=5.2u ad=4.3800e-13 pd=2.6600e-06 as=4.3800e-13 ps=2.6600e-06 nf=1 m=1
XMpar17 a_3261_12259.t2 ib.t0 vss.t8 vss.t7 nfet_03v3 w=0.4u l=3u ad=1.1200e-13 pd=9.6000e-07 as=1.1200e-13 ps=9.6000e-07 nf=1 m=2 par=2
XMpar18 a_10574_5384.t2 inn.t0 a_3261_12259.t0 vss.t4 nfet_03v3 w=0.4u l=5.2u ad=1.1200e-13 pd=9.6000e-07 as=2.4000e-13 ps=2.0000e-06 nf=1 m=1
XMpar19 a_9106_1250.t0 a_9201_6997.t7 a_9188_11609.t0 vss.t0 nfet_03v3 w=1.45u l=5.2u ad=8.7000e-13 pd=4.1000e-06 as=8.7000e-13 ps=4.1000e-06 nf=1 m=1
XMpar20 a_3261_12259.t0 inp.t0 a_9114_8705.t0 vss.t4 nfet_03v3 w=0.4u l=5.2u ad=2.4000e-13 pd=2.0000e-06 as=1.1200e-13 ps=9.6000e-07 nf=1 m=1
XMpar21 a_4485_5385.t2 a_4485_5385.t1 vdd.t24 vdd.t23 pfet_03v3 w=0.4u l=3u ad=2.4000e-13 pd=2.0000e-06 as=2.4000e-13 ps=2.0000e-06 nf=1 m=1
XMpar22 a_10574_5384.t1 a_4485_5385.t1 vdd.t24 vdd.t23 pfet_03v3 w=0.4u l=3u ad=2.4000e-13 pd=2.0000e-06 as=2.4000e-13 ps=2.0000e-06 nf=1 m=1
XMpar23 a_9106_1250.t0 a_10574_3005.t7 out.t1 vss.t0 nfet_03v3 w=1.45u l=5.2u ad=8.7000e-13 pd=4.1000e-06 as=8.7000e-13 ps=4.1000e-06 nf=1 m=1
XMpar24 a_1837_12259.t0 a_9114_8705.t5 a_9201_6997.t0 vss.t3 nfet_03v3 w=0.73u l=5.2u ad=4.3800e-13 pd=2.6600e-06 as=4.3800e-13 ps=2.6600e-06 nf=1 m=1
X16 out.t5 vss.t1 cap_mim_2f0fF c_width=20u c_length=20u
X22 out.t5 vss.t1 cap_mim_2f0fF c_width=20u c_length=20u
Rpar0 a_10574_3005.t0 a_10574_3005.t1 210.8057
Rpar1 a_10574_3005.t0 a_10574_3005.t2 145.9035
Rpar2 a_10574_3005.t0 a_10574_3005.t3 111.2359
Rpar3 a_10574_3005.t0 a_10574_3005.t7 93.1209
Rpar4 a_10574_3005.t1 a_10574_3005.t2 284.9942
Rpar5 a_10574_3005.t1 a_10574_3005.t3 217.2777
Rpar6 a_10574_3005.t1 a_10574_3005.t7 483.4687
Rpar7 a_10574_3005.t2 a_10574_3005.t3 39.4377
Rpar8 a_10574_3005.t2 a_10574_3005.t7 334.6199
Rpar9 a_10574_3005.t3 a_10574_3005.t7 255.1120
Rpar10 a_10574_5384.t0 a_10574_5384.t1 70.1933
Rpar11 a_10574_5384.t0 a_10574_5384.t2 185.2815
Rpar12 a_10574_5384.t0 a_10574_5384.t5 206.8542
Rpar13 a_10574_5384.t1 a_10574_5384.t2 179.8091
Rpar14 a_10574_5384.t1 a_10574_5384.t5 200.7447
Rpar15 a_10574_5384.t2 a_10574_5384.t5 68.5595
Rpar16 a_1216_2752.t0 a_1216_2752.t13 130.4486
Rpar17 a_1216_2752.t0 a_1216_2752.t14 72.5200
Rpar18 a_1216_2752.t13 a_1216_2752.t14 55.5620
Rpar19 a_1411_8542.t0 a_1411_8542.t1 16.7526
Rpar20 a_1411_8542.t0 a_1411_8542.t32 6505.9185
Rpar21 a_1411_8542.t0 a_1411_8542.t33 9666.8099
Rpar22 a_1411_8542.t1 a_1411_8542.t32 124.6825
Rpar23 a_1411_8542.t1 a_1411_8542.t33 185.2593
Rpar24 a_1411_8542.t32 a_1411_8542.t33 134.5559
Rpar25 a_1837_12259.t0 a_1837_12259.t1 66.4704
Rpar26 a_3261_12259.t0 a_3261_12259.t2 82.1854
Rpar27 a_4485_5385.t0 a_4485_5385.t1 74.9190
Rpar28 a_4485_5385.t0 a_4485_5385.t2 555.9636
Rpar29 a_4485_5385.t1 a_4485_5385.t2 30.0733
Rpar30 a_9106_1250.t0 a_9106_1250.t2 63.6706
Rpar31 a_9114_8705.t0 a_9114_8705.t2 232.5190
Rpar32 a_9114_8705.t0 a_9114_8705.t4 330.0955
Rpar33 a_9114_8705.t0 a_9114_8705.t5 63.3084
Rpar34 a_9114_8705.t2 a_9114_8705.t4 81.9768
Rpar35 a_9114_8705.t2 a_9114_8705.t5 165.9814
Rpar36 a_9114_8705.t4 a_9114_8705.t5 235.6354
Rpar37 a_9188_11609.t0 a_9188_11609.t1 392.9967
Rpar38 a_9188_11609.t0 a_9188_11609.t2 179.2818
Rpar39 a_9188_11609.t1 a_9188_11609.t2 19.0736
Rpar40 a_9201_6997.t0 a_9201_6997.t1 322.7506
Rpar41 a_9201_6997.t0 a_9201_6997.t3 284.2773
Rpar42 a_9201_6997.t0 a_9201_6997.t4 216.7312
Rpar43 a_9201_6997.t0 a_9201_6997.t7 563.6601
Rpar44 a_9201_6997.t1 a_9201_6997.t3 192.8480
Rpar45 a_9201_6997.t1 a_9201_6997.t4 147.0261
Rpar46 a_9201_6997.t1 a_9201_6997.t7 67.9436
Rpar47 a_9201_6997.t3 a_9201_6997.t4 38.0098
Rpar48 a_9201_6997.t3 a_9201_6997.t7 336.7948
Rpar49 a_9201_6997.t4 a_9201_6997.t7 256.7702
Rpar50 ib ib.t0 1.7655
Rpar51 ib ib.t1 479.9491
Rpar52 ib.t0 ib.t1 26.5989
Rpar53 inn inn.t0 3.2828
Rpar54 inp inp.t0 3.3313
Rpar55 out out.t0 89.5558
Rpar56 out out.t1 324.0660
Rpar57 out out.t5 18.3482
Rpar58 out.t0 out.t1 104.9553
Rpar59 out.t0 out.t5 340.3666
Rpar60 out.t1 out.t5 1231.6491
Rpar61 vdd vdd.t0 116.4994
Rpar62 vdd vdd.t1 184.5470
Rpar63 vdd vdd.t2 2583.7247
Rpar64 vdd vdd.t23 602.6786
Rpar65 vdd vdd.t24 361.4370
Rpar66 vdd vdd.t8 2385.1733
Rpar67 vdd.t0 vdd.t1 3.5444
Rpar68 vdd.t0 vdd.t2 110.1664
Rpar69 vdd.t0 vdd.t23 173.5904
Rpar70 vdd.t0 vdd.t24 80.1711
Rpar71 vdd.t0 vdd.t8 76.3007
Rpar72 vdd.t1 vdd.t2 137.1572
Rpar73 vdd.t1 vdd.t23 225.8105
Rpar74 vdd.t1 vdd.t24 101.9702
Rpar75 vdd.t1 vdd.t8 78.3319
Rpar76 vdd.t2 vdd.t23 620.9955
Rpar77 vdd.t2 vdd.t24 248.1496
Rpar78 vdd.t2 vdd.t8 186.1484
Rpar79 vdd.t23 vdd.t24 18.6846
Rpar80 vdd.t23 vdd.t8 573.2739
Rpar81 vdd.t24 vdd.t8 229.0801
Rpar82 vss vss.t0 106.5482
Rpar83 vss vss.t1 861.4012
Rpar84 vss vss.t8 141.6579
Rpar85 vss vss.t7 185.7894
Rpar86 vss vss.t3 199.0999
Rpar87 vss vss.t4 237.8326
Rpar88 vss.t0 vss.t1 2068.7085
Rpar89 vss.t0 vss.t8 194.7139
Rpar90 vss.t0 vss.t7 176.2361
Rpar91 vss.t0 vss.t3 370.6209
Rpar92 vss.t0 vss.t4 229.0897
Rpar93 vss.t1 vss.t8 246.5359
Rpar94 vss.t1 vss.t7 137.7939
Rpar95 vss.t1 vss.t3 235.4308
Rpar96 vss.t1 vss.t4 389.1953
Rpar97 vss.t8 vss.t7 3.9216
Rpar98 vss.t8 vss.t3 148.5607
Rpar99 vss.t8 vss.t4 209.7855
Rpar100 vss.t7 vss.t3 188.8440
Rpar101 vss.t7 vss.t4 249.3400
Rpar102 vss.t3 vss.t4 20.8906
Cpar0 a_10574_3005.t0 vss 4.75416e-15
Cpar1 a_10574_3005.t1 vss 2.50852e-15
Cpar2 a_10574_3005.t2 vss 2.26255e-15
Cpar3 a_10574_3005.t3 vss 1.88450e-15
Cpar4 a_10574_3005.t7 vss 3.89537e-15
Cpar5 a_10574_5384.t0 vss 2.25500e-15
Cpar6 a_10574_5384.t1 vss 1.23948e-15
Cpar7 a_10574_5384.t2 vss 1.83270e-15
Cpar8 a_10574_5384.t5 vss 2.92352e-15
Cpar9 a_1216_2752.t0 vss 2.79643e-14
Cpar10 a_1216_2752.t13 vss 1.20636e-15
Cpar11 a_1216_2752.t14 vss 1.50890e-15
Cpar12 a_1411_8542.t0 vss 2.13474e-14
Cpar13 a_1411_8542.t1 vss 2.11322e-14
Cpar14 a_1411_8542.t32 vss 3.11331e-15
Cpar15 a_1411_8542.t33 vss 5.58292e-15
Cpar16 a_1837_12259.t0 vss 2.83066e-15
Cpar17 a_1837_12259.t1 vss 3.25099e-15
Cpar18 a_3261_12259.t0 vss 5.35921e-15
Cpar19 a_3261_12259.t2 vss 3.72075e-15
Cpar20 a_4485_5385.t0 vss 4.05411e-15
Cpar21 a_4485_5385.t1 vss 1.28739e-14
Cpar22 a_4485_5385.t2 vss 2.84410e-15
Cpar23 a_9106_1250.t0 vss 1.57294e-15
Cpar24 a_9106_1250.t2 vss 2.90808e-15
Cpar25 a_9114_8705.t0 vss 2.52033e-15
Cpar26 a_9114_8705.t2 vss 3.46814e-15
Cpar27 a_9114_8705.t4 vss 1.90271e-15
Cpar28 a_9114_8705.t5 vss 4.34782e-15
Cpar29 a_9188_11609.t0 vss 5.73505e-15
Cpar30 a_9188_11609.t1 vss 7.70448e-15
Cpar31 a_9188_11609.t2 vss 6.50534e-15
Cpar32 a_9201_6997.t0 vss 2.31152e-15
Cpar33 a_9201_6997.t1 vss 4.88393e-15
Cpar34 a_9201_6997.t3 vss 2.46069e-15
Cpar35 a_9201_6997.t4 vss 2.08530e-15
Cpar36 a_9201_6997.t7 vss 4.04873e-15
Cpar37 ib out 6.61700e-17
Cpar38 ib vdd 3.31609e-15
Cpar39 ib vss 4.18605e-14
Cpar40 ib.t0 vss 1.11866e-14
Cpar41 ib.t1 vss 1.16405e-15
Cpar42 inn inp 5.19700e-17
Cpar43 inn vdd 3.00400e-17
Cpar44 inn vss 5.73586e-15
Cpar45 inn.t0 vss 4.29989e-16
Cpar46 inp vdd 8.18000e-17
Cpar47 inp vss 5.63976e-15
Cpar48 inp.t0 vss 4.71948e-16
Cpar49 out vdd 6.08933e-15
Cpar50 out vss 2.65603e-14
Cpar51 out.t0 vss 2.94973e-16
Cpar52 out.t1 vss 2.10146e-16
Cpar53 out.t5 vss 1.36416e-14
Cpar54 vdd vss 1.62056e-13
Cpar55 vdd.t0 vss 1.41780e-14
Cpar56 vdd.t1 vss 8.56044e-15
Cpar57 vdd.t2 vss 2.64367e-14
Cpar58 vdd.t23 vss 4.20895e-15
Cpar59 vdd.t24 vss 5.58588e-15
Cpar60 vdd.t8 vss 8.41580e-15
.ends opamp_dut

Vdd vdd 0 1.800000
Vss vss 0 0
Ibias vdd ib 1.250000e-08
Vinp inp 0 DC 1.174100 AC 1 PWL(0 1.174100 4.064705e-07 1.174100 4.471175e-07 1.184100)
Rfb out inn 1m
Cload out 0 2.000000e-13
Xdut vdd vss inp inn out ib opamp_dut
.end
