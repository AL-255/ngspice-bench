* opa1000[0616]: 200f/pmos_miller_3v3_1u_10u_weak (pmos_miller, VDD=3.3V, CL=0.2pF, Iref=0.8125uA)
.include "pdk_opa.inc"
.temp 27
.option gmin=1e-12 rshunt=1e12 reltol=1e-3 abstol=1e-12 vntol=1e-5 method=gear
* Post-PEX R+C extracted netlist for pmos_miller_3v3_1u_10u_weak
.subckt opamp_dut vdd vss inp inn out ib
XMpar0 a_2855_4919.t16 a_1943_4711.t0 vdd.t1 vdd.t0 pfet_03v3 w=3.16u l=2u ad=1.8960e-12 pd=7.5200e-06 as=8.8480e-13 ps=3.7200e-06 nf=1 m=4 par=4
XMpar1 a_1943_4711.t4 ib.t0 vss.t26 vss.t25 nfet_03v3 w=0.75u l=2u ad=2.1000e-13 pd=1.3100e-06 as=2.1000e-13 ps=1.3100e-06 nf=1 m=2 par=2
XMpar2 a_1218_1131.t9 a_5632_2863.t8 vss.t1 vss.t0 nfet_03v3 w=0.89u l=1.25u ad=5.3400e-13 pd=2.9800e-06 as=2.4920e-13 ps=1.4500e-06 nf=1 m=2 par=2
XMpar3 a_1218_1131.t1 inp.t0 a_2855_4919.t0 vdd.t2 pfet_03v3 w=1.91u l=1.3u ad=5.3480e-13 pd=2.4700e-06 as=6.8760e-13 ps=3.1075e-06 nf=1 m=8 par=8
XMpar4 out.t0 a_1943_4711.t0 vdd.t1 vdd.t0 pfet_03v3 w=3.16u l=2u ad=1.4915e-12 pd=6.0000e-06 as=1.2893e-12 ps=5.2400e-06 nf=1 m=10 par=10
XMpar5 a_5632_2863.t9 a_5632_2863.t8 vss.t1 vss.t0 nfet_03v3 w=0.89u l=1.25u ad=2.4920e-13 pd=1.4500e-06 as=2.4920e-13 ps=1.4500e-06 nf=1 m=2 par=2
XMpar6 a_2855_4919.t0 inn.t0 a_5632_2863.t0 vdd.t2 pfet_03v3 w=1.91u l=1.3u ad=6.8760e-13 pd=3.1075e-06 as=5.3480e-13 ps=2.4700e-06 nf=1 m=8 par=8
XMpar7 a_1943_4711.t1 a_1943_4711.t0 vdd.t1 vdd.t0 pfet_03v3 w=3.16u l=2u ad=1.8960e-12 pd=7.5200e-06 as=8.8480e-13 ps=3.7200e-06 nf=1 m=2 par=2
XMpar8 out.t2 a_1218_1131.t11 vss.t1 vss.t0 nfet_03v3 w=0.89u l=1.25u ad=2.4920e-13 pd=1.4500e-06 as=3.0616e-13 ps=1.7560e-06 nf=1 m=10 par=10
XMpar9 ib.t1 ib.t0 vss.t26 vss.t25 nfet_03v3 w=0.75u l=2u ad=4.5000e-13 pd=2.7000e-06 as=2.1000e-13 ps=1.3100e-06 nf=1 m=2 par=2
X31 a_1218_1131.t0 a_10307_1290.t0 vss.t16 ppolyf_u_1k r_width=1u r_length=19.85u
X44 a_10307_1290.t1 out.t19 cap_mim_2f0fF c_width=11.46u c_length=11.46u
Rpar0 a_10307_1290.t0 a_10307_1290.t1 59.1475
Rpar1 a_1218_1131.t0 a_1218_1131.t1 276.8842
Rpar2 a_1218_1131.t0 a_1218_1131.t9 89.6037
Rpar3 a_1218_1131.t0 a_1218_1131.t11 83.7458
Rpar4 a_1218_1131.t1 a_1218_1131.t9 219.4945
Rpar5 a_1218_1131.t1 a_1218_1131.t11 123.2780
Rpar6 a_1218_1131.t9 a_1218_1131.t11 66.3878
Rpar7 a_1943_4711.t0 a_1943_4711.t1 11.8254
Rpar8 a_1943_4711.t0 a_1943_4711.t4 184.8406
Rpar9 a_1943_4711.t1 a_1943_4711.t4 83.9376
Rpar10 a_2855_4919.t0 a_2855_4919.t16 37.6290
Rpar11 a_5632_2863.t0 a_5632_2863.t8 138.0028
Rpar12 a_5632_2863.t0 a_5632_2863.t9 121.0745
Rpar13 a_5632_2863.t8 a_5632_2863.t9 29.4035
Rpar14 ib ib.t0 15.8598
Rpar15 ib ib.t1 7.6113
Rpar16 ib.t0 ib.t1 116.3966
Rpar17 inn inn.t0 2.0244
Rpar18 inp inp.t0 2.0730
Rpar19 out out.t0 2.6968
Rpar20 out out.t2 78.5618
Rpar21 out out.t19 89.2140
Rpar22 out.t2 out.t19 100.1554
Rpar23 vdd vdd.t0 49.0370
Rpar24 vdd vdd.t1 513.7104
Rpar25 vdd vdd.t2 24.7435
Rpar26 vdd.t0 vdd.t1 12.1819
Rpar27 vdd.t0 vdd.t2 154.2538
Rpar28 vdd.t1 vdd.t2 1615.9581
Rpar29 vss vss.t0 63.1384
Rpar30 vss vss.t1 139.2274
Rpar31 vss vss.t16 107.4157
Rpar32 vss vss.t25 112.3919
Rpar33 vss vss.t26 384.2901
Rpar34 vss.t0 vss.t1 4.7179
Rpar35 vss.t0 vss.t16 16.5972
Rpar36 vss.t0 vss.t25 17.6858
Rpar37 vss.t0 vss.t26 61.1637
Rpar38 vss.t1 vss.t16 40.1390
Rpar39 vss.t1 vss.t25 42.7481
Rpar40 vss.t1 vss.t26 147.7360
Rpar41 vss.t16 vss.t25 14.1968
Rpar42 vss.t16 vss.t26 49.7713
Rpar43 vss.t25 vss.t26 17.6592
Cpar0 a_10307_1290.t0 vss 1.71890e-16
Cpar1 a_10307_1290.t1 vss 2.25962e-15
Cpar2 a_1218_1131.t0 vss 1.84540e-15
Cpar3 a_1218_1131.t1 vss 3.28409e-15
Cpar4 a_1218_1131.t11 vss 5.14329e-15
Cpar5 a_1218_1131.t9 vss 1.83641e-15
Cpar6 a_1943_4711.t0 vss 3.16363e-14
Cpar7 a_1943_4711.t1 vss 7.93775e-15
Cpar8 a_1943_4711.t4 vss 2.23603e-15
Cpar9 a_2855_4919.t0 vss 1.40807e-14
Cpar10 a_2855_4919.t16 vss 1.55051e-14
Cpar11 a_5632_2863.t0 vss 5.18914e-15
Cpar12 a_5632_2863.t8 vss 3.17840e-15
Cpar13 a_5632_2863.t9 vss 1.45007e-15
Cpar14 ib out 3.00200e-17
Cpar15 ib vss 7.96272e-15
Cpar16 ib.t0 vss 9.82923e-16
Cpar17 ib.t1 vss 9.05802e-17
Cpar18 inn inp 5.17000e-17
Cpar19 inn vdd 6.30045e-15
Cpar20 inn vss 3.64221e-15
Cpar21 inn.t0 vss 5.20679e-15
Cpar22 inp vdd 6.41888e-15
Cpar23 inp vss 3.56645e-15
Cpar24 inp.t0 vss 5.35176e-15
Cpar25 out vdd 1.06128e-14
Cpar26 out vss 1.66269e-14
Cpar27 out.t0 vss 8.77996e-15
Cpar28 out.t19 vss 8.23721e-15
Cpar29 out.t2 vss 3.48535e-15
Cpar30 vdd vss 1.21793e-13
Cpar31 vdd.t0 vss 3.60154e-14
Cpar32 vdd.t1 vss 7.46251e-15
Cpar33 vdd.t2 vss 1.70974e-14
.ends opamp_dut

Vdd vdd 0 3.300000
Vss vss 0 0
Ibias vdd ib 8.125000e-07
Vinp inp 0 DC 1.480000 AC 1 PWL(0 1.480000 1.175953e-08 1.480000 1.293549e-08 1.490000)
Rfb out inn 1m
Cload out 0 2.000000e-13
Xdut vdd vss inp inn out ib opamp_dut
.end
