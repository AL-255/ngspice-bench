* opa1000[0117]: 200f/current_reuse_3v3_i10u_weak (current_reuse, VDD=3.3V, CL=0.2pF, Iref=1.8571uA)
.include "pdk_opa.inc"
.temp 27
.option gmin=1e-12 rshunt=1e12 reltol=1e-3 abstol=1e-12 vntol=1e-5 method=gear
* Post-PEX R+C extracted netlist for current_reuse_3v3_i10u_weak
.subckt opamp_dut vdd vss inp inn out ib
XMpar0 out.t11 ib.t0 vss.t10 vss.t0 nfet_03v3 w=0.68u l=0.9u ad=2.3392e-13 pd=1.5040e-06 as=1.9040e-13 ps=1.2400e-06 nf=1 m=10 par=10
XMpar1 a_4186_9914.t0 inn.t4 a_6574_12616.t2 vdd.t8 pfet_03v3 w=1.96u l=1.3u ad=7.5787e-13 pd=3.3867e-06 as=5.4880e-13 ps=2.5200e-06 nf=1 m=12 par=12
XMpar2 ib.t1 ib.t0 vss.t10 vss.t0 nfet_03v3 w=0.68u l=0.9u ad=1.9040e-13 pd=1.2400e-06 as=1.9040e-13 ps=1.2400e-06 nf=1 m=2 par=2
XMpar3 a_1059_5940.t1 inp.t4 a_4186_9914.t0 vdd.t8 pfet_03v3 w=1.96u l=1.3u ad=5.4880e-13 pd=2.5200e-06 as=7.5787e-13 ps=3.3867e-06 nf=1 m=12 par=12
XMpar4 out.t0 a_1059_5940.t18 vdd.t1 vdd.t0 pfet_03v3 w=3.2u l=0.75u ad=8.9600e-13 pd=3.7600e-06 as=1.1008e-12 ps=4.5280e-06 nf=1 m=10 par=10
XMpar5 a_4930_5944.t8 ib.t0 vss.t10 vss.t0 nfet_03v3 w=0.68u l=0.9u ad=1.9040e-13 pd=1.2400e-06 as=1.9040e-13 ps=1.2400e-06 nf=1 m=4 par=4
XMpar6 a_4930_5944.t0 inn.t0 a_6574_12616.t14 vss.t0 nfet_03v3 w=2.22u l=1.3u ad=9.7680e-13 pd=4.2100e-06 as=6.2160e-13 ps=2.7800e-06 nf=1 m=4 par=4
XMpar7 a_4186_9914.t12 a_6574_12616.t0 vdd.t1 vdd.t0 pfet_03v3 w=3.2u l=0.75u ad=8.9600e-13 pd=3.7600e-06 as=1.9200e-12 ps=7.6000e-06 nf=1 m=2 par=2
XMpar8 a_1059_5940.t13 inp.t0 a_4930_5944.t0 vss.t0 nfet_03v3 w=2.22u l=1.3u ad=6.2160e-13 pd=2.7800e-06 as=9.7680e-13 ps=4.2100e-06 nf=1 m=4 par=4
XMpar9 a_1059_5940.t0 a_6574_12616.t0 vdd.t1 vdd.t0 pfet_03v3 w=3.2u l=0.75u ad=1.9200e-12 pd=7.6000e-06 as=8.9600e-13 ps=3.7600e-06 nf=1 m=1
XMpar10 a_6574_12616.t1 a_6574_12616.t0 vdd.t1 vdd.t0 pfet_03v3 w=3.2u l=0.75u ad=1.9200e-12 pd=7.6000e-06 as=8.9600e-13 ps=3.7600e-06 nf=1 m=1
X23 a_2853_5940.t1 out.t10 cap_mim_2f0fF c_width=15u c_length=15u
X36 a_1059_5940.t17 a_2853_5940.t0 vss.t8 ppolyf_u_1k r_width=1u r_length=8.31u
Rpar0 a_1059_5940.t0 a_1059_5940.t1 91.1919
Rpar1 a_1059_5940.t0 a_1059_5940.t13 423.2550
Rpar2 a_1059_5940.t0 a_1059_5940.t17 606.5118
Rpar3 a_1059_5940.t0 a_1059_5940.t18 240.7318
Rpar4 a_1059_5940.t1 a_1059_5940.t13 236.2044
Rpar5 a_1059_5940.t1 a_1059_5940.t17 338.4739
Rpar6 a_1059_5940.t1 a_1059_5940.t18 134.3443
Rpar7 a_1059_5940.t13 a_1059_5940.t17 137.3595
Rpar8 a_1059_5940.t13 a_1059_5940.t18 54.5196
Rpar9 a_1059_5940.t17 a_1059_5940.t18 78.1250
Rpar10 a_2853_5940.t0 a_2853_5940.t1 57.6878
Rpar11 a_4186_9914.t0 a_4186_9914.t12 51.8924
Rpar12 a_4930_5944.t0 a_4930_5944.t8 86.4166
Rpar13 a_6574_12616.t0 a_6574_12616.t1 38.1502
Rpar14 a_6574_12616.t0 a_6574_12616.t2 89.3797
Rpar15 a_6574_12616.t0 a_6574_12616.t14 93.2145
Rpar16 a_6574_12616.t1 a_6574_12616.t2 63.5594
Rpar17 a_6574_12616.t1 a_6574_12616.t14 321.8547
Rpar18 a_6574_12616.t2 a_6574_12616.t14 117.4912
Rpar19 ib ib.t0 17.8711
Rpar20 ib ib.t1 17.0061
Rpar21 ib.t0 ib.t1 105.5585
Rpar22 inn inn.t0 3.8523
Rpar23 inn inn.t4 44.9990
Rpar24 inp inp.t0 4.2443
Rpar25 inp inp.t4 44.9504
Rpar26 out out.t0 1.7882
Rpar27 out out.t10 336.2849
Rpar28 out out.t11 336.5056
Rpar29 out.t0 out.t10 412.7113
Rpar30 out.t0 out.t11 412.9821
Rpar31 out.t10 out.t11 96.0154
Rpar32 vdd vdd.t0 59.0670
Rpar33 vdd vdd.t1 53.5160
Rpar34 vdd vdd.t8 93.6288
Rpar35 vdd.t0 vdd.t1 3.5729
Rpar36 vdd.t0 vdd.t8 59.2548
Rpar37 vdd.t1 vdd.t8 49.9820
Rpar38 vss vss.t0 45.4240
Rpar39 vss vss.t10 438.0005
Rpar40 vss vss.t8 132.9206
Rpar41 vss.t0 vss.t10 4.3487
Rpar42 vss.t0 vss.t8 64.7695
Rpar43 vss.t10 vss.t8 717.2154
Cpar0 a_1059_5940.t0 vss 3.43480e-15
Cpar1 a_1059_5940.t1 vss 9.50877e-15
Cpar2 a_1059_5940.t13 vss 3.66318e-15
Cpar3 a_1059_5940.t17 vss 2.25034e-15
Cpar4 a_1059_5940.t18 vss 9.41198e-15
Cpar5 a_2853_5940.t0 vss 5.41100e-17
Cpar6 a_2853_5940.t1 vss 1.95416e-15
Cpar7 a_4186_9914.t0 vss 1.85613e-14
Cpar8 a_4186_9914.t12 vss 3.63168e-15
Cpar9 a_4930_5944.t0 vss 8.07755e-15
Cpar10 a_4930_5944.t8 vss 5.93053e-15
Cpar11 a_6574_12616.t0 vss 6.04487e-15
Cpar12 a_6574_12616.t1 vss 4.50968e-15
Cpar13 a_6574_12616.t14 vss 5.32269e-15
Cpar14 a_6574_12616.t2 vss 1.20760e-14
Cpar15 ib out 8.68750e-16
Cpar16 ib vss 1.57722e-14
Cpar17 ib.t0 vss 2.51778e-15
Cpar18 ib.t1 vss 1.24217e-16
Cpar19 inn inp 1.54500e-16
Cpar20 inn vdd 1.03581e-14
Cpar21 inn vss 7.98217e-15
Cpar22 inn.t0 vss 2.02754e-15
Cpar23 inn.t4 vss 1.31780e-14
Cpar24 inp out 8.87360e-16
Cpar25 inp vdd 9.04041e-15
Cpar26 inp vss 7.68650e-15
Cpar27 inp.t0 vss 2.19356e-15
Cpar28 inp.t4 vss 1.32535e-14
Cpar29 out vdd 7.67108e-15
Cpar30 out vss 1.97343e-14
Cpar31 out.t0 vss 3.13181e-15
Cpar32 out.t10 vss 7.85337e-15
Cpar33 out.t11 vss 3.81610e-15
Cpar34 vdd vss 1.08737e-13
Cpar35 vdd.t0 vss 1.16889e-14
Cpar36 vdd.t1 vss 1.08010e-14
Cpar37 vdd.t8 vss 2.79102e-14
.ends opamp_dut

Vdd vdd 0 3.300000
Vss vss 0 0
Ibias vdd ib 1.857100e-06
Vinp inp 0 DC 1.645000 AC 1 PWL(0 1.645000 5.770455e-09 1.645000 6.347500e-09 1.655000)
Rfb out inn 1m
Cload out 0 2.000000e-13
Xdut vdd vss inp inn out ib opamp_dut
.end
