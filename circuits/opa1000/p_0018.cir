* opa1000[0018]: 200f/cherry_hooper_1v8_i500u_subth (cherry_hooper, VDD=1.8V, CL=0.2pF, Iref=31.25uA)
.include "pdk_opa.inc"
.temp 27
.option gmin=1e-12 rshunt=1e12 reltol=1e-3 abstol=1e-12 vntol=1e-5 method=gear
* Post-PEX R+C extracted netlist for cherry_hooper_1v8_i500u_subth
.subckt opamp_dut vdd vss inp inn out ib
XMpar0 a_11844_28836.t5 inp.t0 a_1850_1294.t0 vss.t4 nfet_03v3 w=2.35u l=0.45u ad=6.5800e-13 pd=2.9100e-06 as=7.0500e-13 ps=3.0969e-06 nf=1 m=160 par=160
XMpar1 a_18414_18306.t5 inn.t0 a_1850_1294.t0 vss.t4 nfet_03v3 w=2.35u l=0.45u ad=6.5800e-13 pd=2.9100e-06 as=7.0500e-13 ps=3.0969e-06 nf=1 m=160 par=160
XMpar2 a_12702_1249.t9 ib.t0 vss.t40 vss.t40 nfet_03v3 w=9.85u l=0.36u ad=2.7580e-12 pd=1.0410e-05 as=3.0207e-12 ps=1.1284e-05 nf=1 m=24 par=24
XMpar3 a_2218_1294.t96 a_11844_28836.t185 a_7336_11424.t129 vss.t0 nfet_03v3 w=10u l=0.4u ad=3.2000e-12 pd=1.1890e-05 as=2.8000e-12 ps=1.0560e-05 nf=1 m=16 par=16
XMpar4 a_18534_11424.t2 a_18534_11424.t1 vdd.t1 vdd.t0 pfet_03v3 w=10u l=0.32u ad=2.8000e-12 pd=1.0560e-05 as=3.0000e-12 ps=1.1225e-05 nf=1 m=64 par=64
XMpar5 a_7336_11424.t1 a_7336_11424.t0 vdd.t1 vdd.t0 pfet_03v3 w=10u l=0.32u ad=2.8000e-12 pd=1.0560e-05 as=3.0000e-12 ps=1.1225e-05 nf=1 m=64 par=64
XMpar6 a_1850_1294.t160 ib.t0 vss.t40 vss.t40 nfet_03v3 w=9.85u l=0.36u ad=2.7580e-12 pd=1.0410e-05 as=3.1520e-12 ps=1.1721e-05 nf=1 m=48 par=48
XMpar7 a_11844_28836.t165 a_10472_21647.t12 vdd.t3 vdd.t2 pfet_03v3 w=9.13u l=0.36u ad=2.5564e-12 pd=9.6900e-06 as=2.8486e-12 ps=1.0667e-05 nf=1 m=20 par=20
XMpar8 a_2218_1294.t0 ib.t0 vss.t40 vss.t40 nfet_03v3 w=9.85u l=0.36u ad=2.7580e-12 pd=1.0410e-05 as=2.7580e-12 ps=1.0410e-05 nf=1 m=96 par=96
XMpar9 a_11844_28836.t0 a_1478_14934.t44 a_7336_11424.t128 vdd.t14 pfet_03v3 w=7.24u l=0.32u ad=2.4906e-12 pd=9.3760e-06 as=2.4906e-12 ps=9.3760e-06 nf=1 m=5 par=5
XMpar10 a_16762_11632.t17 a_16762_11632.t16 vdd.t1 vdd.t0 pfet_03v3 w=10u l=0.32u ad=2.8000e-12 pd=1.0560e-05 as=3.2000e-12 ps=1.1890e-05 nf=1 m=16 par=16
XMpar11 a_1478_14934.t32 ib.t0 vss.t40 vss.t40 nfet_03v3 w=9.85u l=0.36u ad=2.7580e-12 pd=1.0410e-05 as=3.2833e-12 ps=1.2158e-05 nf=1 m=12 par=12
XMpar12 a_12702_1249.t0 a_7336_11424.t149 a_16762_11632.t0 vss.t0 nfet_03v3 w=10u l=0.4u ad=3.6000e-12 pd=1.3220e-05 as=2.8000e-12 ps=1.0560e-05 nf=1 m=16 par=16
XMpar13 a_10472_21647.t0 ib.t0 vss.t40 vss.t40 nfet_03v3 w=9.85u l=0.36u ad=2.7580e-12 pd=1.0410e-05 as=2.7580e-12 ps=1.0410e-05 nf=1 m=12 par=12
XMpar14 out.t0 a_16762_11632.t16 vdd.t1 vdd.t0 pfet_03v3 w=10u l=0.32u ad=2.8000e-12 pd=1.0560e-05 as=3.2000e-12 ps=1.1890e-05 nf=1 m=16 par=16
XMpar15 a_1358_15142.t0 a_1358_15142.t10 vdd.t1 vdd.t0 pfet_03v3 w=10u l=0.32u ad=2.8000e-12 pd=1.0560e-05 as=3.2000e-12 ps=1.1890e-05 nf=1 m=16 par=16
XMpar16 ib.t1 ib.t0 vss.t40 vss.t40 nfet_03v3 w=9.85u l=0.36u ad=2.7580e-12 pd=1.0410e-05 as=3.2833e-12 ps=1.2158e-05 nf=1 m=12 par=12
XMpar17 a_18414_18306.t165 a_10472_21647.t12 vdd.t3 vdd.t2 pfet_03v3 w=9.13u l=0.36u ad=2.5564e-12 pd=9.6900e-06 as=2.8486e-12 ps=1.0667e-05 nf=1 m=20 par=20
XMpar18 a_1358_15142.t0 a_1478_14934.t0 a_1478_14934.t1 vdd.t0 pfet_03v3 w=10u l=0.32u ad=3.2000e-12 pd=1.1890e-05 as=2.8000e-12 ps=1.0560e-05 nf=1 m=16 par=16
XMpar19 a_12702_1249.t0 a_18534_11424.t149 out.t3 vss.t0 nfet_03v3 w=10u l=0.4u ad=3.6000e-12 pd=1.3220e-05 as=2.8000e-12 ps=1.0560e-05 nf=1 m=16 par=16
XMpar20 a_10472_21647.t13 a_10472_21647.t12 vdd.t3 vdd.t2 pfet_03v3 w=9.13u l=0.36u ad=2.5564e-12 pd=9.6900e-06 as=3.1407e-12 ps=1.1644e-05 nf=1 m=10 par=10
XMpar21 a_18534_11424.t133 a_18414_18306.t185 a_2218_1294.t96 vss.t0 nfet_03v3 w=10u l=0.4u ad=2.8000e-12 pd=1.0560e-05 as=3.2000e-12 ps=1.1890e-05 nf=1 m=16 par=16
XMpar22 a_18414_18306.t0 a_1478_14934.t44 a_18534_11424.t0 vdd.t14 pfet_03v3 w=7.24u l=0.32u ad=2.4906e-12 pd=9.3760e-06 as=2.4906e-12 ps=9.3760e-06 nf=1 m=5 par=5
X100 out.t32 vss.t397 cap_mim_2f0fF c_width=20u c_length=20u
X110 out.t32 vss.t397 cap_mim_2f0fF c_width=20u c_length=20u
X222 out.t32 vss.t397 cap_mim_2f0fF c_width=20u c_length=20u
X230 out.t32 vss.t397 cap_mim_2f0fF c_width=20u c_length=20u
X606 out.t32 vss.t397 cap_mim_2f0fF c_width=20u c_length=20u
X611 out.t32 vss.t397 cap_mim_2f0fF c_width=20u c_length=20u
Rpar0 a_10472_21647.t0 a_10472_21647.t12 104.9307
Rpar1 a_10472_21647.t0 a_10472_21647.t13 66.1008
Rpar2 a_10472_21647.t12 a_10472_21647.t13 18.3276
Rpar3 a_11844_28836.t0 a_11844_28836.t5 633.0333
Rpar4 a_11844_28836.t0 a_11844_28836.t165 242.2960
Rpar5 a_11844_28836.t0 a_11844_28836.t185 61.3097
Rpar6 a_11844_28836.t5 a_11844_28836.t165 105.6322
Rpar7 a_11844_28836.t5 a_11844_28836.t185 327.2260
Rpar8 a_11844_28836.t165 a_11844_28836.t185 125.2471
Rpar9 a_12702_1249.t0 a_12702_1249.t9 70.2778
Rpar10 a_1358_15142.t0 a_1358_15142.t10 21.7536
Rpar11 a_1478_14934.t0 a_1478_14934.t1 22.2448
Rpar12 a_1478_14934.t0 a_1478_14934.t32 1455.9372
Rpar13 a_1478_14934.t0 a_1478_14934.t44 4104.8178
Rpar14 a_1478_14934.t1 a_1478_14934.t32 50.6117
Rpar15 a_1478_14934.t1 a_1478_14934.t44 142.6928
Rpar16 a_1478_14934.t32 a_1478_14934.t44 467.9817
Rpar17 a_16762_11632.t0 a_16762_11632.t16 528.1777
Rpar18 a_16762_11632.t0 a_16762_11632.t17 64.9231
Rpar19 a_16762_11632.t16 a_16762_11632.t17 11.8028
Rpar20 a_18414_18306.t0 a_18414_18306.t5 557.6599
Rpar21 a_18414_18306.t0 a_18414_18306.t165 125.0227
Rpar22 a_18414_18306.t0 a_18414_18306.t185 74.1663
Rpar23 a_18414_18306.t5 a_18414_18306.t165 74.9974
Rpar24 a_18414_18306.t5 a_18414_18306.t185 285.7583
Rpar25 a_18414_18306.t165 a_18414_18306.t185 64.0646
Rpar26 a_1850_1294.t0 a_1850_1294.t160 119.8499
Rpar27 a_18534_11424.t0 a_18534_11424.t1 4524.5236
Rpar28 a_18534_11424.t0 a_18534_11424.t2 100.1535
Rpar29 a_18534_11424.t0 a_18534_11424.t133 62.7690
Rpar30 a_18534_11424.t0 a_18534_11424.t149 199.9073
Rpar31 a_18534_11424.t1 a_18534_11424.t2 8.4994
Rpar32 a_18534_11424.t1 a_18534_11424.t133 8041.4052
Rpar33 a_18534_11424.t1 a_18534_11424.t149 4221.4554
Rpar34 a_18534_11424.t2 a_18534_11424.t133 178.0022
Rpar35 a_18534_11424.t2 a_18534_11424.t149 93.4449
Rpar36 a_18534_11424.t133 a_18534_11424.t149 355.2939
Rpar37 a_2218_1294.t0 a_2218_1294.t96 152.6404
Rpar38 a_7336_11424.t0 a_7336_11424.t1 8.4967
Rpar39 a_7336_11424.t0 a_7336_11424.t128 5286.6254
Rpar40 a_7336_11424.t0 a_7336_11424.t149 2988.8715
Rpar41 a_7336_11424.t1 a_7336_11424.t128 117.0232
Rpar42 a_7336_11424.t1 a_7336_11424.t129 1083.7226
Rpar43 a_7336_11424.t1 a_7336_11424.t149 66.1608
Rpar44 a_7336_11424.t128 a_7336_11424.t129 151.0005
Rpar45 a_7336_11424.t128 a_7336_11424.t149 183.6582
Rpar46 a_7336_11424.t129 a_7336_11424.t149 1700.8130
Rpar47 ib ib.t0 2.8557
Rpar48 ib ib.t1 308.1293
Rpar49 ib.t0 ib.t1 14.6248
Rpar50 inn inn.t0 1.6010
Rpar51 inp inp.t0 1.6010
Rpar52 out out.t0 75.5203
Rpar53 out out.t3 1.8535
Rpar54 out out.t32 147.1566
Rpar55 out.t0 out.t32 65.1745
Rpar56 vdd vdd.t0 667.3220
Rpar57 vdd vdd.t1 464.7598
Rpar58 vdd vdd.t2 170.3056
Rpar59 vdd vdd.t3 84.7476
Rpar60 vdd vdd.t14 2086.6388
Rpar61 vdd.t0 vdd.t1 1.9565
Rpar62 vdd.t0 vdd.t2 213.0714
Rpar63 vdd.t0 vdd.t3 210.4134
Rpar64 vdd.t0 vdd.t14 409.7154
Rpar65 vdd.t1 vdd.t2 148.3946
Rpar66 vdd.t1 vdd.t3 146.5435
Rpar67 vdd.t1 vdd.t14 87.3773
Rpar68 vdd.t2 vdd.t3 2.3861
Rpar69 vdd.t2 vdd.t14 666.2496
Rpar70 vdd.t3 vdd.t14 657.9385
Rpar71 vss vss.t0 806.0680
Rpar72 vss vss.t40 53.3205
Rpar73 vss vss.t397 79.8936
Rpar74 vss.t0 vss.t4 50.8396
Rpar75 vss.t0 vss.t40 2.4912
Rpar76 vss.t0 vss.t397 7909.7926
Rpar77 vss.t4 vss.t40 7.2141
Rpar78 vss.t40 vss.t397 523.2240
Cpar0 a_10472_21647.t0 vss 1.69935e-14
Cpar1 a_10472_21647.t12 vss 3.12952e-14
Cpar2 a_10472_21647.t13 vss 1.46768e-14
Cpar3 a_11844_28836.t0 vss 1.30487e-14
Cpar4 a_11844_28836.t165 vss 4.36694e-14
Cpar5 a_11844_28836.t185 vss 2.28280e-14
Cpar6 a_11844_28836.t5 vss 1.05676e-13
Cpar7 a_12702_1249.t0 vss 4.97709e-14
Cpar8 a_12702_1249.t9 vss 3.01854e-14
Cpar9 a_1358_15142.t0 vss 7.38572e-14
Cpar10 a_1358_15142.t10 vss 1.44962e-14
Cpar11 a_1478_14934.t0 vss 9.69321e-15
Cpar12 a_1478_14934.t1 vss 3.01728e-14
Cpar13 a_1478_14934.t32 vss 1.82193e-14
Cpar14 a_1478_14934.t44 vss 9.92550e-15
Cpar15 a_16762_11632.t0 vss 3.54193e-14
Cpar16 a_16762_11632.t16 vss 2.79296e-14
Cpar17 a_16762_11632.t17 vss 4.31514e-14
Cpar18 a_18414_18306.t0 vss 1.20837e-14
Cpar19 a_18414_18306.t165 vss 4.42334e-14
Cpar20 a_18414_18306.t185 vss 2.15967e-14
Cpar21 a_18414_18306.t5 vss 1.04822e-13
Cpar22 a_1850_1294.t0 vss 1.60349e-13
Cpar23 a_1850_1294.t160 vss 9.68212e-14
Cpar24 a_18534_11424.t0 vss 1.14095e-14
Cpar25 a_18534_11424.t1 vss 5.41476e-14
Cpar26 a_18534_11424.t133 vss 3.15452e-14
Cpar27 a_18534_11424.t149 vss 2.05947e-14
Cpar28 a_18534_11424.t2 vss 1.27269e-13
Cpar29 a_2218_1294.t0 vss 8.63763e-14
Cpar30 a_2218_1294.t96 vss 3.28798e-14
Cpar31 a_7336_11424.t0 vss 5.50244e-14
Cpar32 a_7336_11424.t1 vss 1.29531e-13
Cpar33 a_7336_11424.t128 vss 1.45867e-14
Cpar34 a_7336_11424.t129 vss 3.80715e-14
Cpar35 a_7336_11424.t149 vss 2.12546e-14
Cpar36 ib vdd 1.71304e-15
Cpar37 ib vss 1.61649e-13
Cpar38 ib.t0 vss 3.66895e-14
Cpar39 ib.t1 vss 5.85040e-15
Cpar40 inn inp 2.59870e-16
Cpar41 inn vdd 9.06100e-17
Cpar42 inn vss 5.48662e-14
Cpar43 inn.t0 vss 3.63586e-14
Cpar44 inp vdd 1.39940e-16
Cpar45 inp vss 5.47666e-14
Cpar46 inp.t0 vss 3.64285e-14
Cpar47 out vdd 3.98791e-14
Cpar48 out vss 5.49898e-14
Cpar49 out.t0 vss 2.89873e-15
Cpar50 out.t3 vss 2.18672e-15
Cpar51 out.t32 vss 7.91909e-14
Cpar52 vdd vss 5.90799e-13
Cpar53 vdd.t0 vss 3.51460e-13
Cpar54 vdd.t1 vss 1.58094e-13
Cpar55 vdd.t14 vss 2.17552e-14
Cpar56 vdd.t2 vss 8.28015e-14
Cpar57 vdd.t3 vss 5.00876e-14
.ends opamp_dut

Vdd vdd 0 1.800000
Vss vss 0 0
Ibias vdd ib 3.125000e-05
Vinp inp 0 DC 1.181700 AC 1 PWL(0 1.181700 3.000000e-09 1.181700 3.300000e-09 1.191700)
Rfb out inn 1m
Cload out 0 2.000000e-13
Xdut vdd vss inp inn out ib opamp_dut
.end
