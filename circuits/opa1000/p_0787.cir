* opa1000[0787]: 200f/symmetrical_ota_3v3_10u_100u_subth (symmetrical_ota, VDD=3.3V, CL=0.2pF, Iref=5.8333uA)
.include "pdk_opa.inc"
.temp 27
.option gmin=1e-12 rshunt=1e12 reltol=1e-3 abstol=1e-12 vntol=1e-5 method=gear
* Post-PEX R+C extracted netlist for symmetrical_ota_3v3_10u_100u_subth
.subckt opamp_dut vdd vss inp inn out ib
XMpar0 a_2494_1204.t26 ib.t0 vss.t23 vss.t22 nfet_03v3 w=7.01u l=1u ad=1.9628e-12 pd=7.5700e-06 as=3.0844e-12 ps=1.1395e-05 nf=1 m=4 par=4
XMpar1 a_4948_3801.t1 a_4948_3801.t0 vss.t15 vss.t0 nfet_03v3 w=3.48u l=0.6u ad=9.7440e-13 pd=4.0400e-06 as=9.7440e-13 ps=4.0400e-06 nf=1 m=4 par=4
XMpar2 a_2494_1204.t0 inn.t0 a_5774_1204.t0 vss.t0 nfet_03v3 w=1.92u l=0.28u ad=8.7286e-13 pd=2.9769e-06 as=8.7286e-13 ps=2.9769e-06 nf=1 m=26 par=26
XMpar3 out.t0 a_4948_3801.t0 vss.t15 vss.t0 nfet_03v3 w=3.48u l=0.6u ad=9.7440e-13 pd=4.0400e-06 as=1.5312e-12 ps=6.1000e-06 nf=1 m=4 par=4
XMpar4 a_5774_1204.t27 a_5774_1204.t26 vdd.t1 vdd.t0 pfet_03v3 w=10u l=0.6u ad=2.8000e-12 pd=1.0560e-05 as=2.8000e-12 ps=1.0560e-05 nf=1 m=2 par=2
XMpar5 a_1177_3801.t0 inp.t0 a_2494_1204.t0 vss.t0 nfet_03v3 w=1.92u l=0.28u ad=8.7286e-13 pd=2.9769e-06 as=8.7286e-13 ps=2.9769e-06 nf=1 m=26 par=26
XMpar6 ib.t1 ib.t0 vss.t23 vss.t22 nfet_03v3 w=7.01u l=1u ad=1.9628e-12 pd=7.5700e-06 as=1.9628e-12 ps=7.5700e-06 nf=1 m=2 par=2
XMpar7 a_1177_3801.t27 a_1177_3801.t26 vdd.t1 vdd.t0 pfet_03v3 w=10u l=0.6u ad=2.8000e-12 pd=1.0560e-05 as=2.8000e-12 ps=1.0560e-05 nf=1 m=2 par=2
XMpar8 a_4948_3801.t8 a_5774_1204.t26 vdd.t1 vdd.t0 pfet_03v3 w=10u l=0.6u ad=2.8000e-12 pd=1.0560e-05 as=4.4000e-12 ps=1.5880e-05 nf=1 m=4 par=4
XMpar9 out.t3 a_1177_3801.t26 vdd.t1 vdd.t0 pfet_03v3 w=10u l=0.6u ad=2.8000e-12 pd=1.0560e-05 as=4.4000e-12 ps=1.5880e-05 nf=1 m=4 par=4
X20 out.t8 vss.t36 cap_mim_2f0fF c_width=19.27u c_length=19.27u
Rpar0 a_1177_3801.t0 a_1177_3801.t26 185.5084
Rpar1 a_1177_3801.t0 a_1177_3801.t27 50.3046
Rpar2 a_1177_3801.t26 a_1177_3801.t27 37.8021
Rpar3 a_2494_1204.t0 a_2494_1204.t26 61.9959
Rpar4 a_4948_3801.t0 a_4948_3801.t1 21.6359
Rpar5 a_4948_3801.t0 a_4948_3801.t8 286.6777
Rpar6 a_4948_3801.t1 a_4948_3801.t8 55.3889
Rpar7 a_5774_1204.t0 a_5774_1204.t26 185.5084
Rpar8 a_5774_1204.t0 a_5774_1204.t27 50.3046
Rpar9 a_5774_1204.t26 a_5774_1204.t27 37.8021
Rpar10 ib ib.t0 22.1548
Rpar11 ib ib.t1 7.2478
Rpar12 ib.t0 ib.t1 148.2032
Rpar13 inn inn.t0 3.6211
Rpar14 inp inp.t0 3.6211
Rpar15 out out.t0 49.4332
Rpar16 out out.t3 3.1254
Rpar17 out out.t8 247.0331
Rpar18 out.t0 out.t8 125.5896
Rpar19 vdd vdd.t0 67.9912
Rpar20 vdd vdd.t1 146.3320
Rpar21 vdd.t0 vdd.t1 3.4958
Rpar22 vss vss.t0 61.0564
Rpar23 vss vss.t15 613.4304
Rpar24 vss vss.t22 1411.3180
Rpar25 vss vss.t23 1270.3255
Rpar26 vss vss.t36 1334.2922
Rpar27 vss.t0 vss.t15 4.3501
Rpar28 vss.t0 vss.t22 31.1369
Rpar29 vss.t0 vss.t23 34.3066
Rpar30 vss.t0 vss.t36 89.4230
Rpar31 vss.t15 vss.t22 559.8723
Rpar32 vss.t15 vss.t23 546.1999
Rpar33 vss.t15 vss.t36 738.9432
Rpar34 vss.t22 vss.t23 9.2238
Rpar35 vss.t22 vss.t36 206.8740
Rpar36 vss.t23 vss.t36 184.0217
Cpar0 a_1177_3801.t0 vss 1.55093e-14
Cpar1 a_1177_3801.t26 vss 7.80670e-15
Cpar2 a_1177_3801.t27 vss 6.31751e-15
Cpar3 a_2494_1204.t0 vss 2.69614e-14
Cpar4 a_2494_1204.t26 vss 7.17494e-15
Cpar5 a_4948_3801.t0 vss 3.30914e-15
Cpar6 a_4948_3801.t1 vss 2.96370e-15
Cpar7 a_4948_3801.t8 vss 4.45795e-15
Cpar8 a_5774_1204.t0 vss 1.49955e-14
Cpar9 a_5774_1204.t26 vss 7.54811e-15
Cpar10 a_5774_1204.t27 vss 6.10822e-15
Cpar11 ib out 1.91230e-16
Cpar12 ib vss 9.86270e-15
Cpar13 ib.t0 vss 1.46601e-15
Cpar14 ib.t1 vss 3.56771e-16
Cpar15 inn inp 1.01030e-16
Cpar16 inn vss 1.34450e-14
Cpar17 inn.t0 vss 3.02768e-15
Cpar18 inp vdd 1.17100e-17
Cpar19 inp vss 1.33326e-14
Cpar20 inp.t0 vss 3.03158e-15
Cpar21 out vdd 8.01787e-15
Cpar22 out vss 1.81912e-14
Cpar23 out.t0 vss 5.46547e-16
Cpar24 out.t3 vss 4.43550e-16
Cpar25 out.t8 vss 1.11836e-14
Cpar26 vdd vss 6.85786e-14
Cpar27 vdd.t0 vss 1.79408e-14
Cpar28 vdd.t1 vss 1.13068e-14
.ends opamp_dut

Vdd vdd 0 3.300000
Vss vss 0 0
Ibias vdd ib 5.833300e-06
Vinp inp 0 DC 1.645000 AC 1 PWL(0 1.645000 3.000000e-09 1.645000 3.300000e-09 1.655000)
Rfb out inn 1m
Cload out 0 2.000000e-13
Xdut vdd vss inp inn out ib opamp_dut
.end
