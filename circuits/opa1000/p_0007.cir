* opa1000[0007]: 200f/cherry_hooper_1v8_i2u_weak (cherry_hooper, VDD=1.8V, CL=0.2pF, Iref=0.0875uA)
.include "pdk_opa.inc"
.temp 27
.option gmin=1e-12 rshunt=1e12 reltol=1e-3 abstol=1e-12 vntol=1e-5 method=gear
* Post-PEX R+C extracted netlist for cherry_hooper_1v8_i2u_weak
.subckt opamp_dut vdd vss inp inn out ib
XMpar0 a_11082_15283.t6 a_3830_13417.t33 a_11402_15283.t3 vdd.t1 pfet_03v3 w=5.43u l=1u ad=2.0996e-12 pd=8.0133e-06 as=2.0996e-12 ps=8.0133e-06 nf=1 m=3 par=3
XMpar1 a_12334_15283.t1 a_3830_13417.t33 a_945_1294.t0 vdd.t1 pfet_03v3 w=5.43u l=1u ad=2.0996e-12 pd=8.0133e-06 as=2.0996e-12 ps=8.0133e-06 nf=1 m=3 par=3
XMpar2 out.t1 a_11200_11492.t1 vdd.t4 vdd.t3 pfet_03v3 w=1.5u l=1.3u ad=5.8000e-13 pd=2.7733e-06 as=4.2000e-13 ps=2.0600e-06 nf=1 m=3 par=3
XMpar3 a_945_1294.t5 a_945_1294.t4 vdd.t4 vdd.t3 pfet_03v3 w=1.5u l=1.3u ad=5.8000e-13 pd=2.7733e-06 as=5.8000e-13 ps=2.7733e-06 nf=1 m=3 par=3
XMpar4 a_11074_1294.t0 inp.t0 a_11402_15283.t1 vss.t4 nfet_03v3 w=0.4u l=1.8u ad=2.4000e-13 pd=2.0000e-06 as=1.1200e-13 ps=9.6000e-07 nf=1 m=1
XMpar5 a_11082_15283.t1 a_11082_15283.t0 vdd.t4 vdd.t3 pfet_03v3 w=1.5u l=1.3u ad=5.8000e-13 pd=2.7733e-06 as=5.8000e-13 ps=2.7733e-06 nf=1 m=3 par=3
XMpar6 ib.t1 ib vss.t6 vss.t5 nfet_03v3 w=0.4u l=3.25u ad=2.4000e-13 pd=2.0000e-06 as=1.1200e-13 ps=9.6000e-07 nf=1 m=1
XMpar7 a_1821_6287.t2 ib vss.t6 vss.t5 nfet_03v3 w=0.4u l=3.25u ad=1.1200e-13 pd=9.6000e-07 as=1.5467e-13 ps=1.3067e-06 nf=1 m=6 par=6
XMpar8 a_12334_15283.t0 a_2791_13417.t0 vdd.t28 vdd.t27 pfet_03v3 w=0.93u l=3.25u ad=5.5800e-13 pd=3.0600e-06 as=5.5800e-13 ps=3.0600e-06 nf=1 m=1
XMpar9 a_3830_13417.t1 a_3830_13417.t0 a_7477_7983.t0 vdd.t0 pfet_03v3 w=10u l=1u ad=2.8000e-12 pd=1.0560e-05 as=3.2000e-12 ps=1.1890e-05 nf=1 m=16 par=16
XMpar10 a_1821_6287.t0 a_945_1294.t10 out.t0 vss.t0 nfet_03v3 w=9.46u l=1.8u ad=5.6760e-12 pd=2.0120e-05 as=5.6760e-12 ps=2.0120e-05 nf=1 m=1
XMpar11 a_11402_15283.t0 a_2791_13417.t0 vdd.t28 vdd.t27 pfet_03v3 w=0.93u l=3.25u ad=5.5800e-13 pd=3.0600e-06 as=5.5800e-13 ps=3.0600e-06 nf=1 m=1
XMpar12 a_11074_1294.t0 inp.t0 a_11402_15283.t1 vss.t0 nfet_03v3 w=0.4u l=1.8u ad=2.4000e-13 pd=2.0000e-06 as=1.1200e-13 ps=9.6000e-07 nf=1 m=1
XMpar13 a_7477_7983.t14 a_7477_7983.t13 vdd.t4 vdd.t3 pfet_03v3 w=1.5u l=1.3u ad=9.0000e-13 pd=4.2000e-06 as=9.0000e-13 ps=4.2000e-06 nf=1 m=1
XMpar14 a_11546_20933.t0 ib vss.t6 vss.t5 nfet_03v3 w=0.4u l=3.25u ad=1.5467e-13 pd=1.3067e-06 as=1.9733e-13 ps=1.6533e-06 nf=1 m=6 par=6
XMpar15 a_2791_13417.t2 ib vss.t6 vss.t5 nfet_03v3 w=0.4u l=3.25u ad=2.4000e-13 pd=2.0000e-06 as=1.1200e-13 ps=9.6000e-07 nf=1 m=1
XMpar16 a_11074_1294.t2 ib vss.t6 vss.t5 nfet_03v3 w=0.4u l=3.25u ad=2.4000e-13 pd=2.0000e-06 as=1.1200e-13 ps=9.6000e-07 nf=1 m=2 par=2
XMpar17 a_11074_1294.t0 inn.t0 a_12334_15283.t4 vss.t0 nfet_03v3 w=0.4u l=1.8u ad=2.4000e-13 pd=2.0000e-06 as=1.1200e-13 ps=9.6000e-07 nf=1 m=1
XMpar18 a_2791_13417.t1 a_2791_13417.t0 vdd.t28 vdd.t27 pfet_03v3 w=0.93u l=3.25u ad=5.5800e-13 pd=3.0600e-06 as=5.5800e-13 ps=3.0600e-06 nf=1 m=1
XMpar19 a_11200_11492.t2 a_11200_11492.t1 vdd.t4 vdd.t3 pfet_03v3 w=1.5u l=1.3u ad=5.8000e-13 pd=2.7733e-06 as=4.2000e-13 ps=2.0600e-06 nf=1 m=3 par=3
XMpar20 a_11074_1294.t0 inn.t0 a_12334_15283.t4 vss.t4 nfet_03v3 w=0.4u l=1.8u ad=2.4000e-13 pd=2.0000e-06 as=1.1200e-13 ps=9.6000e-07 nf=1 m=1
XMpar21 a_11082_15283.t9 a_11402_15283.t6 a_11546_20933.t6 vss.t35 nfet_03v3 w=9.46u l=1.8u ad=5.6760e-12 pd=2.0120e-05 as=5.6760e-12 ps=2.0120e-05 nf=1 m=1
XMpar22 a_11546_20933.t6 a_12334_15283.t6 a_945_1294.t3 vss.t35 nfet_03v3 w=9.46u l=1.8u ad=5.6760e-12 pd=2.0120e-05 as=5.6760e-12 ps=2.0120e-05 nf=1 m=1
XMpar23 a_3830_13417.t32 ib vss.t6 vss.t5 nfet_03v3 w=0.4u l=3.25u ad=2.4000e-13 pd=2.0000e-06 as=2.4000e-13 ps=2.0000e-06 nf=1 m=1
XMpar24 a_11200_11492.t0 a_11082_15283.t10 a_1821_6287.t0 vss.t0 nfet_03v3 w=9.46u l=1.8u ad=5.6760e-12 pd=2.0120e-05 as=5.6760e-12 ps=2.0120e-05 nf=1 m=1
X6 out.t4 vss.t1 cap_mim_2f0fF c_width=20u c_length=20u
X12 out.t4 vss.t1 cap_mim_2f0fF c_width=20u c_length=20u
Rpar0 a_11074_1294.t0 a_11074_1294.t2 79.9521
Rpar1 a_11082_15283.t0 a_11082_15283.t1 21.5170
Rpar2 a_11082_15283.t0 a_11082_15283.t10 485.2536
Rpar3 a_11082_15283.t0 a_11082_15283.t6 697.9489
Rpar4 a_11082_15283.t0 a_11082_15283.t9 2743.6642
Rpar5 a_11082_15283.t1 a_11082_15283.t10 161.1816
Rpar6 a_11082_15283.t1 a_11082_15283.t6 231.8303
Rpar7 a_11082_15283.t1 a_11082_15283.t9 911.3339
Rpar8 a_11082_15283.t10 a_11082_15283.t6 397.3126
Rpar9 a_11082_15283.t10 a_11082_15283.t9 1561.8512
Rpar10 a_11082_15283.t6 a_11082_15283.t9 70.8509
Rpar11 a_11200_11492.t0 a_11200_11492.t1 403.4961
Rpar12 a_11200_11492.t0 a_11200_11492.t2 120.1394
Rpar13 a_11200_11492.t1 a_11200_11492.t2 17.8014
Rpar14 a_11402_15283.t0 a_11402_15283.t1 557.5203
Rpar15 a_11402_15283.t0 a_11402_15283.t3 67.3276
Rpar16 a_11402_15283.t0 a_11402_15283.t6 219.5909
Rpar17 a_11402_15283.t1 a_11402_15283.t3 179.3708
Rpar18 a_11402_15283.t1 a_11402_15283.t6 853.2587
Rpar19 a_11402_15283.t3 a_11402_15283.t6 103.0418
Rpar20 a_11546_20933.t0 a_11546_20933.t6 69.7541
Rpar21 a_12334_15283.t0 a_12334_15283.t1 88.7775
Rpar22 a_12334_15283.t0 a_12334_15283.t4 390.3016
Rpar23 a_12334_15283.t0 a_12334_15283.t6 176.4163
Rpar24 a_12334_15283.t1 a_12334_15283.t4 143.0941
Rpar25 a_12334_15283.t1 a_12334_15283.t6 135.8698
Rpar26 a_12334_15283.t4 a_12334_15283.t6 597.3383
Rpar27 a_1821_6287.t0 a_1821_6287.t2 72.2963
Rpar28 a_2791_13417.t0 a_2791_13417.t1 28.9857
Rpar29 a_2791_13417.t0 a_2791_13417.t2 86.4713
Rpar30 a_2791_13417.t1 a_2791_13417.t2 178.3393
Rpar31 a_3830_13417.t0 a_3830_13417.t1 17.5893
Rpar32 a_3830_13417.t0 a_3830_13417.t32 732.0686
Rpar33 a_3830_13417.t0 a_3830_13417.t33 457.4664
Rpar34 a_3830_13417.t1 a_3830_13417.t32 109.4367
Rpar35 a_3830_13417.t1 a_3830_13417.t33 68.3865
Rpar36 a_3830_13417.t32 a_3830_13417.t33 348.8227
Rpar37 a_7477_7983.t0 a_7477_7983.t13 275.3894
Rpar38 a_7477_7983.t0 a_7477_7983.t14 83.5258
Rpar39 a_7477_7983.t13 a_7477_7983.t14 46.0605
Rpar40 a_945_1294.t0 a_945_1294.t10 232.5836
Rpar41 a_945_1294.t0 a_945_1294.t3 81.8495
Rpar42 a_945_1294.t0 a_945_1294.t4 1089.8684
Rpar43 a_945_1294.t0 a_945_1294.t5 362.0101
Rpar44 a_945_1294.t10 a_945_1294.t3 423.1355
Rpar45 a_945_1294.t10 a_945_1294.t4 660.5803
Rpar46 a_945_1294.t10 a_945_1294.t5 219.4180
Rpar47 a_945_1294.t3 a_945_1294.t4 1982.7798
Rpar48 a_945_1294.t3 a_945_1294.t5 658.5990
Rpar49 a_945_1294.t4 a_945_1294.t5 21.2012
Rpar50 ib ib.t1 25.2638
Rpar51 inn inn.t0 4.6229
Rpar52 inp inp.t0 4.6715
Rpar53 out out.t0 105.1972
Rpar54 out out.t1 5.3662
Rpar55 out out.t4 58.0345
Rpar56 out.t0 out.t4 470.2843
Rpar57 vdd vdd.t0 1460.9780
Rpar58 vdd vdd.t1 857.2537
Rpar59 vdd vdd.t3 570.5922
Rpar60 vdd vdd.t4 686.9814
Rpar61 vdd vdd.t27 137.4003
Rpar62 vdd vdd.t28 136.1644
Rpar63 vdd.t0 vdd.t1 376.3917
Rpar64 vdd.t0 vdd.t3 156.9188
Rpar65 vdd.t0 vdd.t4 153.6878
Rpar66 vdd.t0 vdd.t27 307.1836
Rpar67 vdd.t0 vdd.t28 242.7390
Rpar68 vdd.t1 vdd.t3 71.7544
Rpar69 vdd.t1 vdd.t4 97.5539
Rpar70 vdd.t1 vdd.t27 841.0515
Rpar71 vdd.t1 vdd.t28 792.0474
Rpar72 vdd.t3 vdd.t4 3.4708
Rpar73 vdd.t3 vdd.t27 257.3658
Rpar74 vdd.t3 vdd.t28 214.1353
Rpar75 vdd.t4 vdd.t27 238.4529
Rpar76 vdd.t4 vdd.t28 193.9679
Rpar77 vdd.t27 vdd.t28 13.8640
Rpar78 vss vss.t0 154.4144
Rpar79 vss vss.t1 8415.5666
Rpar80 vss vss.t6 433.5118
Rpar81 vss vss.t5 540.4793
Rpar82 vss vss.t35 12407.5218
Rpar83 vss vss.t4 33.6685
Rpar84 vss.t0 vss.t1 6797.8154
Rpar85 vss.t0 vss.t6 310.9053
Rpar86 vss.t0 vss.t5 382.2357
Rpar87 vss.t0 vss.t35 10016.6250
Rpar88 vss.t0 vss.t4 12.4396
Rpar89 vss.t1 vss.t6 464.6472
Rpar90 vss.t1 vss.t5 155.9288
Rpar91 vss.t1 vss.t35 108.8756
Rpar92 vss.t1 vss.t4 1167.0179
Rpar93 vss.t6 vss.t5 3.7637
Rpar94 vss.t6 vss.t35 680.8153
Rpar95 vss.t6 vss.t4 53.3176
Rpar96 vss.t5 vss.t35 227.4059
Rpar97 vss.t5 vss.t4 68.8019
Rpar98 vss.t35 vss.t4 1719.9797
Cpar0 a_11074_1294.t0 vss 5.49359e-15
Cpar1 a_11074_1294.t2 vss 7.08633e-15
Cpar2 a_11082_15283.t0 vss 4.01316e-15
Cpar3 a_11082_15283.t1 vss 6.49293e-15
Cpar4 a_11082_15283.t10 vss 6.00310e-15
Cpar5 a_11082_15283.t6 vss 1.02825e-14
Cpar6 a_11082_15283.t9 vss 5.69486e-15
Cpar7 a_11200_11492.t0 vss 7.66472e-15
Cpar8 a_11200_11492.t1 vss 6.37453e-15
Cpar9 a_11200_11492.t2 vss 5.49187e-15
Cpar10 a_11402_15283.t0 vss 2.89992e-15
Cpar11 a_11402_15283.t1 vss 5.43278e-15
Cpar12 a_11402_15283.t3 vss 9.11707e-15
Cpar13 a_11402_15283.t6 vss 4.10660e-15
Cpar14 a_11546_20933.t0 vss 6.89331e-15
Cpar15 a_11546_20933.t6 vss 8.52797e-15
Cpar16 a_12334_15283.t0 vss 3.50248e-15
Cpar17 a_12334_15283.t1 vss 8.74001e-15
Cpar18 a_12334_15283.t4 vss 5.60393e-15
Cpar19 a_12334_15283.t6 vss 4.42878e-15
Cpar20 a_1821_6287.t0 vss 4.79023e-15
Cpar21 a_1821_6287.t2 vss 2.62912e-15
Cpar22 a_2791_13417.t0 vss 1.35851e-14
Cpar23 a_2791_13417.t1 vss 3.83880e-15
Cpar24 a_2791_13417.t2 vss 4.27350e-15
Cpar25 a_3830_13417.t0 vss 2.12603e-14
Cpar26 a_3830_13417.t1 vss 2.00906e-14
Cpar27 a_3830_13417.t32 vss 2.58564e-15
Cpar28 a_3830_13417.t33 vss 6.75429e-15
Cpar29 a_7477_7983.t0 vss 2.83495e-14
Cpar30 a_7477_7983.t13 vss 1.31337e-15
Cpar31 a_7477_7983.t14 vss 2.47730e-15
Cpar32 a_945_1294.t0 vss 8.28343e-15
Cpar33 a_945_1294.t10 vss 5.59457e-15
Cpar34 a_945_1294.t3 vss 5.88967e-15
Cpar35 a_945_1294.t4 vss 3.37454e-15
Cpar36 a_945_1294.t5 vss 5.17620e-15
Cpar37 ib out 9.30280e-16
Cpar38 ib vdd 1.00674e-15
Cpar39 ib vss 5.44438e-14
Cpar40 ib.t1 vss 6.11843e-16
Cpar41 inn inp 5.12600e-17
Cpar42 inn vss 2.44858e-15
Cpar43 inn.t0 vss 2.75306e-16
Cpar44 inp vss 2.45745e-15
Cpar45 inp.t0 vss 2.74088e-16
Cpar46 out vdd 3.62024e-15
Cpar47 out vss 2.47324e-14
Cpar48 out.t0 vss 4.37934e-16
Cpar49 out.t1 vss 2.42188e-17
Cpar50 out.t4 vss 1.77860e-14
Cpar51 vdd vss 1.81000e-13
Cpar52 vdd.t0 vss 2.63246e-14
Cpar53 vdd.t1 vss 9.58605e-15
Cpar54 vdd.t27 vss 5.22343e-15
Cpar55 vdd.t28 vss 5.61154e-15
Cpar56 vdd.t3 vss 1.34712e-14
Cpar57 vdd.t4 vss 1.22586e-14
.ends opamp_dut

Vdd vdd 0 1.800000
Vss vss 0 0
Ibias vdd ib 8.750000e-08
Vinp inp 0 DC 1.181100 AC 1 PWL(0 1.181100 8.020874e-08 1.181100 8.822962e-08 1.191100)
Rfb out inn 1m
Cload out 0 2.000000e-13
Xdut vdd vss inp inn out ib opamp_dut
.end
