* opa1000[0823]: 2p/symmetrical_ota_3v3_1u_10u_subth (symmetrical_ota, VDD=3.3V, CL=2.0pF, Iref=0.9583uA)
.include "pdk_opa.inc"
.temp 27
.option gmin=1e-12 rshunt=1e12 reltol=1e-3 abstol=1e-12 vntol=1e-5 method=gear
* Post-PEX R+C extracted netlist for symmetrical_ota_3v3_1u_10u_subth
.subckt opamp_dut vdd vss inp inn out ib
XMpar0 a_1324_8369.t0 inp.t0 a_3378_1250.t4 vss.t21 nfet_03v3 w=1.98u l=1.6u ad=5.5440e-13 pd=2.5400e-06 as=6.8112e-13 ps=3.0640e-06 nf=1 m=60 par=60
XMpar1 a_3378_1250.t4 inn.t0 a_8454_1250.t4 vss.t21 nfet_03v3 w=1.98u l=1.6u ad=6.8112e-13 pd=3.0640e-06 as=5.5440e-13 ps=2.5400e-06 nf=1 m=60 par=60
XMpar2 out.t0 a_7198_10802.t0 vss.t1 vss.t0 nfet_03v3 w=1.58u l=2u ad=9.4800e-13 pd=4.3600e-06 as=4.4240e-13 ps=2.1400e-06 nf=1 m=4 par=4
XMpar3 ib.t1 ib.t0 vss.t6 vss.t5 nfet_03v3 w=4.49u l=3u ad=1.2572e-12 pd=5.0500e-06 as=1.2572e-12 ps=5.0500e-06 nf=1 m=2 par=2
XMpar4 out.t3 a_1324_8369.t60 vdd.t1 vdd.t0 pfet_03v3 w=6.84u l=2u ad=1.9152e-12 pd=7.4000e-06 as=3.0096e-12 ps=1.1140e-05 nf=1 m=4 par=4
XMpar5 a_7198_10802.t1 a_7198_10802.t0 vss.t1 vss.t0 nfet_03v3 w=1.58u l=2u ad=4.4240e-13 pd=2.1400e-06 as=4.4240e-13 ps=2.1400e-06 nf=1 m=4 par=4
XMpar6 a_8454_1250.t1 a_8454_1250.t0 vdd.t1 vdd.t0 pfet_03v3 w=6.84u l=2u ad=1.9152e-12 pd=7.4000e-06 as=1.9152e-12 ps=7.4000e-06 nf=1 m=2 par=2
XMpar7 a_7198_10802.t8 a_8454_1250.t0 vdd.t1 vdd.t0 pfet_03v3 w=6.84u l=2u ad=1.9152e-12 pd=7.4000e-06 as=3.0096e-12 ps=1.1140e-05 nf=1 m=4 par=4
XMpar8 a_3378_1250.t0 ib.t0 vss.t6 vss.t5 nfet_03v3 w=4.49u l=3u ad=1.2572e-12 pd=5.0500e-06 as=1.9756e-12 ps=7.6150e-06 nf=1 m=4 par=4
XMpar9 a_1324_8369.t61 a_1324_8369.t60 vdd.t1 vdd.t0 pfet_03v3 w=6.84u l=2u ad=1.9152e-12 pd=7.4000e-06 as=1.9152e-12 ps=7.4000e-06 nf=1 m=2 par=2
Rpar0 a_1324_8369.t0 a_1324_8369.t60 119.4127
Rpar1 a_1324_8369.t0 a_1324_8369.t61 63.8899
Rpar2 a_1324_8369.t60 a_1324_8369.t61 24.9982
Rpar3 a_3378_1250.t0 a_3378_1250.t4 66.0361
Rpar4 a_7198_10802.t0 a_7198_10802.t1 12.2346
Rpar5 a_7198_10802.t0 a_7198_10802.t8 99.6177
Rpar6 a_7198_10802.t1 a_7198_10802.t8 63.1045
Rpar7 a_8454_1250.t0 a_8454_1250.t1 24.9982
Rpar8 a_8454_1250.t0 a_8454_1250.t4 119.4127
Rpar9 a_8454_1250.t1 a_8454_1250.t4 63.8899
Rpar10 ib ib.t0 21.4183
Rpar11 ib ib.t1 9.3085
Rpar12 ib.t0 ib.t1 69.7579
Rpar13 inn inn.t0 1.4610
Rpar14 inp inp.t0 1.4610
Rpar15 out out.t0 56.0702
Rpar16 out out.t3 3.9654
Rpar17 out.t0 out.t3 103.9142
Rpar18 vdd vdd.t0 60.8976
Rpar19 vdd vdd.t1 120.5217
Rpar20 vdd.t0 vdd.t1 3.2405
Rpar21 vss vss.t0 356.4379
Rpar22 vss vss.t1 83.1455
Rpar23 vss vss.t6 417.1094
Rpar24 vss vss.t5 162.3240
Rpar25 vss vss.t21 80.9096
Rpar26 vss.t0 vss.t1 54.4292
Rpar27 vss.t0 vss.t6 39.4281
Rpar28 vss.t0 vss.t5 2.0541
Rpar29 vss.t0 vss.t21 6.8499
Rpar30 vss.t1 vss.t6 322.9791
Rpar31 vss.t1 vss.t5 25.7226
Rpar32 vss.t1 vss.t21 61.7848
Rpar33 vss.t6 vss.t5 17.7060
Rpar34 vss.t6 vss.t21 6.8297
Rpar35 vss.t5 vss.t21 3.3989
Cpar0 a_1324_8369.t0 vss 3.47164e-14
Cpar1 a_1324_8369.t60 vss 1.85066e-14
Cpar2 a_1324_8369.t61 vss 5.30655e-15
Cpar3 a_3378_1250.t0 vss 8.16944e-15
Cpar4 a_3378_1250.t4 vss 7.18149e-14
Cpar5 a_7198_10802.t0 vss 5.96468e-15
Cpar6 a_7198_10802.t1 vss 1.89725e-15
Cpar7 a_7198_10802.t8 vss 3.24600e-15
Cpar8 a_8454_1250.t0 vss 1.89321e-14
Cpar9 a_8454_1250.t1 vss 5.42856e-15
Cpar10 a_8454_1250.t4 vss 3.55145e-14
Cpar11 ib inn 1.50300e-17
Cpar12 ib inp 1.27800e-17
Cpar13 ib out 1.28900e-17
Cpar14 ib vdd 1.40130e-16
Cpar15 ib vss 1.56098e-14
Cpar16 ib.t0 vss 2.83445e-15
Cpar17 ib.t1 vss 2.56017e-16
Cpar18 inn inp 3.15530e-16
Cpar19 inn vss 4.40334e-14
Cpar20 inn.t0 vss 2.78034e-14
Cpar21 inp vss 4.39434e-14
Cpar22 inp.t0 vss 2.77836e-14
Cpar23 out vdd 3.92740e-15
Cpar24 out vss 1.02319e-14
Cpar25 out.t0 vss 4.70183e-15
Cpar26 out.t3 vss 3.97600e-15
Cpar27 vdd vss 8.81318e-14
Cpar28 vdd.t0 vss 1.79210e-14
Cpar29 vdd.t1 vss 1.02729e-14
.ends opamp_dut

Vdd vdd 0 3.300000
Vss vss 0 0
Ibias vdd ib 9.583000e-07
Vinp inp 0 DC 1.645000 AC 1 PWL(0 1.645000 2.818031e-08 1.645000 3.099834e-08 1.655000)
Rfb out inn 1m
Cload out 0 2.000000e-12
Xdut vdd vss inp inn out ib opamp_dut
.end
