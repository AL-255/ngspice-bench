* opa1000[0106]: 200f/current_reuse_3v3_i50n_weak (current_reuse, VDD=3.3V, CL=0.2pF, Iref=0.0075uA)
.include "pdk_opa.inc"
.temp 27
.option gmin=1e-12 rshunt=1e12 reltol=1e-3 abstol=1e-12 vntol=1e-5 method=gear
* Post-PEX R+C extracted netlist for current_reuse_3v3_i50n_weak
.subckt opamp_dut vdd vss inp inn out ib
XMpar0 out.t0 a_1255_7366.t6 vdd.t1 vdd.t0 pfet_03v3 w=0.4u l=4u ad=1.3760e-13 pd=1.1680e-06 as=1.6320e-13 ps=1.3760e-06 nf=1 m=10 par=10
XMpar1 out.t1 ib.t0 vss.t2 vss.t1 nfet_03v3 w=0.4u l=5u ad=1.8880e-13 pd=1.5840e-06 as=1.6320e-13 ps=1.3760e-06 nf=1 m=10 par=10
XMpar2 a_6979_2702.t1 a_6979_2702.t0 vdd.t1 vdd.t0 pfet_03v3 w=0.4u l=4u ad=2.4000e-13 pd=2.0000e-06 as=1.1200e-13 ps=9.6000e-07 nf=1 m=1
XMpar3 a_8306_6698.t0 ib.t0 vss.t2 vss.t1 nfet_03v3 w=0.4u l=5u ad=2.4000e-13 pd=2.0000e-06 as=1.1200e-13 ps=9.6000e-07 nf=1 m=4 par=4
XMpar4 a_6979_2702.t4 inn.t0 a_7779_2910.t1 vdd.t6 pfet_03v3 w=0.4u l=5.2u ad=2.4000e-13 pd=2.0000e-06 as=2.4000e-13 ps=2.0000e-06 nf=1 m=2 par=2
XMpar5 a_6979_2702.t2 inn.t2 a_8306_6698.t4 vss.t26 nfet_03v3 w=0.4u l=5.2u ad=2.4000e-13 pd=2.0000e-06 as=2.4000e-13 ps=2.0000e-06 nf=1 m=2 par=2
XMpar6 a_1255_7366.t2 inp.t2 a_8306_6698.t4 vss.t26 nfet_03v3 w=0.4u l=5.2u ad=2.4000e-13 pd=2.0000e-06 as=2.4000e-13 ps=2.0000e-06 nf=1 m=2 par=2
XMpar7 ib.t1 ib.t0 vss.t2 vss.t1 nfet_03v3 w=0.4u l=5u ad=2.4000e-13 pd=2.0000e-06 as=1.1200e-13 ps=9.6000e-07 nf=1 m=2 par=2
XMpar8 a_1255_7366.t0 inp.t0 a_7779_2910.t1 vdd.t6 pfet_03v3 w=0.4u l=5.2u ad=2.4000e-13 pd=2.0000e-06 as=2.4000e-13 ps=2.0000e-06 nf=1 m=2 par=2
XMpar9 a_7779_2910.t0 a_6979_2702.t0 vdd.t1 vdd.t0 pfet_03v3 w=0.4u l=4u ad=1.1200e-13 pd=9.6000e-07 as=2.4000e-13 ps=2.0000e-06 nf=1 m=2 par=2
XMpar10 a_1255_7366.t4 a_6979_2702.t0 vdd.t1 vdd.t0 pfet_03v3 w=0.4u l=4u ad=2.4000e-13 pd=2.0000e-06 as=1.1200e-13 ps=9.6000e-07 nf=1 m=1
X0 a_1255_7366.t5 a_5233_7366.t0 vss.t0 ppolyf_u_1k r_width=1u r_length=19.23u
X2 a_1255_12046.t0 a_5233_12566.t0 vss.t0 ppolyf_u_1k r_width=1u r_length=19.23u
X6 a_1255_9966.t0 a_5233_9446.t0 vss.t0 ppolyf_u_1k r_width=1u r_length=19.23u
X12 a_1255_12046.t0 a_5233_11526.t0 vss.t0 ppolyf_u_1k r_width=1u r_length=19.23u
X14 a_1255_8926.t0 a_5233_9446.t0 vss.t0 ppolyf_u_1k r_width=1u r_length=19.23u
X15 a_5233_13606.t1 out.t20 cap_mim_2f0fF c_width=13.83u c_length=13.83u
X18 a_1255_11006.t0 a_5233_11526.t0 vss.t0 ppolyf_u_1k r_width=1u r_length=19.23u
X19 a_1255_8926.t0 a_5233_8406.t0 vss.t0 ppolyf_u_1k r_width=1u r_length=19.23u
X24 a_1255_11006.t0 a_5233_10486.t0 vss.t0 ppolyf_u_1k r_width=1u r_length=19.23u
X25 a_1255_7886.t0 a_5233_8406.t0 vss.t0 ppolyf_u_1k r_width=1u r_length=19.23u
X28 a_1255_13086.t0 a_5233_13606.t0 vss.t0 ppolyf_u_1k r_width=1u r_length=19.23u
X43 a_1255_9966.t0 a_5233_10486.t0 vss.t0 ppolyf_u_1k r_width=1u r_length=19.23u
X44 a_1255_7886.t0 a_5233_7366.t0 vss.t0 ppolyf_u_1k r_width=1u r_length=19.23u
X50 a_1255_13086.t0 a_5233_12566.t0 vss.t0 ppolyf_u_1k r_width=1u r_length=19.23u
Rpar0 a_1255_7366.t0 a_1255_7366.t6 238.9264
Rpar1 a_1255_7366.t0 a_1255_7366.t2 87.0939
Rpar2 a_1255_7366.t0 a_1255_7366.t4 130.0729
Rpar3 a_1255_7366.t0 a_1255_7366.t5 228.9920
Rpar4 a_1255_7366.t6 a_1255_7366.t2 147.7289
Rpar5 a_1255_7366.t6 a_1255_7366.t4 694.4855
Rpar6 a_1255_7366.t6 a_1255_7366.t5 127.4164
Rpar7 a_1255_7366.t2 a_1255_7366.t4 253.1550
Rpar8 a_1255_7366.t2 a_1255_7366.t5 141.5864
Rpar9 a_1255_7366.t4 a_1255_7366.t5 665.6094
Rpar10 a_5233_13606.t0 a_5233_13606.t1 64.9908
Rpar11 a_6979_2702.t0 a_6979_2702.t1 30.6983
Rpar12 a_6979_2702.t0 a_6979_2702.t2 259.5056
Rpar13 a_6979_2702.t0 a_6979_2702.t4 124.8436
Rpar14 a_6979_2702.t1 a_6979_2702.t2 491.6355
Rpar15 a_6979_2702.t1 a_6979_2702.t4 236.5172
Rpar16 a_6979_2702.t2 a_6979_2702.t4 80.2041
Rpar17 a_7779_2910.t0 a_7779_2910.t1 58.1773
Rpar18 a_8306_6698.t0 a_8306_6698.t4 62.6565
Rpar19 ib ib.t0 16.4433
Rpar20 ib ib.t1 15.2947
Rpar21 ib.t0 ib.t1 34.2096
Rpar22 inn inn.t0 53.3172
Rpar23 inn inn.t2 4.3032
Rpar24 inp inp.t0 53.5573
Rpar25 inp inp.t2 4.3027
Rpar26 out out.t0 219.5546
Rpar27 out out.t1 152.8622
Rpar28 out out.t20 19.7378
Rpar29 out.t0 out.t1 59.1770
Rpar30 out.t0 out.t20 2916.5539
Rpar31 out.t1 out.t20 2030.6144
Rpar32 vdd vdd.t0 23.0430
Rpar33 vdd vdd.t1 159.4092
Rpar34 vdd vdd.t6 85.9104
Rpar35 vdd.t0 vdd.t1 6.6491
Rpar36 vdd.t0 vdd.t6 92.8190
Rpar37 vdd.t1 vdd.t6 88.2716
Rpar38 vss vss.t0 52.1568
Rpar39 vss vss.t1 228.4963
Rpar40 vss vss.t2 269.7459
Rpar41 vss vss.t26 793.8045
Rpar42 vss.t0 vss.t1 46.9755
Rpar43 vss.t0 vss.t2 115.6326
Rpar44 vss.t0 vss.t26 168.3751
Rpar45 vss.t1 vss.t2 14.0831
Rpar46 vss.t1 vss.t26 5.6222
Rpar47 vss.t2 vss.t26 50.9025
Cpar0 a_1255_11006.t0 vss 3.64800e-17
Cpar1 a_1255_12046.t0 vss 3.72200e-17
Cpar2 a_1255_13086.t0 vss 3.35600e-17
Cpar3 a_1255_7366.t0 vss 5.80234e-15
Cpar4 a_1255_7366.t2 vss 5.66084e-15
Cpar5 a_1255_7366.t4 vss 3.71035e-15
Cpar6 a_1255_7366.t5 vss 4.62518e-15
Cpar7 a_1255_7366.t6 vss 2.45305e-14
Cpar8 a_1255_7886.t0 vss 3.91400e-17
Cpar9 a_1255_8926.t0 vss 3.64800e-17
Cpar10 a_1255_9966.t0 vss 3.64800e-17
Cpar11 a_5233_10486.t0 vss 3.98400e-17
Cpar12 a_5233_11526.t0 vss 3.75000e-17
Cpar13 a_5233_12566.t0 vss 4.12800e-17
Cpar14 a_5233_13606.t0 vss 9.94900e-17
Cpar15 a_5233_13606.t1 vss 1.55214e-15
Cpar16 a_5233_7366.t0 vss 3.88400e-17
Cpar17 a_5233_8406.t0 vss 3.94000e-17
Cpar18 a_5233_9446.t0 vss 3.96800e-17
Cpar19 a_6979_2702.t0 vss 1.28073e-14
Cpar20 a_6979_2702.t1 vss 2.57573e-15
Cpar21 a_6979_2702.t2 vss 4.70660e-15
Cpar22 a_6979_2702.t4 vss 5.21290e-15
Cpar23 a_7779_2910.t0 vss 3.30981e-15
Cpar24 a_7779_2910.t1 vss 9.49795e-15
Cpar25 a_8306_6698.t0 vss 1.76394e-14
Cpar26 a_8306_6698.t4 vss 9.43119e-15
Cpar27 ib out 2.23584e-15
Cpar28 ib vdd 1.25980e-16
Cpar29 ib vss 5.71577e-14
Cpar30 ib.t0 vss 9.36477e-15
Cpar31 ib.t1 vss 7.14500e-16
Cpar32 inn inp 2.09090e-16
Cpar33 inn vdd 5.21917e-15
Cpar34 inn vss 9.64420e-15
Cpar35 inn.t0 vss 5.12166e-15
Cpar36 inn.t2 vss 2.39016e-15
Cpar37 inp out 2.54600e-17
Cpar38 inp vdd 6.19139e-15
Cpar39 inp vss 9.80699e-15
Cpar40 inp.t0 vss 5.59786e-15
Cpar41 inp.t2 vss 2.58311e-15
Cpar42 out vdd 1.67774e-14
Cpar43 out vss 2.75665e-14
Cpar44 out.t0 vss 8.71811e-15
Cpar45 out.t1 vss 1.22581e-14
Cpar46 out.t20 vss 8.84918e-15
Cpar47 vdd vss 1.30795e-13
Cpar48 vdd.t0 vss 3.50692e-14
Cpar49 vdd.t1 vss 1.31274e-14
Cpar50 vdd.t6 vss 1.57976e-14
.ends opamp_dut

Vdd vdd 0 3.300000
Vss vss 0 0
Ibias vdd ib 7.500000e-09
Vinp inp 0 DC 1.645000 AC 1 PWL(0 1.645000 1.017338e-06 1.645000 1.119072e-06 1.655000)
Rfb out inn 1m
Cload out 0 2.000000e-13
Xdut vdd vss inp inn out ib opamp_dut
.end
