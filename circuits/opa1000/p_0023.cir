* opa1000[0023]: 200f/cherry_hooper_3v3_i200n_weak (cherry_hooper, VDD=3.3V, CL=0.2pF, Iref=0.0136uA)
.include "pdk_opa.inc"
.temp 27
.option gmin=1e-12 rshunt=1e12 reltol=1e-3 abstol=1e-12 vntol=1e-5 method=gear
* Post-PEX R+C extracted netlist for cherry_hooper_3v3_i200n_weak
.subckt opamp_dut vdd vss inp inn out ib
XMpar0 a_4381_8948.t0 ib.t0 vss.t9 vss.t8 nfet_03v3 w=0.4u l=5u ad=1.5467e-13 pd=1.3067e-06 as=1.5467e-13 ps=1.3067e-06 nf=1 m=6 par=6
XMpar1 a_10254_4340.t0 a_8946_7239.t0 vdd.t4 vdd.t3 pfet_03v3 w=0.4u l=5u ad=2.4000e-13 pd=2.0000e-06 as=2.4000e-13 ps=2.0000e-06 nf=1 m=1
XMpar2 a_10254_4340.t1 a_1289_5632.t3 a_10254_5886.t5 vdd.t15 pfet_03v3 w=0.4u l=14.16u ad=2.4000e-13 pd=2.0000e-06 as=2.4000e-13 ps=2.0000e-06 nf=1 m=1
XMpar3 out.t0 a_7980_11646.t1 vdd.t1 vdd.t0 pfet_03v3 w=0.4u l=3.2u ad=1.5467e-13 pd=1.3067e-06 as=1.1200e-13 ps=9.6000e-07 nf=1 m=3 par=3
XMpar4 a_6191_13306.t0 inp.t0 a_8534_1294.t1 vss.t5 nfet_03v3 w=0.4u l=6.5u ad=2.4000e-13 pd=2.0000e-06 as=1.1200e-13 ps=9.6000e-07 nf=1 m=2 par=2
XMpar5 a_10254_5886.t0 a_10254_4340.t4 a_3967_13306.t4 vss.t4 nfet_03v3 w=0.48u l=6.5u ad=2.8800e-13 pd=2.1600e-06 as=2.8800e-13 ps=2.1600e-06 nf=1 m=1
XMpar6 a_3967_13306.t4 a_8534_1294.t4 a_6994_4340.t5 vss.t4 nfet_03v3 w=0.48u l=6.5u ad=2.8800e-13 pd=2.1600e-06 as=2.8800e-13 ps=2.1600e-06 nf=1 m=1
XMpar7 a_10254_4340.t2 inn.t0 a_6191_13306.t0 vss.t5 nfet_03v3 w=0.4u l=6.5u ad=1.1200e-13 pd=9.6000e-07 as=2.4000e-13 ps=2.0000e-06 nf=1 m=2 par=2
XMpar8 a_8534_1294.t0 a_8946_7239.t0 vdd.t4 vdd.t3 pfet_03v3 w=0.4u l=5u ad=2.4000e-13 pd=2.0000e-06 as=2.4000e-13 ps=2.0000e-06 nf=1 m=1
XMpar9 a_10254_5886.t2 a_10254_5886.t1 vdd.t1 vdd.t0 pfet_03v3 w=0.4u l=3.2u ad=1.1200e-13 pd=9.6000e-07 as=2.4000e-13 ps=2.0000e-06 nf=1 m=2 par=2
XMpar10 a_6191_13306.t2 ib.t0 vss.t9 vss.t8 nfet_03v3 w=0.4u l=5u ad=1.1200e-13 pd=9.6000e-07 as=1.1200e-13 ps=9.6000e-07 nf=1 m=2 par=2
XMpar11 a_1169_5841.t0 a_1289_5632.t1 a_1289_5632.t2 vdd.t2 pfet_03v3 w=0.56u l=1u ad=3.3600e-13 pd=2.3200e-06 as=3.3600e-13 ps=2.3200e-06 nf=1 m=1
XMpar12 a_7980_11646.t2 a_7980_11646.t1 vdd.t1 vdd.t0 pfet_03v3 w=0.4u l=3.2u ad=1.5467e-13 pd=1.3067e-06 as=1.1200e-13 ps=9.6000e-07 nf=1 m=3 par=3
XMpar13 a_4381_8948.t6 a_10254_5886.t6 out.t1 vss.t0 nfet_03v3 w=0.71u l=6.5u ad=4.2600e-13 pd=2.6200e-06 as=4.2600e-13 ps=2.6200e-06 nf=1 m=1
XMpar14 a_1169_5841.t2 a_1169_5841.t1 vdd.t1 vdd.t0 pfet_03v3 w=0.4u l=3.2u ad=2.4000e-13 pd=2.0000e-06 as=2.4000e-13 ps=2.0000e-06 nf=1 m=1
XMpar15 a_4381_8948.t6 a_6994_4340.t6 a_7980_11646.t0 vss.t0 nfet_03v3 w=0.71u l=6.5u ad=4.2600e-13 pd=2.6200e-06 as=4.2600e-13 ps=2.6200e-06 nf=1 m=1
XMpar16 a_3967_13306.t0 ib.t0 vss.t9 vss.t8 nfet_03v3 w=0.4u l=5u ad=1.1200e-13 pd=9.6000e-07 as=1.7600e-13 ps=1.4800e-06 nf=1 m=4 par=4
XMpar17 a_1289_5632.t0 ib.t0 vss.t9 vss.t8 nfet_03v3 w=0.4u l=5u ad=2.4000e-13 pd=2.0000e-06 as=2.4000e-13 ps=2.0000e-06 nf=1 m=1
XMpar18 a_6994_4340.t2 a_6994_4340.t1 vdd.t1 vdd.t0 pfet_03v3 w=0.4u l=3.2u ad=1.1200e-13 pd=9.6000e-07 as=2.4000e-13 ps=2.0000e-06 nf=1 m=2 par=2
XMpar19 a_6994_4340.t0 a_1289_5632.t3 a_8534_1294.t3 vdd.t15 pfet_03v3 w=0.4u l=14.16u ad=2.4000e-13 pd=2.0000e-06 as=2.4000e-13 ps=2.0000e-06 nf=1 m=1
XMpar20 a_8946_7239.t2 ib.t0 vss.t9 vss.t8 nfet_03v3 w=0.4u l=5u ad=2.4000e-13 pd=2.0000e-06 as=1.1200e-13 ps=9.6000e-07 nf=1 m=1
XMpar21 a_8946_7239.t1 a_8946_7239.t0 vdd.t4 vdd.t3 pfet_03v3 w=0.4u l=5u ad=2.4000e-13 pd=2.0000e-06 as=2.4000e-13 ps=2.0000e-06 nf=1 m=1
XMpar22 ib.t1 ib.t0 vss.t9 vss.t8 nfet_03v3 w=0.4u l=5u ad=2.4000e-13 pd=2.0000e-06 as=1.1200e-13 ps=9.6000e-07 nf=1 m=1
X5 out.t4 vss.t1 cap_mim_2f0fF c_width=20u c_length=20u
X9 out.t4 vss.t1 cap_mim_2f0fF c_width=20u c_length=20u
X37 out.t4 vss.t1 cap_mim_2f0fF c_width=20u c_length=20u
Rpar0 a_10254_4340.t0 a_10254_4340.t1 177.5586
Rpar1 a_10254_4340.t0 a_10254_4340.t2 355.5531
Rpar2 a_10254_4340.t0 a_10254_4340.t4 93.7095
Rpar3 a_10254_4340.t1 a_10254_4340.t2 160.2358
Rpar4 a_10254_4340.t1 a_10254_4340.t4 82.3235
Rpar5 a_10254_4340.t2 a_10254_4340.t4 164.8492
Rpar6 a_10254_5886.t0 a_10254_5886.t1 445.1289
Rpar7 a_10254_5886.t0 a_10254_5886.t2 462.7696
Rpar8 a_10254_5886.t0 a_10254_5886.t5 155.2033
Rpar9 a_10254_5886.t0 a_10254_5886.t6 92.5491
Rpar10 a_10254_5886.t1 a_10254_5886.t2 30.5086
Rpar11 a_10254_5886.t1 a_10254_5886.t5 172.4510
Rpar12 a_10254_5886.t1 a_10254_5886.t6 447.0911
Rpar13 a_10254_5886.t2 a_10254_5886.t5 179.2853
Rpar14 a_10254_5886.t2 a_10254_5886.t6 464.8095
Rpar15 a_10254_5886.t5 a_10254_5886.t6 155.8875
Rpar16 a_1169_5841.t0 a_1169_5841.t1 83.0782
Rpar17 a_1169_5841.t0 a_1169_5841.t2 83.7651
Rpar18 a_1169_5841.t1 a_1169_5841.t2 39.1732
Rpar19 a_1289_5632.t0 a_1289_5632.t1 897.8334
Rpar20 a_1289_5632.t0 a_1289_5632.t2 393.8482
Rpar21 a_1289_5632.t0 a_1289_5632.t3 175.2211
Rpar22 a_1289_5632.t1 a_1289_5632.t2 52.7212
Rpar23 a_1289_5632.t1 a_1289_5632.t3 253.3709
Rpar24 a_1289_5632.t2 a_1289_5632.t3 111.1450
Rpar25 a_3967_13306.t0 a_3967_13306.t4 102.0978
Rpar26 a_4381_8948.t0 a_4381_8948.t6 53.2969
Rpar27 a_6191_13306.t0 a_6191_13306.t2 110.0713
Rpar28 a_6994_4340.t0 a_6994_4340.t1 228.3608
Rpar29 a_6994_4340.t0 a_6994_4340.t2 237.4108
Rpar30 a_6994_4340.t0 a_6994_4340.t5 196.5218
Rpar31 a_6994_4340.t0 a_6994_4340.t6 147.9070
Rpar32 a_6994_4340.t1 a_6994_4340.t2 30.3594
Rpar33 a_6994_4340.t1 a_6994_4340.t5 417.7421
Rpar34 a_6994_4340.t1 a_6994_4340.t6 314.4026
Rpar35 a_6994_4340.t2 a_6994_4340.t5 434.2974
Rpar36 a_6994_4340.t2 a_6994_4340.t6 326.8625
Rpar37 a_6994_4340.t5 a_6994_4340.t6 96.7285
Rpar38 a_7980_11646.t0 a_7980_11646.t1 193.5661
Rpar39 a_7980_11646.t0 a_7980_11646.t2 133.5066
Rpar40 a_7980_11646.t1 a_7980_11646.t2 19.5672
Rpar41 a_8534_1294.t0 a_8534_1294.t1 352.4850
Rpar42 a_8534_1294.t0 a_8534_1294.t3 209.2738
Rpar43 a_8534_1294.t0 a_8534_1294.t4 119.6135
Rpar44 a_8534_1294.t1 a_8534_1294.t3 137.7458
Rpar45 a_8534_1294.t1 a_8534_1294.t4 137.4856
Rpar46 a_8534_1294.t3 a_8534_1294.t4 81.6265
Rpar47 a_8946_7239.t0 a_8946_7239.t1 31.0064
Rpar48 a_8946_7239.t0 a_8946_7239.t2 70.3499
Rpar49 a_8946_7239.t1 a_8946_7239.t2 242.3075
Rpar50 ib ib.t0 2.3597
Rpar51 ib ib.t1 587.5229
Rpar52 ib.t0 ib.t1 27.3537
Rpar53 inn inn.t0 3.2172
Rpar54 inp inp.t0 3.2658
Rpar55 out out.t0 7.6145
Rpar56 out out.t1 63.1793
Rpar57 out out.t4 113.7268
Rpar58 out.t1 out.t4 326.3880
Rpar59 vdd vdd.t0 315.7406
Rpar60 vdd vdd.t1 327.9382
Rpar61 vdd vdd.t4 649.4301
Rpar62 vdd vdd.t3 1910.0248
Rpar63 vdd vdd.t15 6524.2133
Rpar64 vdd vdd.t2 497.5938
Rpar65 vdd.t0 vdd.t1 4.1238
Rpar66 vdd.t0 vdd.t4 106.8042
Rpar67 vdd.t0 vdd.t3 175.8819
Rpar68 vdd.t0 vdd.t15 109.3904
Rpar69 vdd.t0 vdd.t2 214.8118
Rpar70 vdd.t1 vdd.t4 138.5661
Rpar71 vdd.t1 vdd.t3 244.4783
Rpar72 vdd.t1 vdd.t15 161.7218
Rpar73 vdd.t1 vdd.t2 221.0404
Rpar74 vdd.t4 vdd.t3 19.3038
Rpar75 vdd.t4 vdd.t15 326.6432
Rpar76 vdd.t4 vdd.t2 459.4615
Rpar77 vdd.t3 vdd.t15 406.1781
Rpar78 vdd.t3 vdd.t2 1351.3122
Rpar79 vdd.t15 vdd.t2 4615.7772
Rpar80 vss vss.t0 501.7422
Rpar81 vss vss.t1 1146.3050
Rpar82 vss vss.t8 491.5652
Rpar83 vss vss.t9 935.5631
Rpar84 vss vss.t5 54.9962
Rpar85 vss vss.t4 343.7624
Rpar86 vss.t0 vss.t1 1404.9220
Rpar87 vss.t0 vss.t8 149.1596
Rpar88 vss.t0 vss.t9 95.6824
Rpar89 vss.t0 vss.t5 461.2504
Rpar90 vss.t0 vss.t4 88.0759
Rpar91 vss.t1 vss.t8 76.9369
Rpar92 vss.t1 vss.t9 367.0180
Rpar93 vss.t1 vss.t5 1055.8609
Rpar94 vss.t1 vss.t4 964.6903
Rpar95 vss.t8 vss.t9 3.5963
Rpar96 vss.t8 vss.t5 398.5104
Rpar97 vss.t8 vss.t4 112.3656
Rpar98 vss.t9 vss.t5 784.6677
Rpar99 vss.t9 vss.t4 178.8952
Rpar100 vss.t5 vss.t4 316.4820
Cpar0 a_10254_4340.t0 vss 2.03161e-15
Cpar1 a_10254_4340.t1 vss 2.58747e-15
Cpar2 a_10254_4340.t2 vss 3.04090e-15
Cpar3 a_10254_4340.t4 vss 4.71975e-15
Cpar4 a_10254_5886.t0 vss 2.35730e-15
Cpar5 a_10254_5886.t1 vss 4.06198e-15
Cpar6 a_10254_5886.t2 vss 1.62655e-15
Cpar7 a_10254_5886.t5 vss 2.66398e-15
Cpar8 a_10254_5886.t6 vss 4.94441e-15
Cpar9 a_1169_5841.t0 vss 1.33289e-15
Cpar10 a_1169_5841.t1 vss 2.47239e-15
Cpar11 a_1169_5841.t2 vss 1.17919e-15
Cpar12 a_1289_5632.t0 vss 7.04786e-15
Cpar13 a_1289_5632.t1 vss 1.87984e-15
Cpar14 a_1289_5632.t2 vss 3.49488e-15
Cpar15 a_1289_5632.t3 vss 1.54115e-14
Cpar16 a_3967_13306.t0 vss 7.22472e-15
Cpar17 a_3967_13306.t4 vss 6.48604e-15
Cpar18 a_4381_8948.t0 vss 3.46102e-15
Cpar19 a_4381_8948.t6 vss 1.67845e-15
Cpar20 a_6191_13306.t0 vss 7.84554e-15
Cpar21 a_6191_13306.t2 vss 7.57567e-15
Cpar22 a_6994_4340.t0 vss 2.76530e-15
Cpar23 a_6994_4340.t1 vss 4.24635e-15
Cpar24 a_6994_4340.t2 vss 1.78063e-15
Cpar25 a_6994_4340.t5 vss 2.43760e-15
Cpar26 a_6994_4340.t6 vss 5.27036e-15
Cpar27 a_7980_11646.t0 vss 3.11454e-15
Cpar28 a_7980_11646.t1 vss 1.22534e-14
Cpar29 a_7980_11646.t2 vss 4.07494e-15
Cpar30 a_8534_1294.t0 vss 2.34196e-15
Cpar31 a_8534_1294.t1 vss 3.14214e-15
Cpar32 a_8534_1294.t3 vss 2.90615e-15
Cpar33 a_8534_1294.t4 vss 5.18145e-15
Cpar34 a_8946_7239.t0 vss 1.11270e-14
Cpar35 a_8946_7239.t1 vss 1.87229e-15
Cpar36 a_8946_7239.t2 vss 3.36231e-15
Cpar37 ib out 2.59770e-16
Cpar38 ib vdd 2.38786e-15
Cpar39 ib vss 5.49542e-14
Cpar40 ib.t0 vss 9.75405e-15
Cpar41 ib.t1 vss 8.04153e-16
Cpar42 inn inp 5.16000e-17
Cpar43 inn vdd 1.36600e-17
Cpar44 inn vss 6.79082e-15
Cpar45 inn.t0 vss 4.63274e-16
Cpar46 inp vdd 1.49500e-17
Cpar47 inp vss 6.92659e-15
Cpar48 inp.t0 vss 4.75307e-16
Cpar49 out vdd 6.56647e-15
Cpar50 out vss 3.56316e-14
Cpar52 out.t1 vss 8.93389e-17
Cpar53 out.t4 vss 1.03479e-14
Cpar54 vdd vss 1.43687e-13
Cpar55 vdd.t0 vss 2.47065e-14
Cpar56 vdd.t1 vss 1.63875e-14
Cpar57 vdd.t15 vss 1.16996e-14
Cpar58 vdd.t2 vss 2.73519e-15
Cpar59 vdd.t3 vss 6.44618e-15
Cpar60 vdd.t4 vss 9.58756e-15
.ends opamp_dut

Vdd vdd 0 3.300000
Vss vss 0 0
Ibias vdd ib 1.360000e-08
Vinp inp 0 DC 2.071400 AC 1 PWL(0 2.071400 4.745216e-07 2.071400 5.219738e-07 2.081400)
Rfb out inn 1m
Cload out 0 2.000000e-13
Xdut vdd vss inp inn out ib opamp_dut
.end
