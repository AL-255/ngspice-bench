* opa1000[0864]: 200f/telescopic_nmos_3v3_1u_10u_subth (telescopic_nmos, VDD=3.3V, CL=0.2pF, Iref=1.0625uA)
.include "pdk_opa.inc"
.temp 27
.option gmin=1e-12 rshunt=1e12 reltol=1e-3 abstol=1e-12 vntol=1e-5 method=gear
* Post-PEX R+C extracted netlist for telescopic_nmos_3v3_1u_10u_subth
.subckt opamp_dut vdd vss inp inn out ib
XMpar0 a_1586_8544.t0 inn.t0 a_6908_6397.t8 vss.t0 nfet_03v3 w=2.01u l=1.6u ad=6.7631e-13 pd=3.0376e-06 as=6.0064e-13 ps=2.7259e-06 nf=1 m=34 par=34
XMpar1 a_1856_13992.t89 a_1856_13992.t88 a_4250_1204.t0 vss.t0 nfet_03v3 w=1.81u l=0.8u ad=5.0680e-13 pd=2.3700e-06 as=7.9640e-13 ps=3.5950e-06 nf=1 m=8 par=8
XMpar2 a_1856_13992.t1 a_1856_13992.t0 a_4280_10622.t2 vdd.t0 pfet_03v3 w=1.96u l=0.8u ad=5.4880e-13 pd=2.5200e-06 as=6.0582e-13 ps=2.7564e-06 nf=1 m=44 par=44
XMpar3 a_1586_8544.t0 inp.t0 a_4250_1204.t1 vss.t0 nfet_03v3 w=2.01u l=1.6u ad=6.7631e-13 pd=3.0376e-06 as=6.0064e-13 ps=2.7259e-06 nf=1 m=34 par=34
XMpar4 a_1736_14200.t0 a_1856_13992.t0 out.t0 vdd.t0 pfet_03v3 w=1.96u l=0.8u ad=6.0582e-13 pd=2.7564e-06 as=6.0582e-13 ps=2.7564e-06 nf=1 m=44 par=44
XMpar5 a_4280_10622.t0 a_1856_13992.t112 vdd.t11 vdd.t10 pfet_03v3 w=1.91u l=2u ad=5.3480e-13 pd=2.4700e-06 as=6.1120e-13 ps=2.7888e-06 nf=1 m=16 par=16
XMpar6 a_1736_14200.t10 a_1856_13992.t112 vdd.t11 vdd.t10 pfet_03v3 w=1.91u l=2u ad=5.3480e-13 pd=2.4700e-06 as=6.1120e-13 ps=2.7888e-06 nf=1 m=16 par=16
XMpar7 a_1586_8544.t34 ib.t0 vss.t34 vss.t0 nfet_03v3 w=2.94u l=2u ad=8.2320e-13 pd=3.5000e-06 as=1.0584e-12 ps=4.3950e-06 nf=1 m=8 par=8
XMpar8 a_6908_6397.t0 a_1856_13992.t88 out.t10 vss.t0 nfet_03v3 w=1.81u l=0.8u ad=6.5160e-13 pd=2.9825e-06 as=5.0680e-13 ps=2.3700e-06 nf=1 m=8 par=8
XMpar9 ib.t1 ib.t0 vss.t34 vss.t0 nfet_03v3 w=2.94u l=2u ad=8.2320e-13 pd=3.5000e-06 as=8.2320e-13 ps=3.5000e-06 nf=1 m=2 par=2
Rpar0 a_1586_8544.t0 a_1586_8544.t34 49.7275
Rpar1 a_1736_14200.t0 a_1736_14200.t10 46.0922
Rpar2 a_1856_13992.t0 a_1856_13992.t1 8.6684
Rpar3 a_1856_13992.t0 a_1856_13992.t88 1503.9323
Rpar4 a_1856_13992.t0 a_1856_13992.t89 441.5513
Rpar5 a_1856_13992.t0 a_1856_13992.t112 217.5614
Rpar6 a_1856_13992.t1 a_1856_13992.t88 707.7730
Rpar7 a_1856_13992.t1 a_1856_13992.t89 207.8006
Rpar8 a_1856_13992.t1 a_1856_13992.t112 102.3877
Rpar9 a_1856_13992.t88 a_1856_13992.t89 16.4756
Rpar10 a_1856_13992.t88 a_1856_13992.t112 406.5627
Rpar11 a_1856_13992.t89 a_1856_13992.t112 119.3659
Rpar12 a_4250_1204.t0 a_4250_1204.t1 37.5810
Rpar13 a_4280_10622.t0 a_4280_10622.t2 59.6130
Rpar14 a_6908_6397.t0 a_6908_6397.t8 57.7960
Rpar15 ib ib.t0 21.3768
Rpar16 ib ib.t1 10.6582
Rpar17 ib.t0 ib.t1 64.2373
Rpar18 inn inn.t0 1.8274
Rpar19 inp inp.t0 1.8274
Rpar20 out out.t0 2.5259
Rpar21 out out.t10 56.9012
Rpar22 vdd vdd.t0 20.5741
Rpar23 vdd vdd.t10 193.4442
Rpar24 vdd vdd.t11 2312.2728
Rpar25 vdd.t0 vdd.t10 70.0992
Rpar26 vdd.t0 vdd.t11 837.9081
Rpar27 vdd.t10 vdd.t11 10.8557
Rpar28 vss vss.t0 47.3620
Rpar29 vss vss.t34 1517.6887
Rpar30 vss.t0 vss.t34 3.9810
Cpar0 a_1586_8544.t0 vss 4.14872e-14
Cpar1 a_1586_8544.t34 vss 7.75824e-15
Cpar2 a_1736_14200.t0 vss 4.22761e-14
Cpar3 a_1736_14200.t10 vss 2.33337e-14
Cpar4 a_1856_13992.t0 vss 6.47775e-14
Cpar5 a_1856_13992.t1 vss 3.46716e-14
Cpar6 a_1856_13992.t112 vss 5.47207e-14
Cpar7 a_1856_13992.t88 vss 1.19922e-14
Cpar8 a_1856_13992.t89 vss 6.90268e-15
Cpar9 a_4250_1204.t0 vss 5.72952e-15
Cpar10 a_4250_1204.t1 vss 2.67586e-14
Cpar11 a_4280_10622.t0 vss 2.65612e-14
Cpar12 a_4280_10622.t2 vss 5.04416e-14
Cpar13 a_6908_6397.t0 vss 6.19836e-15
Cpar14 a_6908_6397.t8 vss 2.75230e-14
Cpar15 ib out 2.67530e-16
Cpar16 ib vss 1.79740e-14
Cpar17 ib.t0 vss 3.74611e-15
Cpar18 ib.t1 vss 2.92482e-16
Cpar19 inn inp 1.39130e-16
Cpar20 inn vss 2.72305e-14
Cpar21 inn.t0 vss 1.50682e-14
Cpar22 inp vss 2.74649e-14
Cpar23 inp.t0 vss 1.50719e-14
Cpar24 out vdd 8.73431e-15
Cpar25 out vss 2.04744e-14
Cpar26 out.t0 vss 3.90595e-14
Cpar27 out.t10 vss 1.04869e-14
Cpar28 vdd vss 2.57368e-13
Cpar29 vdd.t0 vss 8.75565e-14
Cpar30 vdd.t10 vss 5.28132e-14
Cpar31 vdd.t11 vss 7.87180e-15
.ends opamp_dut

Vdd vdd 0 3.300000
Vss vss 0 0
Ibias vdd ib 1.062500e-06
Vinp inp 0 DC 1.711000 AC 1 PWL(0 1.711000 7.561930e-09 1.711000 8.318123e-09 1.721000)
Rfb out inn 1m
Cload out 0 2.000000e-13
Xdut vdd vss inp inn out ib opamp_dut
.end
