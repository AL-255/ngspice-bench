* opa1000[0597]: 200f/pmos_miller_1v8_i10u_subth (pmos_miller, VDD=1.8V, CL=0.2pF, Iref=1.0625uA)
.include "pdk_opa.inc"
.temp 27
.option gmin=1e-12 rshunt=1e12 reltol=1e-3 abstol=1e-12 vntol=1e-5 method=gear
* Post-PEX R+C extracted netlist for pmos_miller_1v8_i10u_subth
.subckt opamp_dut vdd vss inp inn out ib
XMpar0 a_3118_9987.t0 inn.t0 a_6160_7334.t0 vdd.t2 pfet_03v3 w=2.04u l=0.54u ad=6.1472e-13 pd=2.7787e-06 as=6.1472e-13 ps=2.7787e-06 nf=1 m=30 par=30
XMpar1 a_3118_9987.t60 a_1805_1131.t2 vdd.t1 vdd.t0 pfet_03v3 w=10u l=2.25u ad=2.8000e-12 pd=1.0560e-05 as=2.8000e-12 ps=1.0560e-05 nf=1 m=4 par=4
XMpar2 out.t4 a_1805_1131.t2 vdd.t1 vdd.t0 pfet_03v3 w=10u l=2.25u ad=3.4400e-12 pd=1.2688e-05 as=2.8000e-12 ps=1.0560e-05 nf=1 m=10 par=10
XMpar3 a_1034_7583.t0 inp.t0 a_3118_9987.t0 vdd.t2 pfet_03v3 w=2.04u l=0.54u ad=6.1472e-13 pd=2.7787e-06 as=6.1472e-13 ps=2.7787e-06 nf=1 m=30 par=30
XMpar4 a_1805_1131.t0 ib.t0 vss.t15 vss.t14 nfet_03v3 w=3.3u l=2.25u ad=9.2400e-13 pd=3.8600e-06 as=9.2400e-13 ps=3.8600e-06 nf=1 m=2 par=2
XMpar5 ib.t1 ib.t0 vss.t15 vss.t14 nfet_03v3 w=3.3u l=2.25u ad=1.9800e-12 pd=7.8000e-06 as=9.2400e-13 ps=3.8600e-06 nf=1 m=2 par=2
XMpar6 a_1805_1131.t3 a_1805_1131.t2 vdd.t1 vdd.t0 pfet_03v3 w=10u l=2.25u ad=2.8000e-12 pd=1.0560e-05 as=2.8000e-12 ps=1.0560e-05 nf=1 m=2 par=2
XMpar7 out.t0 a_1034_7583.t33 vss.t1 vss.t0 nfet_03v3 w=4.32u l=1.13u ad=1.2096e-12 pd=4.8800e-06 as=1.4861e-12 ps=5.8720e-06 nf=1 m=10 par=10
XMpar8 a_1034_7583.t30 a_6160_7334.t30 vss.t1 vss.t0 nfet_03v3 w=4.32u l=1.13u ad=2.5920e-12 pd=9.8400e-06 as=1.2096e-12 ps=4.8800e-06 nf=1 m=2 par=2
XMpar9 a_6160_7334.t31 a_6160_7334.t30 vss.t1 vss.t0 nfet_03v3 w=4.32u l=1.13u ad=1.2096e-12 pd=4.8800e-06 as=1.2096e-12 ps=4.8800e-06 nf=1 m=2 par=2
X10 a_1034_7583.t32 a_3002_7583.t0 vss.t36 ppolyf_u_1k r_width=1u r_length=9.18u
X23 a_3002_7583.t1 out.t12 cap_mim_2f0fF c_width=13.23u c_length=13.23u
Rpar0 a_1034_7583.t0 a_1034_7583.t30 172.3162
Rpar1 a_1034_7583.t0 a_1034_7583.t32 126.2442
Rpar2 a_1034_7583.t0 a_1034_7583.t33 166.1026
Rpar3 a_1034_7583.t30 a_1034_7583.t32 122.7363
Rpar4 a_1034_7583.t30 a_1034_7583.t33 161.4872
Rpar5 a_1034_7583.t32 a_1034_7583.t33 118.3105
Rpar6 a_1805_1131.t0 a_1805_1131.t2 100.5876
Rpar7 a_1805_1131.t0 a_1805_1131.t3 79.4037
Rpar8 a_1805_1131.t2 a_1805_1131.t3 27.5080
Rpar9 a_3002_7583.t0 a_3002_7583.t1 80.0117
Rpar10 a_3118_9987.t0 a_3118_9987.t60 63.3390
Rpar11 a_6160_7334.t0 a_6160_7334.t30 223.8315
Rpar12 a_6160_7334.t0 a_6160_7334.t31 81.3619
Rpar13 a_6160_7334.t30 a_6160_7334.t31 26.2959
Rpar14 ib ib.t0 13.4453
Rpar15 ib ib.t1 3.8960
Rpar16 inn inn.t0 2.5751
Rpar17 inp inp.t0 2.5751
Rpar18 out out.t0 45.0021
Rpar19 out out.t4 67.0238
Rpar20 out out.t12 20.3232
Rpar21 out.t0 out.t4 120.0284
Rpar22 out.t0 out.t12 636.1195
Rpar23 out.t4 out.t12 947.4030
Rpar24 vdd vdd.t0 265.4976
Rpar25 vdd vdd.t1 2393.3063
Rpar26 vdd vdd.t2 20.4673
Rpar27 vdd.t0 vdd.t1 5.7121
Rpar28 vdd.t0 vdd.t2 100.8532
Rpar29 vdd.t1 vdd.t2 909.1334
Rpar30 vss vss.t0 148.6807
Rpar31 vss vss.t1 438.7030
Rpar32 vss vss.t14 147.5330
Rpar33 vss vss.t15 191.1081
Rpar34 vss vss.t36 1739.5857
Rpar35 vss.t0 vss.t1 3.0063
Rpar36 vss.t0 vss.t14 66.7756
Rpar37 vss.t0 vss.t15 88.7886
Rpar38 vss.t0 vss.t36 773.2895
Rpar39 vss.t1 vss.t14 207.8829
Rpar40 vss.t1 vss.t15 273.6816
Rpar41 vss.t1 vss.t36 2423.7743
Rpar42 vss.t14 vss.t15 11.9741
Rpar43 vss.t14 vss.t36 22.2032
Rpar44 vss.t15 vss.t36 153.8380
Cpar0 a_1034_7583.t0 vss 1.35166e-14
Cpar1 a_1034_7583.t30 vss 4.06762e-15
Cpar2 a_1034_7583.t32 vss 2.00477e-15
Cpar3 a_1034_7583.t33 vss 1.16320e-14
Cpar4 a_1805_1131.t0 vss 2.04867e-15
Cpar5 a_1805_1131.t2 vss 4.16397e-14
Cpar6 a_1805_1131.t3 vss 4.22434e-15
Cpar7 a_3002_7583.t0 vss 2.28250e-16
Cpar8 a_3002_7583.t1 vss 4.12850e-15
Cpar9 a_3118_9987.t0 vss 3.97571e-14
Cpar10 a_3118_9987.t60 vss 1.69916e-14
Cpar11 a_6160_7334.t0 vss 1.72369e-14
Cpar12 a_6160_7334.t30 vss 6.27333e-15
Cpar13 a_6160_7334.t31 vss 4.46414e-15
Cpar14 ib vdd 3.22600e-17
Cpar15 ib vss 1.00308e-14
Cpar16 ib.t0 vss 1.17955e-15
Cpar17 ib.t1 vss 2.56300e-16
Cpar18 inn inp 1.03280e-16
Cpar19 inn vdd 1.24641e-14
Cpar20 inn vss 5.86088e-15
Cpar21 inn.t0 vss 1.41841e-14
Cpar22 inp vdd 1.25898e-14
Cpar23 inp vss 5.88096e-15
Cpar24 inp.t0 vss 1.42243e-14
Cpar25 out vdd 1.37096e-14
Cpar26 out vss 1.45161e-14
Cpar27 out.t0 vss 5.96589e-15
Cpar28 out.t12 vss 6.37971e-15
Cpar29 out.t4 vss 1.45004e-14
Cpar30 vdd vss 1.92516e-13
Cpar31 vdd.t0 vss 4.24680e-14
Cpar32 vdd.t1 vss 1.10995e-14
Cpar33 vdd.t2 vss 3.29862e-14
.ends opamp_dut

Vdd vdd 0 1.800000
Vss vss 0 0
Ibias vdd ib 1.062500e-06
Vinp inp 0 DC 0.805000 AC 1 PWL(0 0.805000 1.038060e-08 0.805000 1.141866e-08 0.815000)
Rfb out inn 1m
Cload out 0 2.000000e-13
Xdut vdd vss inp inn out ib opamp_dut
.end
