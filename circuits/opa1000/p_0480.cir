* opa1000[0480]: 2p/nmos_miller_3v3_i50n_weak (nmos_miller, VDD=3.3V, CL=2.0pF, Iref=0.0082uA)
.include "pdk_opa.inc"
.temp 27
.option gmin=1e-12 rshunt=1e12 reltol=1e-3 abstol=1e-12 vntol=1e-5 method=gear
* Post-PEX R+C extracted netlist for nmos_miller_3v3_i50n_weak
.subckt opamp_dut vdd vss inp inn out ib
XMpar0 out.t3 ib.t0 vss.t9 vss.t8 nfet_03v3 w=0.4u l=5u ad=1.8880e-13 pd=1.5840e-06 as=1.6320e-13 ps=1.3760e-06 nf=1 m=10 par=10
XMpar1 out.t0 a_756_4168.t5 vdd.t1 vdd.t0 pfet_03v3 w=0.4u l=2.4u ad=1.3760e-13 pd=1.1680e-06 as=1.3760e-13 ps=1.1680e-06 nf=1 m=10 par=10
XMpar2 ib.t1 ib.t0 vss.t9 vss.t8 nfet_03v3 w=0.4u l=5u ad=2.4000e-13 pd=2.0000e-06 as=1.1200e-13 ps=9.6000e-07 nf=1 m=2 par=2
XMpar3 a_8246_4127.t0 inn.t0 a_8372_1041.t0 vss.t2 nfet_03v3 w=0.4u l=3.9u ad=2.4000e-13 pd=2.0000e-06 as=2.4000e-13 ps=2.0000e-06 nf=1 m=2 par=2
XMpar4 a_8246_4127.t2 ib.t0 vss.t9 vss.t8 nfet_03v3 w=0.4u l=5u ad=2.4000e-13 pd=2.0000e-06 as=1.1200e-13 ps=9.6000e-07 nf=1 m=4 par=4
XMpar5 a_756_4168.t3 a_8372_1041.t2 vdd.t1 vdd.t0 pfet_03v3 w=0.4u l=2.4u ad=2.4000e-13 pd=2.0000e-06 as=1.1200e-13 ps=9.6000e-07 nf=1 m=2 par=2
XMpar6 a_8372_1041.t3 a_8372_1041.t2 vdd.t1 vdd.t0 pfet_03v3 w=0.4u l=2.4u ad=1.1200e-13 pd=9.6000e-07 as=1.1200e-13 ps=9.6000e-07 nf=1 m=2 par=2
XMpar7 a_756_4168.t0 inp.t0 a_8246_4127.t0 vss.t2 nfet_03v3 w=0.4u l=3.9u ad=2.4000e-13 pd=2.0000e-06 as=2.4000e-13 ps=2.0000e-06 nf=1 m=2 par=2
X5 a_4734_10408.t1 out.t1 cap_mim_2f0fF c_width=16.58u c_length=16.59u
X7 a_756_4688.t0 a_4734_4168.t0 vss.t0 ppolyf_u_1k r_width=1u r_length=19.23u
X12 a_756_9888.t0 a_4734_10408.t0 vss.t0 ppolyf_u_1k r_width=1u r_length=19.23u
X14 a_756_6768.t0 a_4734_7288.t0 vss.t0 ppolyf_u_1k r_width=1u r_length=19.23u
X17 a_756_4168.t2 a_4734_4168.t0 vss.t0 ppolyf_u_1k r_width=1u r_length=19.23u
X19 a_756_9888.t0 a_4734_9368.t0 vss.t0 ppolyf_u_1k r_width=1u r_length=19.23u
X21 a_756_6768.t0 a_4734_6248.t0 vss.t0 ppolyf_u_1k r_width=1u r_length=19.23u
X25 a_756_8848.t0 a_4734_9368.t0 vss.t0 ppolyf_u_1k r_width=1u r_length=19.23u
X27 a_756_5728.t0 a_4734_6248.t0 vss.t0 ppolyf_u_1k r_width=1u r_length=19.23u
X32 a_756_8848.t0 a_4734_8328.t0 vss.t0 ppolyf_u_1k r_width=1u r_length=19.23u
X34 a_756_5728.t0 a_4734_5208.t0 vss.t0 ppolyf_u_1k r_width=1u r_length=19.23u
X41 a_4734_10408.t1 out.t1 cap_mim_2f0fF c_width=16.58u c_length=16.59u
X42 a_756_7808.t0 a_4734_8328.t0 vss.t0 ppolyf_u_1k r_width=1u r_length=19.23u
X43 a_756_4688.t0 a_4734_5208.t0 vss.t0 ppolyf_u_1k r_width=1u r_length=19.23u
X45 a_756_7808.t0 a_4734_7288.t0 vss.t0 ppolyf_u_1k r_width=1u r_length=19.23u
Rpar0 a_4734_10408.t0 a_4734_10408.t1 59.5369
Rpar1 a_756_4168.t0 a_756_4168.t5 144.7231
Rpar2 a_756_4168.t0 a_756_4168.t2 130.4164
Rpar3 a_756_4168.t0 a_756_4168.t3 304.8144
Rpar4 a_756_4168.t5 a_756_4168.t2 122.0920
Rpar5 a_756_4168.t5 a_756_4168.t3 64.5189
Rpar6 a_756_4168.t2 a_756_4168.t3 257.1490
Rpar7 a_8246_4127.t0 a_8246_4127.t2 62.9117
Rpar8 a_8372_1041.t0 a_8372_1041.t2 100.6397
Rpar9 a_8372_1041.t0 a_8372_1041.t3 96.9693
Rpar10 a_8372_1041.t2 a_8372_1041.t3 29.6507
Rpar11 ib ib.t0 16.4425
Rpar12 ib ib.t1 15.2949
Rpar13 ib.t0 ib.t1 34.2079
Rpar14 inn inn.t0 4.6138
Rpar15 inp inp.t0 4.6134
Rpar16 out out.t0 50.9284
Rpar17 out out.t1 23.2809
Rpar18 out out.t3 91.8708
Rpar19 out.t0 out.t1 302.7496
Rpar20 out.t0 out.t3 94.7785
Rpar21 out.t1 out.t3 546.1361
Rpar22 vdd vdd.t0 294.3231
Rpar23 vdd vdd.t1 122.3504
Rpar24 vdd.t0 vdd.t1 6.2950
Rpar25 vss vss.t0 66.8733
Rpar26 vss vss.t8 87.5043
Rpar27 vss vss.t9 115.3202
Rpar28 vss vss.t2 370.7001
Rpar29 vss.t0 vss.t8 84.6295
Rpar30 vss.t0 vss.t9 126.9079
Rpar31 vss.t0 vss.t2 365.9814
Rpar32 vss.t8 vss.t9 13.3176
Rpar33 vss.t8 vss.t2 4.0730
Rpar34 vss.t9 vss.t2 63.6779
Cpar0 a_4734_10408.t0 vss 1.33471e-16
Cpar1 a_4734_10408.t1 vss 6.69716e-15
Cpar2 a_4734_4168.t0 vss 3.67400e-17
Cpar3 a_4734_5208.t0 vss 3.83600e-17
Cpar4 a_4734_6248.t0 vss 3.68600e-17
Cpar5 a_4734_7288.t0 vss 3.68600e-17
Cpar6 a_4734_8328.t0 vss 3.86000e-17
Cpar7 a_4734_9368.t0 vss 4.54000e-17
Cpar8 a_756_4168.t0 vss 4.14101e-15
Cpar9 a_756_4168.t2 vss 3.68481e-15
Cpar10 a_756_4168.t3 vss 3.08604e-15
Cpar11 a_756_4168.t5 vss 1.45801e-14
Cpar12 a_756_4688.t0 vss 3.20200e-17
Cpar13 a_756_5728.t0 vss 2.93600e-17
Cpar14 a_756_6768.t0 vss 2.93600e-17
Cpar15 a_756_7808.t0 vss 2.93600e-17
Cpar16 a_756_8848.t0 vss 3.00800e-17
Cpar17 a_756_9888.t0 vss 2.64400e-17
Cpar18 a_8246_4127.t0 vss 8.79010e-15
Cpar19 a_8246_4127.t2 vss 1.73606e-14
Cpar20 a_8372_1041.t0 vss 3.91687e-15
Cpar21 a_8372_1041.t2 vss 6.61759e-15
Cpar22 a_8372_1041.t3 vss 2.08981e-15
Cpar23 ib out 2.27172e-15
Cpar24 ib vss 5.71174e-14
Cpar25 ib.t0 vss 9.25811e-15
Cpar26 ib.t1 vss 7.06331e-16
Cpar27 inn inp 1.03420e-16
Cpar28 inn vss 5.11418e-15
Cpar29 inn.t0 vss 9.18290e-16
Cpar30 inp vss 5.12913e-15
Cpar31 inp.t0 vss 9.15070e-16
Cpar32 out vdd 1.27184e-14
Cpar33 out vss 2.62073e-14
Cpar34 out.t0 vss 4.18149e-15
Cpar35 out.t1 vss 1.58459e-14
Cpar36 out.t3 vss 7.60836e-15
Cpar37 vdd vss 7.23408e-14
Cpar38 vdd.t0 vss 2.34050e-14
Cpar39 vdd.t1 vss 7.72101e-15
.ends opamp_dut

Vdd vdd 0 3.300000
Vss vss 0 0
Ibias vdd ib 8.200000e-09
Vinp inp 0 DC 1.645000 AC 1 PWL(0 1.645000 3.827542e-06 1.645000 4.210296e-06 1.655000)
Rfb out inn 1m
Cload out 0 2.000000e-12
Xdut vdd vss inp inn out ib opamp_dut
.end
