* opa1000[0765]: 200f/symmetrical_ota_1v8_i20u_subth (symmetrical_ota, VDD=1.8V, CL=0.2pF, Iref=3.3333uA)
.include "pdk_opa.inc"
.temp 27
.option gmin=1e-12 rshunt=1e12 reltol=1e-3 abstol=1e-12 vntol=1e-5 method=gear
* Post-PEX R+C extracted netlist for symmetrical_ota_1v8_i20u_subth
.subckt opamp_dut vdd vss inp inn out ib
XMpar0 out.t2 a_1231_10481.t8 vdd.t1 vdd.t0 pfet_03v3 w=10u l=1.69u ad=2.8000e-12 pd=1.0560e-05 as=4.4000e-12 ps=1.5880e-05 nf=1 m=4 par=4
XMpar1 a_5378_13154.t0 inn.t0 a_7412_13154.t0 vss.t0 nfet_03v3 w=1.77u l=0.39u ad=6.3720e-13 pd=2.9325e-06 as=4.9560e-13 ps=2.3300e-06 nf=1 m=8 par=8
XMpar2 ib.t1 ib.t0 vss.t34 vss.t33 nfet_03v3 w=4.9u l=1.2u ad=1.3720e-12 pd=5.4600e-06 as=1.3720e-12 ps=5.4600e-06 nf=1 m=2 par=2
XMpar3 a_5516_10481.t0 a_7412_13154.t8 vdd.t1 vdd.t0 pfet_03v3 w=10u l=1.69u ad=2.8000e-12 pd=1.0560e-05 as=4.4000e-12 ps=1.5880e-05 nf=1 m=4 par=4
XMpar4 a_1231_10481.t9 a_1231_10481.t8 vdd.t1 vdd.t0 pfet_03v3 w=10u l=1.69u ad=2.8000e-12 pd=1.0560e-05 as=2.8000e-12 ps=1.0560e-05 nf=1 m=2 par=2
XMpar5 a_7412_13154.t9 a_7412_13154.t8 vdd.t1 vdd.t0 pfet_03v3 w=10u l=1.69u ad=2.8000e-12 pd=1.0560e-05 as=2.8000e-12 ps=1.0560e-05 nf=1 m=2 par=2
XMpar6 a_5378_13154.t16 ib.t0 vss.t34 vss.t33 nfet_03v3 w=4.9u l=1.2u ad=1.3720e-12 pd=5.4600e-06 as=2.1560e-12 ps=8.2300e-06 nf=1 m=4 par=4
XMpar7 out.t0 a_5516_10481.t4 vss.t1 vss.t0 nfet_03v3 w=4.42u l=1.69u ad=1.2376e-12 pd=4.9800e-06 as=1.9448e-12 ps=7.5100e-06 nf=1 m=4 par=4
XMpar8 a_5516_10481.t5 a_5516_10481.t4 vss.t1 vss.t0 nfet_03v3 w=4.42u l=1.69u ad=1.2376e-12 pd=4.9800e-06 as=1.2376e-12 ps=4.9800e-06 nf=1 m=4 par=4
XMpar9 a_1231_10481.t0 inp.t0 a_5378_13154.t0 vss.t0 nfet_03v3 w=1.77u l=0.39u ad=4.9560e-13 pd=2.3300e-06 as=6.3720e-13 ps=2.9325e-06 nf=1 m=8 par=8
X7 out.t8 vss.t30 cap_mim_2f0fF c_width=18.66u c_length=18.67u
X27 out.t8 vss.t30 cap_mim_2f0fF c_width=18.66u c_length=18.67u
X42 out.t8 vss.t30 cap_mim_2f0fF c_width=18.66u c_length=18.67u
Rpar0 a_1231_10481.t0 a_1231_10481.t8 129.2223
Rpar1 a_1231_10481.t0 a_1231_10481.t9 58.7013
Rpar2 a_1231_10481.t8 a_1231_10481.t9 27.6896
Rpar3 a_5378_13154.t0 a_5378_13154.t16 79.7533
Rpar4 a_5516_10481.t0 a_5516_10481.t4 217.4591
Rpar5 a_5516_10481.t0 a_5516_10481.t5 44.8563
Rpar6 a_5516_10481.t4 a_5516_10481.t5 19.0600
Rpar7 a_7412_13154.t0 a_7412_13154.t8 129.2223
Rpar8 a_7412_13154.t0 a_7412_13154.t9 58.7013
Rpar9 a_7412_13154.t8 a_7412_13154.t9 27.6896
Rpar10 ib ib.t0 19.7037
Rpar11 ib ib.t1 7.7852
Rpar12 ib.t0 ib.t1 124.0750
Rpar13 inn inn.t0 5.6920
Rpar14 inp inp.t0 5.7406
Rpar15 out out.t0 438.1437
Rpar16 out out.t8 17.3938
Rpar17 out out.t2 174.6565
Rpar18 out.t0 out.t8 1736.2086
Rpar19 out.t0 out.t2 51.0028
Rpar20 out.t8 out.t2 692.1019
Rpar21 vdd vdd.t0 42.0631
Rpar22 vdd vdd.t1 105.3885
Rpar23 vdd.t0 vdd.t1 3.4186
Rpar24 vss vss.t0 95.1579
Rpar25 vss vss.t1 848.7699
Rpar26 vss vss.t30 62.5331
Rpar27 vss vss.t33 85.3538
Rpar28 vss vss.t34 178.9229
Rpar29 vss.t0 vss.t1 4.4713
Rpar30 vss.t0 vss.t30 256.7384
Rpar31 vss.t0 vss.t33 254.5269
Rpar32 vss.t0 vss.t34 533.5542
Rpar33 vss.t1 vss.t30 2290.0032
Rpar34 vss.t30 vss.t33 230.2868
Rpar35 vss.t30 vss.t34 482.7385
Rpar36 vss.t33 vss.t34 5.8909
Cpar0 a_1231_10481.t0 vss 2.66576e-15
Cpar1 a_1231_10481.t8 vss 1.54505e-14
Cpar2 a_1231_10481.t9 vss 4.64144e-15
Cpar3 a_5378_13154.t0 vss 7.74628e-15
Cpar4 a_5378_13154.t16 vss 8.26081e-15
Cpar5 a_5516_10481.t0 vss 3.02444e-15
Cpar6 a_5516_10481.t4 vss 6.17604e-15
Cpar7 a_5516_10481.t5 vss 2.19160e-15
Cpar8 a_7412_13154.t0 vss 2.68498e-15
Cpar9 a_7412_13154.t8 vss 1.55615e-14
Cpar10 a_7412_13154.t9 vss 4.67480e-15
Cpar11 ib out 1.98010e-16
Cpar12 ib vss 9.67478e-15
Cpar13 ib.t0 vss 1.74738e-15
Cpar14 ib.t1 vss 3.17677e-16
Cpar15 inn inp 5.18200e-17
Cpar16 inn vdd 2.45300e-17
Cpar17 inn vss 4.13438e-15
Cpar18 inn.t0 vss 5.27952e-16
Cpar19 inp vdd 4.71400e-17
Cpar20 inp vss 4.07509e-15
Cpar21 inp.t0 vss 5.34800e-16
Cpar22 out vdd 6.03634e-15
Cpar23 out vss 4.25167e-14
Cpar24 out.t0 vss 2.74863e-16
Cpar25 out.t2 vss 5.19122e-16
Cpar26 out.t8 vss 1.38006e-14
Cpar27 vdd vss 8.92759e-14
Cpar28 vdd.t0 vss 2.11945e-14
Cpar29 vdd.t1 vss 1.11306e-14
.ends opamp_dut

Vdd vdd 0 1.800000
Vss vss 0 0
Ibias vdd ib 3.333300e-06
Vinp inp 0 DC 0.895000 AC 1 PWL(0 0.895000 1.165927e-08 0.895000 1.282520e-08 0.905000)
Rfb out inn 1m
Cload out 0 2.000000e-13
Xdut vdd vss inp inn out ib opamp_dut
.end
