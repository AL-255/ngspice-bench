* opa1000[0011]: 200f/cherry_hooper_1v8_i10u_weak (cherry_hooper, VDD=1.8V, CL=0.2pF, Iref=0.5uA)
.include "pdk_opa.inc"
.temp 27
.option gmin=1e-12 rshunt=1e12 reltol=1e-3 abstol=1e-12 vntol=1e-5 method=gear
* Post-PEX R+C extracted netlist for cherry_hooper_1v8_i10u_weak
.subckt opamp_dut vdd vss inp inn out ib
XMpar0 a_1256_6874.t0 a_1376_6666.t1 a_1376_6666.t2 vdd.t2 pfet_03v3 w=10u l=0.6u ad=3.2000e-12 pd=1.1890e-05 as=2.8000e-12 ps=1.0560e-05 nf=1 m=16 par=16
XMpar1 a_1921_2749.t2 ib.t0 vss.t9 vss.t8 nfet_03v3 w=0.4u l=0.9u ad=1.1200e-13 pd=9.6000e-07 as=1.1200e-13 ps=9.6000e-07 nf=1 m=2 par=2
XMpar2 a_1276_1249.t3 ib.t0 vss.t9 vss.t8 nfet_03v3 w=0.4u l=0.9u ad=1.1200e-13 pd=9.6000e-07 as=1.5467e-13 ps=1.3067e-06 nf=1 m=6 par=6
XMpar3 a_1315_12420.t6 a_1376_6666.t33 a_7250_12629.t3 vdd.t20 pfet_03v3 w=6.88u l=1u ad=3.0272e-12 pd=1.1200e-05 as=1.9264e-12 ps=7.4400e-06 nf=1 m=4 par=4
XMpar4 a_1337_2749.t0 a_8494_8534.t7 a_8494_12629.t7 vss.t0 nfet_03v3 w=5.22u l=0.5u ad=3.1320e-12 pd=1.1640e-05 as=1.4616e-12 ps=5.7800e-06 nf=1 m=2 par=2
XMpar5 a_1337_2749.t3 ib.t0 vss.t9 vss.t8 nfet_03v3 w=0.4u l=0.9u ad=1.1200e-13 pd=9.6000e-07 as=1.7600e-13 ps=1.4800e-06 nf=1 m=4 par=4
XMpar6 a_7780_10294.t3 a_7780_10294.t2 vdd.t5 vdd.t4 pfet_03v3 w=3.77u l=0.6u ad=1.4577e-12 pd=5.8000e-06 as=1.0556e-12 ps=4.3300e-06 nf=1 m=3 par=3
XMpar7 a_1256_6874.t13 a_1256_6874.t12 vdd.t5 vdd.t4 pfet_03v3 w=3.77u l=0.6u ad=2.2620e-12 pd=8.7400e-06 as=2.2620e-12 ps=8.7400e-06 nf=1 m=1
XMpar8 a_8494_12629.t0 a_1376_6666.t33 a_8494_8534.t0 vdd.t20 pfet_03v3 w=6.88u l=1u ad=3.0272e-12 pd=1.1200e-05 as=1.9264e-12 ps=7.4400e-06 nf=1 m=4 par=4
XMpar9 a_1921_2749.t0 inp.t0 a_7250_12629.t1 vss.t6 nfet_03v3 w=1.19u l=1.3u ad=7.1400e-13 pd=3.5800e-06 as=3.3320e-13 ps=1.7500e-06 nf=1 m=2 par=2
XMpar10 a_1315_12420.t3 a_1315_12420.t2 vdd.t5 vdd.t4 pfet_03v3 w=3.77u l=0.6u ad=1.0556e-12 pd=4.3300e-06 as=2.2620e-12 ps=8.7400e-06 nf=1 m=2 par=2
XMpar11 a_1921_2749.t0 inn.t0 a_8494_8534.t4 vss.t6 nfet_03v3 w=1.19u l=1.3u ad=7.1400e-13 pd=3.5800e-06 as=3.3320e-13 ps=1.7500e-06 nf=1 m=2 par=2
XMpar12 a_3010_14594.t2 ib.t0 vss.t9 vss.t8 nfet_03v3 w=0.4u l=0.9u ad=2.4000e-13 pd=2.0000e-06 as=1.1200e-13 ps=9.6000e-07 nf=1 m=1
XMpar13 a_8494_8534.t1 a_3010_14594.t0 vdd.t1 vdd.t0 pfet_03v3 w=1.09u l=0.9u ad=6.5400e-13 pd=3.3800e-06 as=6.5400e-13 ps=3.3800e-06 nf=1 m=1
XMpar14 a_8494_12629.t4 a_8494_12629.t3 vdd.t5 vdd.t4 pfet_03v3 w=3.77u l=0.6u ad=1.0556e-12 pd=4.3300e-06 as=2.2620e-12 ps=8.7400e-06 nf=1 m=2 par=2
XMpar15 out.t2 a_7780_10294.t2 vdd.t5 vdd.t4 pfet_03v3 w=3.77u l=0.6u ad=1.4577e-12 pd=5.8000e-06 as=1.0556e-12 ps=4.3300e-06 nf=1 m=3 par=3
XMpar16 a_7250_12629.t0 a_3010_14594.t0 vdd.t1 vdd.t0 pfet_03v3 w=1.09u l=0.9u ad=6.5400e-13 pd=3.3800e-06 as=6.5400e-13 ps=3.3800e-06 nf=1 m=1
XMpar17 a_1276_1249.t0 a_8494_12629.t10 out.t0 vss.t0 nfet_03v3 w=7.83u l=0.5u ad=4.6980e-12 pd=1.6860e-05 as=2.1924e-12 ps=8.3900e-06 nf=1 m=2 par=2
XMpar18 a_1276_1249.t0 a_1315_12420.t10 a_7780_10294.t0 vss.t0 nfet_03v3 w=7.83u l=0.5u ad=4.6980e-12 pd=1.6860e-05 as=2.1924e-12 ps=8.3900e-06 nf=1 m=2 par=2
XMpar19 a_1376_6666.t0 ib.t0 vss.t9 vss.t8 nfet_03v3 w=0.4u l=0.9u ad=2.4000e-13 pd=2.0000e-06 as=2.4000e-13 ps=2.0000e-06 nf=1 m=1
XMpar20 a_1315_12420.t0 a_7250_12629.t7 a_1337_2749.t0 vss.t0 nfet_03v3 w=5.22u l=0.5u ad=1.4616e-12 pd=5.7800e-06 as=3.1320e-12 ps=1.1640e-05 nf=1 m=2 par=2
XMpar21 a_3010_14594.t1 a_3010_14594.t0 vdd.t1 vdd.t0 pfet_03v3 w=1.09u l=0.9u ad=6.5400e-13 pd=3.3800e-06 as=6.5400e-13 ps=3.3800e-06 nf=1 m=1
XMpar22 ib.t1 ib.t0 vss.t9 vss.t8 nfet_03v3 w=0.4u l=0.9u ad=2.4000e-13 pd=2.0000e-06 as=1.1200e-13 ps=9.6000e-07 nf=1 m=1
X13 out.t5 vss.t2 cap_mim_2f0fF c_width=20u c_length=20u
X28 out.t5 vss.t2 cap_mim_2f0fF c_width=20u c_length=20u
X46 out.t5 vss.t2 cap_mim_2f0fF c_width=20u c_length=20u
X58 out.t5 vss.t2 cap_mim_2f0fF c_width=20u c_length=20u
Rpar0 a_1256_6874.t0 a_1256_6874.t12 463.8004
Rpar1 a_1256_6874.t0 a_1256_6874.t13 58.8688
Rpar2 a_1256_6874.t12 a_1256_6874.t13 71.1413
Rpar3 a_1276_1249.t0 a_1276_1249.t3 49.2975
Rpar4 a_1315_12420.t0 a_1315_12420.t10 160.3084
Rpar5 a_1315_12420.t0 a_1315_12420.t2 1065.4275
Rpar6 a_1315_12420.t0 a_1315_12420.t3 174.6453
Rpar7 a_1315_12420.t0 a_1315_12420.t6 110.8789
Rpar8 a_1315_12420.t10 a_1315_12420.t2 3051.4451
Rpar9 a_1315_12420.t10 a_1315_12420.t3 500.1942
Rpar10 a_1315_12420.t10 a_1315_12420.t6 317.5636
Rpar11 a_1315_12420.t2 a_1315_12420.t3 55.4895
Rpar12 a_1315_12420.t2 a_1315_12420.t6 529.4544
Rpar13 a_1315_12420.t3 a_1315_12420.t6 86.7884
Rpar14 a_1337_2749.t0 a_1337_2749.t3 51.9295
Rpar15 a_1376_6666.t0 a_1376_6666.t1 9118.1432
Rpar16 a_1376_6666.t0 a_1376_6666.t2 190.1748
Rpar17 a_1376_6666.t0 a_1376_6666.t33 135.0563
Rpar18 a_1376_6666.t1 a_1376_6666.t2 18.7927
Rpar19 a_1376_6666.t1 a_1376_6666.t33 2717.1830
Rpar20 a_1376_6666.t2 a_1376_6666.t33 56.6716
Rpar21 a_1921_2749.t0 a_1921_2749.t2 79.9200
Rpar22 a_3010_14594.t0 a_3010_14594.t1 41.9963
Rpar23 a_3010_14594.t0 a_3010_14594.t2 138.4771
Rpar24 a_3010_14594.t1 a_3010_14594.t2 127.6569
Rpar25 a_7250_12629.t0 a_7250_12629.t1 85.4896
Rpar26 a_7250_12629.t0 a_7250_12629.t3 131.6782
Rpar27 a_7250_12629.t0 a_7250_12629.t7 275.2971
Rpar28 a_7250_12629.t1 a_7250_12629.t3 99.6794
Rpar29 a_7250_12629.t1 a_7250_12629.t7 176.8434
Rpar30 a_7250_12629.t3 a_7250_12629.t7 320.9916
Rpar31 a_7780_10294.t0 a_7780_10294.t2 399.8020
Rpar32 a_7780_10294.t0 a_7780_10294.t3 75.4981
Rpar33 a_7780_10294.t2 a_7780_10294.t3 22.4592
Rpar34 a_8494_12629.t0 a_8494_12629.t10 317.5636
Rpar35 a_8494_12629.t0 a_8494_12629.t3 529.4544
Rpar36 a_8494_12629.t0 a_8494_12629.t4 86.7884
Rpar37 a_8494_12629.t0 a_8494_12629.t7 110.8789
Rpar38 a_8494_12629.t10 a_8494_12629.t3 3051.4451
Rpar39 a_8494_12629.t10 a_8494_12629.t4 500.1942
Rpar40 a_8494_12629.t10 a_8494_12629.t7 160.3084
Rpar41 a_8494_12629.t3 a_8494_12629.t4 55.4895
Rpar42 a_8494_12629.t3 a_8494_12629.t7 1065.4275
Rpar43 a_8494_12629.t4 a_8494_12629.t7 174.6453
Rpar44 a_8494_8534.t0 a_8494_8534.t1 131.6782
Rpar45 a_8494_8534.t0 a_8494_8534.t4 99.6794
Rpar46 a_8494_8534.t0 a_8494_8534.t7 320.9916
Rpar47 a_8494_8534.t1 a_8494_8534.t4 85.4896
Rpar48 a_8494_8534.t1 a_8494_8534.t7 275.2971
Rpar49 a_8494_8534.t4 a_8494_8534.t7 176.8434
Rpar50 ib ib.t0 12.5369
Rpar51 ib ib.t1 15.6646
Rpar52 inn inn.t0 8.7079
Rpar53 inp inp.t0 8.7565
Rpar54 out out.t0 83.6592
Rpar55 out out.t2 3.9566
Rpar56 out out.t5 129.0833
Rpar57 out.t0 out.t5 527.9502
Rpar58 vdd vdd.t0 1471.4903
Rpar59 vdd vdd.t1 549.4424
Rpar60 vdd vdd.t5 140.6083
Rpar61 vdd vdd.t4 207.4537
Rpar62 vdd vdd.t2 1789.9318
Rpar63 vdd vdd.t20 88.0520
Rpar64 vdd.t0 vdd.t1 20.7011
Rpar65 vdd.t0 vdd.t5 268.3101
Rpar66 vdd.t0 vdd.t4 328.4467
Rpar67 vdd.t0 vdd.t2 362.0442
Rpar68 vdd.t0 vdd.t20 247.4147
Rpar69 vdd.t1 vdd.t5 96.6302
Rpar70 vdd.t1 vdd.t4 111.8461
Rpar71 vdd.t1 vdd.t2 106.0526
Rpar72 vdd.t1 vdd.t20 92.3826
Rpar73 vdd.t5 vdd.t4 3.5688
Rpar74 vdd.t5 vdd.t2 227.2865
Rpar75 vdd.t5 vdd.t20 48.3303
Rpar76 vdd.t4 vdd.t2 186.3757
Rpar77 vdd.t4 vdd.t20 68.2641
Rpar78 vdd.t2 vdd.t20 300.9572
Rpar79 vss vss.t0 112.0535
Rpar80 vss vss.t8 60.4924
Rpar81 vss vss.t9 166.4224
Rpar82 vss vss.t2 2643.1078
Rpar83 vss vss.t6 78.0168
Rpar84 vss.t0 vss.t8 214.6034
Rpar85 vss.t0 vss.t9 579.5445
Rpar86 vss.t0 vss.t2 562.4315
Rpar87 vss.t0 vss.t6 4.2463
Rpar88 vss.t8 vss.t9 2.7618
Rpar89 vss.t8 vss.t2 117.7568
Rpar90 vss.t8 vss.t6 141.3115
Rpar91 vss.t9 vss.t2 303.9656
Rpar92 vss.t9 vss.t6 380.8117
Rpar93 vss.t2 vss.t6 334.6938
Cpar0 a_1256_6874.t0 vss 3.14462e-14
Cpar1 a_1256_6874.t12 vss 9.39232e-16
Cpar2 a_1256_6874.t13 vss 4.14954e-15
Cpar3 a_1276_1249.t0 vss 6.33584e-15
Cpar4 a_1276_1249.t3 vss 1.48855e-15
Cpar5 a_1315_12420.t0 vss 4.71692e-15
Cpar6 a_1315_12420.t10 vss 2.51264e-15
Cpar7 a_1315_12420.t2 vss 1.64354e-15
Cpar8 a_1315_12420.t3 vss 4.92573e-15
Cpar9 a_1315_12420.t6 vss 9.70169e-15
Cpar10 a_1337_2749.t0 vss 5.42947e-15
Cpar11 a_1337_2749.t3 vss 1.92043e-15
Cpar12 a_1376_6666.t0 vss 2.36916e-15
Cpar13 a_1376_6666.t1 vss 1.63465e-14
Cpar14 a_1376_6666.t2 vss 2.44064e-14
Cpar15 a_1376_6666.t33 vss 1.25180e-14
Cpar16 a_1921_2749.t0 vss 3.72740e-15
Cpar17 a_1921_2749.t2 vss 2.35287e-15
Cpar18 a_3010_14594.t0 vss 5.34907e-15
Cpar19 a_3010_14594.t1 vss 3.27770e-15
Cpar20 a_3010_14594.t2 vss 3.10156e-15
Cpar21 a_7250_12629.t0 vss 2.33616e-15
Cpar22 a_7250_12629.t1 vss 2.98559e-15
Cpar23 a_7250_12629.t3 vss 7.63407e-15
Cpar24 a_7250_12629.t7 vss 2.43244e-15
Cpar25 a_7780_10294.t0 vss 5.73219e-15
Cpar26 a_7780_10294.t2 vss 4.85138e-15
Cpar27 a_7780_10294.t3 vss 6.65223e-15
Cpar28 a_8494_12629.t0 vss 7.85116e-15
Cpar29 a_8494_12629.t10 vss 2.03339e-15
Cpar30 a_8494_12629.t3 vss 1.33005e-15
Cpar31 a_8494_12629.t4 vss 3.98619e-15
Cpar32 a_8494_12629.t7 vss 3.81720e-15
Cpar33 a_8494_8534.t0 vss 6.98276e-15
Cpar34 a_8494_8534.t1 vss 2.13684e-15
Cpar35 a_8494_8534.t4 vss 2.73084e-15
Cpar36 a_8494_8534.t7 vss 2.22492e-15
Cpar37 ib out 1.71600e-17
Cpar38 ib vdd 3.22720e-16
Cpar39 ib vss 1.93553e-14
Cpar40 ib.t0 vss 4.52833e-15
Cpar41 ib.t1 vss 3.29500e-17
Cpar42 inn inp 5.16000e-17
Cpar43 inn vss 2.03019e-15
Cpar44 inn.t0 vss 2.74859e-16
Cpar45 inp vss 2.05990e-15
Cpar46 inp.t0 vss 2.78222e-16
Cpar47 out vdd 6.54882e-15
Cpar48 out vss 3.84244e-14
Cpar49 out.t0 vss 1.96884e-16
Cpar50 out.t2 vss 5.99643e-17
Cpar51 out.t5 vss 1.76075e-14
Cpar52 vdd vss 1.56051e-13
Cpar53 vdd.t0 vss 2.15138e-15
Cpar54 vdd.t1 vss 4.06348e-15
Cpar55 vdd.t2 vss 1.77443e-14
Cpar56 vdd.t20 vss 1.16055e-14
Cpar57 vdd.t4 vss 9.59084e-15
Cpar58 vdd.t5 vss 1.15878e-14
.ends opamp_dut

Vdd vdd 0 1.800000
Vss vss 0 0
Ibias vdd ib 5.000000e-07
Vinp inp 0 DC 1.195500 AC 1 PWL(0 1.195500 1.758725e-08 1.195500 1.934597e-08 1.205500)
Rfb out inn 1m
Cload out 0 2.000000e-13
Xdut vdd vss inp inn out ib opamp_dut
.end
