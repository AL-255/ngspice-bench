* opa1000[0020]: 200f/cherry_hooper_3v3_i50n_subth (cherry_hooper, VDD=3.3V, CL=0.2pF, Iref=0.0036uA)
.include "pdk_opa.inc"
.temp 27
.option gmin=1e-12 rshunt=1e12 reltol=1e-3 abstol=1e-12 vntol=1e-5 method=gear
* Post-PEX R+C extracted netlist for cherry_hooper_3v3_i50n_subth
.subckt opamp_dut vdd vss inp inn out ib
XMpar0 a_1366_3176.t2 a_1366_3176.t1 vdd.t1 vdd.t0 pfet_03v3 w=0.61u l=6u ad=2.3587e-13 pd=1.5867e-06 as=2.3587e-13 ps=1.5867e-06 nf=1 m=3 par=3
XMpar1 a_4548_1385.t2 ib.t0 vss.t6 vss.t5 nfet_03v3 w=0.4u l=6.25u ad=2.4000e-13 pd=2.0000e-06 as=1.1200e-13 ps=9.6000e-07 nf=1 m=1
XMpar2 a_10894_3429.t2 a_4548_1385.t0 vdd.t21 vdd.t20 pfet_03v3 w=0.4u l=6.25u ad=2.4000e-13 pd=2.0000e-06 as=2.4000e-13 ps=2.0000e-06 nf=1 m=1
XMpar3 a_1352_9993.t1 a_1352_9993.t0 vdd.t1 vdd.t0 pfet_03v3 w=0.61u l=6u ad=3.6600e-13 pd=2.4200e-06 as=3.6600e-13 ps=2.4200e-06 nf=1 m=1
XMpar4 a_1366_3176.t7 a_1472_9785.t3 a_9594_9993.t3 vdd.t22 pfet_03v3 w=0.4u l=11.67u ad=2.4000e-13 pd=2.0000e-06 as=2.4000e-13 ps=2.0000e-06 nf=1 m=1
XMpar5 out.t0 a_6940_11583.t1 vdd.t1 vdd.t0 pfet_03v3 w=0.61u l=6u ad=2.3587e-13 pd=1.5867e-06 as=1.7080e-13 ps=1.1700e-06 nf=1 m=3 par=3
XMpar6 a_6940_11583.t0 a_1366_3176.t8 a_8020_6779.t0 vss.t2 nfet_03v3 w=0.57u l=4.4u ad=3.4200e-13 pd=2.3400e-06 as=3.4200e-13 ps=2.3400e-06 nf=1 m=1
XMpar7 a_10894_5109.t3 a_10894_5109.t2 vdd.t1 vdd.t0 pfet_03v3 w=0.61u l=6u ad=2.3587e-13 pd=1.5867e-06 as=2.3587e-13 ps=1.5867e-06 nf=1 m=3 par=3
XMpar8 a_6940_11583.t2 a_6940_11583.t1 vdd.t1 vdd.t0 pfet_03v3 w=0.61u l=6u ad=2.3587e-13 pd=1.5867e-06 as=1.7080e-13 ps=1.1700e-06 nf=1 m=3 par=3
XMpar9 a_9586_5109.t2 ib.t0 vss.t6 vss.t5 nfet_03v3 w=0.4u l=6.25u ad=1.5467e-13 pd=1.3067e-06 as=1.9733e-13 ps=1.6533e-06 nf=1 m=6 par=6
XMpar10 a_8020_6779.t1 ib.t0 vss.t6 vss.t5 nfet_03v3 w=0.4u l=6.25u ad=1.1200e-13 pd=9.6000e-07 as=1.5467e-13 ps=1.3067e-06 nf=1 m=6 par=6
XMpar11 a_1472_9785.t0 ib.t0 vss.t6 vss.t5 nfet_03v3 w=0.4u l=6.25u ad=2.4000e-13 pd=2.0000e-06 as=2.4000e-13 ps=2.0000e-06 nf=1 m=1
XMpar12 a_8594_9993.t2 ib.t0 vss.t6 vss.t5 nfet_03v3 w=0.4u l=6.25u ad=2.4000e-13 pd=2.0000e-06 as=1.1200e-13 ps=9.6000e-07 nf=1 m=2 par=2
XMpar13 a_10894_5109.t0 a_10894_3429.t4 a_9586_5109.t0 vss.t2 nfet_03v3 w=0.57u l=4.4u ad=3.4200e-13 pd=2.3400e-06 as=3.4200e-13 ps=2.3400e-06 nf=1 m=1
XMpar14 a_8594_9993.t0 inp.t0 a_9594_9993.t0 vss.t2 nfet_03v3 w=0.4u l=4.4u ad=2.4000e-13 pd=2.0000e-06 as=1.1200e-13 ps=9.6000e-07 nf=1 m=1
XMpar15 a_10894_3429.t0 inn.t0 a_8594_9993.t0 vss.t4 nfet_03v3 w=0.4u l=4.4u ad=1.1200e-13 pd=9.6000e-07 as=2.4000e-13 ps=2.0000e-06 nf=1 m=1
XMpar16 a_4548_1385.t1 a_4548_1385.t0 vdd.t21 vdd.t20 pfet_03v3 w=0.4u l=6.25u ad=2.4000e-13 pd=2.0000e-06 as=2.4000e-13 ps=2.0000e-06 nf=1 m=1
XMpar17 a_9594_9993.t2 a_4548_1385.t0 vdd.t21 vdd.t20 pfet_03v3 w=0.4u l=6.25u ad=2.4000e-13 pd=2.0000e-06 as=2.4000e-13 ps=2.0000e-06 nf=1 m=1
XMpar18 a_8594_9993.t0 inp.t0 a_9594_9993.t0 vss.t4 nfet_03v3 w=0.4u l=4.4u ad=2.4000e-13 pd=2.0000e-06 as=1.1200e-13 ps=9.6000e-07 nf=1 m=1
XMpar19 a_8020_6779.t0 a_10894_5109.t8 out.t3 vss.t2 nfet_03v3 w=0.57u l=4.4u ad=3.4200e-13 pd=2.3400e-06 as=3.4200e-13 ps=2.3400e-06 nf=1 m=1
XMpar20 a_1352_9993.t2 a_1472_9785.t1 a_1472_9785.t2 vdd.t25 pfet_03v3 w=0.4u l=1u ad=2.4000e-13 pd=2.0000e-06 as=2.4000e-13 ps=2.0000e-06 nf=1 m=1
XMpar21 a_1366_3176.t0 a_9594_9993.t4 a_9586_5109.t0 vss.t2 nfet_03v3 w=0.57u l=4.4u ad=3.4200e-13 pd=2.3400e-06 as=3.4200e-13 ps=2.3400e-06 nf=1 m=1
XMpar22 ib.t1 ib.t0 vss.t6 vss.t5 nfet_03v3 w=0.4u l=6.25u ad=2.4000e-13 pd=2.0000e-06 as=1.1200e-13 ps=9.6000e-07 nf=1 m=1
XMpar23 a_10894_3429.t3 a_1472_9785.t3 a_10894_5109.t1 vdd.t22 pfet_03v3 w=0.4u l=11.67u ad=2.4000e-13 pd=2.0000e-06 as=2.4000e-13 ps=2.0000e-06 nf=1 m=1
XMpar24 a_10894_3429.t0 inn.t0 a_8594_9993.t0 vss.t2 nfet_03v3 w=0.4u l=4.4u ad=1.1200e-13 pd=9.6000e-07 as=2.4000e-13 ps=2.0000e-06 nf=1 m=1
X22 out.t4 vss.t0 cap_mim_2f0fF c_width=20u c_length=20u
X34 out.t4 vss.t0 cap_mim_2f0fF c_width=20u c_length=20u
Rpar0 a_10894_3429.t0 a_10894_3429.t2 144.9313
Rpar1 a_10894_3429.t0 a_10894_3429.t3 241.5799
Rpar2 a_10894_3429.t0 a_10894_3429.t4 168.4640
Rpar3 a_10894_3429.t2 a_10894_3429.t3 414.2727
Rpar4 a_10894_3429.t2 a_10894_3429.t4 288.8901
Rpar5 a_10894_3429.t3 a_10894_3429.t4 81.3854
Rpar6 a_10894_5109.t0 a_10894_5109.t1 203.5764
Rpar7 a_10894_5109.t0 a_10894_5109.t2 511.5391
Rpar8 a_10894_5109.t0 a_10894_5109.t3 202.7492
Rpar9 a_10894_5109.t0 a_10894_5109.t8 143.4974
Rpar10 a_10894_5109.t1 a_10894_5109.t2 335.1588
Rpar11 a_10894_5109.t1 a_10894_5109.t3 132.8407
Rpar12 a_10894_5109.t1 a_10894_5109.t8 172.6325
Rpar13 a_10894_5109.t2 a_10894_5109.t3 22.3050
Rpar14 a_10894_5109.t2 a_10894_5109.t8 433.7845
Rpar15 a_10894_5109.t3 a_10894_5109.t8 171.9311
Rpar16 a_1352_9993.t0 a_1352_9993.t1 31.4374
Rpar17 a_1352_9993.t0 a_1352_9993.t2 239.3689
Rpar18 a_1352_9993.t1 a_1352_9993.t2 239.8335
Rpar19 a_1366_3176.t0 a_1366_3176.t1 366.9900
Rpar20 a_1366_3176.t0 a_1366_3176.t2 145.4568
Rpar21 a_1366_3176.t0 a_1366_3176.t7 267.4768
Rpar22 a_1366_3176.t0 a_1366_3176.t8 419.0907
Rpar23 a_1366_3176.t1 a_1366_3176.t2 22.2813
Rpar24 a_1366_3176.t1 a_1366_3176.t7 367.9502
Rpar25 a_1366_3176.t1 a_1366_3176.t8 576.5154
Rpar26 a_1366_3176.t2 a_1366_3176.t7 145.8374
Rpar27 a_1366_3176.t2 a_1366_3176.t8 228.5025
Rpar28 a_1366_3176.t7 a_1366_3176.t8 274.3871
Rpar29 a_1472_9785.t0 a_1472_9785.t1 487.5862
Rpar30 a_1472_9785.t0 a_1472_9785.t2 240.7858
Rpar31 a_1472_9785.t0 a_1472_9785.t3 74.9213
Rpar32 a_1472_9785.t1 a_1472_9785.t2 53.2651
Rpar33 a_1472_9785.t1 a_1472_9785.t3 339.2588
Rpar34 a_1472_9785.t2 a_1472_9785.t3 167.5370
Rpar35 a_4548_1385.t0 a_4548_1385.t1 30.5282
Rpar36 a_4548_1385.t0 a_4548_1385.t2 93.8112
Rpar37 a_4548_1385.t1 a_4548_1385.t2 407.0058
Rpar38 a_6940_11583.t0 a_6940_11583.t1 156.6824
Rpar39 a_6940_11583.t0 a_6940_11583.t2 103.5569
Rpar40 a_6940_11583.t1 a_6940_11583.t2 19.8428
Rpar41 a_8020_6779.t0 a_8020_6779.t1 55.6176
Rpar42 a_8594_9993.t0 a_8594_9993.t2 113.1677
Rpar43 a_9586_5109.t0 a_9586_5109.t2 107.7944
Rpar44 a_9594_9993.t0 a_9594_9993.t2 124.1468
Rpar45 a_9594_9993.t0 a_9594_9993.t3 196.4519
Rpar46 a_9594_9993.t0 a_9594_9993.t4 182.2074
Rpar47 a_9594_9993.t2 a_9594_9993.t3 345.1488
Rpar48 a_9594_9993.t2 a_9594_9993.t4 320.1225
Rpar49 a_9594_9993.t3 a_9594_9993.t4 83.3063
Rpar50 ib ib.t0 1.9557
Rpar51 ib.t0 ib.t1 25.8259
Rpar52 inn inn.t0 3.1426
Rpar53 inp inp.t0 3.1912
Rpar54 out out.t0 142.5358
Rpar55 out out.t3 392.8464
Rpar56 out out.t4 18.0250
Rpar57 out.t0 out.t3 77.5358
Rpar58 out.t0 out.t4 541.7231
Rpar59 out.t3 out.t4 1493.0567
Rpar60 vdd vdd.t0 647.9015
Rpar61 vdd vdd.t1 1179.6444
Rpar62 vdd vdd.t20 150.6244
Rpar63 vdd vdd.t21 105.8162
Rpar64 vdd vdd.t22 6637.8960
Rpar65 vdd vdd.t25 2193.7700
Rpar66 vdd.t0 vdd.t1 4.1290
Rpar67 vdd.t0 vdd.t20 160.3821
Rpar68 vdd.t0 vdd.t21 127.0393
Rpar69 vdd.t0 vdd.t22 90.4399
Rpar70 vdd.t0 vdd.t25 159.8721
Rpar71 vdd.t1 vdd.t20 210.6894
Rpar72 vdd.t1 vdd.t21 170.6148
Rpar73 vdd.t1 vdd.t22 114.7086
Rpar74 vdd.t1 vdd.t25 290.0226
Rpar75 vdd.t20 vdd.t21 18.8419
Rpar76 vdd.t20 vdd.t22 445.7907
Rpar77 vdd.t20 vdd.t25 1288.1048
Rpar78 vdd.t21 vdd.t22 374.5191
Rpar79 vdd.t21 vdd.t25 921.1798
Rpar80 vdd.t22 vdd.t25 1501.0175
Rpar81 vss vss.t0 3525.5101
Rpar82 vss vss.t6 128.3780
Rpar83 vss vss.t5 51.4789
Rpar84 vss vss.t2 315.7476
Rpar85 vss vss.t4 557.3598
Rpar86 vss.t0 vss.t6 83.5876
Rpar87 vss.t0 vss.t5 181.7481
Rpar88 vss.t0 vss.t2 1129.4862
Rpar89 vss.t0 vss.t4 2162.2903
Rpar90 vss.t6 vss.t5 4.8252
Rpar91 vss.t6 vss.t2 28.0364
Rpar92 vss.t6 vss.t4 36.8835
Rpar93 vss.t5 vss.t2 4.1410
Rpar94 vss.t5 vss.t4 16.1807
Rpar95 vss.t2 vss.t4 32.8142
Cpar0 a_10894_3429.t0 vss 3.96058e-15
Cpar1 a_10894_3429.t2 vss 3.76486e-15
Cpar2 a_10894_3429.t3 vss 2.99089e-15
Cpar3 a_10894_3429.t4 vss 4.77949e-15
Cpar4 a_10894_5109.t0 vss 2.58754e-15
Cpar5 a_10894_5109.t1 vss 2.93611e-15
Cpar6 a_10894_5109.t2 vss 9.66669e-15
Cpar7 a_10894_5109.t3 vss 4.10385e-15
Cpar8 a_10894_5109.t8 vss 5.05451e-15
Cpar9 a_1352_9993.t0 vss 6.08151e-15
Cpar10 a_1352_9993.t1 vss 4.16478e-15
Cpar11 a_1352_9993.t2 vss 6.35875e-15
Cpar12 a_1366_3176.t0 vss 3.55040e-15
Cpar13 a_1366_3176.t1 vss 1.19972e-14
Cpar14 a_1366_3176.t2 vss 5.96277e-15
Cpar15 a_1366_3176.t7 vss 4.20856e-15
Cpar16 a_1366_3176.t8 vss 6.52665e-15
Cpar17 a_1472_9785.t0 vss 4.35466e-15
Cpar18 a_1472_9785.t1 vss 1.91162e-15
Cpar19 a_1472_9785.t2 vss 3.16603e-15
Cpar20 a_1472_9785.t3 vss 1.30248e-14
Cpar21 a_4548_1385.t0 vss 1.93155e-14
Cpar22 a_4548_1385.t1 vss 3.99960e-15
Cpar23 a_4548_1385.t2 vss 6.50593e-15
Cpar24 a_6940_11583.t0 vss 2.95547e-15
Cpar25 a_6940_11583.t1 vss 2.31570e-14
Cpar26 a_6940_11583.t2 vss 6.42022e-15
Cpar27 a_8020_6779.t0 vss 2.11124e-15
Cpar28 a_8020_6779.t1 vss 4.06469e-15
Cpar29 a_8594_9993.t0 vss 6.80846e-15
Cpar30 a_8594_9993.t2 vss 9.05683e-15
Cpar31 a_9586_5109.t0 vss 8.77865e-15
Cpar32 a_9586_5109.t2 vss 1.62346e-14
Cpar33 a_9594_9993.t0 vss 5.58361e-15
Cpar34 a_9594_9993.t2 vss 4.43254e-15
Cpar35 a_9594_9993.t3 vss 4.45249e-15
Cpar36 a_9594_9993.t4 vss 6.15192e-15
Cpar37 ib out 2.14210e-16
Cpar38 ib vdd 8.47740e-16
Cpar39 ib vss 6.94815e-14
Cpar40 ib.t0 vss 1.19799e-14
Cpar41 ib.t1 vss 7.03268e-16
Cpar42 inn inp 5.19700e-17
Cpar43 inn vss 4.92301e-15
Cpar44 inn.t0 vss 4.00921e-16
Cpar45 inp vdd 5.31300e-17
Cpar46 inp vss 4.90068e-15
Cpar47 inp.t0 vss 4.43263e-16
Cpar48 out vdd 6.73608e-15
Cpar49 out vss 2.64149e-14
Cpar50 out.t0 vss 4.56920e-16
Cpar51 out.t3 vss 1.77189e-16
Cpar52 out.t4 vss 1.47825e-14
Cpar53 vdd vss 1.79149e-13
Cpar54 vdd.t0 vss 4.48702e-14
Cpar55 vdd.t1 vss 2.90730e-14
Cpar56 vdd.t20 vss 8.98023e-15
Cpar57 vdd.t21 vss 1.13048e-14
Cpar58 vdd.t22 vss 1.13022e-14
Cpar59 vdd.t25 vss 3.47727e-15
.ends opamp_dut

Vdd vdd 0 3.300000
Vss vss 0 0
Ibias vdd ib 3.600000e-09
Vinp inp 0 DC 2.034500 AC 1 PWL(0 2.034500 1.128545e-06 2.034500 1.241400e-06 2.044500)
Rfb out inn 1m
Cload out 0 2.000000e-13
Xdut vdd vss inp inn out ib opamp_dut
.end
