* opa1000[0847]: 200f/telescopic_nmos_1v8_i10u_weak (telescopic_nmos, VDD=1.8V, CL=0.2pF, Iref=2.5uA)
.include "pdk_opa.inc"
.temp 27
.option gmin=1e-12 rshunt=1e12 reltol=1e-3 abstol=1e-12 vntol=1e-5 method=gear
* Post-PEX R+C extracted netlist for telescopic_nmos_1v8_i10u_weak
.subckt opamp_dut vdd vss inp inn out ib
XMpar0 a_2009_5828.t2 a_2129_5620.t0 out.t0 vdd.t8 pfet_03v3 w=1.96u l=1.13u ad=9.4793e-13 pd=4.1745e-06 as=6.0582e-13 ps=2.7564e-06 nf=1 m=22 par=22
XMpar1 a_1670_9925.t0 inn.t0 a_6574_4054.t6 vss.t0 nfet_03v3 w=2.03u l=1.63u ad=7.8493e-13 pd=3.4800e-06 as=5.6840e-13 ps=2.5900e-06 nf=1 m=12 par=12
XMpar2 a_1670_9925.t0 inp.t0 a_4076_1205.t0 vss.t0 nfet_03v3 w=2.03u l=1.63u ad=7.8493e-13 pd=3.4800e-06 as=5.6840e-13 ps=2.5900e-06 nf=1 m=12 par=12
XMpar3 a_2009_5828.t0 a_2129_5620.t72 vdd.t1 vdd.t0 pfet_03v3 w=2.06u l=1.8u ad=5.7680e-13 pd=2.6200e-06 as=5.7680e-13 ps=2.6200e-06 nf=1 m=12 par=12
XMpar4 a_6574_4054.t0 vdd.t58 out.t16 vss.t0 nfet_03v3 w=1.54u l=1.13u ad=5.9547e-13 pd=2.8267e-06 as=4.3120e-13 ps=2.1000e-06 nf=1 m=6 par=6
XMpar5 a_1670_9925.t24 ib.t0 vss.t25 vss.t24 nfet_03v3 w=1.63u l=1.5u ad=4.5640e-13 pd=2.1900e-06 as=5.8680e-13 ps=2.7575e-06 nf=1 m=8 par=8
XMpar6 a_2962_5828.t0 a_2129_5620.t72 vdd.t1 vdd.t0 pfet_03v3 w=2.06u l=1.8u ad=7.9653e-13 pd=3.5200e-06 as=5.7680e-13 ps=2.6200e-06 nf=1 m=12 par=12
XMpar7 ib.t1 ib.t0 vss.t25 vss.t24 nfet_03v3 w=1.63u l=1.5u ad=4.5640e-13 pd=2.1900e-06 as=4.5640e-13 ps=2.1900e-06 nf=1 m=2 par=2
XMpar8 a_2129_5620.t1 a_2129_5620.t0 a_2962_5828.t2 vdd.t8 pfet_03v3 w=1.96u l=1.13u ad=6.0582e-13 pd=2.7564e-06 as=8.3389e-13 ps=3.7018e-06 nf=1 m=22 par=22
XMpar9 a_2129_5620.t44 vdd.t58 a_4076_1205.t12 vss.t0 nfet_03v3 w=1.54u l=1.13u ad=4.3120e-13 pd=2.1000e-06 as=5.9547e-13 ps=2.8267e-06 nf=1 m=6 par=6
Rpar0 a_1670_9925.t0 a_1670_9925.t24 61.4276
Rpar1 a_2009_5828.t0 a_2009_5828.t2 58.7392
Rpar2 a_2129_5620.t0 a_2129_5620.t1 8.7761
Rpar3 a_2129_5620.t0 a_2129_5620.t44 315.4362
Rpar4 a_2129_5620.t0 a_2129_5620.t72 291.5536
Rpar5 a_2129_5620.t1 a_2129_5620.t44 114.7062
Rpar6 a_2129_5620.t1 a_2129_5620.t72 106.0215
Rpar7 a_2129_5620.t44 a_2129_5620.t72 134.8555
Rpar8 a_2962_5828.t0 a_2962_5828.t2 59.8256
Rpar9 a_4076_1205.t0 a_4076_1205.t12 36.2378
Rpar10 a_6574_4054.t0 a_6574_4054.t6 36.2378
Rpar11 ib ib.t0 11.6697
Rpar12 ib ib.t1 10.7779
Rpar13 inn inn.t0 2.2111
Rpar14 inp inp.t0 2.2111
Rpar15 out out.t0 3.5939
Rpar16 out out.t16 57.2552
Rpar17 vdd vdd.t0 25.7190
Rpar18 vdd vdd.t1 562.8680
Rpar19 vdd vdd.t8 132.6229
Rpar20 vdd vdd.t58 1112.7962
Rpar21 vdd.t0 vdd.t1 11.1892
Rpar22 vdd.t0 vdd.t8 65.9619
Rpar23 vdd.t0 vdd.t58 553.4650
Rpar24 vdd.t1 vdd.t8 1443.5933
Rpar25 vdd.t8 vdd.t58 60.0892
Rpar26 vss vss.t0 37.8293
Rpar27 vss vss.t24 1170.4480
Rpar28 vss vss.t25 2148.7981
Rpar29 vss.t0 vss.t24 99.0135
Rpar30 vss.t0 vss.t25 181.7968
Rpar31 vss.t24 vss.t25 5.4561
Cpar0 a_1670_9925.t0 vss 1.65395e-14
Cpar1 a_1670_9925.t24 vss 5.08362e-15
Cpar2 a_2009_5828.t0 vss 1.68951e-14
Cpar3 a_2009_5828.t2 vss 2.88804e-14
Cpar4 a_2129_5620.t0 vss 4.51666e-14
Cpar5 a_2129_5620.t1 vss 2.42894e-14
Cpar6 a_2129_5620.t44 vss 4.96350e-15
Cpar7 a_2129_5620.t72 vss 4.07536e-14
Cpar8 a_2962_5828.t0 vss 2.23475e-14
Cpar9 a_2962_5828.t2 vss 3.53962e-14
Cpar10 a_4076_1205.t0 vss 9.73409e-15
Cpar11 a_4076_1205.t12 vss 3.09214e-15
Cpar12 a_6574_4054.t0 vss 2.84836e-15
Cpar13 a_6574_4054.t6 vss 8.96677e-15
Cpar14 ib vdd 3.17140e-16
Cpar15 ib vss 1.43168e-14
Cpar16 ib.t0 vss 2.61906e-15
Cpar17 ib.t1 vss 1.31684e-16
Cpar18 inn inp 1.03890e-16
Cpar19 inn vdd 1.54500e-17
Cpar20 inn vss 1.19178e-14
Cpar21 inn.t0 vss 4.14431e-15
Cpar22 inp vdd 1.99000e-17
Cpar23 inp vss 1.17687e-14
Cpar24 inp.t0 vss 4.14972e-15
Cpar25 out vdd 4.55561e-15
Cpar26 out vss 1.40384e-14
Cpar27 out.t0 vss 2.31358e-14
Cpar28 out.t16 vss 5.38709e-15
Cpar29 vdd vss 2.08142e-13
Cpar30 vdd.t0 vss 3.63414e-14
Cpar31 vdd.t1 vss 5.46064e-15
Cpar32 vdd.t58 vss 3.50714e-15
Cpar33 vdd.t8 vss 6.40331e-14
.ends opamp_dut

Vdd vdd 0 1.800000
Vss vss 0 0
Ibias vdd ib 2.500000e-06
Vinp inp 0 DC 0.931000 AC 1 PWL(0 0.931000 3.739925e-09 0.931000 4.113917e-09 0.941000)
Rfb out inn 1m
Cload out 0 2.000000e-13
Xdut vdd vss inp inn out ib opamp_dut
.end
