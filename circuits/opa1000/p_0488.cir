* opa1000[0488]: 2p/nmos_miller_3v3_i2u_weak (nmos_miller, VDD=3.3V, CL=2.0pF, Iref=0.3714uA)
.include "pdk_opa.inc"
.temp 27
.option gmin=1e-12 rshunt=1e12 reltol=1e-3 abstol=1e-12 vntol=1e-5 method=gear
* Post-PEX R+C extracted netlist for nmos_miller_3v3_i2u_weak
.subckt opamp_dut vdd vss inp inn out ib
XMpar0 a_1009_5363.t5 a_7240_1085.t4 vdd.t1 vdd.t0 pfet_03v3 w=3.01u l=2.03u ad=1.8060e-12 pd=7.2200e-06 as=8.4280e-13 ps=3.5700e-06 nf=1 m=2 par=2
XMpar1 out.t2 a_1009_5363.t7 vdd.t1 vdd.t0 pfet_03v3 w=3.01u l=2.03u ad=8.4280e-13 pd=3.5700e-06 as=1.0354e-12 ps=4.3000e-06 nf=1 m=10 par=10
XMpar2 a_3810_3566.t4 ib.t0 vss.t6 vss.t5 nfet_03v3 w=0.74u l=3.9u ad=4.4400e-13 pd=2.6800e-06 as=2.0720e-13 ps=1.3000e-06 nf=1 m=4 par=4
XMpar3 out.t3 ib.t0 vss.t6 vss.t5 nfet_03v3 w=0.74u l=3.9u ad=3.4928e-13 pd=2.1280e-06 as=3.0192e-13 ps=1.8520e-06 nf=1 m=10 par=10
XMpar4 a_7240_1085.t5 a_7240_1085.t4 vdd.t1 vdd.t0 pfet_03v3 w=3.01u l=2.03u ad=8.4280e-13 pd=3.5700e-06 as=8.4280e-13 ps=3.5700e-06 nf=1 m=2 par=2
XMpar5 a_1009_5363.t1 inp.t0 a_3810_3566.t0 vss.t1 nfet_03v3 w=1.45u l=4.5u ad=4.0600e-13 pd=2.0100e-06 as=6.3800e-13 ps=3.0550e-06 nf=1 m=4 par=4
XMpar6 ib.t1 ib.t0 vss.t6 vss.t5 nfet_03v3 w=0.74u l=3.9u ad=4.4400e-13 pd=2.6800e-06 as=2.0720e-13 ps=1.3000e-06 nf=1 m=2 par=2
XMpar7 a_3810_3566.t0 inn.t0 a_7240_1085.t0 vss.t1 nfet_03v3 w=1.45u l=4.5u ad=6.3800e-13 pd=3.0550e-06 as=4.0600e-13 ps=2.0100e-06 nf=1 m=4 par=4
X3 a_1009_5883.t0 a_4399_5363.t0 vss.t0 ppolyf_u_1k r_width=1u r_length=16.29u
X8 a_1009_5363.t0 a_4399_5363.t0 vss.t0 ppolyf_u_1k r_width=1u r_length=16.29u
X25 a_1009_6923.t1 out.t0 cap_mim_2f0fF c_width=16.58u c_length=16.59u
X28 a_1009_6923.t0 a_4399_6403.t0 vss.t0 ppolyf_u_1k r_width=1u r_length=16.29u
X35 a_1009_5883.t0 a_4399_6403.t0 vss.t0 ppolyf_u_1k r_width=1u r_length=16.29u
X41 a_1009_6923.t1 out.t0 cap_mim_2f0fF c_width=16.58u c_length=16.59u
Rpar0 a_1009_5363.t0 a_1009_5363.t1 336.9216
Rpar1 a_1009_5363.t0 a_1009_5363.t7 69.9652
Rpar2 a_1009_5363.t0 a_1009_5363.t5 587.3070
Rpar3 a_1009_5363.t1 a_1009_5363.t7 132.6130
Rpar4 a_1009_5363.t1 a_1009_5363.t5 101.9060
Rpar5 a_1009_5363.t7 a_1009_5363.t5 231.1651
Rpar6 a_1009_6923.t0 a_1009_6923.t1 66.5160
Rpar7 a_3810_3566.t0 a_3810_3566.t4 61.8643
Rpar8 a_7240_1085.t0 a_7240_1085.t4 177.1296
Rpar9 a_7240_1085.t0 a_7240_1085.t5 78.8728
Rpar10 a_7240_1085.t4 a_7240_1085.t5 23.4134
Rpar11 ib ib.t0 15.4884
Rpar12 ib ib.t1 13.3810
Rpar13 ib.t0 ib.t1 31.0824
Rpar14 inn inn.t0 1.9843
Rpar15 inp inp.t0 2.0329
Rpar16 out out.t0 184.2645
Rpar17 out out.t3 213.8744
Rpar18 out out.t2 2.7290
Rpar19 out.t0 out.t3 160.2456
Rpar20 out.t0 out.t2 74.7329
Rpar21 out.t3 out.t2 86.7419
Rpar22 vdd vdd.t0 58.5366
Rpar23 vdd vdd.t1 118.8099
Rpar24 vdd.t0 vdd.t1 3.4233
Rpar25 vss vss.t0 350.9132
Rpar26 vss vss.t1 179.4715
Rpar27 vss vss.t6 233.2587
Rpar28 vss vss.t5 380.8143
Rpar29 vss.t0 vss.t1 9.2709
Rpar30 vss.t0 vss.t6 104.3578
Rpar31 vss.t0 vss.t5 26.8922
Rpar32 vss.t1 vss.t6 17.2316
Rpar33 vss.t1 vss.t5 2.2633
Rpar34 vss.t6 vss.t5 29.4472
Cpar0 a_1009_5363.t0 vss 2.67591e-15
Cpar1 a_1009_5363.t1 vss 3.68744e-15
Cpar2 a_1009_5363.t5 vss 4.00564e-15
Cpar3 a_1009_5363.t7 vss 1.54953e-14
Cpar4 a_1009_5883.t0 vss 4.45000e-17
Cpar5 a_1009_6923.t0 vss 2.12460e-16
Cpar6 a_1009_6923.t1 vss 9.10897e-15
Cpar7 a_3810_3566.t0 vss 9.36564e-15
Cpar8 a_3810_3566.t4 vss 1.45668e-14
Cpar9 a_4399_5363.t0 vss 4.25800e-17
Cpar10 a_4399_6403.t0 vss 3.64200e-17
Cpar11 a_7240_1085.t0 vss 3.42257e-15
Cpar12 a_7240_1085.t4 vss 7.21378e-15
Cpar13 a_7240_1085.t5 vss 3.05181e-15
Cpar14 ib inn 2.69100e-17
Cpar15 ib inp 1.03400e-17
Cpar16 ib out 2.40897e-15
Cpar17 ib vdd 2.55430e-16
Cpar18 ib vss 4.73641e-14
Cpar19 ib.t0 vss 8.49780e-15
Cpar20 ib.t1 vss 6.85260e-16
Cpar21 inn inp 5.21200e-17
Cpar22 inn vdd 1.44850e-16
Cpar23 inn vss 9.59499e-15
Cpar24 inn.t0 vss 1.30453e-15
Cpar25 inp vdd 1.77600e-17
Cpar26 inp vss 9.74371e-15
Cpar27 inp.t0 vss 1.23504e-15
Cpar28 out vdd 9.59613e-15
Cpar29 out vss 2.08532e-14
Cpar30 out.t0 vss 1.61302e-14
Cpar31 out.t2 vss 4.15203e-15
Cpar32 out.t3 vss 6.70256e-15
Cpar33 vdd vss 7.56963e-14
Cpar34 vdd.t0 vss 1.88209e-14
Cpar35 vdd.t1 vss 1.10579e-14
.ends opamp_dut

Vdd vdd 0 3.300000
Vss vss 0 0
Ibias vdd ib 3.714000e-07
Vinp inp 0 DC 1.645000 AC 1 PWL(0 1.645000 1.137105e-07 1.645000 1.250816e-07 1.655000)
Rfb out inn 1m
Cload out 0 2.000000e-12
Xdut vdd vss inp inn out ib opamp_dut
.end
