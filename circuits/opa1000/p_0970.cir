* opa1000[0970]: 2p/telescopic_pmos_1v8_1u_10u_subth (telescopic_pmos, VDD=1.8V, CL=2.0pF, Iref=0.85uA)
.include "pdk_opa.inc"
.temp 27
.option gmin=1e-12 rshunt=1e12 reltol=1e-3 abstol=1e-12 vntol=1e-5 method=gear
* Post-PEX R+C extracted netlist for telescopic_pmos_1v8_1u_10u_subth
.subckt opamp_dut vdd vss inp inn out ib
XMpar0 a_2082_5246.t48 vss.t40 a_2522_5246.t24 vdd.t2 pfet_03v3 w=2.5u l=1.6u ad=7.7500e-13 pd=3.3544e-06 as=7.5000e-13 ps=3.2562e-06 nf=1 m=64 par=64
XMpar1 a_8230_10070.t48 vss.t40 out.t0 vdd.t2 pfet_03v3 w=2.5u l=1.6u ad=7.7500e-13 pd=3.3544e-06 as=7.5000e-13 ps=3.2562e-06 nf=1 m=64 par=64
XMpar2 a_3346_15392.t0 inn.t0 a_8230_10070.t0 vdd.t3 pfet_03v3 w=1.98u l=0.8u ad=6.3360e-13 pd=2.8675e-06 as=5.5440e-13 ps=2.5400e-06 nf=1 m=48 par=48
XMpar3 a_2082_5246.t0 inp.t0 a_3346_15392.t0 vdd.t3 pfet_03v3 w=1.98u l=0.8u ad=5.5440e-13 pd=2.5400e-06 as=6.3360e-13 ps=2.8675e-06 nf=1 m=48 par=48
XMpar4 ib.t1 ib.t0 vss.t9 vss.t8 nfet_03v3 w=3.02u l=2.5u ad=1.8120e-12 pd=7.2400e-06 as=8.4560e-13 ps=3.5800e-06 nf=1 m=2 par=2
XMpar5 a_5404_3179.t0 a_2522_5246.t0 out.t1 vss.t0 nfet_03v3 w=2.08u l=1.6u ad=6.9333e-13 pd=3.0933e-06 as=5.8240e-13 ps=2.6400e-06 nf=1 m=12 par=12
XMpar6 a_2522_5246.t1 a_2522_5246.t0 a_2535_3179.t1 vss.t0 nfet_03v3 w=2.08u l=1.6u ad=5.8240e-13 pd=2.6400e-06 as=8.0427e-13 ps=3.5467e-06 nf=1 m=12 par=12
XMpar7 a_3346_15392.t96 a_2270_11900.t2 vdd.t1 vdd.t0 pfet_03v3 w=10u l=2.5u ad=2.8000e-12 pd=1.0560e-05 as=3.6000e-12 ps=1.3220e-05 nf=1 m=8 par=8
XMpar8 a_2270_11900.t3 a_2270_11900.t2 vdd.t1 vdd.t0 pfet_03v3 w=10u l=2.5u ad=2.8000e-12 pd=1.0560e-05 as=2.8000e-12 ps=1.0560e-05 nf=1 m=2 par=2
XMpar9 a_2535_3179.t0 a_2522_5246.t88 vss.t4 vss.t3 nfet_03v3 w=2.42u l=1.6u ad=1.4520e-12 pd=6.0400e-06 as=6.7760e-13 ps=2.9800e-06 nf=1 m=2 par=2
XMpar10 a_2270_11900.t0 ib.t0 vss.t9 vss.t8 nfet_03v3 w=3.02u l=2.5u ad=8.4560e-13 pd=3.5800e-06 as=8.4560e-13 ps=3.5800e-06 nf=1 m=2 par=2
XMpar11 a_5404_3179.t12 a_2522_5246.t88 vss.t4 vss.t3 nfet_03v3 w=2.42u l=1.6u ad=6.7760e-13 pd=2.9800e-06 as=6.7760e-13 ps=2.9800e-06 nf=1 m=2 par=2
Rpar0 a_2082_5246.t0 a_2082_5246.t48 52.3035
Rpar1 a_2270_11900.t0 a_2270_11900.t2 84.5612
Rpar2 a_2270_11900.t0 a_2270_11900.t3 55.5178
Rpar3 a_2270_11900.t2 a_2270_11900.t3 27.3844
Rpar4 a_2522_5246.t0 a_2522_5246.t1 15.2823
Rpar5 a_2522_5246.t0 a_2522_5246.t24 329.8836
Rpar6 a_2522_5246.t0 a_2522_5246.t88 446.0041
Rpar7 a_2522_5246.t1 a_2522_5246.t24 95.3379
Rpar8 a_2522_5246.t1 a_2522_5246.t88 128.8972
Rpar9 a_2522_5246.t24 a_2522_5246.t88 159.4982
Rpar10 a_2535_3179.t0 a_2535_3179.t1 62.3042
Rpar11 a_3346_15392.t0 a_3346_15392.t96 37.1572
Rpar12 a_5404_3179.t0 a_5404_3179.t12 66.8570
Rpar13 a_8230_10070.t0 a_8230_10070.t48 52.3035
Rpar14 ib ib.t0 13.1362
Rpar15 ib ib.t1 3.9412
Rpar16 inn inn.t0 1.5912
Rpar17 inp inp.t0 1.5912
Rpar18 out out.t0 2.3735
Rpar19 out out.t1 56.3529
Rpar20 vdd vdd.t0 165.1121
Rpar21 vdd vdd.t1 819.8297
Rpar22 vdd vdd.t3 21.6365
Rpar23 vdd vdd.t2 772.4175
Rpar24 vdd.t0 vdd.t1 6.0145
Rpar25 vdd.t0 vdd.t3 62.0914
Rpar26 vdd.t0 vdd.t2 55.0648
Rpar27 vdd.t1 vdd.t3 308.3020
Rpar28 vdd.t1 vdd.t2 273.4129
Rpar29 vdd.t3 vdd.t2 290.4724
Rpar30 vss vss.t0 47.5921
Rpar31 vss vss.t8 676.1601
Rpar32 vss vss.t40 216.0955
Rpar33 vss vss.t9 486.2548
Rpar34 vss vss.t3 186.6518
Rpar35 vss vss.t4 301.9053
Rpar36 vss.t0 vss.t8 471.3975
Rpar37 vss.t0 vss.t40 152.1703
Rpar38 vss.t0 vss.t9 339.4265
Rpar39 vss.t0 vss.t3 3.5263
Rpar40 vss.t0 vss.t4 10.6379
Rpar41 vss.t8 vss.t40 149.2382
Rpar42 vss.t8 vss.t9 13.3972
Rpar43 vss.t8 vss.t3 2202.5642
Rpar44 vss.t40 vss.t9 107.3140
Rpar45 vss.t40 vss.t3 710.3512
Rpar46 vss.t40 vss.t4 1987.3492
Rpar47 vss.t9 vss.t3 1585.7594
Rpar48 vss.t3 vss.t4 26.9452
Cpar0 a_2082_5246.t0 vss 2.71204e-14
Cpar1 a_2082_5246.t48 vss 4.38071e-14
Cpar2 a_2270_11900.t0 vss 1.75542e-15
Cpar3 a_2270_11900.t2 vss 2.82191e-14
Cpar4 a_2270_11900.t3 vss 3.62601e-15
Cpar5 a_2522_5246.t0 vss 1.94654e-14
Cpar6 a_2522_5246.t1 vss 7.78606e-15
Cpar7 a_2522_5246.t24 vss 2.91662e-14
Cpar8 a_2522_5246.t88 vss 5.21028e-15
Cpar9 a_2535_3179.t0 vss 3.61558e-15
Cpar10 a_2535_3179.t1 vss 1.00671e-14
Cpar11 a_3346_15392.t0 vss 5.77788e-14
Cpar12 a_3346_15392.t96 vss 1.85716e-14
Cpar13 a_5404_3179.t0 vss 1.42222e-14
Cpar14 a_5404_3179.t12 vss 4.74429e-15
Cpar15 a_8230_10070.t0 vss 2.71219e-14
Cpar16 a_8230_10070.t48 vss 4.38089e-14
Cpar17 ib vdd 5.97000e-17
Cpar18 ib vss 1.02861e-14
Cpar19 ib.t0 vss 1.16736e-15
Cpar20 ib.t1 vss 2.30850e-16
Cpar21 inn inp 1.56820e-16
Cpar22 inn vdd 2.25470e-14
Cpar23 inn vss 5.68620e-15
Cpar24 inn.t0 vss 3.22667e-14
Cpar25 inp vdd 2.26898e-14
Cpar26 inp vss 5.71070e-15
Cpar27 inp.t0 vss 3.23144e-14
Cpar28 out vdd 1.03923e-14
Cpar29 out vss 3.20634e-14
Cpar30 out.t0 vss 3.54635e-14
Cpar31 out.t1 vss 1.02030e-14
Cpar32 vdd vss 5.64218e-13
Cpar33 vdd.t0 vss 1.65654e-14
Cpar34 vdd.t1 vss 6.22048e-15
Cpar35 vdd.t2 vss 6.72392e-14
Cpar36 vdd.t3 vss 3.26399e-14
.ends opamp_dut

Vdd vdd 0 1.800000
Vss vss 0 0
Ibias vdd ib 8.500000e-07
Vinp inp 0 DC 0.805000 AC 1 PWL(0 0.805000 3.827905e-08 0.805000 4.210695e-08 0.815000)
Rfb out inn 1m
Cload out 0 2.000000e-12
Xdut vdd vss inp inn out ib opamp_dut
.end
