* opa1000[0983]: 2p/telescopic_pmos_3v3_i200n_weak (telescopic_pmos, VDD=3.3V, CL=2.0pF, Iref=0.052uA)
.include "pdk_opa.inc"
.temp 27
.option gmin=1e-12 rshunt=1e12 reltol=1e-3 abstol=1e-12 vntol=1e-5 method=gear
* Post-PEX R+C extracted netlist for telescopic_pmos_3v3_i200n_weak
.subckt opamp_dut vdd vss inp inn out ib
XMpar0 a_2822_10434.t0 a_4372_13960.t2 vdd.t1 vdd.t0 pfet_03v3 w=0.79u l=7.5u ad=2.2120e-13 pd=1.3500e-06 as=4.1080e-13 ps=2.4225e-06 nf=1 m=8 par=8
XMpar1 a_4242_10434.t8 a_5032_996.t0 a_5032_996.t1 vdd.t7 pfet_03v3 w=1.79u l=4.2u ad=1.0740e-12 pd=4.7800e-06 as=1.0740e-12 ps=4.7800e-06 nf=1 m=2 par=2
XMpar2 a_4912_1204.t1 a_5032_996.t8 vss.t10 vss.t9 nfet_03v3 w=0.4u l=5.2u ad=2.4000e-13 pd=2.0000e-06 as=1.1200e-13 ps=9.6000e-07 nf=1 m=2 par=2
XMpar3 a_6404_2910.t0 a_5032_996.t8 vss.t10 vss.t9 nfet_03v3 w=0.4u l=5.2u ad=1.1200e-13 pd=9.6000e-07 as=1.1200e-13 ps=9.6000e-07 nf=1 m=2 par=2
XMpar4 a_4372_13960.t3 a_4372_13960.t2 vdd.t1 vdd.t0 pfet_03v3 w=0.79u l=7.5u ad=4.7400e-13 pd=2.7800e-06 as=2.2120e-13 ps=1.3500e-06 nf=1 m=2 par=2
XMpar5 a_2822_10434.t1 inp.t0 a_4242_10434.t0 vdd.t2 pfet_03v3 w=1.65u l=6.5u ad=7.2600e-13 pd=3.3550e-06 as=5.9400e-13 ps=2.7825e-06 nf=1 m=8 par=8
XMpar6 a_2822_10434.t1 inn.t0 a_7374_10434.t0 vdd.t2 pfet_03v3 w=1.65u l=6.5u ad=7.2600e-13 pd=3.3550e-06 as=5.9400e-13 ps=2.7825e-06 nf=1 m=8 par=8
XMpar7 ib.t1 ib.t0 vss.t2 vss.t1 nfet_03v3 w=0.4u l=7.5u ad=2.4000e-13 pd=2.0000e-06 as=1.1200e-13 ps=9.6000e-07 nf=1 m=2 par=2
XMpar8 a_7374_10434.t8 a_5032_996.t0 out.t0 vdd.t7 pfet_03v3 w=1.79u l=4.2u ad=1.0740e-12 pd=4.7800e-06 as=1.0740e-12 ps=4.7800e-06 nf=1 m=2 par=2
XMpar9 a_4912_1204.t0 a_5032_996.t4 a_5032_996.t5 vss.t0 nfet_03v3 w=0.47u l=4.2u ad=2.8200e-13 pd=2.1400e-06 as=2.8200e-13 ps=2.1400e-06 nf=1 m=2 par=2
XMpar10 a_4372_13960.t0 ib.t0 vss.t2 vss.t1 nfet_03v3 w=0.4u l=7.5u ad=1.1200e-13 pd=9.6000e-07 as=1.1200e-13 ps=9.6000e-07 nf=1 m=2 par=2
XMpar11 a_6404_2910.t1 a_5032_996.t4 out.t1 vss.t0 nfet_03v3 w=0.47u l=4.2u ad=2.8200e-13 pd=2.1400e-06 as=1.3160e-13 ps=1.0300e-06 nf=1 m=2 par=2
X11 out.t4 vss.t14 cap_mim_2f0fF c_width=9u c_length=9u
Rpar0 a_2822_10434.t0 a_2822_10434.t1 59.9984
Rpar1 a_4242_10434.t0 a_4242_10434.t8 76.6245
Rpar2 a_4372_13960.t0 a_4372_13960.t2 131.3039
Rpar3 a_4372_13960.t0 a_4372_13960.t3 197.3404
Rpar4 a_4372_13960.t2 a_4372_13960.t3 15.1384
Rpar5 a_4912_1204.t0 a_4912_1204.t1 57.0599
Rpar6 a_5032_996.t0 a_5032_996.t1 13.1424
Rpar7 a_5032_996.t0 a_5032_996.t8 330.6246
Rpar8 a_5032_996.t0 a_5032_996.t4 276.4693
Rpar9 a_5032_996.t0 a_5032_996.t5 211.9199
Rpar10 a_5032_996.t1 a_5032_996.t8 233.1563
Rpar11 a_5032_996.t1 a_5032_996.t4 194.9660
Rpar12 a_5032_996.t1 a_5032_996.t5 149.4458
Rpar13 a_5032_996.t8 a_5032_996.t4 186.3672
Rpar14 a_5032_996.t8 a_5032_996.t5 142.8547
Rpar15 a_5032_996.t4 a_5032_996.t5 26.1628
Rpar16 a_6404_2910.t0 a_6404_2910.t1 73.6183
Rpar17 a_7374_10434.t0 a_7374_10434.t8 55.0915
Rpar18 ib ib.t0 21.8108
Rpar19 ib ib.t1 10.1368
Rpar20 ib.t0 ib.t1 58.4563
Rpar21 inn inn.t0 2.2124
Rpar22 inp inp.t0 2.2124
Rpar23 out out.t0 8.1605
Rpar24 out out.t1 170.4849
Rpar25 out out.t4 142.9452
Rpar26 out.t0 out.t1 190.7739
Rpar27 out.t0 out.t4 159.9567
Rpar28 out.t1 out.t4 178.8985
Rpar29 vdd vdd.t0 24.8415
Rpar30 vdd vdd.t1 249.4687
Rpar31 vdd vdd.t2 133.6638
Rpar32 vdd vdd.t7 192.4342
Rpar33 vdd.t0 vdd.t1 13.0143
Rpar34 vdd.t0 vdd.t2 390.3096
Rpar35 vdd.t0 vdd.t7 561.9240
Rpar36 vdd.t1 vdd.t2 3919.6546
Rpar37 vdd.t1 vdd.t7 5643.0794
Rpar38 vdd.t2 vdd.t7 39.0016
Rpar39 vss vss.t0 102.8306
Rpar40 vss vss.t1 135.4666
Rpar41 vss vss.t10 375.2767
Rpar42 vss vss.t9 105.0246
Rpar43 vss vss.t14 257.4723
Rpar44 vss vss.t2 701.3897
Rpar45 vss.t0 vss.t1 9.1884
Rpar46 vss.t0 vss.t10 27.4393
Rpar47 vss.t0 vss.t9 4.5668
Rpar48 vss.t0 vss.t14 200.0293
Rpar49 vss.t0 vss.t2 46.5986
Rpar50 vss.t1 vss.t10 45.8551
Rpar51 vss.t1 vss.t9 7.5590
Rpar52 vss.t1 vss.t14 188.4718
Rpar53 vss.t1 vss.t2 28.5934
Rpar54 vss.t10 vss.t9 29.7112
Rpar55 vss.t10 vss.t14 824.8017
Rpar56 vss.t10 vss.t2 248.8192
Rpar57 vss.t9 vss.t14 173.8995
Rpar58 vss.t9 vss.t2 31.5824
Rpar59 vss.t14 vss.t2 762.1725
Cpar0 a_2822_10434.t0 vss 1.93483e-14
Cpar1 a_2822_10434.t1 vss 3.19061e-14
Cpar2 a_4242_10434.t0 vss 1.67119e-14
Cpar3 a_4242_10434.t8 vss 9.98059e-15
Cpar4 a_4372_13960.t0 vss 7.01951e-15
Cpar5 a_4372_13960.t2 vss 4.78265e-14
Cpar6 a_4372_13960.t3 vss 8.71586e-15
Cpar7 a_4912_1204.t0 vss 3.52333e-15
Cpar8 a_4912_1204.t1 vss 3.61084e-15
Cpar9 a_5032_996.t0 vss 9.04170e-15
Cpar10 a_5032_996.t1 vss 3.35593e-15
Cpar11 a_5032_996.t4 vss 5.80185e-15
Cpar12 a_5032_996.t5 vss 2.06897e-15
Cpar13 a_5032_996.t8 vss 6.74293e-15
Cpar14 a_6404_2910.t0 vss 4.06687e-15
Cpar15 a_6404_2910.t1 vss 5.05147e-15
Cpar16 a_7374_10434.t0 vss 1.86162e-14
Cpar17 a_7374_10434.t8 vss 1.07445e-14
Cpar18 ib inn 2.86300e-17
Cpar19 ib inp 2.31900e-17
Cpar20 ib out 2.92200e-17
Cpar21 ib vdd 2.93880e-16
Cpar22 ib vss 2.07122e-14
Cpar23 ib.t0 vss 2.73991e-15
Cpar24 ib.t1 vss 1.64140e-16
Cpar25 inn inp 1.06710e-16
Cpar26 inn vdd 2.03049e-14
Cpar27 inn vss 5.15270e-15
Cpar28 inn.t0 vss 2.40536e-14
Cpar29 inp vdd 2.00808e-14
Cpar30 inp vss 5.15040e-15
Cpar31 inp.t0 vss 2.38334e-14
Cpar32 out vdd 4.29093e-15
Cpar33 out vss 1.26423e-14
Cpar34 out.t0 vss 1.07630e-15
Cpar35 out.t1 vss 1.41604e-15
Cpar36 out.t4 vss 1.05219e-14
Cpar37 vdd vss 2.55842e-13
Cpar38 vdd.t0 vss 4.18748e-14
Cpar39 vdd.t1 vss 6.73079e-15
Cpar40 vdd.t2 vss 5.82604e-14
Cpar41 vdd.t7 vss 1.83974e-14
.ends opamp_dut

Vdd vdd 0 3.300000
Vss vss 0 0
Ibias vdd ib 5.200000e-08
Vinp inp 0 DC 1.480000 AC 1 PWL(0 1.480000 6.719301e-07 1.480000 7.391232e-07 1.490000)
Rfb out inn 1m
Cload out 0 2.000000e-12
Xdut vdd vss inp inn out ib opamp_dut
.end
