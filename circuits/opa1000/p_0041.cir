* opa1000[0041]: 2p/cherry_hooper_1v8_ulp_lt0p1uw_weak (cherry_hooper, VDD=1.8V, CL=2.0pF, Iref=0.0001uA)
.include "pdk_opa.inc"
.temp 27
.option gmin=1e-12 rshunt=1e12 reltol=1e-3 abstol=1e-12 vntol=1e-5 method=gear
* Post-PEX R+C extracted netlist for cherry_hooper_1v8_ulp_lt0p1uw_weak
.subckt opamp_dut vdd vss inp inn out ib
XMpar0 a_9479_10323.t0 ib.t0 vss.t9 vss.t0 nfet_03v3 w=0.4u l=5u ad=1.1200e-13 pd=9.6000e-07 as=1.5467e-13 ps=1.3067e-06 nf=1 m=6 par=6
XMpar1 a_12174_1250.t1 inn.t0 a_9634_8823.t0 vss.t0 nfet_03v3 w=0.4u l=5u ad=1.1200e-13 pd=9.6000e-07 as=2.4000e-13 ps=2.0000e-06 nf=1 m=2 par=2
XMpar2 a_11040_4160.t2 a_11040_4160.t1 vdd.t6 vdd.t5 pfet_03v3 w=0.4u l=1.3u ad=1.5467e-13 pd=1.3067e-06 as=1.1200e-13 ps=9.6000e-07 nf=1 m=3 par=3
XMpar3 out.t0 a_11040_4160.t1 vdd.t6 vdd.t5 pfet_03v3 w=0.4u l=1.3u ad=1.5467e-13 pd=1.3067e-06 as=1.1200e-13 ps=9.6000e-07 nf=1 m=3 par=3
XMpar4 a_1130_10278.t2 a_1130_10278.t1 vdd.t6 vdd.t5 pfet_03v3 w=0.4u l=1.3u ad=2.4000e-13 pd=2.0000e-06 as=2.4000e-13 ps=2.0000e-06 nf=1 m=1
XMpar5 a_9634_8823.t0 ib.t0 vss.t9 vss.t0 nfet_03v3 w=0.4u l=5u ad=2.4000e-13 pd=2.0000e-06 as=1.1200e-13 ps=9.6000e-07 nf=1 m=2 par=2
XMpar6 a_10746_5822.t0 ib.t0 vss.t9 vss.t0 nfet_03v3 w=0.4u l=5u ad=2.4000e-13 pd=2.0000e-06 as=1.7600e-13 ps=1.4800e-06 nf=1 m=4 par=4
XMpar7 a_10746_5822.t0 a_12174_1250.t4 a_12174_5822.t4 vss.t0 nfet_03v3 w=0.4u l=5u ad=2.4000e-13 pd=2.0000e-06 as=2.4000e-13 ps=2.0000e-06 nf=1 m=1
XMpar8 a_11040_4160.t0 a_4921_2497.t6 a_9479_10323.t0 vss.t0 nfet_03v3 w=0.4u l=5u ad=2.4000e-13 pd=2.0000e-06 as=2.4000e-13 ps=2.0000e-06 nf=1 m=1
XMpar9 a_10746_5822.t0 a_10754_8823.t4 a_4921_2497.t4 vss.t0 nfet_03v3 w=0.4u l=5u ad=2.4000e-13 pd=2.0000e-06 as=2.4000e-13 ps=2.0000e-06 nf=1 m=1
XMpar10 a_1323_2542.t2 a_1323_2542.t1 vdd.t2 vdd.t1 pfet_03v3 w=0.4u l=5u ad=2.4000e-13 pd=2.0000e-06 as=2.4000e-13 ps=2.0000e-06 nf=1 m=1
XMpar11 a_12174_5822.t1 a_12174_5822.t0 vdd.t6 vdd.t5 pfet_03v3 w=0.4u l=1.3u ad=1.1200e-13 pd=9.6000e-07 as=2.4000e-13 ps=2.0000e-06 nf=1 m=2 par=2
XMpar12 a_4921_2497.t1 a_4921_2497.t0 vdd.t6 vdd.t5 pfet_03v3 w=0.4u l=1.3u ad=1.1200e-13 pd=9.6000e-07 as=2.4000e-13 ps=2.0000e-06 nf=1 m=2 par=2
XMpar13 a_10754_8823.t1 inp.t0 a_9634_8823.t0 vss.t0 nfet_03v3 w=0.4u l=5u ad=1.1200e-13 pd=9.6000e-07 as=2.4000e-13 ps=2.0000e-06 nf=1 m=2 par=2
XMpar14 a_10754_8823.t3 a_1250_10070.t3 a_4921_2497.t5 vdd.t15 pfet_03v3 w=0.4u l=16u ad=2.4000e-13 pd=2.0000e-06 as=2.4000e-13 ps=2.0000e-06 nf=1 m=1
XMpar15 ib.t1 ib.t0 vss.t9 vss.t0 nfet_03v3 w=0.4u l=5u ad=2.4000e-13 pd=2.0000e-06 as=1.1200e-13 ps=9.6000e-07 nf=1 m=1
XMpar16 a_12174_1250.t3 a_1250_10070.t3 a_12174_5822.t5 vdd.t15 pfet_03v3 w=0.4u l=16u ad=2.4000e-13 pd=2.0000e-06 as=2.4000e-13 ps=2.0000e-06 nf=1 m=1
XMpar17 a_9479_10323.t0 a_12174_5822.t6 out.t3 vss.t0 nfet_03v3 w=0.4u l=5u ad=2.4000e-13 pd=2.0000e-06 as=2.4000e-13 ps=2.0000e-06 nf=1 m=1
XMpar18 a_1323_2542.t0 ib.t0 vss.t9 vss.t0 nfet_03v3 w=0.4u l=5u ad=2.4000e-13 pd=2.0000e-06 as=1.1200e-13 ps=9.6000e-07 nf=1 m=1
XMpar19 a_1130_10278.t0 a_1250_10070.t1 a_1250_10070.t2 vdd.t0 pfet_03v3 w=0.51u l=1u ad=3.0600e-13 pd=2.2200e-06 as=3.0600e-13 ps=2.2200e-06 nf=1 m=1
XMpar20 a_12174_1250.t0 a_1323_2542.t1 vdd.t2 vdd.t1 pfet_03v3 w=0.4u l=5u ad=2.4000e-13 pd=2.0000e-06 as=2.4000e-13 ps=2.0000e-06 nf=1 m=1
XMpar21 a_10754_8823.t0 a_1323_2542.t1 vdd.t2 vdd.t1 pfet_03v3 w=0.4u l=5u ad=2.4000e-13 pd=2.0000e-06 as=2.4000e-13 ps=2.0000e-06 nf=1 m=1
XMpar22 a_1250_10070.t0 ib.t0 vss.t9 vss.t0 nfet_03v3 w=0.4u l=5u ad=2.4000e-13 pd=2.0000e-06 as=2.4000e-13 ps=2.0000e-06 nf=1 m=1
X30 out.t4 vss.t6 cap_mim_2f0fF c_width=14.58u c_length=14.58u
X39 out.t4 vss.t6 cap_mim_2f0fF c_width=14.58u c_length=14.58u
Rpar0 a_10754_8823.t0 a_10754_8823.t1 120.7278
Rpar1 a_10754_8823.t0 a_10754_8823.t3 414.2862
Rpar2 a_10754_8823.t0 a_10754_8823.t4 73.0830
Rpar3 a_10754_8823.t1 a_10754_8823.t3 709.6148
Rpar4 a_10754_8823.t1 a_10754_8823.t4 125.1811
Rpar5 a_10754_8823.t3 a_10754_8823.t4 139.8201
Rpar6 a_11040_4160.t0 a_11040_4160.t1 215.4972
Rpar7 a_11040_4160.t0 a_11040_4160.t2 133.8427
Rpar8 a_11040_4160.t1 a_11040_4160.t2 19.8145
Rpar9 a_1130_10278.t0 a_1130_10278.t1 255.9773
Rpar10 a_1130_10278.t0 a_1130_10278.t2 142.3049
Rpar11 a_1130_10278.t1 a_1130_10278.t2 48.9860
Rpar12 a_12174_1250.t0 a_12174_1250.t1 132.9273
Rpar13 a_12174_1250.t0 a_12174_1250.t3 175.2006
Rpar14 a_12174_1250.t0 a_12174_1250.t4 103.2316
Rpar15 a_12174_1250.t1 a_12174_1250.t3 369.4917
Rpar16 a_12174_1250.t1 a_12174_1250.t4 217.7117
Rpar17 a_12174_1250.t3 a_12174_1250.t4 100.1492
Rpar18 a_12174_5822.t0 a_12174_5822.t1 36.1242
Rpar19 a_12174_5822.t0 a_12174_5822.t4 422.1751
Rpar20 a_12174_5822.t0 a_12174_5822.t5 252.6693
Rpar21 a_12174_5822.t0 a_12174_5822.t6 385.5257
Rpar22 a_12174_5822.t1 a_12174_5822.t4 295.1839
Rpar23 a_12174_5822.t1 a_12174_5822.t5 176.6659
Rpar24 a_12174_5822.t1 a_12174_5822.t6 269.5588
Rpar25 a_12174_5822.t4 a_12174_5822.t5 641.3653
Rpar26 a_12174_5822.t4 a_12174_5822.t6 151.6343
Rpar27 a_12174_5822.t5 a_12174_5822.t6 585.6878
Rpar28 a_1250_10070.t0 a_1250_10070.t1 306.2092
Rpar29 a_1250_10070.t0 a_1250_10070.t2 138.7004
Rpar30 a_1250_10070.t0 a_1250_10070.t3 223.5934
Rpar31 a_1250_10070.t1 a_1250_10070.t2 53.8917
Rpar32 a_1250_10070.t1 a_1250_10070.t3 423.0858
Rpar33 a_1250_10070.t2 a_1250_10070.t3 191.6407
Rpar34 a_1323_2542.t0 a_1323_2542.t1 81.5614
Rpar35 a_1323_2542.t0 a_1323_2542.t2 558.7038
Rpar36 a_1323_2542.t1 a_1323_2542.t2 29.3415
Rpar37 a_4921_2497.t0 a_4921_2497.t1 34.3462
Rpar38 a_4921_2497.t0 a_4921_2497.t4 574.6593
Rpar39 a_4921_2497.t0 a_4921_2497.t5 248.1488
Rpar40 a_4921_2497.t0 a_4921_2497.t6 1398.0734
Rpar41 a_4921_2497.t1 a_4921_2497.t4 401.8005
Rpar42 a_4921_2497.t1 a_4921_2497.t5 173.5051
Rpar43 a_4921_2497.t1 a_4921_2497.t6 977.5299
Rpar44 a_4921_2497.t4 a_4921_2497.t5 121.5822
Rpar45 a_4921_2497.t4 a_4921_2497.t6 179.8491
Rpar46 a_4921_2497.t5 a_4921_2497.t6 295.7942
Rpar47 ib ib.t0 2.4448
Rpar48 ib.t0 ib.t1 23.3959
Rpar49 inn inn.t0 3.1042
Rpar50 inp inp.t0 3.1527
Rpar51 out out.t0 88.2059
Rpar52 out out.t3 146.7047
Rpar53 out out.t4 17.3401
Rpar54 out.t0 out.t3 433.2356
Rpar55 out.t0 out.t4 439.4953
Rpar56 out.t3 out.t4 730.9720
Rpar57 vdd vdd.t0 168.3172
Rpar58 vdd vdd.t1 678.1624
Rpar59 vdd vdd.t6 454.3067
Rpar60 vdd vdd.t5 350.6550
Rpar61 vdd vdd.t15 737.1879
Rpar62 vdd vdd.t2 234.4030
Rpar63 vdd.t0 vdd.t1 1951.5311
Rpar64 vdd.t0 vdd.t6 1307.3473
Rpar65 vdd.t0 vdd.t5 1009.0711
Rpar66 vdd.t0 vdd.t15 2121.3875
Rpar67 vdd.t0 vdd.t2 674.5358
Rpar68 vdd.t1 vdd.t6 236.4898
Rpar69 vdd.t1 vdd.t5 197.3265
Rpar70 vdd.t1 vdd.t15 571.9248
Rpar71 vdd.t1 vdd.t2 19.3747
Rpar72 vdd.t6 vdd.t5 4.2773
Rpar73 vdd.t6 vdd.t15 82.5263
Rpar74 vdd.t6 vdd.t2 129.0625
Rpar75 vdd.t5 vdd.t15 77.6562
Rpar76 vdd.t5 vdd.t2 104.6655
Rpar77 vdd.t15 vdd.t2 265.6775
Rpar78 vss vss.t0 108.3590
Rpar79 vss vss.t9 169.8727
Rpar80 vss vss.t6 4356.6535
Rpar81 vss.t0 vss.t9 3.1401
Rpar82 vss.t0 vss.t6 73.9849
Rpar83 vss.t9 vss.t6 863.8420
Cpar0 a_10746_5822.t0 vss 1.02628e-14
Cpar1 a_10754_8823.t0 vss 2.85321e-15
Cpar2 a_10754_8823.t1 vss 3.10977e-15
Cpar3 a_10754_8823.t3 vss 4.78696e-15
Cpar4 a_10754_8823.t4 vss 6.13131e-15
Cpar5 a_11040_4160.t0 vss 5.32435e-15
Cpar6 a_11040_4160.t1 vss 7.09639e-15
Cpar7 a_11040_4160.t2 vss 5.09408e-15
Cpar8 a_1130_10278.t0 vss 3.66903e-15
Cpar9 a_1130_10278.t1 vss 1.76374e-15
Cpar10 a_1130_10278.t2 vss 2.73834e-15
Cpar11 a_12174_1250.t0 vss 2.47796e-15
Cpar12 a_12174_1250.t1 vss 2.59774e-15
Cpar13 a_12174_1250.t3 vss 2.79760e-15
Cpar14 a_12174_1250.t4 vss 4.17799e-15
Cpar15 a_12174_5822.t0 vss 2.47106e-15
Cpar16 a_12174_5822.t1 vss 2.40654e-15
Cpar17 a_12174_5822.t4 vss 2.27739e-15
Cpar18 a_12174_5822.t5 vss 2.79384e-15
Cpar19 a_12174_5822.t6 vss 4.72334e-15
Cpar20 a_1250_10070.t0 vss 5.91653e-15
Cpar21 a_1250_10070.t1 vss 2.68036e-15
Cpar22 a_1250_10070.t2 vss 5.04821e-15
Cpar23 a_1250_10070.t3 vss 1.80828e-14
Cpar24 a_1323_2542.t0 vss 5.66437e-15
Cpar25 a_1323_2542.t1 vss 1.73180e-14
Cpar26 a_1323_2542.t2 vss 3.44753e-15
Cpar27 a_4921_2497.t0 vss 3.13937e-15
Cpar28 a_4921_2497.t1 vss 2.80262e-15
Cpar29 a_4921_2497.t4 vss 5.00297e-15
Cpar30 a_4921_2497.t5 vss 5.34234e-15
Cpar31 a_4921_2497.t6 vss 7.76978e-15
Cpar32 a_9479_10323.t0 vss 5.12594e-15
Cpar33 a_9634_8823.t0 vss 9.75546e-15
Cpar34 ib inn 1.19300e-17
Cpar35 ib inp 1.14900e-17
Cpar36 ib out 2.28300e-16
Cpar37 ib vdd 7.71740e-16
Cpar38 ib vss 5.00337e-14
Cpar39 ib.t0 vss 1.00424e-14
Cpar40 ib.t1 vss 5.62844e-16
Cpar41 inn inp 5.12600e-17
Cpar42 inn vdd 2.10600e-17
Cpar43 inn vss 5.45630e-15
Cpar44 inn.t0 vss 4.31557e-16
Cpar45 inp vdd 3.16700e-17
Cpar46 inp vss 5.42967e-15
Cpar47 inp.t0 vss 4.45797e-16
Cpar48 out vdd 5.32581e-15
Cpar49 out vss 1.78392e-14
Cpar50 out.t0 vss 3.76827e-16
Cpar51 out.t3 vss 4.14171e-16
Cpar52 out.t4 vss 1.40738e-14
Cpar53 vdd vss 1.31865e-13
Cpar54 vdd.t0 vss 2.90721e-15
Cpar55 vdd.t1 vss 6.16239e-15
Cpar56 vdd.t15 vss 1.31074e-14
Cpar57 vdd.t2 vss 9.29639e-15
Cpar58 vdd.t5 vss 1.69686e-14
Cpar59 vdd.t6 vss 1.27785e-14
.ends opamp_dut

Vdd vdd 0 1.800000
Vss vss 0 0
Ibias vdd ib 1.000000e-10
Vinp inp 0 DC 1.161600 AC 1 PWL(0 1.161600 3.168839e-05 1.161600 3.485723e-05 1.171600)
Rfb out inn 1m
Cload out 0 2.000000e-12
Xdut vdd vss inp inn out ib opamp_dut
.end
