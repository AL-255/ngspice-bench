* opa1000[0271]: 200f/folded_cascode_pmos_3v3_i50n_subth (folded_cascode_pmos, VDD=3.3V, CL=0.2pF, Iref=0.0111uA)
.include "pdk_opa.inc"
.temp 27
.option gmin=1e-12 rshunt=1e12 reltol=1e-3 abstol=1e-12 vntol=1e-5 method=gear
* Post-PEX R+C extracted netlist for folded_cascode_pmos_3v3_i50n_subth
.subckt opamp_dut vdd vss inp inn out ib
XMpar0 a_1423_7894.t0 ib vss.t3 vss.t2 nfet_03v3 w=0.4u l=7.5u ad=2.4000e-13 pd=2.0000e-06 as=1.1200e-13 ps=9.6000e-07 nf=1 m=2 par=2
XMpar1 a_1932_11398.t0 inp.t0 a_2390_4314.t0 vdd.t8 pfet_03v3 w=8u l=8.25u ad=3.5200e-12 pd=1.2880e-05 as=2.8800e-12 ps=1.0720e-05 nf=1 m=8 par=8
XMpar2 a_3392_9772.t1 a_3392_9772.t0 vdd.t1 vdd.t0 pfet_03v3 w=0.45u l=9.75u ad=2.7000e-13 pd=2.1000e-06 as=1.2600e-13 ps=1.0100e-06 nf=1 m=2 par=2
XMpar3 a_7534_11398.t8 ib vss.t3 vss.t2 nfet_03v3 w=0.4u l=7.5u ad=1.1200e-13 pd=9.6000e-07 as=1.7600e-13 ps=1.4800e-06 nf=1 m=4 par=4
XMpar4 a_1932_11398.t0 inn.t0 a_7534_11398.t0 vdd.t8 pfet_03v3 w=8u l=8.25u ad=3.5200e-12 pd=1.2880e-05 as=2.8800e-12 ps=1.0720e-05 nf=1 m=8 par=8
XMpar5 a_7534_11398.t12 a_1423_7894.t6 out.t1 vss.t0 nfet_03v3 w=0.4u l=2.8u ad=2.4000e-13 pd=2.0000e-06 as=2.4000e-13 ps=2.0000e-06 nf=1 m=2 par=2
XMpar6 a_2390_4314.t8 ib vss.t3 vss.t2 nfet_03v3 w=0.4u l=7.5u ad=1.1200e-13 pd=9.6000e-07 as=1.7600e-13 ps=1.4800e-06 nf=1 m=4 par=4
XMpar7 ib.t1 ib vss.t3 vss.t2 nfet_03v3 w=0.4u l=7.5u ad=2.4000e-13 pd=2.0000e-06 as=1.1200e-13 ps=9.6000e-07 nf=1 m=2 par=2
XMpar8 a_2390_4314.t12 a_1423_7894.t6 a_3392_9772.t4 vss.t0 nfet_03v3 w=0.4u l=2.8u ad=2.4000e-13 pd=2.0000e-06 as=2.4000e-13 ps=2.0000e-06 nf=1 m=2 par=2
XMpar9 a_1932_11398.t16 a_1423_7894.t2 vdd.t1 vdd.t0 pfet_03v3 w=0.45u l=9.75u ad=1.2600e-13 pd=1.0100e-06 as=1.9800e-13 ps=1.5550e-06 nf=1 m=4 par=4
XMpar10 out.t0 a_3392_9772.t0 vdd.t1 vdd.t0 pfet_03v3 w=0.45u l=9.75u ad=1.2600e-13 pd=1.0100e-06 as=1.2600e-13 ps=1.0100e-06 nf=1 m=2 par=2
XMpar11 a_1423_7894.t3 a_1423_7894.t2 vdd.t1 vdd.t0 pfet_03v3 w=0.45u l=9.75u ad=1.2600e-13 pd=1.0100e-06 as=1.2600e-13 ps=1.0100e-06 nf=1 m=2 par=2
Rpar0 a_1423_7894.t0 a_1423_7894.t2 211.2464
Rpar1 a_1423_7894.t0 a_1423_7894.t3 337.6734
Rpar2 a_1423_7894.t0 a_1423_7894.t6 120.5791
Rpar3 a_1423_7894.t2 a_1423_7894.t3 36.1233
Rpar4 a_1423_7894.t2 a_1423_7894.t6 91.9191
Rpar5 a_1423_7894.t3 a_1423_7894.t6 146.9310
Rpar6 a_1932_11398.t0 a_1932_11398.t16 65.5541
Rpar7 a_2390_4314.t0 a_2390_4314.t8 90.3353
Rpar8 a_2390_4314.t0 a_2390_4314.t12 212.7400
Rpar9 a_2390_4314.t8 a_2390_4314.t12 79.3970
Rpar10 a_3392_9772.t0 a_3392_9772.t1 21.8574
Rpar11 a_3392_9772.t0 a_3392_9772.t4 168.8990
Rpar12 a_3392_9772.t1 a_3392_9772.t4 125.6096
Rpar13 a_7534_11398.t0 a_7534_11398.t8 99.2003
Rpar14 a_7534_11398.t0 a_7534_11398.t12 152.3693
Rpar15 a_7534_11398.t8 a_7534_11398.t12 83.3728
Rpar16 ib ib.t1 13.4840
Rpar17 inn inn.t0 2.8910
Rpar18 inp inp.t0 2.8910
Rpar19 out out.t0 72.3126
Rpar20 out out.t1 10.1951
Rpar21 vdd vdd.t0 227.4335
Rpar22 vdd vdd.t1 573.4161
Rpar23 vdd vdd.t8 21.1320
Rpar24 vdd.t0 vdd.t1 5.6406
Rpar25 vdd.t0 vdd.t8 86.7397
Rpar26 vdd.t1 vdd.t8 218.6923
Rpar27 vss vss.t0 144.7534
Rpar28 vss vss.t2 29.0714
Rpar29 vss vss.t3 76.1811
Rpar30 vss.t0 vss.t2 5.2959
Rpar31 vss.t0 vss.t3 35.1642
Rpar32 vss.t2 vss.t3 6.4292
Cpar0 a_1423_7894.t0 vss 8.27192e-15
Cpar1 a_1423_7894.t2 vss 2.82206e-14
Cpar2 a_1423_7894.t3 vss 5.00462e-15
Cpar3 a_1423_7894.t6 vss 1.15669e-14
Cpar4 a_1932_11398.t0 vss 5.29881e-14
Cpar5 a_1932_11398.t16 vss 7.47429e-15
Cpar6 a_2390_4314.t0 vss 2.64080e-14
Cpar7 a_2390_4314.t12 vss 4.50257e-15
Cpar8 a_2390_4314.t8 vss 6.85370e-15
Cpar9 a_3392_9772.t0 vss 2.25887e-14
Cpar10 a_3392_9772.t1 vss 7.00668e-15
Cpar11 a_3392_9772.t4 vss 6.52356e-15
Cpar12 a_7534_11398.t0 vss 2.34380e-14
Cpar13 a_7534_11398.t12 vss 4.17022e-15
Cpar14 a_7534_11398.t8 vss 5.97863e-15
Cpar15 ib vss 6.08778e-14
Cpar16 ib.t1 vss 5.42509e-16
Cpar17 inn inp 1.05060e-16
Cpar18 inn out 1.37800e-17
Cpar19 inn vdd 2.63079e-14
Cpar20 inn vss 6.05744e-15
Cpar21 inn.t0 vss 3.86656e-14
Cpar22 inp vdd 2.68639e-14
Cpar23 inp vss 6.14934e-15
Cpar24 inp.t0 vss 3.91340e-14
Cpar25 out vdd 4.92790e-15
Cpar26 out vss 1.12167e-14
Cpar27 out.t0 vss 6.62794e-15
Cpar28 out.t1 vss 6.31760e-16
Cpar29 vdd vss 4.00949e-13
Cpar30 vdd.t0 vss 3.04566e-14
Cpar31 vdd.t1 vss 1.32836e-14
Cpar32 vdd.t8 vss 9.90602e-14
.ends opamp_dut

Vdd vdd 0 3.300000
Vss vss 0 0
Ibias vdd ib 1.110000e-08
Vinp inp 0 DC 1.381000 AC 1 PWL(0 1.381000 6.583397e-07 1.381000 7.241737e-07 1.391000)
Rfb out inn 1m
Cload out 0 2.000000e-13
Xdut vdd vss inp inn out ib opamp_dut
.end
