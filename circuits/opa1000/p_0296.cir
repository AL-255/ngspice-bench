* opa1000[0296]: 2p/folded_cascode_pmos_1v8_i200n_weak (folded_cascode_pmos, VDD=1.8V, CL=2.0pF, Iref=0.0578uA)
.include "pdk_opa.inc"
.temp 27
.option gmin=1e-12 rshunt=1e12 reltol=1e-3 abstol=1e-12 vntol=1e-5 method=gear
* Post-PEX R+C extracted netlist for folded_cascode_pmos_1v8_i200n_weak
.subckt opamp_dut vdd vss inp inn out ib
XMpar0 a_1664_12865.t2 inp.t0 a_5890_5136.t1 vdd.t9 pfet_03v3 w=1.74u l=8.13u ad=1.0440e-12 pd=4.6800e-06 as=4.8720e-13 ps=2.3000e-06 nf=1 m=4 par=4
XMpar1 a_1664_12865.t2 inn.t0 a_8334_6636.t2 vdd.t9 pfet_03v3 w=1.74u l=8.13u ad=1.0440e-12 pd=4.6800e-06 as=4.8720e-13 ps=2.3000e-06 nf=1 m=4 par=4
XMpar2 a_1784_12657.t4 ib vss.t5 vss.t4 nfet_03v3 w=0.4u l=3u ad=1.1200e-13 pd=9.6000e-07 as=1.1200e-13 ps=9.6000e-07 nf=1 m=2 par=2
XMpar3 a_1664_12865.t0 a_1784_12657.t0 vdd.t1 vdd.t0 pfet_03v3 w=0.83u l=9.75u ad=4.9800e-13 pd=2.8600e-06 as=3.6520e-13 ps=2.1250e-06 nf=1 m=4 par=4
XMpar4 a_8334_6636.t0 a_1784_12657.t6 out.t0 vss.t0 nfet_03v3 w=0.4u l=4.2u ad=2.4000e-13 pd=2.0000e-06 as=1.1200e-13 ps=9.6000e-07 nf=1 m=2 par=2
XMpar5 a_5890_5136.t5 ib vss.t5 vss.t4 nfet_03v3 w=0.4u l=3u ad=1.1200e-13 pd=9.6000e-07 as=1.7600e-13 ps=1.4800e-06 nf=1 m=4 par=4
XMpar6 a_1784_12657.t1 a_1784_12657.t0 vdd.t1 vdd.t0 pfet_03v3 w=0.83u l=9.75u ad=4.9800e-13 pd=2.8600e-06 as=2.3240e-13 ps=1.3900e-06 nf=1 m=2 par=2
XMpar7 ib.t1 ib vss.t5 vss.t4 nfet_03v3 w=0.4u l=3u ad=2.4000e-13 pd=2.0000e-06 as=1.1200e-13 ps=9.6000e-07 nf=1 m=2 par=2
XMpar8 out.t2 a_4192_8296.t2 vdd.t1 vdd.t0 pfet_03v3 w=0.83u l=9.75u ad=2.3240e-13 pd=1.3900e-06 as=2.3240e-13 ps=1.3900e-06 nf=1 m=2 par=2
XMpar9 a_4192_8296.t0 a_1784_12657.t6 a_5890_5136.t0 vss.t0 nfet_03v3 w=0.4u l=4.2u ad=1.1200e-13 pd=9.6000e-07 as=2.4000e-13 ps=2.0000e-06 nf=1 m=2 par=2
XMpar10 a_8334_6636.t6 ib vss.t5 vss.t4 nfet_03v3 w=0.4u l=3u ad=1.1200e-13 pd=9.6000e-07 as=1.7600e-13 ps=1.4800e-06 nf=1 m=4 par=4
XMpar11 a_4192_8296.t3 a_4192_8296.t2 vdd.t1 vdd.t0 pfet_03v3 w=0.83u l=9.75u ad=4.9800e-13 pd=2.8600e-06 as=2.3240e-13 ps=1.3900e-06 nf=1 m=2 par=2
X27 out.t4 vss.t1 cap_mim_2f0fF c_width=11.18u c_length=11.18u
Rpar0 a_1664_12865.t0 a_1664_12865.t2 50.3028
Rpar1 a_1784_12657.t0 a_1784_12657.t1 15.1356
Rpar2 a_1784_12657.t0 a_1784_12657.t4 336.1050
Rpar3 a_1784_12657.t0 a_1784_12657.t6 412.7493
Rpar4 a_1784_12657.t1 a_1784_12657.t4 259.4233
Rpar5 a_1784_12657.t1 a_1784_12657.t6 318.5813
Rpar6 a_1784_12657.t4 a_1784_12657.t6 81.2939
Rpar7 a_4192_8296.t0 a_4192_8296.t2 127.4808
Rpar8 a_4192_8296.t0 a_4192_8296.t3 83.0934
Rpar9 a_4192_8296.t2 a_4192_8296.t3 21.3639
Rpar10 a_5890_5136.t0 a_5890_5136.t1 245.8692
Rpar11 a_5890_5136.t0 a_5890_5136.t5 64.9370
Rpar12 a_5890_5136.t1 a_5890_5136.t5 113.3921
Rpar13 a_8334_6636.t0 a_8334_6636.t2 98.8597
Rpar14 a_8334_6636.t0 a_8334_6636.t6 60.1263
Rpar15 a_8334_6636.t2 a_8334_6636.t6 91.7544
Rpar16 ib ib.t1 17.4508
Rpar17 inn inn.t0 3.2002
Rpar18 inp inp.t0 3.2002
Rpar19 out out.t0 113.3816
Rpar20 out out.t2 83.2301
Rpar21 out out.t4 15.1252
Rpar22 out.t0 out.t2 314.4441
Rpar23 out.t0 out.t4 1343.6782
Rpar24 out.t2 out.t4 986.3547
Rpar25 vdd vdd.t0 126.6817
Rpar26 vdd vdd.t1 49.3676
Rpar27 vdd vdd.t9 288.3586
Rpar28 vdd.t0 vdd.t1 8.5791
Rpar29 vdd.t0 vdd.t9 10.4948
Rpar30 vdd.t1 vdd.t9 25.1858
Rpar31 vss vss.t0 158.6063
Rpar32 vss vss.t1 74.6131
Rpar33 vss vss.t4 71.2277
Rpar34 vss vss.t5 90.4809
Rpar35 vss.t0 vss.t1 558.8095
Rpar36 vss.t0 vss.t4 2.9263
Rpar37 vss.t0 vss.t5 19.7847
Rpar38 vss.t1 vss.t4 250.9529
Rpar39 vss.t1 vss.t5 318.7868
Rpar40 vss.t4 vss.t5 5.6889
Cpar0 a_1664_12865.t0 vss 1.57588e-14
Cpar1 a_1664_12865.t2 vss 1.89298e-14
Cpar2 a_1784_12657.t0 vss 3.15110e-14
Cpar3 a_1784_12657.t1 vss 7.67997e-15
Cpar4 a_1784_12657.t4 vss 4.98555e-15
Cpar5 a_1784_12657.t6 vss 1.03105e-14
Cpar6 a_4192_8296.t0 vss 2.73061e-15
Cpar7 a_4192_8296.t2 vss 2.33575e-14
Cpar8 a_4192_8296.t3 vss 5.61308e-15
Cpar9 a_5890_5136.t0 vss 3.10994e-15
Cpar10 a_5890_5136.t1 vss 8.25302e-15
Cpar11 a_5890_5136.t5 vss 4.93504e-15
Cpar12 a_8334_6636.t0 vss 3.37904e-15
Cpar13 a_8334_6636.t2 vss 8.15447e-15
Cpar14 a_8334_6636.t6 vss 3.96586e-15
Cpar15 ib out 2.31586e-15
Cpar16 ib vss 3.01399e-14
Cpar17 ib.t1 vss 6.23962e-16
Cpar18 inn inp 1.03020e-16
Cpar19 inn vdd 1.33343e-14
Cpar20 inn vss 4.10965e-15
Cpar21 inn.t0 vss 1.37869e-14
Cpar22 inp vdd 1.31750e-14
Cpar23 inp vss 4.02269e-15
Cpar24 inp.t0 vss 1.36459e-14
Cpar25 out vdd 4.69801e-15
Cpar26 out vss 1.47775e-14
Cpar27 out.t0 vss 9.23164e-16
Cpar28 out.t2 vss 1.61210e-15
Cpar29 out.t4 vss 1.12103e-14
Cpar30 vdd vss 2.00229e-13
Cpar31 vdd.t0 vss 6.41541e-14
Cpar32 vdd.t1 vss 1.88246e-14
Cpar33 vdd.t9 vss 2.54329e-14
.ends opamp_dut

Vdd vdd 0 1.800000
Vss vss 0 0
Ibias vdd ib 5.780000e-08
Vinp inp 0 DC 0.751000 AC 1 PWL(0 0.751000 1.393588e-06 0.751000 1.532947e-06 0.761000)
Rfb out inn 1m
Cload out 0 2.000000e-12
Xdut vdd vss inp inn out ib opamp_dut
.end
