* opa1000[0119]: 200f/current_reuse_3v3_i20u_weak (current_reuse, VDD=3.3V, CL=0.2pF, Iref=3.7143uA)
.include "pdk_opa.inc"
.temp 27
.option gmin=1e-12 rshunt=1e12 reltol=1e-3 abstol=1e-12 vntol=1e-5 method=gear
* Post-PEX R+C extracted netlist for current_reuse_3v3_i20u_weak
.subckt opamp_dut vdd vss inp inn out ib
XMpar0 out.t0 a_957_5538.t14 vdd.t1 vdd.t0 pfet_03v3 w=5.61u l=0.6u ad=1.5708e-12 pd=6.1700e-06 as=1.9298e-12 ps=7.4200e-06 nf=1 m=10 par=10
XMpar1 a_3234_9666.t0 inp.t4 a_957_5538.t1 vdd.t4 pfet_03v3 w=1.97u l=1.13u ad=7.0920e-13 pd=3.1825e-06 as=5.5160e-13 ps=2.5300e-06 nf=1 m=8 par=8
XMpar2 a_4586_5498.t0 inp.t0 a_957_5538.t9 vss.t0 nfet_03v3 w=1.7u l=1.13u ad=7.4800e-13 pd=3.4300e-06 as=4.7600e-13 ps=2.2600e-06 nf=1 m=4 par=4
XMpar3 a_3234_9666.t0 inn.t4 a_6124_11182.t0 vdd.t4 pfet_03v3 w=1.97u l=1.13u ad=7.0920e-13 pd=3.1825e-06 as=5.5160e-13 ps=2.5300e-06 nf=1 m=8 par=8
XMpar4 a_3234_9666.t8 a_6124_11182.t12 vdd.t1 vdd.t0 pfet_03v3 w=5.61u l=0.6u ad=1.5708e-12 pd=6.1700e-06 as=3.3660e-12 ps=1.2420e-05 nf=1 m=2 par=2
XMpar5 out.t9 ib.t0 vss.t10 vss.t0 nfet_03v3 w=2.39u l=1.5u ad=8.2216e-13 pd=3.5560e-06 as=6.6920e-13 ps=2.9500e-06 nf=1 m=10 par=10
XMpar6 a_4586_5498.t8 ib.t0 vss.t10 vss.t0 nfet_03v3 w=2.39u l=1.5u ad=6.6920e-13 pd=2.9500e-06 as=6.6920e-13 ps=2.9500e-06 nf=1 m=4 par=4
XMpar7 ib.t1 ib.t0 vss.t10 vss.t0 nfet_03v3 w=2.39u l=1.5u ad=6.6920e-13 pd=2.9500e-06 as=6.6920e-13 ps=2.9500e-06 nf=1 m=2 par=2
XMpar8 a_4586_5498.t0 inn.t0 a_6124_11182.t8 vss.t0 nfet_03v3 w=1.7u l=1.13u ad=7.4800e-13 pd=3.4300e-06 as=4.7600e-13 ps=2.2600e-06 nf=1 m=4 par=4
XMpar9 a_957_5538.t13 a_6124_11182.t12 vdd.t1 vdd.t0 pfet_03v3 w=5.61u l=0.6u ad=3.3660e-12 pd=1.2420e-05 as=1.5708e-12 ps=6.1700e-06 nf=1 m=1
XMpar10 a_6124_11182.t13 a_6124_11182.t12 vdd.t1 vdd.t0 pfet_03v3 w=5.61u l=0.6u ad=3.3660e-12 pd=1.2420e-05 as=1.5708e-12 ps=6.1700e-06 nf=1 m=1
X18 a_957_5538.t0 a_1891_5538.t0 vss.t4 ppolyf_u_1k r_width=1u r_length=4.01u
X30 a_1891_5538.t1 out.t20 cap_mim_2f0fF c_width=12.99u c_length=12.99u
Rpar0 a_1891_5538.t0 a_1891_5538.t1 47.6953
Rpar1 a_3234_9666.t0 a_3234_9666.t8 58.2784
Rpar2 a_4586_5498.t0 a_4586_5498.t8 64.8024
Rpar3 a_6124_11182.t0 a_6124_11182.t8 102.3202
Rpar4 a_6124_11182.t0 a_6124_11182.t12 159.6693
Rpar5 a_6124_11182.t0 a_6124_11182.t13 55.7970
Rpar6 a_6124_11182.t8 a_6124_11182.t12 95.1626
Rpar7 a_6124_11182.t8 a_6124_11182.t13 263.2727
Rpar8 a_6124_11182.t12 a_6124_11182.t13 58.3159
Rpar9 a_957_5538.t0 a_957_5538.t1 213.4266
Rpar10 a_957_5538.t0 a_957_5538.t9 172.7289
Rpar11 a_957_5538.t0 a_957_5538.t13 667.4259
Rpar12 a_957_5538.t0 a_957_5538.t14 79.4281
Rpar13 a_957_5538.t1 a_957_5538.t9 222.0485
Rpar14 a_957_5538.t1 a_957_5538.t13 66.5367
Rpar15 a_957_5538.t1 a_957_5538.t14 96.3062
Rpar16 a_957_5538.t9 a_957_5538.t13 694.3884
Rpar17 a_957_5538.t9 a_957_5538.t14 82.6368
Rpar18 a_957_5538.t13 a_957_5538.t14 301.1680
Rpar19 ib ib.t0 23.3542
Rpar20 ib ib.t1 12.4597
Rpar21 ib.t0 ib.t1 60.2810
Rpar22 inn inn.t0 4.1713
Rpar23 inn inn.t4 53.3044
Rpar24 inp inp.t0 4.2199
Rpar25 inp inp.t4 62.5816
Rpar26 out out.t0 1.5996
Rpar27 out out.t9 115.7649
Rpar28 out out.t20 159.9751
Rpar29 out.t9 out.t20 63.1327
Rpar30 vdd vdd.t0 50.1865
Rpar31 vdd vdd.t1 60.6531
Rpar32 vdd vdd.t4 100.0874
Rpar33 vdd.t0 vdd.t1 3.2756
Rpar34 vdd.t0 vdd.t4 63.1413
Rpar35 vdd.t1 vdd.t4 81.1519
Rpar36 vss vss.t0 24.7150
Rpar37 vss vss.t10 180.2606
Rpar38 vss vss.t4 227.9782
Rpar39 vss.t0 vss.t10 4.3230
Rpar40 vss.t0 vss.t4 56.7854
Rpar41 vss.t10 vss.t4 731.9891
Cpar0 a_1891_5538.t0 vss 5.35000e-17
Cpar1 a_1891_5538.t1 vss 1.78325e-15
Cpar2 a_3234_9666.t0 vss 1.17419e-14
Cpar3 a_3234_9666.t8 vss 3.87786e-15
Cpar4 a_4586_5498.t0 vss 5.06690e-15
Cpar5 a_4586_5498.t8 vss 7.30401e-15
Cpar6 a_6124_11182.t0 vss 6.88573e-15
Cpar7 a_6124_11182.t12 vss 4.29788e-15
Cpar8 a_6124_11182.t13 vss 5.01095e-15
Cpar9 a_6124_11182.t8 vss 3.57210e-15
Cpar10 a_957_5538.t0 vss 2.03602e-15
Cpar11 a_957_5538.t1 vss 6.53159e-15
Cpar12 a_957_5538.t13 vss 3.78077e-15
Cpar13 a_957_5538.t14 vss 1.04721e-14
Cpar14 a_957_5538.t9 vss 2.76285e-15
Cpar15 ib out 1.72915e-15
Cpar16 ib vss 2.25460e-14
Cpar17 ib.t0 vss 4.49706e-15
Cpar18 ib.t1 vss 3.17665e-16
Cpar19 inn inp 1.03180e-16
Cpar20 inn vdd 5.89629e-15
Cpar21 inn vss 7.19385e-15
Cpar22 inn.t0 vss 1.62562e-15
Cpar23 inn.t4 vss 7.92288e-15
Cpar24 inp out 1.16329e-15
Cpar25 inp vdd 6.31080e-15
Cpar26 inp vss 7.56706e-15
Cpar27 inp.t0 vss 1.68986e-15
Cpar28 inp.t4 vss 8.11428e-15
Cpar29 out vdd 1.10927e-14
Cpar30 out vss 1.69012e-14
Cpar31 out.t0 vss 4.93860e-15
Cpar32 out.t20 vss 7.62901e-15
Cpar33 out.t9 vss 6.29832e-15
Cpar34 vdd vss 8.93132e-14
Cpar35 vdd.t0 vss 1.48497e-14
Cpar36 vdd.t1 vss 1.20876e-14
Cpar37 vdd.t4 vss 1.69098e-14
.ends opamp_dut

Vdd vdd 0 3.300000
Vss vss 0 0
Ibias vdd ib 3.714300e-06
Vinp inp 0 DC 1.645000 AC 1 PWL(0 1.645000 3.000000e-09 1.645000 3.300000e-09 1.655000)
Rfb out inn 1m
Cload out 0 2.000000e-13
Xdut vdd vss inp inn out ib opamp_dut
.end
