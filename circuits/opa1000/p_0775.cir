* opa1000[0775]: 200f/symmetrical_ota_3v3_i200n_weak (symmetrical_ota, VDD=3.3V, CL=0.2pF, Iref=0.0383uA)
.include "pdk_opa.inc"
.temp 27
.option gmin=1e-12 rshunt=1e12 reltol=1e-3 abstol=1e-12 vntol=1e-5 method=gear
* Post-PEX R+C extracted netlist for symmetrical_ota_3v3_i200n_weak
.subckt opamp_dut vdd vss inp inn out ib
XMpar0 a_6490_4151.t1 a_6490_4151.t0 vdd.t1 vdd.t0 pfet_03v3 w=0.4u l=3.9u ad=2.4000e-13 pd=2.0000e-06 as=1.1200e-13 ps=9.6000e-07 nf=1 m=2 par=2
XMpar1 a_2148_7125.t5 a_2148_7125.t4 vss.t3 vss.t2 nfet_03v3 w=0.4u l=3.9u ad=1.1200e-13 pd=9.6000e-07 as=1.1200e-13 ps=9.6000e-07 nf=1 m=4 par=4
XMpar2 a_1822_2865.t4 ib.t0 vss.t19 vss.t18 nfet_03v3 w=0.4u l=3u ad=1.1200e-13 pd=9.6000e-07 as=1.7600e-13 ps=1.4800e-06 nf=1 m=4 par=4
XMpar3 a_2148_7125.t0 a_6490_4151.t0 vdd.t1 vdd.t0 pfet_03v3 w=0.4u l=3.9u ad=2.4000e-13 pd=2.0000e-06 as=1.7600e-13 ps=1.4800e-06 nf=1 m=4 par=4
XMpar4 out.t1 a_2148_7125.t4 vss.t3 vss.t2 nfet_03v3 w=0.4u l=3.9u ad=1.1200e-13 pd=9.6000e-07 as=1.7600e-13 ps=1.4800e-06 nf=1 m=4 par=4
XMpar5 a_1822_2865.t0 inn.t0 a_6490_4151.t4 vss.t0 nfet_03v3 w=0.59u l=8.13u ad=3.5400e-13 pd=2.3800e-06 as=1.6520e-13 ps=1.1500e-06 nf=1 m=2 par=2
XMpar6 a_1710_4151.t0 inp.t0 a_1822_2865.t0 vss.t0 nfet_03v3 w=0.59u l=8.13u ad=1.6520e-13 pd=1.1500e-06 as=3.5400e-13 ps=2.3800e-06 nf=1 m=2 par=2
XMpar7 a_1710_4151.t3 a_1710_4151.t2 vdd.t1 vdd.t0 pfet_03v3 w=0.4u l=3.9u ad=2.4000e-13 pd=2.0000e-06 as=1.1200e-13 ps=9.6000e-07 nf=1 m=2 par=2
XMpar8 out.t0 a_1710_4151.t2 vdd.t1 vdd.t0 pfet_03v3 w=0.4u l=3.9u ad=2.4000e-13 pd=2.0000e-06 as=1.7600e-13 ps=1.4800e-06 nf=1 m=4 par=4
XMpar9 ib.t1 ib.t0 vss.t19 vss.t18 nfet_03v3 w=0.4u l=3u ad=1.1200e-13 pd=9.6000e-07 as=1.1200e-13 ps=9.6000e-07 nf=1 m=2 par=2
Rpar0 a_1710_4151.t0 a_1710_4151.t2 84.6759
Rpar1 a_1710_4151.t0 a_1710_4151.t3 120.0656
Rpar2 a_1710_4151.t2 a_1710_4151.t3 15.6122
Rpar3 a_1822_2865.t0 a_1822_2865.t4 43.4146
Rpar4 a_2148_7125.t0 a_2148_7125.t4 142.2149
Rpar5 a_2148_7125.t0 a_2148_7125.t5 63.2589
Rpar6 a_2148_7125.t4 a_2148_7125.t5 23.0248
Rpar7 a_6490_4151.t0 a_6490_4151.t1 15.6122
Rpar8 a_6490_4151.t0 a_6490_4151.t4 84.6756
Rpar9 a_6490_4151.t1 a_6490_4151.t4 120.0660
Rpar10 ib ib.t0 17.2395
Rpar11 ib ib.t1 17.5055
Rpar12 ib.t0 ib.t1 117.3571
Rpar13 inn inn.t0 3.3941
Rpar14 inp inp.t0 3.4427
Rpar15 out out.t0 6.1375
Rpar16 out out.t1 38.6179
Rpar17 vdd vdd.t0 191.2723
Rpar18 vdd vdd.t1 70.6158
Rpar19 vdd.t0 vdd.t1 7.5742
Rpar20 vss vss.t0 121.1281
Rpar21 vss vss.t2 427.0871
Rpar22 vss vss.t3 484.7769
Rpar23 vss vss.t18 41.0980
Rpar24 vss vss.t19 130.3524
Rpar25 vss.t0 vss.t2 184.8581
Rpar26 vss.t0 vss.t3 209.8969
Rpar27 vss.t0 vss.t18 7.6755
Rpar28 vss.t0 vss.t19 33.7128
Rpar29 vss.t2 vss.t3 10.5422
Rpar30 vss.t2 vss.t18 84.3404
Rpar31 vss.t2 vss.t19 385.7049
Rpar32 vss.t3 vss.t18 95.7707
Rpar33 vss.t3 vss.t19 438.0249
Rpar34 vss.t18 vss.t19 9.6001
Cpar0 a_1710_4151.t0 vss 3.60463e-15
Cpar1 a_1710_4151.t2 vss 1.86708e-14
Cpar2 a_1710_4151.t3 vss 4.88395e-15
Cpar3 a_1822_2865.t0 vss 4.87779e-15
Cpar4 a_1822_2865.t4 vss 3.11225e-15
Cpar5 a_2148_7125.t0 vss 3.89092e-15
Cpar6 a_2148_7125.t4 vss 8.78264e-15
Cpar7 a_2148_7125.t5 vss 2.22009e-15
Cpar8 a_6490_4151.t0 vss 1.75738e-14
Cpar9 a_6490_4151.t1 vss 4.59697e-15
Cpar10 a_6490_4151.t4 vss 3.39282e-15
Cpar11 ib inp 3.43000e-17
Cpar12 ib vss 1.40949e-14
Cpar13 ib.t0 vss 1.91915e-15
Cpar14 ib.t1 vss 8.66493e-17
Cpar15 inn inp 5.15000e-17
Cpar16 inn vdd 1.67900e-17
Cpar17 inn vss 8.26892e-15
Cpar18 inn.t0 vss 5.79397e-16
Cpar19 inp vdd 9.03100e-17
Cpar20 inp vss 8.17401e-15
Cpar21 inp.t0 vss 6.58612e-16
Cpar22 out vdd 7.00243e-15
Cpar23 out vss 1.31132e-14
Cpar24 out.t0 vss 3.08737e-15
Cpar25 out.t1 vss 5.63917e-15
Cpar26 vdd vss 8.68449e-14
Cpar27 vdd.t0 vss 3.57338e-14
Cpar28 vdd.t1 vss 8.56736e-15
.ends opamp_dut

Vdd vdd 0 3.300000
Vss vss 0 0
Ibias vdd ib 3.830000e-08
Vinp inp 0 DC 1.645000 AC 1 PWL(0 1.645000 1.187967e-07 1.645000 1.306764e-07 1.655000)
Rfb out inn 1m
Cload out 0 2.000000e-13
Xdut vdd vss inp inn out ib opamp_dut
.end
