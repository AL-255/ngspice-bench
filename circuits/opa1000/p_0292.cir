* opa1000[0292]: 2p/folded_cascode_pmos_1v8_ulp_lt0p1uw_subth (folded_cascode_pmos, VDD=1.8V, CL=2.0pF, Iref=0.0046uA)
.include "pdk_opa.inc"
.temp 27
.option gmin=1e-12 rshunt=1e12 reltol=1e-3 abstol=1e-12 vntol=1e-5 method=gear
* Post-PEX R+C extracted netlist for folded_cascode_pmos_1v8_ulp_lt0p1uw_subth
.subckt opamp_dut vdd vss inp inn out ib
XMpar0 a_10094_4269.t6 inn.t0 a_4130_10501.t4 vdd.t10 pfet_03v3 w=8u l=6.5u ad=2.2400e-12 pd=8.5600e-06 as=3.5200e-12 ps=1.2880e-05 nf=1 m=8 par=8
XMpar1 a_5550_9001.t2 ib.t0 vss.t5 vss.t4 nfet_03v3 w=0.4u l=6.5u ad=1.1200e-13 pd=9.6000e-07 as=1.7600e-13 ps=1.4800e-06 nf=1 m=4 par=4
XMpar2 a_6044_5517.t1 a_6044_5517.t0 vdd.t1 vdd.t0 pfet_03v3 w=0.4u l=9.5u ad=1.1200e-13 pd=9.6000e-07 as=1.1200e-13 ps=9.6000e-07 nf=1 m=2 par=2
XMpar3 a_4130_10501.t0 a_6044_5517.t0 vdd.t1 vdd.t0 pfet_03v3 w=0.4u l=9.5u ad=1.1200e-13 pd=9.6000e-07 as=1.7600e-13 ps=1.4800e-06 nf=1 m=4 par=4
XMpar4 out.t1 a_8170_1249.t2 vdd.t1 vdd.t0 pfet_03v3 w=0.4u l=9.5u ad=2.4000e-13 pd=2.0000e-06 as=1.1200e-13 ps=9.6000e-07 nf=1 m=2 par=2
XMpar5 a_8170_1249.t3 a_8170_1249.t2 vdd.t1 vdd.t0 pfet_03v3 w=0.4u l=9.5u ad=2.4000e-13 pd=2.0000e-06 as=1.1200e-13 ps=9.6000e-07 nf=1 m=2 par=2
XMpar6 a_4130_10501.t4 inp.t0 a_5550_9001.t6 vdd.t10 pfet_03v3 w=8u l=6.5u ad=3.5200e-12 pd=1.2880e-05 as=2.2400e-12 ps=8.5600e-06 nf=1 m=8 par=8
XMpar7 a_6044_5517.t4 ib.t0 vss.t5 vss.t4 nfet_03v3 w=0.4u l=6.5u ad=1.1200e-13 pd=9.6000e-07 as=1.1200e-13 ps=9.6000e-07 nf=1 m=2 par=2
XMpar8 a_10094_4269.t2 ib.t0 vss.t5 vss.t4 nfet_03v3 w=0.4u l=6.5u ad=1.1200e-13 pd=9.6000e-07 as=1.7600e-13 ps=1.4800e-06 nf=1 m=4 par=4
XMpar9 a_10094_4269.t0 a_6044_5517.t6 out.t0 vss.t0 nfet_03v3 w=0.4u l=5.5u ad=2.4000e-13 pd=2.0000e-06 as=1.1200e-13 ps=9.6000e-07 nf=1 m=2 par=2
XMpar10 ib.t1 ib.t0 vss.t5 vss.t4 nfet_03v3 w=0.4u l=6.5u ad=2.4000e-13 pd=2.0000e-06 as=1.1200e-13 ps=9.6000e-07 nf=1 m=2 par=2
XMpar11 a_5550_9001.t0 a_6044_5517.t6 a_8170_1249.t0 vss.t0 nfet_03v3 w=0.4u l=5.5u ad=2.4000e-13 pd=2.0000e-06 as=1.1200e-13 ps=9.6000e-07 nf=1 m=2 par=2
X42 out.t4 vss.t3 cap_mim_2f0fF c_width=19.62u c_length=19.63u
Rpar0 a_10094_4269.t0 a_10094_4269.t6 356.5592
Rpar1 a_10094_4269.t0 a_10094_4269.t2 133.9327
Rpar2 a_10094_4269.t6 a_10094_4269.t2 76.4538
Rpar3 a_4130_10501.t0 a_4130_10501.t4 70.2346
Rpar4 a_5550_9001.t0 a_5550_9001.t6 160.6860
Rpar5 a_5550_9001.t0 a_5550_9001.t2 162.6232
Rpar6 a_5550_9001.t6 a_5550_9001.t2 54.1180
Rpar7 a_6044_5517.t0 a_6044_5517.t1 35.2749
Rpar8 a_6044_5517.t0 a_6044_5517.t4 205.7848
Rpar9 a_6044_5517.t0 a_6044_5517.t6 242.2210
Rpar10 a_6044_5517.t1 a_6044_5517.t4 151.5677
Rpar11 a_6044_5517.t1 a_6044_5517.t6 178.4042
Rpar12 a_6044_5517.t4 a_6044_5517.t6 136.1487
Rpar13 a_8170_1249.t0 a_8170_1249.t2 129.7151
Rpar14 a_8170_1249.t0 a_8170_1249.t3 149.7149
Rpar15 a_8170_1249.t2 a_8170_1249.t3 14.9959
Rpar16 ib ib.t0 16.2033
Rpar17 ib ib.t1 10.2522
Rpar18 ib.t0 ib.t1 49.5778
Rpar19 inn inn.t0 2.7290
Rpar20 inp inp.t0 2.7290
Rpar21 out out.t0 160.4864
Rpar22 out out.t1 76.8654
Rpar23 out out.t4 15.9770
Rpar24 out.t0 out.t1 173.8285
Rpar25 out.t0 out.t4 1194.2302
Rpar26 out.t1 out.t4 571.9798
Rpar27 vdd vdd.t0 304.2077
Rpar28 vdd vdd.t1 486.2896
Rpar29 vdd vdd.t10 21.4543
Rpar30 vdd.t0 vdd.t1 6.7682
Rpar31 vdd.t0 vdd.t10 127.6925
Rpar32 vdd.t1 vdd.t10 204.1222
Rpar33 vss vss.t0 54.3435
Rpar34 vss vss.t4 271.5904
Rpar35 vss vss.t5 1005.9518
Rpar36 vss vss.t3 69.6135
Rpar37 vss.t0 vss.t4 204.4627
Rpar38 vss.t0 vss.t5 755.9014
Rpar39 vss.t0 vss.t3 187.7602
Rpar40 vss.t4 vss.t5 4.9783
Rpar41 vss.t4 vss.t3 938.3613
Rpar42 vss.t5 vss.t3 3475.6245
Cpar0 a_10094_4269.t0 vss 4.43167e-15
Cpar1 a_10094_4269.t2 vss 6.89138e-15
Cpar2 a_10094_4269.t6 vss 1.80795e-14
Cpar3 a_4130_10501.t0 vss 8.14450e-15
Cpar4 a_4130_10501.t4 vss 4.14835e-14
Cpar5 a_5550_9001.t0 vss 4.77396e-15
Cpar6 a_5550_9001.t2 vss 4.66791e-15
Cpar7 a_5550_9001.t6 vss 1.44447e-14
Cpar8 a_6044_5517.t0 vss 2.59627e-14
Cpar9 a_6044_5517.t1 vss 5.20581e-15
Cpar10 a_6044_5517.t4 vss 5.52997e-15
Cpar11 a_6044_5517.t6 vss 1.34882e-14
Cpar12 a_8170_1249.t0 vss 3.75449e-15
Cpar13 a_8170_1249.t2 vss 2.46282e-14
Cpar14 a_8170_1249.t3 vss 6.40102e-15
Cpar15 ib inn 5.26900e-17
Cpar16 ib inp 5.26900e-17
Cpar17 ib vdd 1.80120e-16
Cpar18 ib vss 4.69675e-14
Cpar19 ib.t0 vss 3.38088e-15
Cpar20 ib.t1 vss 6.89036e-17
Cpar21 inn inp 1.04240e-16
Cpar22 inn vdd 2.14231e-14
Cpar23 inn vss 5.62116e-15
Cpar24 inn.t0 vss 3.04952e-14
Cpar25 inp vdd 2.11839e-14
Cpar26 inp vss 5.60053e-15
Cpar27 inp.t0 vss 3.03498e-14
Cpar28 out vdd 6.41877e-15
Cpar29 out vss 1.95591e-14
Cpar30 out.t0 vss 5.01030e-16
Cpar31 out.t1 vss 8.09527e-16
Cpar32 out.t4 vss 1.43651e-14
Cpar33 vdd vss 3.40415e-13
Cpar34 vdd.t0 vss 3.47494e-14
Cpar35 vdd.t1 vss 1.55454e-14
Cpar36 vdd.t10 vss 7.84437e-14
.ends opamp_dut

Vdd vdd 0 1.800000
Vss vss 0 0
Ibias vdd ib 4.600000e-09
Vinp inp 0 DC 0.751000 AC 1 PWL(0 0.751000 1.395423e-05 0.751000 1.534965e-05 0.761000)
Rfb out inn 1m
Cload out 0 2.000000e-12
Xdut vdd vss inp inn out ib opamp_dut
.end
