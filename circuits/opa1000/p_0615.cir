* opa1000[0615]: 200f/pmos_miller_3v3_1u_10u_subth (pmos_miller, VDD=3.3V, CL=0.2pF, Iref=0.8125uA)
.include "pdk_opa.inc"
.temp 27
.option gmin=1e-12 rshunt=1e12 reltol=1e-3 abstol=1e-12 vntol=1e-5 method=gear
* Post-PEX R+C extracted netlist for pmos_miller_3v3_1u_10u_subth
.subckt opamp_dut vdd vss inp inn out ib
XMpar0 a_1120_10432.t1 a_1120_10432.t0 vdd.t1 vdd.t0 pfet_03v3 w=8.24u l=1.6u ad=2.3072e-12 pd=8.8000e-06 as=2.3072e-12 ps=8.8000e-06 nf=1 m=2 par=2
XMpar1 a_1634_5545.t0 inn.t0 a_5892_1041.t0 vdd.t4 pfet_03v3 w=2u l=1.3u ad=6.4348e-13 pd=2.9043e-06 as=5.8783e-13 ps=2.6748e-06 nf=1 m=46 par=46
XMpar2 out.t0 a_1120_10432.t0 vdd.t1 vdd.t0 pfet_03v3 w=8.24u l=1.6u ad=2.8346e-12 pd=1.0576e-05 as=2.3072e-12 ps=8.8000e-06 nf=1 m=10 par=10
XMpar3 a_1634_5545.t0 inp.t0 a_958_1041.t0 vdd.t4 pfet_03v3 w=2u l=1.3u ad=6.4348e-13 pd=2.9043e-06 as=5.8783e-13 ps=2.6748e-06 nf=1 m=46 par=46
XMpar4 out.t6 a_958_1041.t49 vss.t1 vss.t0 nfet_03v3 w=2.99u l=1u ad=8.3720e-13 pd=3.5500e-06 as=1.0286e-12 ps=4.2760e-06 nf=1 m=10 par=10
XMpar5 ib.t1 ib.t0 vss.t30 vss.t29 nfet_03v3 w=1.75u l=1.6u ad=1.0500e-12 pd=4.7000e-06 as=4.9000e-13 ps=2.3100e-06 nf=1 m=2 par=2
XMpar6 a_958_1041.t47 a_5892_1041.t46 vss.t1 vss.t0 nfet_03v3 w=2.99u l=1u ad=1.7940e-12 pd=7.1800e-06 as=8.3720e-13 ps=3.5500e-06 nf=1 m=2 par=2
XMpar7 a_5892_1041.t47 a_5892_1041.t46 vss.t1 vss.t0 nfet_03v3 w=2.99u l=1u ad=8.3720e-13 pd=3.5500e-06 as=8.3720e-13 ps=3.5500e-06 nf=1 m=2 par=2
XMpar8 a_1634_5545.t46 a_1120_10432.t0 vdd.t1 vdd.t0 pfet_03v3 w=8.24u l=1.6u ad=2.3072e-12 pd=8.8000e-06 as=2.3072e-12 ps=8.8000e-06 nf=1 m=4 par=4
XMpar9 a_1120_10432.t4 ib.t0 vss.t30 vss.t29 nfet_03v3 w=1.75u l=1.6u ad=4.9000e-13 pd=2.3100e-06 as=4.9000e-13 ps=2.3100e-06 nf=1 m=2 par=2
X52 a_958_1041.t46 a_7799_3468.t0 vss.t28 ppolyf_u_1k r_width=1u r_length=18.01u
X123 a_7799_3468.t1 out.t4 cap_mim_2f0fF c_width=13.23u c_length=13.23u
Rpar0 a_1120_10432.t0 a_1120_10432.t1 25.0873
Rpar1 a_1120_10432.t0 a_1120_10432.t4 144.1993
Rpar2 a_1120_10432.t1 a_1120_10432.t4 104.2021
Rpar3 a_1634_5545.t0 a_1634_5545.t46 67.0735
Rpar4 a_5892_1041.t0 a_5892_1041.t46 262.0695
Rpar5 a_5892_1041.t0 a_5892_1041.t47 108.6343
Rpar6 a_5892_1041.t46 a_5892_1041.t47 25.9673
Rpar7 a_7799_3468.t0 a_7799_3468.t1 46.3805
Rpar8 a_958_1041.t0 a_958_1041.t46 139.0695
Rpar9 a_958_1041.t0 a_958_1041.t47 341.9002
Rpar10 a_958_1041.t0 a_958_1041.t49 115.1018
Rpar11 a_958_1041.t46 a_958_1041.t47 351.9716
Rpar12 a_958_1041.t46 a_958_1041.t49 118.4924
Rpar13 a_958_1041.t47 a_958_1041.t49 131.2635
Rpar14 ib ib.t0 17.1909
Rpar15 ib ib.t1 5.1402
Rpar16 ib.t0 ib.t1 100.9431
Rpar17 inn inn.t0 1.6991
Rpar18 inp inp.t0 1.6991
Rpar19 out out.t0 315.2596
Rpar20 out out.t6 2.3680
Rpar21 out out.t4 256.8897
Rpar22 out.t0 out.t6 246.4067
Rpar23 out.t0 out.t4 158.0390
Rpar24 out.t6 out.t4 200.7848
Rpar25 vdd vdd.t0 25.8356
Rpar26 vdd vdd.t1 202.4090
Rpar27 vdd vdd.t4 48.6711
Rpar28 vdd.t0 vdd.t1 5.2530
Rpar29 vdd.t0 vdd.t4 156.7197
Rpar30 vdd.t1 vdd.t4 1227.8223
Rpar31 vss vss.t0 51.7498
Rpar32 vss vss.t1 65.2449
Rpar33 vss vss.t28 101.9325
Rpar34 vss vss.t29 152.9157
Rpar35 vss vss.t30 245.9486
Rpar36 vss.t0 vss.t1 6.3975
Rpar37 vss.t0 vss.t28 2.7942
Rpar38 vss.t0 vss.t29 5.0154
Rpar39 vss.t0 vss.t30 20.5728
Rpar40 vss.t1 vss.t28 20.5487
Rpar41 vss.t1 vss.t29 14.4561
Rpar42 vss.t1 vss.t30 29.3643
Rpar43 vss.t28 vss.t29 80.4584
Rpar44 vss.t28 vss.t30 153.5720
Rpar45 vss.t29 vss.t30 26.6247
Cpar0 a_1120_10432.t0 vss 3.33323e-14
Cpar1 a_1120_10432.t1 vss 5.28083e-15
Cpar2 a_1120_10432.t4 vss 2.41571e-15
Cpar3 a_1634_5545.t0 vss 6.74049e-14
Cpar4 a_1634_5545.t46 vss 1.47187e-14
Cpar5 a_5892_1041.t0 vss 3.52096e-14
Cpar6 a_5892_1041.t46 vss 5.99246e-15
Cpar7 a_5892_1041.t47 vss 5.48288e-15
Cpar8 a_7799_3468.t0 vss 1.08780e-16
Cpar9 a_7799_3468.t1 vss 2.54165e-15
Cpar10 a_958_1041.t0 vss 2.48110e-14
Cpar11 a_958_1041.t46 vss 3.99910e-15
Cpar12 a_958_1041.t47 vss 6.07977e-15
Cpar13 a_958_1041.t49 vss 1.18932e-14
Cpar14 ib vss 7.46760e-15
Cpar15 ib.t0 vss 9.41315e-16
Cpar16 ib.t1 vss 1.20405e-16
Cpar17 inn inp 1.40800e-16
Cpar18 inn out 4.34700e-17
Cpar19 inn vdd 2.85153e-14
Cpar20 inn vss 5.05387e-15
Cpar21 inn.t0 vss 4.37848e-14
Cpar22 inp vdd 2.84675e-14
Cpar23 inp vss 5.01737e-15
Cpar24 inp.t0 vss 4.37974e-14
Cpar25 out vdd 1.16724e-14
Cpar26 out vss 1.99202e-14
Cpar27 out.t0 vss 1.46588e-14
Cpar28 out.t4 vss 9.12192e-15
Cpar29 out.t6 vss 4.49643e-15
Cpar30 vdd vss 2.52225e-13
Cpar31 vdd.t0 vss 3.25403e-14
Cpar32 vdd.t1 vss 9.88849e-15
Cpar33 vdd.t4 vss 7.80529e-14
.ends opamp_dut

Vdd vdd 0 3.300000
Vss vss 0 0
Ibias vdd ib 8.125000e-07
Vinp inp 0 DC 1.480000 AC 1 PWL(0 1.480000 1.246492e-08 1.480000 1.371141e-08 1.490000)
Rfb out inn 1m
Cload out 0 2.000000e-13
Xdut vdd vss inp inn out ib opamp_dut
.end
