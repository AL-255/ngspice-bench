* opa1000[0755]: 200f/symmetrical_ota_1v8_i200n_subth (symmetrical_ota, VDD=1.8V, CL=0.2pF, Iref=0.035uA)
.include "pdk_opa.inc"
.temp 27
.option gmin=1e-12 rshunt=1e12 reltol=1e-3 abstol=1e-12 vntol=1e-5 method=gear
* Post-PEX R+C extracted netlist for symmetrical_ota_1v8_i200n_subth
.subckt opamp_dut vdd vss inp inn out ib
XMpar0 a_1645_2567.t5 a_1645_2567.t4 vdd.t1 vdd.t0 pfet_03v3 w=0.69u l=4.23u ad=4.1400e-13 pd=2.5800e-06 as=1.9320e-13 ps=1.2500e-06 nf=1 m=2 par=2
XMpar1 a_1778_9315.t0 inn.t0 a_6356_2567.t0 vss.t1 nfet_03v3 w=1.55u l=3.84u ad=6.8200e-13 pd=3.2050e-06 as=4.3400e-13 ps=2.1100e-06 nf=1 m=4 par=4
XMpar2 a_1884_996.t0 a_6356_2567.t4 vdd.t1 vdd.t0 pfet_03v3 w=0.69u l=4.23u ad=4.1400e-13 pd=2.5800e-06 as=3.0360e-13 ps=1.9150e-06 nf=1 m=4 par=4
XMpar3 a_1645_2567.t0 inp.t0 a_1778_9315.t0 vss.t1 nfet_03v3 w=1.55u l=3.84u ad=4.3400e-13 pd=2.1100e-06 as=6.8200e-13 ps=3.2050e-06 nf=1 m=4 par=4
XMpar4 out.t3 a_1884_996.t4 vss.t6 vss.t5 nfet_03v3 w=0.4u l=4.23u ad=1.1200e-13 pd=9.6000e-07 as=1.7600e-13 ps=1.4800e-06 nf=1 m=4 par=4
XMpar5 out.t0 a_1645_2567.t4 vdd.t1 vdd.t0 pfet_03v3 w=0.69u l=4.23u ad=4.1400e-13 pd=2.5800e-06 as=3.0360e-13 ps=1.9150e-06 nf=1 m=4 par=4
XMpar6 a_1778_9315.t8 ib.t0 vss.t20 vss.t1 nfet_03v3 w=0.4u l=5u ad=1.1200e-13 pd=9.6000e-07 as=1.7600e-13 ps=1.4800e-06 nf=1 m=4 par=4
XMpar7 a_1884_996.t5 a_1884_996.t4 vss.t6 vss.t5 nfet_03v3 w=0.4u l=4.23u ad=1.1200e-13 pd=9.6000e-07 as=1.1200e-13 ps=9.6000e-07 nf=1 m=4 par=4
XMpar8 ib.t1 ib.t0 vss.t20 vss.t1 nfet_03v3 w=0.4u l=5u ad=1.1200e-13 pd=9.6000e-07 as=1.1200e-13 ps=9.6000e-07 nf=1 m=2 par=2
XMpar9 a_6356_2567.t5 a_6356_2567.t4 vdd.t1 vdd.t0 pfet_03v3 w=0.69u l=4.23u ad=4.1400e-13 pd=2.5800e-06 as=1.9320e-13 ps=1.2500e-06 nf=1 m=2 par=2
X6 out.t8 vss.t0 cap_mim_2f0fF c_width=9.22u c_length=9.22u
Rpar0 a_1645_2567.t0 a_1645_2567.t4 136.1817
Rpar1 a_1645_2567.t0 a_1645_2567.t5 168.2121
Rpar2 a_1645_2567.t4 a_1645_2567.t5 14.3056
Rpar3 a_1778_9315.t0 a_1778_9315.t8 51.6354
Rpar4 a_1884_996.t0 a_1884_996.t4 173.2130
Rpar5 a_1884_996.t0 a_1884_996.t5 75.5808
Rpar6 a_1884_996.t4 a_1884_996.t5 22.8138
Rpar7 a_6356_2567.t0 a_6356_2567.t4 79.8473
Rpar8 a_6356_2567.t0 a_6356_2567.t5 98.6284
Rpar9 a_6356_2567.t4 a_6356_2567.t5 14.7961
Rpar10 ib ib.t0 11.2450
Rpar11 ib ib.t1 16.6189
Rpar12 inn inn.t0 1.9880
Rpar13 inp inp.t0 2.0366
Rpar14 out out.t0 6.5709
Rpar15 out out.t3 79.5777
Rpar16 out out.t8 119.2891
Rpar17 out.t0 out.t3 144.9020
Rpar18 out.t0 out.t8 217.2118
Rpar19 out.t3 out.t8 188.6374
Rpar20 vdd vdd.t0 221.4391
Rpar21 vdd vdd.t1 63.9791
Rpar22 vdd.t0 vdd.t1 8.7772
Rpar23 vss vss.t0 847.4681
Rpar24 vss vss.t1 351.2052
Rpar25 vss vss.t5 108.7010
Rpar26 vss vss.t6 88.1454
Rpar27 vss vss.t20 2963.2801
Rpar28 vss.t0 vss.t1 82.3604
Rpar29 vss.t0 vss.t5 757.8524
Rpar30 vss.t0 vss.t6 614.5192
Rpar31 vss.t0 vss.t20 695.3725
Rpar32 vss.t1 vss.t5 306.3679
Rpar33 vss.t1 vss.t6 248.1147
Rpar34 vss.t1 vss.t20 6.8700
Rpar35 vss.t5 vss.t6 13.3522
Rpar36 vss.t6 vss.t20 2086.6792
Cpar0 a_1645_2567.t0 vss 5.45753e-15
Cpar1 a_1645_2567.t4 vss 1.83864e-14
Cpar2 a_1645_2567.t5 vss 5.57587e-15
Cpar3 a_1778_9315.t0 vss 6.14487e-15
Cpar4 a_1778_9315.t8 vss 4.53197e-15
Cpar5 a_1884_996.t0 vss 4.07421e-15
Cpar6 a_1884_996.t4 vss 9.04127e-15
Cpar7 a_1884_996.t5 vss 2.19405e-15
Cpar8 a_6356_2567.t0 vss 5.29942e-15
Cpar9 a_6356_2567.t4 vss 1.82722e-14
Cpar10 a_6356_2567.t5 vss 4.88392e-15
Cpar11 ib inp 1.83200e-17
Cpar12 ib vdd 5.45200e-17
Cpar13 ib vss 2.12969e-14
Cpar14 ib.t0 vss 2.70970e-15
Cpar15 ib.t1 vss 1.32073e-16
Cpar16 inn inp 5.26200e-17
Cpar17 inn vss 8.61578e-15
Cpar18 inn.t0 vss 1.08085e-15
Cpar19 inp out 2.63100e-17
Cpar20 inp vss 8.48494e-15
Cpar21 inp.t0 vss 1.17540e-15
Cpar22 out vdd 5.96384e-15
Cpar23 out vss 1.38276e-14
Cpar24 out.t0 vss 1.34644e-15
Cpar25 out.t3 vss 1.66092e-15
Cpar26 out.t8 vss 1.16263e-14
Cpar27 vdd vss 9.32601e-14
Cpar28 vdd.t0 vss 3.12694e-14
Cpar29 vdd.t1 vss 1.42304e-14
.ends opamp_dut

Vdd vdd 0 1.800000
Vss vss 0 0
Ibias vdd ib 3.500000e-08
Vinp inp 0 DC 0.895000 AC 1 PWL(0 0.895000 1.722811e-07 0.895000 1.895092e-07 0.905000)
Rfb out inn 1m
Cload out 0 2.000000e-13
Xdut vdd vss inp inn out ib opamp_dut
.end
