* opa1000[0200]: 200f/folded_cascode_nmos_3v3_i10u_subth (folded_cascode_nmos, VDD=3.3V, CL=0.2pF, Iref=2.5556uA)
.include "pdk_opa.inc"
.temp 27
.option gmin=1e-12 rshunt=1e12 reltol=1e-3 abstol=1e-12 vntol=1e-5 method=gear
* Post-PEX R+C extracted netlist for folded_cascode_nmos_3v3_i10u_subth
.subckt opamp_dut vdd vss inp inn out ib
XMpar0 a_2094_7214.t12 ib.t10 a_3286_9022.t0 vdd.t10 pfet_03v3 w=1.95u l=0.45u ad=6.0273e-13 pd=2.7455e-06 as=6.0273e-13 ps=2.7455e-06 nf=1 m=22 par=22
XMpar1 a_5824_9022.t0 ib.t10 out.t2 vdd.t10 pfet_03v3 w=1.95u l=0.45u ad=6.0273e-13 pd=2.7455e-06 as=6.0273e-13 ps=2.7455e-06 nf=1 m=22 par=22
XMpar2 a_1794_7214.t0 inp.t0 a_2094_7214.t0 vss.t0 nfet_03v3 w=1.94u l=0.9u ad=6.4667e-13 pd=2.9300e-06 as=5.4320e-13 ps=2.5000e-06 nf=1 m=12 par=12
XMpar3 a_1176_1041.t0 ib.t0 vss.t13 vss.t12 nfet_03v3 w=3.79u l=1.2u ad=1.0612e-12 pd=4.3500e-06 as=1.0612e-12 ps=4.3500e-06 nf=1 m=2 par=2
XMpar4 a_1794_7214.t0 inn.t0 a_5824_9022.t22 vss.t0 nfet_03v3 w=1.94u l=0.9u ad=6.4667e-13 pd=2.9300e-06 as=5.4320e-13 ps=2.5000e-06 nf=1 m=12 par=12
XMpar5 a_1176_1041.t3 a_1176_1041.t2 vdd.t1 vdd.t0 pfet_03v3 w=10u l=1.08u ad=2.8000e-12 pd=1.0560e-05 as=6.0000e-12 ps=2.1200e-05 nf=1 m=2 par=2
XMpar6 a_2094_7214.t34 a_1176_1041.t2 vdd.t1 vdd.t0 pfet_03v3 w=10u l=1.08u ad=2.8000e-12 pd=1.0560e-05 as=4.4000e-12 ps=1.5880e-05 nf=1 m=4 par=4
XMpar7 ib.t1 ib.t0 vss.t13 vss.t12 nfet_03v3 w=3.79u l=1.2u ad=2.2740e-12 pd=8.7800e-06 as=1.0612e-12 ps=4.3500e-06 nf=1 m=2 par=2
XMpar8 a_1794_7214.t12 ib.t0 vss.t13 vss.t12 nfet_03v3 w=3.79u l=1.2u ad=1.0612e-12 pd=4.3500e-06 as=1.0612e-12 ps=4.3500e-06 nf=1 m=4 par=4
XMpar9 a_5824_9022.t34 a_1176_1041.t2 vdd.t1 vdd.t0 pfet_03v3 w=10u l=1.08u ad=2.8000e-12 pd=1.0560e-05 as=4.4000e-12 ps=1.5880e-05 nf=1 m=4 par=4
XMpar10 out.t0 a_3286_9022.t22 vss.t13 vss.t12 nfet_03v3 w=3.79u l=1.2u ad=1.0612e-12 pd=4.3500e-06 as=1.0612e-12 ps=4.3500e-06 nf=1 m=2 par=2
XMpar11 a_3286_9022.t23 a_3286_9022.t22 vss.t13 vss.t12 nfet_03v3 w=3.79u l=1.2u ad=2.2740e-12 pd=8.7800e-06 as=1.0612e-12 ps=4.3500e-06 nf=1 m=2 par=2
Rpar0 a_1176_1041.t0 a_1176_1041.t2 78.3850
Rpar1 a_1176_1041.t0 a_1176_1041.t3 73.6647
Rpar2 a_1176_1041.t2 a_1176_1041.t3 31.3607
Rpar3 a_1794_7214.t0 a_1794_7214.t12 40.2069
Rpar4 a_2094_7214.t0 a_2094_7214.t12 43.2130
Rpar5 a_2094_7214.t0 a_2094_7214.t34 65.3861
Rpar6 a_2094_7214.t12 a_2094_7214.t34 124.7017
Rpar7 a_3286_9022.t0 a_3286_9022.t22 252.2817
Rpar8 a_3286_9022.t0 a_3286_9022.t23 57.0126
Rpar9 a_3286_9022.t22 a_3286_9022.t23 20.9899
Rpar10 a_5824_9022.t0 a_5824_9022.t22 43.2130
Rpar11 a_5824_9022.t0 a_5824_9022.t34 124.7017
Rpar12 a_5824_9022.t22 a_5824_9022.t34 65.3861
Rpar13 ib ib.t0 337.9906
Rpar14 ib ib.t1 99.8221
Rpar15 ib ib.t10 2.2384
Rpar16 ib.t0 ib.t1 17.6406
Rpar17 inn inn.t0 1.8195
Rpar18 inp inp.t0 1.8681
Rpar19 out out.t0 38.9802
Rpar20 out out.t2 2.4370
Rpar21 vdd vdd.t0 308.9242
Rpar22 vdd vdd.t1 198.5097
Rpar23 vdd vdd.t10 41.8934
Rpar24 vdd.t0 vdd.t1 3.8469
Rpar25 vdd.t0 vdd.t10 318.2085
Rpar26 vdd.t1 vdd.t10 204.4757
Rpar27 vss vss.t0 240.2537
Rpar28 vss vss.t12 64.4323
Rpar29 vss vss.t13 100.6752
Rpar30 vss.t0 vss.t12 49.6504
Rpar31 vss.t0 vss.t13 70.0311
Rpar32 vss.t12 vss.t13 4.3525
Cpar0 a_1176_1041.t0 vss 2.56850e-15
Cpar1 a_1176_1041.t2 vss 1.46602e-14
Cpar2 a_1176_1041.t3 vss 3.95543e-15
Cpar3 a_1794_7214.t0 vss 1.34691e-14
Cpar4 a_1794_7214.t12 vss 5.66061e-15
Cpar5 a_2094_7214.t0 vss 8.76652e-15
Cpar6 a_2094_7214.t12 vss 1.38262e-14
Cpar7 a_2094_7214.t34 vss 9.89036e-15
Cpar8 a_3286_9022.t0 vss 1.19284e-14
Cpar9 a_3286_9022.t22 vss 5.04989e-15
Cpar10 a_3286_9022.t23 vss 4.60896e-15
Cpar11 a_5824_9022.t0 vss 1.23263e-14
Cpar12 a_5824_9022.t22 vss 7.81545e-15
Cpar13 a_5824_9022.t34 vss 8.81738e-15
Cpar14 ib inn 1.32200e-17
Cpar15 ib inp 1.94200e-17
Cpar16 ib out 2.70461e-15
Cpar17 ib vdd 2.10592e-14
Cpar18 ib vss 2.23169e-14
Cpar19 ib.t0 vss 9.24274e-15
Cpar20 ib.t1 vss 5.20556e-15
Cpar21 ib.t10 vss 1.28499e-14
Cpar22 inn inp 5.12600e-17
Cpar23 inn vdd 3.95700e-17
Cpar24 inn vss 8.75699e-15
Cpar25 inn.t0 vss 1.74929e-15
Cpar26 inp vdd 4.73200e-17
Cpar27 inp vss 8.66333e-15
Cpar28 inp.t0 vss 1.79382e-15
Cpar29 out vdd 3.86178e-15
Cpar30 out vss 9.39795e-15
Cpar31 out.t0 vss 3.92189e-15
Cpar32 out.t2 vss 1.22167e-14
Cpar33 vdd vss 1.24439e-13
Cpar34 vdd.t0 vss 1.83533e-14
Cpar35 vdd.t1 vss 1.21346e-14
Cpar36 vdd.t10 vss 2.46581e-14
.ends opamp_dut

Vdd vdd 0 3.300000
Vss vss 0 0
Ibias vdd ib 2.555600e-06
Vinp inp 0 DC 1.810000 AC 1 PWL(0 1.810000 3.440994e-09 1.810000 3.785094e-09 1.820000)
Rfb out inn 1m
Cload out 0 2.000000e-13
Xdut vdd vss inp inn out ib opamp_dut
.end
