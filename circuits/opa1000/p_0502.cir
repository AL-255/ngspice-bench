* opa1000[0502]: 200f/pmos_5t_1v8_i50n_subth (pmos_5t, VDD=1.8V, CL=0.2pF, Iref=0.013uA)
.include "pdk_opa.inc"
.temp 27
.option gmin=1e-12 rshunt=1e12 reltol=1e-3 abstol=1e-12 vntol=1e-5 method=gear
* Post-PEX R+C extracted netlist for pmos_5t_1v8_i50n_subth
.subckt opamp_dut vdd vss inp inn out ib
XMpar0 a_1634_7733.t0 inp.t0 a_3130_7733.t0 vdd.t4 pfet_03v3 w=3.19u l=6.88u ad=1.4036e-12 pd=5.6650e-06 as=1.1484e-12 ps=4.7075e-06 nf=1 m=8 par=8
XMpar1 out.t0 a_3130_7733.t8 vss.t1 vss.t0 nfet_03v3 w=0.4u l=3.9u ad=1.1200e-13 pd=9.6000e-07 as=1.1200e-13 ps=9.6000e-07 nf=1 m=2 par=2
XMpar2 a_3130_7733.t9 a_3130_7733.t8 vss.t1 vss.t0 nfet_03v3 w=0.4u l=3.9u ad=2.4000e-13 pd=2.0000e-06 as=1.1200e-13 ps=9.6000e-07 nf=1 m=2 par=2
XMpar3 a_1634_7733.t0 inn.t0 out.t1 vdd.t4 pfet_03v3 w=3.19u l=6.88u ad=1.4036e-12 pd=5.6650e-06 as=1.1484e-12 ps=4.7075e-06 nf=1 m=8 par=8
XMpar4 a_1634_7733.t16 a_1981_4362.t2 vdd.t1 vdd.t0 pfet_03v3 w=0.53u l=6.25u ad=1.4840e-13 pd=1.0900e-06 as=2.7560e-13 ps=1.9675e-06 nf=1 m=8 par=8
XMpar5 ib.t1 ib.t0 vss.t7 vss.t6 nfet_03v3 w=0.4u l=6.25u ad=2.4000e-13 pd=2.0000e-06 as=1.1200e-13 ps=9.6000e-07 nf=1 m=2 par=2
XMpar6 a_1981_4362.t0 ib.t0 vss.t7 vss.t6 nfet_03v3 w=0.4u l=6.25u ad=1.1200e-13 pd=9.6000e-07 as=1.1200e-13 ps=9.6000e-07 nf=1 m=2 par=2
XMpar7 a_1981_4362.t3 a_1981_4362.t2 vdd.t1 vdd.t0 pfet_03v3 w=0.53u l=6.25u ad=3.1800e-13 pd=2.2600e-06 as=1.4840e-13 ps=1.0900e-06 nf=1 m=2 par=2
Rpar0 a_1634_7733.t0 a_1634_7733.t16 40.0865
Rpar1 a_1981_4362.t0 a_1981_4362.t2 90.6713
Rpar2 a_1981_4362.t0 a_1981_4362.t3 142.8578
Rpar3 a_1981_4362.t2 a_1981_4362.t3 15.6048
Rpar4 a_3130_7733.t0 a_3130_7733.t8 153.8959
Rpar5 a_3130_7733.t0 a_3130_7733.t9 115.0739
Rpar6 a_3130_7733.t8 a_3130_7733.t9 21.4660
Rpar7 ib ib.t0 11.5933
Rpar8 ib ib.t1 8.8363
Rpar9 inn inn.t0 2.4324
Rpar10 inp inp.t0 2.4324
Rpar11 out out.t0 15.1734
Rpar12 out out.t1 50.4741
Rpar13 vdd vdd.t0 160.3053
Rpar14 vdd vdd.t1 1685.6756
Rpar15 vdd vdd.t4 21.7823
Rpar16 vdd.t0 vdd.t1 12.6247
Rpar17 vdd.t0 vdd.t4 65.3654
Rpar18 vdd.t1 vdd.t4 687.3440
Rpar19 vss vss.t0 71.9007
Rpar20 vss vss.t1 140.5768
Rpar21 vss vss.t6 104.3670
Rpar22 vss vss.t7 184.6982
Rpar23 vss.t0 vss.t1 24.2952
Rpar24 vss.t0 vss.t6 14.1993
Rpar25 vss.t0 vss.t7 26.5332
Rpar26 vss.t1 vss.t6 34.7570
Rpar27 vss.t1 vss.t7 66.1616
Rpar28 vss.t6 vss.t7 32.1850
Cpar0 a_1634_7733.t0 vss 4.02828e-14
Cpar1 a_1634_7733.t16 vss 1.31327e-14
Cpar2 a_1981_4362.t0 vss 5.61453e-15
Cpar3 a_1981_4362.t2 vss 4.14292e-14
Cpar4 a_1981_4362.t3 vss 7.65413e-15
Cpar5 a_3130_7733.t0 vss 1.38427e-14
Cpar6 a_3130_7733.t8 vss 7.16037e-15
Cpar7 a_3130_7733.t9 vss 3.01752e-15
Cpar8 ib vss 1.80705e-14
Cpar9 ib.t0 vss 1.97741e-15
Cpar10 ib.t1 vss 1.06270e-16
Cpar11 inn inp 1.05400e-16
Cpar12 inn out 5.91083e-15
Cpar13 inn vdd 2.15113e-14
Cpar14 inn vss 4.83923e-15
Cpar15 inn.t0 vss 2.76078e-14
Cpar16 inp vdd 2.18066e-14
Cpar17 inp vss 4.85177e-15
Cpar18 inp.t0 vss 2.78847e-14
Cpar19 out vdd 4.75434e-15
Cpar20 out vss 1.04963e-14
Cpar21 out.t0 vss 2.85409e-16
Cpar22 out.t1 vss 1.66735e-14
Cpar23 vdd vss 2.38325e-13
Cpar24 vdd.t0 vss 3.51109e-14
Cpar25 vdd.t1 vss 5.39066e-15
Cpar26 vdd.t4 vss 6.59553e-14
.ends opamp_dut

Vdd vdd 0 1.800000
Vss vss 0 0
Ibias vdd ib 1.300000e-08
Vinp inp 0 DC 0.805000 AC 1 PWL(0 0.805000 2.626741e-07 0.805000 2.889415e-07 0.815000)
Rfb out inn 1m
Cload out 0 2.000000e-13
Xdut vdd vss inp inn out ib opamp_dut
.end
