* opa1000[0753]: 200f/symmetrical_ota_1v8_i50n_weak (symmetrical_ota, VDD=1.8V, CL=0.2pF, Iref=0.0108uA)
.include "pdk_opa.inc"
.temp 27
.option gmin=1e-12 rshunt=1e12 reltol=1e-3 abstol=1e-12 vntol=1e-5 method=gear
* Post-PEX R+C extracted netlist for symmetrical_ota_1v8_i50n_weak
.subckt opamp_dut vdd vss inp inn out ib
XMpar0 a_1710_4202.t3 a_1710_4202.t2 vdd.t1 vdd.t0 pfet_03v3 w=0.4u l=3.9u ad=2.4000e-13 pd=2.0000e-06 as=1.1200e-13 ps=9.6000e-07 nf=1 m=2 par=2
XMpar1 a_1822_2910.t4 inn.t0 a_6490_4202.t0 vss.t12 nfet_03v3 w=0.4u l=8.13u ad=2.4000e-13 pd=2.0000e-06 as=1.1200e-13 ps=9.6000e-07 nf=1 m=2 par=2
XMpar2 a_1822_2910.t0 ib.t0 vss.t1 vss.t0 nfet_03v3 w=0.4u l=4u ad=1.1200e-13 pd=9.6000e-07 as=1.7600e-13 ps=1.4800e-06 nf=1 m=4 par=4
XMpar3 out.t0 a_1710_4202.t2 vdd.t1 vdd.t0 pfet_03v3 w=0.4u l=3.9u ad=2.4000e-13 pd=2.0000e-06 as=1.7600e-13 ps=1.4800e-06 nf=1 m=4 par=4
XMpar4 a_1710_4202.t0 inp.t0 a_1822_2910.t4 vss.t12 nfet_03v3 w=0.4u l=8.13u ad=1.1200e-13 pd=9.6000e-07 as=2.4000e-13 ps=2.0000e-06 nf=1 m=2 par=2
XMpar5 a_4038_7221.t8 a_6490_4202.t2 vdd.t1 vdd.t0 pfet_03v3 w=0.4u l=3.9u ad=2.4000e-13 pd=2.0000e-06 as=1.7600e-13 ps=1.4800e-06 nf=1 m=4 par=4
XMpar6 ib.t1 ib.t0 vss.t1 vss.t0 nfet_03v3 w=0.4u l=4u ad=1.1200e-13 pd=9.6000e-07 as=1.1200e-13 ps=9.6000e-07 nf=1 m=2 par=2
XMpar7 out.t2 a_4038_7221.t0 vss.t17 vss.t16 nfet_03v3 w=0.4u l=3.9u ad=2.4000e-13 pd=2.0000e-06 as=1.1200e-13 ps=9.6000e-07 nf=1 m=4 par=4
XMpar8 a_6490_4202.t3 a_6490_4202.t2 vdd.t1 vdd.t0 pfet_03v3 w=0.4u l=3.9u ad=2.4000e-13 pd=2.0000e-06 as=1.1200e-13 ps=9.6000e-07 nf=1 m=2 par=2
XMpar9 a_4038_7221.t1 a_4038_7221.t0 vss.t17 vss.t16 nfet_03v3 w=0.4u l=3.9u ad=1.1200e-13 pd=9.6000e-07 as=1.1200e-13 ps=9.6000e-07 nf=1 m=4 par=4
Rpar0 a_1710_4202.t0 a_1710_4202.t2 104.8010
Rpar1 a_1710_4202.t0 a_1710_4202.t3 148.6019
Rpar2 a_1710_4202.t2 a_1710_4202.t3 15.3869
Rpar3 a_1822_2910.t0 a_1822_2910.t4 44.1224
Rpar4 a_4038_7221.t0 a_4038_7221.t1 14.3797
Rpar5 a_4038_7221.t0 a_4038_7221.t8 106.0608
Rpar6 a_4038_7221.t1 a_4038_7221.t8 106.6660
Rpar7 a_6490_4202.t0 a_6490_4202.t2 104.8007
Rpar8 a_6490_4202.t0 a_6490_4202.t3 148.6025
Rpar9 a_6490_4202.t2 a_6490_4202.t3 15.3869
Rpar10 ib ib.t0 18.8340
Rpar11 ib ib.t1 18.4191
Rpar12 ib.t0 ib.t1 102.4258
Rpar13 inn inn.t0 3.3504
Rpar14 inp inp.t0 3.3990
Rpar15 out out.t0 7.0920
Rpar16 out out.t2 87.7094
Rpar17 out.t0 out.t2 183.1119
Rpar18 vdd vdd.t0 166.4526
Rpar19 vdd vdd.t1 61.4538
Rpar20 vdd.t0 vdd.t1 7.6066
Rpar21 vss vss.t0 58.7674
Rpar22 vss vss.t1 188.3285
Rpar23 vss vss.t12 140.0818
Rpar24 vss vss.t16 585.3521
Rpar25 vss vss.t17 1203.1427
Rpar26 vss.t0 vss.t1 10.5626
Rpar27 vss.t0 vss.t12 6.8211
Rpar28 vss.t0 vss.t16 95.0315
Rpar29 vss.t0 vss.t17 195.4912
Rpar30 vss.t1 vss.t12 28.2034
Rpar31 vss.t1 vss.t16 438.9768
Rpar32 vss.t1 vss.t17 903.5432
Rpar33 vss.t12 vss.t16 206.0499
Rpar34 vss.t12 vss.t17 423.8057
Rpar35 vss.t16 vss.t17 20.8401
Cpar0 a_1710_4202.t0 vss 4.10080e-15
Cpar1 a_1710_4202.t2 vss 1.78405e-14
Cpar2 a_1710_4202.t3 vss 4.86596e-15
Cpar3 a_1822_2910.t0 vss 3.59786e-15
Cpar4 a_1822_2910.t4 vss 4.87881e-15
Cpar5 a_4038_7221.t0 vss 1.00014e-14
Cpar6 a_4038_7221.t1 vss 2.51686e-15
Cpar7 a_4038_7221.t8 vss 4.08417e-15
Cpar8 a_6490_4202.t0 vss 4.04471e-15
Cpar9 a_6490_4202.t2 vss 1.75966e-14
Cpar10 a_6490_4202.t3 vss 4.79939e-15
Cpar11 ib inp 3.30100e-17
Cpar12 ib vss 1.76308e-14
Cpar13 ib.t0 vss 2.38653e-15
Cpar14 ib.t1 vss 1.05926e-16
Cpar15 inn inp 5.15000e-17
Cpar16 inn vdd 1.51700e-17
Cpar17 inn vss 8.35189e-15
Cpar18 inn.t0 vss 5.48804e-16
Cpar19 inp vdd 1.79700e-17
Cpar20 inp vss 8.18931e-15
Cpar21 inp.t0 vss 5.81826e-16
Cpar22 out vdd 6.39837e-15
Cpar23 out vss 1.47793e-14
Cpar24 out.t0 vss 3.75046e-15
Cpar25 out.t2 vss 8.64239e-15
Cpar26 vdd vss 8.47882e-14
Cpar27 vdd.t0 vss 3.50772e-14
Cpar28 vdd.t1 vss 8.05956e-15
.ends opamp_dut

Vdd vdd 0 1.800000
Vss vss 0 0
Ibias vdd ib 1.080000e-08
Vinp inp 0 DC 0.895000 AC 1 PWL(0 0.895000 3.668382e-07 0.895000 4.035220e-07 0.905000)
Rfb out inn 1m
Cload out 0 2.000000e-13
Xdut vdd vss inp inn out ib opamp_dut
.end
