* opa1000[0871]: 200f/telescopic_nmos_3v3_i150u_subth (telescopic_nmos, VDD=3.3V, CL=0.2pF, Iref=43.125uA)
.include "pdk_opa.inc"
.temp 27
.option gmin=1e-12 rshunt=1e12 reltol=1e-3 abstol=1e-12 vntol=1e-5 method=gear
* Post-PEX R+C extracted netlist for telescopic_nmos_3v3_i150u_subth
.subckt opamp_dut vdd vss inp inn out ib
XMpar0 a_1673_18017.t1 a_1793_17809.t906 vdd.t2 vdd.t1 pfet_03v3 w=4.39u l=0.88u ad=1.2292e-12 pd=4.9500e-06 as=1.2292e-12 ps=4.9500e-06 nf=1 m=160 par=160
XMpar1 a_2325_18017.t41 a_1793_17809.t0 out.t2 vdd.t0 pfet_03v3 w=7.54u l=0.38u ad=3.1970e-12 pd=1.1781e-05 as=2.6541e-12 ps=9.9405e-06 nf=1 m=160 par=160
XMpar2 a_1793_17809.t321 a_1793_17809.t320 a_8294_11096.t0 vss.t0 nfet_03v3 w=1.99u l=0.38u ad=6.9174e-13 pd=3.1056e-06 as=7.8143e-13 ps=3.4761e-06 nf=1 m=142 par=142
XMpar3 a_1673_18017.t0 a_1793_17809.t0 a_1793_17809.t1 vdd.t0 pfet_03v3 w=7.54u l=0.38u ad=3.3478e-12 pd=1.2292e-05 as=2.5938e-12 ps=9.7360e-06 nf=1 m=160 par=160
XMpar4 a_1254_24166.t0 inp.t0 a_8294_11096.t32 vss.t0 nfet_03v3 w=3.29u l=0.35u ad=9.7384e-13 pd=4.0465e-06 as=9.2120e-13 ps=3.8500e-06 nf=1 m=160 par=160
XMpar5 a_2325_18017.t0 a_1793_17809.t906 vdd.t2 vdd.t1 pfet_03v3 w=4.39u l=0.88u ad=1.2292e-12 pd=4.9500e-06 as=1.3170e-12 ps=5.2644e-06 nf=1 m=160 par=160
XMpar6 a_7266_11096.t0 a_1793_17809.t320 out.t0 vss.t0 nfet_03v3 w=1.99u l=0.38u ad=8.4831e-13 pd=3.7523e-06 as=6.5727e-13 ps=2.9633e-06 nf=1 m=140 par=140
XMpar7 a_1254_24166.t0 inn.t0 a_7266_11096.t30 vss.t0 nfet_03v3 w=3.29u l=0.35u ad=9.7519e-13 pd=4.0515e-06 as=9.2120e-13 ps=3.8500e-06 nf=1 m=156 par=156
XMpar8 a_1254_24166.t320 ib.t0 vss.t148 vss.t147 nfet_03v3 w=10u l=0.65u ad=2.8000e-12 pd=1.0560e-05 as=3.0667e-12 ps=1.1447e-05 nf=1 m=24 par=24
XMpar9 ib.t1 ib.t0 vss.t148 vss.t147 nfet_03v3 w=10u l=0.65u ad=2.8000e-12 pd=1.0560e-05 as=2.8000e-12 ps=1.0560e-05 nf=1 m=6 par=6
XMpar10 a_1254_24166.t0 inn.t0 a_7266_11096.t30 vss.t123 nfet_03v3 w=3.29u l=0.35u ad=9.2120e-13 pd=3.8500e-06 as=9.2120e-13 ps=3.8500e-06 nf=1 m=4 par=4
XMpar11 a_7266_11096.t0 a_1793_17809.t320 out.t0 vss.t123 nfet_03v3 w=1.99u l=0.38u ad=1.1940e-12 pd=5.1800e-06 as=5.5720e-13 ps=2.5500e-06 nf=1 m=2 par=2
Rpar0 a_1254_24166.t0 a_1254_24166.t320 67.6163
Rpar1 a_1673_18017.t0 a_1673_18017.t1 65.8780
Rpar2 a_1793_17809.t0 a_1793_17809.t1 5.9508
Rpar3 a_1793_17809.t1 a_1793_17809.t906 81.9026
Rpar4 a_1793_17809.t1 a_1793_17809.t321 87.9028
Rpar5 a_1793_17809.t906 a_1793_17809.t321 172.4046
Rpar6 a_1793_17809.t320 a_1793_17809.t321 4.0329
Rpar7 a_2325_18017.t0 a_2325_18017.t41 52.3986
Rpar8 a_7266_11096.t0 a_7266_11096.t30 56.0458
Rpar9 a_8294_11096.t0 a_8294_11096.t32 60.0219
Rpar10 ib ib.t0 55.9121
Rpar11 ib ib.t1 4.2963
Rpar12 ib.t0 ib.t1 27.0145
Rpar13 inn inn.t0 1.7766
Rpar14 inp inp.t0 1.7766
Rpar15 out out.t0 278.7803
Rpar16 out out.t2 2.6400
Rpar17 out.t0 out.t2 63.6072
Rpar18 vdd vdd.t0 244.5321
Rpar19 vdd vdd.t1 73.0550
Rpar20 vdd vdd.t2 3922.9311
Rpar21 vdd.t0 vdd.t1 23.8524
Rpar22 vdd.t0 vdd.t2 1280.8356
Rpar23 vdd.t1 vdd.t2 9.2667
Rpar24 vss vss.t0 31.3835
Rpar25 vss vss.t123 2884.5757
Rpar26 vss vss.t147 2512.2200
Rpar27 vss.t0 vss.t123 2.8363
Rpar28 vss.t0 vss.t147 116.0713
Rpar29 vss.t147 vss.t148 4.2581
Cpar0 a_1254_24166.t0 vss 2.55178e-13
Cpar1 a_1254_24166.t320 vss 6.17495e-14
Cpar2 a_1673_18017.t0 vss 4.08329e-13
Cpar3 a_1673_18017.t1 vss 2.11378e-13
Cpar4 a_1793_17809.t0 vss 2.35869e-13
Cpar5 a_1793_17809.t1 vss 2.71406e-13
Cpar6 a_1793_17809.t320 vss 1.07473e-13
Cpar7 a_1793_17809.t321 vss 1.10907e-13
Cpar8 a_1793_17809.t906 vss 3.47116e-13
Cpar9 a_2325_18017.t0 vss 2.18571e-13
Cpar10 a_2325_18017.t41 vss 4.32289e-13
Cpar11 a_7266_11096.t0 vss 1.58362e-13
Cpar12 a_7266_11096.t30 vss 1.46769e-13
Cpar13 a_8294_11096.t0 vss 1.77446e-13
Cpar14 a_8294_11096.t32 vss 1.62024e-13
Cpar15 ib out 1.60400e-17
Cpar16 ib vdd 1.33610e-16
Cpar17 ib vss 3.72547e-14
Cpar18 ib.t0 vss 7.61998e-15
Cpar19 ib.t1 vss 2.10931e-15
Cpar20 inn inp 2.07310e-16
Cpar21 inn vss 5.19155e-14
Cpar22 inn.t0 vss 3.39631e-14
Cpar23 inp vss 5.20928e-14
Cpar24 inp.t0 vss 3.39835e-14
Cpar25 out vdd 6.93438e-14
Cpar26 out vss 3.45481e-14
Cpar27 out.t0 vss 1.55710e-13
Cpar28 out.t2 vss 4.23668e-13
Cpar29 vdd vss 1.50909e-12
Cpar30 vdd.t0 vss 4.10882e-13
Cpar31 vdd.t1 vss 3.17372e-13
Cpar32 vdd.t2 vss 6.93913e-14
.ends opamp_dut

Vdd vdd 0 3.300000
Vss vss 0 0
Ibias vdd ib 4.312500e-05
Vinp inp 0 DC 1.711000 AC 1 PWL(0 1.711000 3.000000e-09 1.711000 3.300000e-09 1.721000)
Rfb out inn 1m
Cload out 0 2.000000e-13
Xdut vdd vss inp inn out ib opamp_dut
.end
