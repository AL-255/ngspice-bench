* opa1000[0800]: 2p/symmetrical_ota_1v8_i1u_subth (symmetrical_ota, VDD=1.8V, CL=2.0pF, Iref=0.1917uA)
.include "pdk_opa.inc"
.temp 27
.option gmin=1e-12 rshunt=1e12 reltol=1e-3 abstol=1e-12 vntol=1e-5 method=gear
* Post-PEX R+C extracted netlist for symmetrical_ota_1v8_i1u_subth
.subckt opamp_dut vdd vss inp inn out ib
XMpar0 a_1141_6124.t4 inp.t0 a_5050_8472.t0 vss.t2 nfet_03v3 w=2.02u l=1.56u ad=6.0600e-13 pd=2.7462e-06 as=7.2720e-13 ps=3.2450e-06 nf=1 m=32 par=32
XMpar1 a_5050_8472.t0 inn.t0 a_8334_8472.t0 vss.t2 nfet_03v3 w=2.02u l=1.56u ad=7.2720e-13 pd=3.2450e-06 as=6.0600e-13 ps=2.7462e-06 nf=1 m=32 par=32
XMpar2 a_8334_8472.t33 a_8334_8472.t32 vdd.t1 vdd.t0 pfet_03v3 w=2.8u l=3.6u ad=7.8400e-13 pd=3.3600e-06 as=7.8400e-13 ps=3.3600e-06 nf=1 m=2 par=2
XMpar3 a_6878_1086.t0 a_8334_8472.t32 vdd.t1 vdd.t0 pfet_03v3 w=2.8u l=3.6u ad=7.8400e-13 pd=3.3600e-06 as=1.2320e-12 ps=5.0800e-06 nf=1 m=4 par=4
XMpar4 a_5050_8472.t32 ib.t0 vss.t23 vss.t22 nfet_03v3 w=1.53u l=5.25u ad=4.2840e-13 pd=2.0900e-06 as=6.7320e-13 ps=3.1750e-06 nf=1 m=4 par=4
XMpar5 out.t0 a_1141_6124.t0 vdd.t1 vdd.t0 pfet_03v3 w=2.8u l=3.6u ad=7.8400e-13 pd=3.3600e-06 as=1.2320e-12 ps=5.0800e-06 nf=1 m=4 par=4
XMpar6 a_6878_1086.t5 a_6878_1086.t4 vss.t1 vss.t0 nfet_03v3 w=0.73u l=3.6u ad=2.0440e-13 pd=1.2900e-06 as=2.0440e-13 ps=1.2900e-06 nf=1 m=4 par=4
XMpar7 out.t1 a_6878_1086.t4 vss.t1 vss.t0 nfet_03v3 w=0.73u l=3.6u ad=4.3800e-13 pd=2.6600e-06 as=2.0440e-13 ps=1.2900e-06 nf=1 m=4 par=4
XMpar8 a_1141_6124.t1 a_1141_6124.t0 vdd.t1 vdd.t0 pfet_03v3 w=2.8u l=3.6u ad=7.8400e-13 pd=3.3600e-06 as=7.8400e-13 ps=3.3600e-06 nf=1 m=2 par=2
XMpar9 ib.t1 ib.t0 vss.t23 vss.t22 nfet_03v3 w=1.53u l=5.25u ad=4.2840e-13 pd=2.0900e-06 as=4.2840e-13 ps=2.0900e-06 nf=1 m=2 par=2
X31 out.t8 vss.t18 cap_mim_2f0fF c_width=11.18u c_length=11.18u
Rpar0 a_1141_6124.t0 a_1141_6124.t1 24.2872
Rpar1 a_1141_6124.t0 a_1141_6124.t4 97.6008
Rpar2 a_1141_6124.t1 a_1141_6124.t4 77.3141
Rpar3 a_5050_8472.t0 a_5050_8472.t32 68.0443
Rpar4 a_6878_1086.t0 a_6878_1086.t4 136.5443
Rpar5 a_6878_1086.t0 a_6878_1086.t5 126.4574
Rpar6 a_6878_1086.t4 a_6878_1086.t5 13.7231
Rpar7 a_8334_8472.t0 a_8334_8472.t32 97.6008
Rpar8 a_8334_8472.t0 a_8334_8472.t33 77.3141
Rpar9 a_8334_8472.t32 a_8334_8472.t33 24.2872
Rpar10 ib ib.t0 23.5120
Rpar11 ib ib.t1 13.9336
Rpar12 ib.t0 ib.t1 64.9601
Rpar13 inn inn.t0 2.1464
Rpar14 inp inp.t0 2.1464
Rpar15 out out.t0 80.4698
Rpar16 out out.t1 60.7975
Rpar17 out out.t8 15.2697
Rpar18 out.t0 out.t1 233.2286
Rpar19 out.t0 out.t8 953.6425
Rpar20 out.t1 out.t8 720.5072
Rpar21 vdd vdd.t0 111.3446
Rpar22 vdd vdd.t1 165.6041
Rpar23 vdd.t0 vdd.t1 3.3671
Rpar24 vss vss.t0 380.7043
Rpar25 vss vss.t1 70.8327
Rpar26 vss vss.t2 139.1156
Rpar27 vss vss.t18 71.8002
Rpar28 vss vss.t22 275.0080
Rpar29 vss vss.t23 807.7685
Rpar30 vss.t0 vss.t1 42.2850
Rpar31 vss.t0 vss.t2 76.5568
Rpar32 vss.t0 vss.t18 1314.2844
Rpar33 vss.t0 vss.t22 5.0616
Rpar34 vss.t0 vss.t23 16.3303
Rpar35 vss.t1 vss.t2 209.1090
Rpar36 vss.t1 vss.t18 244.5319
Rpar37 vss.t1 vss.t22 31.7974
Rpar38 vss.t1 vss.t23 98.8185
Rpar39 vss.t2 vss.t18 480.2612
Rpar40 vss.t2 vss.t22 49.9226
Rpar41 vss.t2 vss.t23 129.4888
Rpar42 vss.t18 vss.t22 949.3950
Rpar43 vss.t18 vss.t23 2788.6143
Rpar44 vss.t22 vss.t23 10.5896
Cpar0 a_1141_6124.t0 vss 1.90327e-14
Cpar1 a_1141_6124.t1 vss 4.04591e-15
Cpar2 a_1141_6124.t4 vss 2.25838e-14
Cpar3 a_5050_8472.t0 vss 4.34162e-14
Cpar4 a_5050_8472.t32 vss 6.76619e-15
Cpar5 a_6878_1086.t0 vss 2.99072e-15
Cpar6 a_6878_1086.t4 vss 7.40259e-15
Cpar7 a_6878_1086.t5 vss 2.01651e-15
Cpar8 a_8334_8472.t0 vss 2.36046e-14
Cpar9 a_8334_8472.t32 vss 1.98933e-14
Cpar10 a_8334_8472.t33 vss 4.22885e-15
Cpar11 ib out 1.91630e-16
Cpar12 ib vdd 2.06100e-17
Cpar13 ib vss 2.19092e-14
Cpar14 ib.t0 vss 3.46955e-15
Cpar15 ib.t1 vss 1.59162e-16
Cpar16 inn inp 1.56220e-16
Cpar17 inn vdd 5.31000e-17
Cpar18 inn vss 2.57965e-14
Cpar19 inn.t0 vss 1.52536e-14
Cpar20 inp vdd 1.77890e-16
Cpar21 inp vss 2.59864e-14
Cpar22 inp.t0 vss 1.53433e-14
Cpar23 out vdd 4.62269e-15
Cpar24 out vss 1.80998e-14
Cpar25 out.t0 vss 1.22724e-15
Cpar26 out.t1 vss 1.35204e-15
Cpar27 out.t8 vss 9.26807e-15
Cpar28 vdd vss 9.39611e-14
Cpar29 vdd.t0 vss 2.04375e-14
Cpar30 vdd.t1 vss 1.35644e-14
.ends opamp_dut

Vdd vdd 0 1.800000
Vss vss 0 0
Ibias vdd ib 1.917000e-07
Vinp inp 0 DC 0.895000 AC 1 PWL(0 0.895000 1.486285e-07 0.895000 1.634913e-07 0.905000)
Rfb out inn 1m
Cload out 0 2.000000e-12
Xdut vdd vss inp inn out ib opamp_dut
.end
