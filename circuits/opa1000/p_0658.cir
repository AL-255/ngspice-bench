* opa1000[0658]: 2p/pmos_miller_3v3_1u_10u_weak (pmos_miller, VDD=3.3V, CL=2.0pF, Iref=0.8125uA)
.include "pdk_opa.inc"
.temp 27
.option gmin=1e-12 rshunt=1e12 reltol=1e-3 abstol=1e-12 vntol=1e-5 method=gear
* Post-PEX R+C extracted netlist for pmos_miller_3v3_1u_10u_weak
.subckt opamp_dut vdd vss inp inn out ib
XMpar0 a_1093_8502.t0 inp.t0 a_3066_1249.t1 vdd.t14 pfet_03v3 w=1.82u l=2.5u ad=5.0960e-13 pd=2.3800e-06 as=7.0373e-13 ps=3.2000e-06 nf=1 m=12 par=12
XMpar1 out.t0 a_2197_5997.t2 vdd.t1 vdd.t0 pfet_03v3 w=2.49u l=1.6u ad=8.5656e-13 pd=3.6760e-06 as=6.9720e-13 ps=3.0500e-06 nf=1 m=10 par=10
XMpar2 a_3066_1249.t0 a_2197_5997.t2 vdd.t1 vdd.t0 pfet_03v3 w=2.49u l=1.6u ad=6.9720e-13 pd=3.0500e-06 as=6.9720e-13 ps=3.0500e-06 nf=1 m=4 par=4
XMpar3 a_2197_5997.t3 a_2197_5997.t2 vdd.t1 vdd.t0 pfet_03v3 w=2.49u l=1.6u ad=6.9720e-13 pd=3.0500e-06 as=6.9720e-13 ps=3.0500e-06 nf=1 m=2 par=2
XMpar4 a_3066_1249.t1 inn.t0 a_6432_3941.t0 vdd.t14 pfet_03v3 w=1.82u l=2.5u ad=7.0373e-13 pd=3.2000e-06 as=5.0960e-13 ps=2.3800e-06 nf=1 m=12 par=12
XMpar5 out.t1 a_1093_8502.t15 vss.t1 vss.t0 nfet_03v3 w=0.89u l=1.25u ad=3.0616e-13 pd=1.7560e-06 as=3.0616e-13 ps=1.7560e-06 nf=1 m=10 par=10
XMpar6 ib.t1 ib.t0 vss.t7 vss.t6 nfet_03v3 w=0.57u l=1.6u ad=3.4200e-13 pd=2.3400e-06 as=1.5960e-13 ps=1.1300e-06 nf=1 m=2 par=2
XMpar7 a_1093_8502.t13 a_6432_3941.t12 vss.t1 vss.t0 nfet_03v3 w=0.89u l=1.25u ad=5.3400e-13 pd=2.9800e-06 as=2.4920e-13 ps=1.4500e-06 nf=1 m=2 par=2
XMpar8 a_6432_3941.t13 a_6432_3941.t12 vss.t1 vss.t0 nfet_03v3 w=0.89u l=1.25u ad=2.4920e-13 pd=1.4500e-06 as=2.4920e-13 ps=1.4500e-06 nf=1 m=2 par=2
XMpar9 a_2197_5997.t0 ib.t0 vss.t7 vss.t6 nfet_03v3 w=0.57u l=1.6u ad=1.5960e-13 pd=1.1300e-06 as=1.5960e-13 ps=1.1300e-06 nf=1 m=2 par=2
X20 a_1093_9022.t0 a_4203_8502.t0 vss.t21 ppolyf_u_1k r_width=1u r_length=14.89u
X23 a_1093_9022.t1 out.t11 cap_mim_2f0fF c_width=14.37u c_length=14.36u
X24 a_1093_8502.t12 a_4203_8502.t0 vss.t21 ppolyf_u_1k r_width=1u r_length=14.89u
X35 a_1093_9022.t1 out.t11 cap_mim_2f0fF c_width=14.37u c_length=14.36u
Rpar0 a_1093_8502.t0 a_1093_8502.t12 170.0582
Rpar1 a_1093_8502.t0 a_1093_8502.t13 85.0110
Rpar2 a_1093_8502.t0 a_1093_8502.t15 206.1373
Rpar3 a_1093_8502.t12 a_1093_8502.t13 276.3598
Rpar4 a_1093_8502.t12 a_1093_8502.t15 73.6822
Rpar5 a_1093_8502.t13 a_1093_8502.t15 334.9916
Rpar6 a_1093_9022.t0 a_1093_9022.t1 61.3509
Rpar7 a_2197_5997.t0 a_2197_5997.t2 118.4014
Rpar8 a_2197_5997.t0 a_2197_5997.t3 113.4889
Rpar9 a_2197_5997.t2 a_2197_5997.t3 24.6385
Rpar10 a_3066_1249.t0 a_3066_1249.t1 50.1697
Rpar11 a_6432_3941.t0 a_6432_3941.t12 92.7969
Rpar12 a_6432_3941.t0 a_6432_3941.t13 81.4138
Rpar13 a_6432_3941.t12 a_6432_3941.t13 31.1243
Rpar14 ib ib.t0 12.3598
Rpar15 ib ib.t1 7.4968
Rpar16 inn inn.t0 1.8864
Rpar17 inp inp.t0 1.8864
Rpar18 out out.t0 231.5348
Rpar19 out out.t1 4.0556
Rpar20 out out.t11 189.6854
Rpar21 out.t0 out.t1 120.9501
Rpar22 out.t0 out.t11 255.3803
Rpar23 out.t1 out.t11 99.0887
Rpar24 vdd vdd.t0 62.7211
Rpar25 vdd vdd.t1 274.0877
Rpar26 vdd vdd.t14 463.9416
Rpar27 vdd.t0 vdd.t1 4.7093
Rpar28 vdd.t0 vdd.t14 85.2515
Rpar29 vdd.t1 vdd.t14 372.5441
Rpar30 vss vss.t0 140.3646
Rpar31 vss vss.t1 136.5713
Rpar32 vss vss.t6 194.4571
Rpar33 vss vss.t7 299.0072
Rpar34 vss vss.t21 263.5334
Rpar35 vss.t0 vss.t1 6.8815
Rpar36 vss.t0 vss.t6 307.7769
Rpar37 vss.t0 vss.t7 487.8504
Rpar38 vss.t0 vss.t21 144.4860
Rpar39 vss.t1 vss.t6 187.3301
Rpar40 vss.t1 vss.t7 303.3839
Rpar41 vss.t1 vss.t21 60.4215
Rpar42 vss.t6 vss.t7 15.5280
Rpar43 vss.t6 vss.t21 49.4949
Rpar44 vss.t7 vss.t21 96.0429
Cpar0 a_1093_8502.t0 vss 6.35170e-15
Cpar1 a_1093_8502.t12 vss 2.90024e-15
Cpar2 a_1093_8502.t13 vss 2.74518e-15
Cpar3 a_1093_8502.t15 vss 7.39124e-15
Cpar4 a_1093_9022.t0 vss 1.46523e-16
Cpar5 a_1093_9022.t1 vss 5.52088e-15
Cpar6 a_2197_5997.t0 vss 2.05436e-15
Cpar7 a_2197_5997.t2 vss 2.35744e-14
Cpar8 a_2197_5997.t3 vss 3.91891e-15
Cpar9 a_3066_1249.t0 vss 1.02559e-14
Cpar10 a_3066_1249.t1 vss 2.17313e-14
Cpar11 a_4203_8502.t0 vss 3.47600e-17
Cpar12 a_6432_3941.t0 vss 8.87892e-15
Cpar13 a_6432_3941.t12 vss 4.85733e-15
Cpar14 a_6432_3941.t13 vss 2.01432e-15
Cpar15 ib out 4.77300e-17
Cpar16 ib vss 6.99925e-15
Cpar17 ib.t0 vss 6.95341e-16
Cpar18 ib.t1 vss 5.95700e-17
Cpar19 inn inp 1.02380e-16
Cpar20 inn vdd 1.37270e-14
Cpar21 inn vss 4.15182e-15
Cpar22 inn.t0 vss 1.62974e-14
Cpar23 inp vdd 1.36804e-14
Cpar24 inp vss 4.20729e-15
Cpar25 inp.t0 vss 1.62168e-14
Cpar26 out vdd 7.37490e-15
Cpar27 out vss 2.08624e-14
Cpar28 out.t0 vss 5.39101e-15
Cpar29 out.t1 vss 2.63986e-15
Cpar30 out.t11 vss 1.23496e-14
Cpar31 vdd vss 1.48094e-13
Cpar32 vdd.t0 vss 2.15523e-14
Cpar33 vdd.t1 vss 6.63471e-15
Cpar34 vdd.t14 vss 3.80908e-14
.ends opamp_dut

Vdd vdd 0 3.300000
Vss vss 0 0
Ibias vdd ib 8.125000e-07
Vinp inp 0 DC 1.480000 AC 1 PWL(0 1.480000 4.088890e-08 1.480000 4.497780e-08 1.490000)
Rfb out inn 1m
Cload out 0 2.000000e-12
Xdut vdd vss inp inn out ib opamp_dut
.end
