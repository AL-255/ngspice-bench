* opa1000[0977]: 2p/telescopic_pmos_1v8_i150u_weak (telescopic_pmos, VDD=1.8V, CL=2.0pF, Iref=34.5uA)
.include "pdk_opa.inc"
.temp 27
.option gmin=1e-12 rshunt=1e12 reltol=1e-3 abstol=1e-12 vntol=1e-5 method=gear
* Post-PEX R+C extracted netlist for telescopic_pmos_1v8_i150u_weak
.subckt opamp_dut vdd vss inp inn out ib
XMpar0 a_4904_3148.t0 a_5024_2940.t0 out.t0 vss.t0 nfet_03v3 w=1.93u l=0.48u ad=6.7274e-13 pd=3.0407e-06 as=6.2863e-13 ps=2.8571e-06 nf=1 m=28 par=28
XMpar1 a_3858_13247.t160 vss.t113 a_5024_2940.t56 vdd.t0 pfet_03v3 w=2.01u l=0.48u ad=6.0218e-13 pd=2.7322e-06 as=5.7593e-13 ps=2.6241e-06 nf=1 m=98 par=98
XMpar2 a_3602_13247.t0 inp.t0 a_3858_13247.t0 vdd.t7 pfet_03v3 w=3.46u l=0.68u ad=1.0380e-12 pd=4.2762e-06 as=9.6880e-13 ps=4.0200e-06 nf=1 m=160 par=160
XMpar3 ib.t1 ib.t0 vss.t2 vss.t1 nfet_03v3 w=1.89u l=0.39u ad=7.3080e-13 pd=3.2933e-06 as=5.2920e-13 ps=2.4500e-06 nf=1 m=6 par=6
XMpar4 a_11958_7491.t160 vss.t113 out.t9 vdd.t0 pfet_03v3 w=2.01u l=0.48u ad=6.0218e-13 pd=2.7322e-06 as=5.7593e-13 ps=2.6241e-06 nf=1 m=98 par=98
XMpar5 a_3602_13247.t160 a_5636_10376.t0 vdd.t4 vdd.t3 pfet_03v3 w=6.45u l=0.39u ad=1.8060e-12 pd=7.0100e-06 as=1.9780e-12 ps=7.6008e-06 nf=1 m=24 par=24
XMpar6 a_5636_10376.t12 ib.t0 vss.t2 vss.t1 nfet_03v3 w=1.89u l=0.39u ad=5.2920e-13 pd=2.4500e-06 as=5.2920e-13 ps=2.4500e-06 nf=1 m=6 par=6
XMpar7 a_11958_7491.t0 inn.t0 a_3602_13247.t0 vdd.t7 pfet_03v3 w=3.46u l=0.68u ad=9.6880e-13 pd=4.0200e-06 as=1.0380e-12 ps=4.2762e-06 nf=1 m=160 par=160
XMpar8 a_5024_2940.t1 a_5024_2940.t0 a_6636_3148.t0 vss.t0 nfet_03v3 w=1.93u l=0.48u ad=6.2863e-13 pd=2.8571e-06 as=6.2863e-13 ps=2.8571e-06 nf=1 m=28 par=28
XMpar9 a_5636_10376.t1 a_5636_10376.t0 vdd.t4 vdd.t3 pfet_03v3 w=6.45u l=0.39u ad=1.8060e-12 pd=7.0100e-06 as=1.8060e-12 ps=7.0100e-06 nf=1 m=6 par=6
XMpar10 a_6636_3148.t3 a_5024_2940.t154 vss.t46 vss.t0 nfet_03v3 w=2.04u l=0.42u ad=5.7120e-13 pd=2.6000e-06 as=6.5280e-13 ps=2.9350e-06 nf=1 m=8 par=8
XMpar11 a_4904_3148.t18 a_5024_2940.t154 vss.t46 vss.t0 nfet_03v3 w=2.04u l=0.42u ad=5.7120e-13 pd=2.6000e-06 as=6.5280e-13 ps=2.9350e-06 nf=1 m=8 par=8
X595 out.t126 vss.t38 cap_mim_2f0fF c_width=15u c_length=15u
Rpar0 a_11958_7491.t0 a_11958_7491.t160 61.4461
Rpar1 a_3602_13247.t0 a_3602_13247.t160 40.1978
Rpar2 a_3858_13247.t0 a_3858_13247.t160 61.4461
Rpar3 a_4904_3148.t0 a_4904_3148.t18 52.7619
Rpar4 a_5024_2940.t0 a_5024_2940.t1 16.8147
Rpar5 a_5024_2940.t0 a_5024_2940.t56 457.2170
Rpar6 a_5024_2940.t0 a_5024_2940.t154 385.3729
Rpar7 a_5024_2940.t1 a_5024_2940.t56 144.4967
Rpar8 a_5024_2940.t1 a_5024_2940.t154 121.7914
Rpar9 a_5024_2940.t56 a_5024_2940.t154 243.9881
Rpar10 a_5636_10376.t0 a_5636_10376.t1 19.2490
Rpar11 a_5636_10376.t0 a_5636_10376.t12 207.2634
Rpar12 a_5636_10376.t1 a_5636_10376.t12 57.8081
Rpar13 a_6636_3148.t0 a_6636_3148.t3 80.0628
Rpar14 ib ib.t0 23.2821
Rpar15 ib ib.t1 2.8619
Rpar16 ib.t0 ib.t1 46.9377
Rpar17 inn inn.t0 1.5317
Rpar18 inp inp.t0 1.5317
Rpar19 out out.t0 65.4512
Rpar20 out out.t9 1.7159
Rpar21 out out.t126 205.8935
Rpar22 out.t0 out.t126 97.1152
Rpar23 vdd vdd.t0 326.1565
Rpar24 vdd vdd.t7 19.8174
Rpar25 vdd vdd.t3 2057.0623
Rpar26 vdd.t0 vdd.t7 113.6115
Rpar27 vdd.t0 vdd.t3 40.4798
Rpar28 vdd.t0 vdd.t4 172.2617
Rpar29 vdd.t7 vdd.t3 716.5451
Rpar30 vdd.t7 vdd.t4 3049.2596
Rpar31 vdd.t3 vdd.t4 2.8734
Rpar32 vss vss.t0 48.1549
Rpar33 vss vss.t1 1616.5255
Rpar34 vss vss.t2 2890.6724
Rpar35 vss vss.t113 502.2571
Rpar36 vss vss.t38 393.4332
Rpar37 vss vss.t46 309.3196
Rpar38 vss.t0 vss.t1 5.2679
Rpar39 vss.t0 vss.t2 10.3109
Rpar40 vss.t0 vss.t113 106.8542
Rpar41 vss.t0 vss.t38 142.1427
Rpar42 vss.t0 vss.t46 3.6433
Rpar43 vss.t1 vss.t2 7.2804
Rpar44 vss.t1 vss.t113 154.1415
Rpar45 vss.t1 vss.t38 790.4431
Rpar46 vss.t2 vss.t113 275.9640
Rpar47 vss.t2 vss.t38 1412.7702
Rpar48 vss.t113 vss.t38 99.0793
Rpar49 vss.t113 vss.t46 3820.0903
Rpar50 vss.t38 vss.t46 3304.1792
Cpar0 a_11958_7491.t0 vss 1.44452e-13
Cpar1 a_11958_7491.t160 vss 5.92066e-14
Cpar2 a_3602_13247.t0 vss 2.67158e-13
Cpar3 a_3602_13247.t160 vss 3.37437e-14
Cpar4 a_3858_13247.t0 vss 1.45961e-13
Cpar5 a_3858_13247.t160 vss 5.98248e-14
Cpar6 a_4904_3148.t0 vss 1.97035e-14
Cpar7 a_4904_3148.t18 vss 7.49402e-15
Cpar8 a_5024_2940.t0 vss 2.25764e-14
Cpar9 a_5024_2940.t1 vss 2.02937e-14
Cpar10 a_5024_2940.t154 vss 9.28161e-15
Cpar11 a_5024_2940.t56 vss 4.35494e-14
Cpar12 a_5636_10376.t0 vss 2.13695e-14
Cpar13 a_5636_10376.t1 vss 1.10831e-14
Cpar14 a_5636_10376.t12 vss 4.39939e-15
Cpar15 a_6636_3148.t0 vss 2.52961e-14
Cpar16 a_6636_3148.t3 vss 8.83206e-15
Cpar17 ib vdd 7.92700e-17
Cpar18 ib vss 1.18956e-14
Cpar19 ib.t0 vss 9.01259e-16
Cpar20 ib.t1 vss 4.66725e-16
Cpar21 inn inp 2.58380e-16
Cpar22 inn vdd 6.13525e-14
Cpar23 inn vss 9.77916e-15
Cpar24 inn.t0 vss 1.10195e-13
Cpar25 inp vdd 6.17493e-14
Cpar26 inp vss 9.81305e-15
Cpar27 inp.t0 vss 1.10334e-13
Cpar28 out vdd 1.07639e-14
Cpar29 out vss 3.72346e-14
Cpar30 out.t0 vss 1.34793e-14
Cpar31 out.t126 vss 5.03891e-14
Cpar32 out.t9 vss 2.47534e-14
Cpar33 vdd vss 7.43885e-13
Cpar34 vdd.t0 vss 7.43719e-14
Cpar35 vdd.t3 vss 2.02260e-14
Cpar36 vdd.t4 vss 9.61606e-15
Cpar37 vdd.t7 vss 1.54784e-13
.ends opamp_dut

Vdd vdd 0 1.800000
Vss vss 0 0
Ibias vdd ib 3.450000e-05
Vinp inp 0 DC 0.805000 AC 1 PWL(0 0.805000 3.000000e-09 0.805000 3.300000e-09 0.815000)
Rfb out inn 1m
Cload out 0 2.000000e-12
Xdut vdd vss inp inn out ib opamp_dut
.end
