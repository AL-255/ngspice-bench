* opa1000[0803]: 2p/symmetrical_ota_1v8_1u_10u_weak (symmetrical_ota, VDD=1.8V, CL=2.0pF, Iref=0.9583uA)
.include "pdk_opa.inc"
.temp 27
.option gmin=1e-12 rshunt=1e12 reltol=1e-3 abstol=1e-12 vntol=1e-5 method=gear
* Post-PEX R+C extracted netlist for symmetrical_ota_1v8_1u_10u_weak
.subckt opamp_dut vdd vss inp inn out ib
XMpar0 a_6934_3047.t5 a_6934_3047.t4 vdd.t1 vdd.t0 pfet_03v3 w=3.83u l=3.13u ad=1.0724e-12 pd=4.3900e-06 as=1.0724e-12 ps=4.3900e-06 nf=1 m=2 par=2
XMpar1 a_1295_6425.t5 a_1295_6425.t4 vdd.t1 vdd.t0 pfet_03v3 w=3.83u l=3.13u ad=1.0724e-12 pd=4.3900e-06 as=1.0724e-12 ps=4.3900e-06 nf=1 m=2 par=2
XMpar2 out.t0 a_1295_6425.t4 vdd.t1 vdd.t0 pfet_03v3 w=3.83u l=3.13u ad=1.0724e-12 pd=4.3900e-06 as=1.6852e-12 ps=6.6250e-06 nf=1 m=4 par=4
XMpar3 a_4050_3047.t4 ib.t0 vss.t11 vss.t10 nfet_03v3 w=1.53u l=3u ad=4.2840e-13 pd=2.0900e-06 as=6.7320e-13 ps=3.1750e-06 nf=1 m=4 par=4
XMpar4 out.t1 a_3564_4659.t3 vss.t5 vss.t4 nfet_03v3 w=0.93u l=3.13u ad=2.6040e-13 pd=1.4900e-06 as=4.0920e-13 ps=2.2750e-06 nf=1 m=4 par=4
XMpar5 ib.t1 ib.t0 vss.t11 vss.t10 nfet_03v3 w=1.53u l=3u ad=4.2840e-13 pd=2.0900e-06 as=4.2840e-13 ps=2.0900e-06 nf=1 m=2 par=2
XMpar6 a_3564_4659.t0 a_6934_3047.t4 vdd.t1 vdd.t0 pfet_03v3 w=3.83u l=3.13u ad=1.0724e-12 pd=4.3900e-06 as=1.6852e-12 ps=6.6250e-06 nf=1 m=4 par=4
XMpar7 a_4050_3047.t0 inn.t0 a_6934_3047.t0 vss.t0 nfet_03v3 w=1.99u l=2u ad=8.7560e-13 pd=3.8650e-06 as=5.5720e-13 ps=2.5500e-06 nf=1 m=4 par=4
XMpar8 a_3564_4659.t4 a_3564_4659.t3 vss.t5 vss.t4 nfet_03v3 w=0.93u l=3.13u ad=2.6040e-13 pd=1.4900e-06 as=2.6040e-13 ps=1.4900e-06 nf=1 m=4 par=4
XMpar9 a_1295_6425.t0 inp.t0 a_4050_3047.t0 vss.t0 nfet_03v3 w=1.99u l=2u ad=5.5720e-13 pd=2.5500e-06 as=8.7560e-13 ps=3.8650e-06 nf=1 m=4 par=4
X34 out.t8 vss.t30 cap_mim_2f0fF c_width=6.71u c_length=6.71u
Rpar0 a_1295_6425.t0 a_1295_6425.t4 130.7745
Rpar1 a_1295_6425.t0 a_1295_6425.t5 92.6516
Rpar2 a_1295_6425.t4 a_1295_6425.t5 23.2543
Rpar3 a_3564_4659.t0 a_3564_4659.t4 61.5095
Rpar4 a_3564_4659.t0 a_3564_4659.t3 146.9104
Rpar5 a_3564_4659.t4 a_3564_4659.t3 21.8466
Rpar6 a_4050_3047.t0 a_4050_3047.t4 38.4519
Rpar7 a_6934_3047.t0 a_6934_3047.t4 130.7745
Rpar8 a_6934_3047.t0 a_6934_3047.t5 92.6516
Rpar9 a_6934_3047.t4 a_6934_3047.t5 23.2543
Rpar10 ib ib.t0 18.6986
Rpar11 ib ib.t1 12.0330
Rpar12 ib.t0 ib.t1 85.0331
Rpar13 inn inn.t0 2.9051
Rpar14 inp inp.t0 2.9537
Rpar15 out out.t0 4.4623
Rpar16 out out.t1 51.5689
Rpar17 out out.t8 102.8250
Rpar18 out.t1 out.t8 78.4487
Rpar19 vdd vdd.t0 35.0095
Rpar20 vdd vdd.t1 55.1227
Rpar21 vdd.t0 vdd.t1 3.3598
Rpar22 vss vss.t0 139.6608
Rpar23 vss vss.t10 164.8921
Rpar24 vss vss.t11 617.2429
Rpar25 vss vss.t4 179.9592
Rpar26 vss vss.t5 801.4196
Rpar27 vss vss.t30 72.1873
Rpar28 vss.t0 vss.t10 2.3388
Rpar29 vss.t0 vss.t11 13.2686
Rpar30 vss.t0 vss.t4 2.6510
Rpar31 vss.t0 vss.t5 14.4290
Rpar32 vss.t0 vss.t30 304.1003
Rpar33 vss.t10 vss.t11 15.2405
Rpar34 vss.t10 vss.t4 1.6412
Rpar35 vss.t10 vss.t5 18.3387
Rpar36 vss.t10 vss.t30 359.0394
Rpar37 vss.t11 vss.t4 18.5973
Rpar38 vss.t11 vss.t5 106.4017
Rpar39 vss.t11 vss.t30 1343.9972
Rpar40 vss.t4 vss.t5 15.4324
Rpar41 vss.t4 vss.t30 391.8467
Rpar42 vss.t5 vss.t30 1745.0272
Cpar0 a_1295_6425.t0 vss 3.57437e-15
Cpar1 a_1295_6425.t4 vss 1.54030e-14
Cpar2 a_1295_6425.t5 vss 3.33976e-15
Cpar3 a_3564_4659.t0 vss 3.09190e-15
Cpar4 a_3564_4659.t3 vss 7.03099e-15
Cpar5 a_3564_4659.t4 vss 1.76320e-15
Cpar6 a_4050_3047.t0 vss 5.49538e-15
Cpar7 a_4050_3047.t4 vss 2.58891e-15
Cpar8 a_6934_3047.t0 vss 3.48766e-15
Cpar9 a_6934_3047.t4 vss 1.50294e-14
Cpar10 a_6934_3047.t5 vss 3.25876e-15
Cpar11 ib inn 1.22700e-17
Cpar12 ib inp 1.75900e-17
Cpar13 ib vss 1.45181e-14
Cpar14 ib.t0 vss 2.26412e-15
Cpar15 ib.t1 vss 1.01748e-16
Cpar16 inn inp 5.13900e-17
Cpar17 inn vss 5.29656e-15
Cpar18 inn.t0 vss 8.98197e-16
Cpar19 inp vss 5.13499e-15
Cpar20 inp.t0 vss 9.32937e-16
Cpar21 out vdd 3.75718e-15
Cpar22 out vss 1.06040e-14
Cpar23 out.t0 vss 1.07868e-15
Cpar24 out.t1 vss 1.67264e-15
Cpar25 out.t8 vss 7.65019e-15
Cpar26 vdd vss 8.04986e-14
Cpar27 vdd.t0 vss 1.91693e-14
Cpar28 vdd.t1 vss 1.22377e-14
.ends opamp_dut

Vdd vdd 0 1.800000
Vss vss 0 0
Ibias vdd ib 9.583000e-07
Vinp inp 0 DC 0.895000 AC 1 PWL(0 0.895000 3.955839e-08 0.895000 4.351423e-08 0.905000)
Rfb out inn 1m
Cload out 0 2.000000e-12
Xdut vdd vss inp inn out ib opamp_dut
.end
