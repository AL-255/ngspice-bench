* opa1000[0275]: 200f/folded_cascode_pmos_3v3_0p1u_1u_subth (folded_cascode_pmos, VDD=3.3V, CL=0.2pF, Iref=0.0778uA)
.include "pdk_opa.inc"
.temp 27
.option gmin=1e-12 rshunt=1e12 reltol=1e-3 abstol=1e-12 vntol=1e-5 method=gear
* Post-PEX R+C extracted netlist for folded_cascode_pmos_3v3_0p1u_1u_subth
.subckt opamp_dut vdd vss inp inn out ib
XMpar0 a_5614_1204.t11 ib vss.t2 vss.t1 nfet_03v3 w=0.4u l=3u ad=1.1200e-13 pd=9.6000e-07 as=1.7600e-13 ps=1.4800e-06 nf=1 m=4 par=4
XMpar1 a_1538_1204.t1 inp.t0 a_2298_1204.t0 vdd.t2 pfet_03v3 w=1.92u l=3.2u ad=6.6048e-13 pd=2.9920e-06 as=6.6048e-13 ps=2.9920e-06 nf=1 m=10 par=10
XMpar2 a_1538_1204.t1 inn.t0 a_5614_1204.t1 vdd.t2 pfet_03v3 w=1.92u l=3.2u ad=6.6048e-13 pd=2.9920e-06 as=6.6048e-13 ps=2.9920e-06 nf=1 m=10 par=10
XMpar3 a_2298_1204.t14 a_1366_10540.t6 a_3292_8707.t4 vss.t0 nfet_03v3 w=0.58u l=1.6u ad=3.4800e-13 pd=2.3600e-06 as=1.6240e-13 ps=1.1400e-06 nf=1 m=2 par=2
XMpar4 a_1366_10540.t3 a_1366_10540.t2 vdd.t1 vdd.t0 pfet_03v3 w=2.53u l=5.2u ad=7.0840e-13 pd=3.0900e-06 as=7.0840e-13 ps=3.0900e-06 nf=1 m=2 par=2
XMpar5 a_2298_1204.t10 ib vss.t2 vss.t1 nfet_03v3 w=0.4u l=3u ad=1.1200e-13 pd=9.6000e-07 as=1.7600e-13 ps=1.4800e-06 nf=1 m=4 par=4
XMpar6 a_3292_8707.t1 a_3292_8707.t0 vdd.t1 vdd.t0 pfet_03v3 w=2.53u l=5.2u ad=1.5180e-12 pd=6.2600e-06 as=7.0840e-13 ps=3.0900e-06 nf=1 m=2 par=2
XMpar7 a_1366_10540.t0 ib vss.t2 vss.t1 nfet_03v3 w=0.4u l=3u ad=1.1200e-13 pd=9.6000e-07 as=1.1200e-13 ps=9.6000e-07 nf=1 m=2 par=2
XMpar8 out.t1 a_3292_8707.t0 vdd.t1 vdd.t0 pfet_03v3 w=2.53u l=5.2u ad=7.0840e-13 pd=3.0900e-06 as=7.0840e-13 ps=3.0900e-06 nf=1 m=2 par=2
XMpar9 a_1538_1204.t0 a_1366_10540.t2 vdd.t1 vdd.t0 pfet_03v3 w=2.53u l=5.2u ad=7.0840e-13 pd=3.0900e-06 as=1.1132e-12 ps=4.6750e-06 nf=1 m=4 par=4
XMpar10 a_5614_1204.t0 a_1366_10540.t6 out.t0 vss.t0 nfet_03v3 w=0.58u l=1.6u ad=3.4800e-13 pd=2.3600e-06 as=1.6240e-13 ps=1.1400e-06 nf=1 m=2 par=2
XMpar11 ib.t1 ib vss.t2 vss.t1 nfet_03v3 w=0.4u l=3u ad=2.4000e-13 pd=2.0000e-06 as=1.1200e-13 ps=9.6000e-07 nf=1 m=2 par=2
Rpar0 a_1366_10540.t0 a_1366_10540.t2 202.0611
Rpar1 a_1366_10540.t0 a_1366_10540.t3 177.4353
Rpar2 a_1366_10540.t0 a_1366_10540.t6 83.8263
Rpar3 a_1366_10540.t2 a_1366_10540.t3 24.6134
Rpar4 a_1366_10540.t2 a_1366_10540.t6 254.0913
Rpar5 a_1366_10540.t3 a_1366_10540.t6 223.1245
Rpar6 a_1538_1204.t0 a_1538_1204.t1 62.9051
Rpar7 a_2298_1204.t0 a_2298_1204.t10 59.2100
Rpar8 a_2298_1204.t0 a_2298_1204.t14 99.3245
Rpar9 a_2298_1204.t10 a_2298_1204.t14 64.2964
Rpar10 a_3292_8707.t0 a_3292_8707.t1 17.7368
Rpar11 a_3292_8707.t0 a_3292_8707.t4 178.9274
Rpar12 a_3292_8707.t1 a_3292_8707.t4 64.1791
Rpar13 a_5614_1204.t0 a_5614_1204.t1 99.3245
Rpar14 a_5614_1204.t0 a_5614_1204.t11 64.2964
Rpar15 a_5614_1204.t1 a_5614_1204.t11 59.2100
Rpar16 ib ib.t1 17.6519
Rpar17 inn inn.t0 1.9741
Rpar18 inp inp.t0 1.9741
Rpar19 out out.t0 13.2900
Rpar20 out out.t1 39.8972
Rpar21 vdd vdd.t0 33.4017
Rpar22 vdd vdd.t1 54.5645
Rpar23 vdd vdd.t2 319.5061
Rpar24 vdd.t0 vdd.t1 4.4914
Rpar25 vdd.t0 vdd.t2 77.9722
Rpar26 vdd.t1 vdd.t2 116.1830
Rpar27 vss vss.t0 309.9432
Rpar28 vss vss.t1 73.7356
Rpar29 vss vss.t2 244.7320
Rpar30 vss.t0 vss.t1 7.7537
Rpar31 vss.t0 vss.t2 29.4795
Rpar32 vss.t1 vss.t2 5.5603
Cpar0 a_1366_10540.t0 vss 2.75701e-15
Cpar1 a_1366_10540.t2 vss 2.07150e-14
Cpar2 a_1366_10540.t3 vss 3.63185e-15
Cpar3 a_1366_10540.t6 vss 4.64716e-15
Cpar4 a_1538_1204.t0 vss 8.96652e-15
Cpar5 a_1538_1204.t1 vss 2.25618e-14
Cpar6 a_2298_1204.t0 vss 1.20491e-14
Cpar7 a_2298_1204.t10 vss 3.64700e-15
Cpar8 a_2298_1204.t14 vss 2.58108e-15
Cpar9 a_3292_8707.t0 vss 1.39371e-14
Cpar10 a_3292_8707.t1 vss 4.24854e-15
Cpar11 a_3292_8707.t4 vss 1.31861e-15
Cpar12 a_5614_1204.t0 vss 2.27551e-15
Cpar13 a_5614_1204.t1 vss 1.06226e-14
Cpar14 a_5614_1204.t11 vss 3.21524e-15
Cpar15 ib inp 2.05000e-17
Cpar16 ib vdd 8.33900e-17
Cpar17 ib vss 2.86902e-14
Cpar18 ib.t1 vss 4.57236e-16
Cpar19 inn inp 1.03640e-16
Cpar20 inn vdd 1.41281e-14
Cpar21 inn vss 4.26985e-15
Cpar22 inn.t0 vss 1.64708e-14
Cpar23 inp vdd 1.40278e-14
Cpar24 inp vss 4.13901e-15
Cpar25 inp.t0 vss 1.64082e-14
Cpar26 out vdd 3.37794e-15
Cpar27 out vss 4.57675e-15
Cpar28 out.t0 vss 1.62639e-16
Cpar29 out.t1 vss 4.30268e-15
Cpar30 vdd vss 1.70808e-13
Cpar31 vdd.t0 vss 2.38699e-14
Cpar32 vdd.t1 vss 1.64366e-14
Cpar33 vdd.t2 vss 3.83275e-14
.ends opamp_dut

Vdd vdd 0 3.300000
Vss vss 0 0
Ibias vdd ib 7.780000e-08
Vinp inp 0 DC 1.381000 AC 1 PWL(0 1.381000 9.635320e-08 1.381000 1.059885e-07 1.391000)
Rfb out inn 1m
Cload out 0 2.000000e-13
Xdut vdd vss inp inn out ib opamp_dut
.end
