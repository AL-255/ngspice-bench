* opa1000[0581]: 2p/pmos_5t_3v3_i150u_weak (pmos_5t, VDD=3.3V, CL=2.0pF, Iref=39.0uA)
.include "pdk_opa.inc"
.temp 27
.option gmin=1e-12 rshunt=1e12 reltol=1e-3 abstol=1e-12 vntol=1e-5 method=gear
* Post-PEX R+C extracted netlist for pmos_5t_3v3_i150u_weak
.subckt opamp_dut vdd vss inp inn out ib
XMpar0 a_1372_11188.t0 a_1176_10980.t6 vdd.t1 vdd.t0 pfet_03v3 w=10u l=0.98u ad=2.8000e-12 pd=1.0560e-05 as=3.0667e-12 ps=1.1447e-05 nf=1 m=24 par=24
XMpar1 a_1372_11188.t12 inn.t0 out.t11 vdd.t32 pfet_03v3 w=2.7u l=0.68u ad=7.9920e-13 pd=3.4270e-06 as=7.7760e-13 ps=3.3435e-06 nf=1 m=160 par=160
XMpar2 a_1372_11188.t12 inp.t0 a_1738_1205.t0 vdd.t32 pfet_03v3 w=2.7u l=0.68u ad=7.9920e-13 pd=3.4270e-06 as=7.7760e-13 ps=3.3435e-06 nf=1 m=160 par=160
XMpar3 out.t0 a_1738_1205.t160 vss.t1 vss.t0 nfet_03v3 w=1.95u l=0.88u ad=5.4600e-13 pd=2.5100e-06 as=5.4600e-13 ps=2.5100e-06 nf=1 m=16 par=16
XMpar4 a_1738_1205.t161 a_1738_1205.t160 vss.t1 vss.t0 nfet_03v3 w=1.95u l=0.88u ad=5.4600e-13 pd=2.5100e-06 as=6.2400e-13 ps=2.8337e-06 nf=1 m=16 par=16
XMpar5 a_1176_10980.t7 a_1176_10980.t6 vdd.t1 vdd.t0 pfet_03v3 w=10u l=0.98u ad=2.8000e-12 pd=1.0560e-05 as=2.8000e-12 ps=1.0560e-05 nf=1 m=6 par=6
XMpar6 a_1176_10980.t0 ib.t0 vss.t53 vss.t0 nfet_03v3 w=5.2u l=0.98u ad=1.4560e-12 pd=5.7600e-06 as=1.4560e-12 ps=5.7600e-06 nf=1 m=6 par=6
XMpar7 ib.t1 ib.t0 vss.t53 vss.t0 nfet_03v3 w=5.2u l=0.98u ad=2.0107e-12 pd=7.7067e-06 as=1.4560e-12 ps=5.7600e-06 nf=1 m=6 par=6
Rpar0 a_1176_10980.t0 a_1176_10980.t6 420.9441
Rpar1 a_1176_10980.t0 a_1176_10980.t7 29.4993
Rpar2 a_1176_10980.t6 a_1176_10980.t7 18.9408
Rpar3 a_1372_11188.t0 a_1372_11188.t12 49.3749
Rpar4 a_1738_1205.t0 a_1738_1205.t160 205.8906
Rpar5 a_1738_1205.t0 a_1738_1205.t161 63.0221
Rpar6 a_1738_1205.t160 a_1738_1205.t161 14.8813
Rpar7 ib ib.t0 34.6240
Rpar8 ib ib.t1 2.3994
Rpar9 ib.t0 ib.t1 27.5391
Rpar10 inn inn.t0 1.5661
Rpar11 inp inp.t0 1.5661
Rpar12 out out.t0 3.1784
Rpar13 out out.t11 45.3153
Rpar14 vdd vdd.t0 613.3073
Rpar15 vdd vdd.t1 6032.7488
Rpar16 vdd vdd.t32 49.8733
Rpar17 vdd.t0 vdd.t1 4.4846
Rpar18 vdd.t0 vdd.t32 72.6462
Rpar19 vdd.t1 vdd.t32 714.5785
Rpar20 vss vss.t0 62.1153
Rpar21 vss vss.t1 516.4608
Rpar22 vss vss.t53 295.7997
Rpar23 vss.t0 vss.t1 3.8107
Rpar24 vss.t0 vss.t53 4.9022
Rpar25 vss.t1 vss.t53 69.4122
Cpar0 a_1176_10980.t0 vss 5.01682e-15
Cpar1 a_1176_10980.t6 vss 4.32879e-14
Cpar2 a_1176_10980.t7 vss 1.02372e-14
Cpar3 a_1372_11188.t0 vss 5.04043e-14
Cpar4 a_1372_11188.t12 vss 2.19340e-13
Cpar5 a_1738_1205.t0 vss 1.03654e-13
Cpar6 a_1738_1205.t160 vss 2.50086e-14
Cpar7 a_1738_1205.t161 vss 1.18910e-14
Cpar8 ib out 1.44000e-17
Cpar9 ib vdd 3.63430e-16
Cpar10 ib vss 1.83382e-14
Cpar11 ib.t0 vss 2.27481e-15
Cpar12 ib.t1 vss 1.04400e-15
Cpar13 inn inp 2.53610e-16
Cpar14 inn out 3.11430e-14
Cpar15 inn vdd 6.10493e-14
Cpar16 inn vss 9.05339e-15
Cpar17 inn.t0 vss 1.06084e-13
Cpar18 inp vdd 6.10381e-14
Cpar19 inp vss 8.95629e-15
Cpar20 inp.t0 vss 1.06084e-13
Cpar21 out vdd 1.61954e-14
Cpar22 out vss 1.96544e-14
Cpar23 out.t0 vss 1.00214e-14
Cpar24 out.t11 vss 1.22946e-13
Cpar25 vdd vss 5.04673e-13
Cpar26 vdd.t0 vss 4.74657e-14
Cpar27 vdd.t1 vss 1.65743e-14
Cpar28 vdd.t32 vss 1.70115e-13
.ends opamp_dut

Vdd vdd 0 3.300000
Vss vss 0 0
Ibias vdd ib 3.900000e-05
Vinp inp 0 DC 1.480000 AC 1 PWL(0 1.480000 3.000000e-09 1.480000 3.300000e-09 1.490000)
Rfb out inn 1m
Cload out 0 2.000000e-12
Xdut vdd vss inp inn out ib opamp_dut
.end
