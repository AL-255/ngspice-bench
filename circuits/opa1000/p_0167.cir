* opa1000[0167]: 200f/folded_cascode_nmos_1v8_ulp_lt0p1uw_weak (folded_cascode_nmos, VDD=1.8V, CL=0.2pF, Iref=0.0014uA)
.include "pdk_opa.inc"
.temp 27
.option gmin=1e-12 rshunt=1e12 reltol=1e-3 abstol=1e-12 vntol=1e-5 method=gear
* Post-PEX R+C extracted netlist for folded_cascode_nmos_1v8_ulp_lt0p1uw_weak
.subckt opamp_dut vdd vss inp inn out ib
XMpar0 out.t0 a_2212_10012.t0 vss.t1 vss.t0 nfet_03v3 w=0.4u l=9.5u ad=1.1200e-13 pd=9.6000e-07 as=1.1200e-13 ps=9.6000e-07 nf=1 m=2 par=2
XMpar1 a_2212_10012.t4 ib.t10 a_4114_8512.t3 vdd.t11 pfet_03v3 w=0.4u l=4u ad=1.1200e-13 pd=9.6000e-07 as=2.4000e-13 ps=2.0000e-06 nf=1 m=2 par=2
XMpar2 a_6254_8512.t0 a_3234_5927.t0 vdd.t1 vdd.t0 pfet_03v3 w=0.4u l=6.5u ad=1.1200e-13 pd=9.6000e-07 as=2.4000e-13 ps=2.0000e-06 nf=1 m=4 par=4
XMpar3 a_2212_10012.t1 a_2212_10012.t0 vss.t1 vss.t0 nfet_03v3 w=0.4u l=9.5u ad=2.4000e-13 pd=2.0000e-06 as=1.1200e-13 ps=9.6000e-07 nf=1 m=2 par=2
XMpar4 a_1684_2750.t4 inp.t0 a_4114_8512.t5 vss.t22 nfet_03v3 w=0.4u l=8u ad=2.4000e-13 pd=2.0000e-06 as=1.1200e-13 ps=9.6000e-07 nf=1 m=2 par=2
XMpar5 a_4114_8512.t0 a_3234_5927.t0 vdd.t1 vdd.t0 pfet_03v3 w=0.4u l=6.5u ad=1.1200e-13 pd=9.6000e-07 as=2.4000e-13 ps=2.0000e-06 nf=1 m=4 par=4
XMpar6 a_6254_8512.t2 ib.t10 out.t1 vdd.t11 pfet_03v3 w=0.4u l=4u ad=2.4000e-13 pd=2.0000e-06 as=1.1200e-13 ps=9.6000e-07 nf=1 m=2 par=2
XMpar7 a_1684_2750.t0 ib.t0 vss.t1 vss.t0 nfet_03v3 w=0.4u l=9.5u ad=2.4000e-13 pd=2.0000e-06 as=1.1200e-13 ps=9.6000e-07 nf=1 m=4 par=4
XMpar8 a_1684_2750.t4 inn.t0 a_6254_8512.t4 vss.t22 nfet_03v3 w=0.4u l=8u ad=2.4000e-13 pd=2.0000e-06 as=1.1200e-13 ps=9.6000e-07 nf=1 m=2 par=2
XMpar9 a_3234_5927.t1 a_3234_5927.t0 vdd.t1 vdd.t0 pfet_03v3 w=0.4u l=6.5u ad=1.1200e-13 pd=9.6000e-07 as=2.4000e-13 ps=2.0000e-06 nf=1 m=2 par=2
XMpar10 ib.t1 ib.t0 vss.t1 vss.t0 nfet_03v3 w=0.4u l=9.5u ad=2.4000e-13 pd=2.0000e-06 as=1.1200e-13 ps=9.6000e-07 nf=1 m=2 par=2
XMpar11 a_3234_5927.t4 ib.t0 vss.t1 vss.t0 nfet_03v3 w=0.4u l=9.5u ad=2.4000e-13 pd=2.0000e-06 as=1.1200e-13 ps=9.6000e-07 nf=1 m=2 par=2
X16 out.t4 vss.t4 cap_mim_2f0fF c_width=14.82u c_length=14.81u
X23 out.t4 vss.t4 cap_mim_2f0fF c_width=14.82u c_length=14.81u
Rpar0 a_1684_2750.t0 a_1684_2750.t4 52.6560
Rpar1 a_2212_10012.t0 a_2212_10012.t1 22.9399
Rpar2 a_2212_10012.t0 a_2212_10012.t4 133.2809
Rpar3 a_2212_10012.t1 a_2212_10012.t4 105.4827
Rpar4 a_3234_5927.t0 a_3234_5927.t1 26.4839
Rpar5 a_3234_5927.t0 a_3234_5927.t4 67.3470
Rpar6 a_3234_5927.t1 a_3234_5927.t4 185.8161
Rpar7 a_4114_8512.t0 a_4114_8512.t3 58.1550
Rpar8 a_4114_8512.t0 a_4114_8512.t5 101.5262
Rpar9 a_4114_8512.t3 a_4114_8512.t5 159.1776
Rpar10 a_6254_8512.t0 a_6254_8512.t2 58.1550
Rpar11 a_6254_8512.t0 a_6254_8512.t4 101.5262
Rpar12 a_6254_8512.t2 a_6254_8512.t4 159.1776
Rpar13 ib ib.t0 11.7604
Rpar14 ib ib.t1 19.8980
Rpar15 ib ib.t10 92.7346
Rpar16 ib.t0 ib.t1 34.4912
Rpar17 ib.t0 ib.t10 319.5998
Rpar18 ib.t1 ib.t10 169.8120
Rpar19 inn inn.t0 3.3924
Rpar20 inp inp.t0 3.4410
Rpar21 out out.t0 87.5279
Rpar22 out out.t1 13.5345
Rpar23 out out.t4 160.6699
Rpar24 out.t0 out.t4 139.8870
Rpar25 vdd vdd.t0 145.8006
Rpar26 vdd vdd.t1 185.9310
Rpar27 vdd vdd.t11 162.7983
Rpar28 vdd.t0 vdd.t1 6.7237
Rpar29 vdd.t0 vdd.t11 56.3796
Rpar30 vdd.t1 vdd.t11 84.9008
Rpar31 vss vss.t0 112.2357
Rpar32 vss vss.t1 640.5180
Rpar33 vss vss.t22 91.9643
Rpar34 vss vss.t4 7054.8391
Rpar35 vss.t0 vss.t1 9.9528
Rpar36 vss.t0 vss.t22 4.8343
Rpar37 vss.t0 vss.t4 58.1916
Rpar38 vss.t1 vss.t22 24.4265
Rpar39 vss.t1 vss.t4 217.8352
Rpar40 vss.t22 vss.t4 588.3462
Cpar0 a_1684_2750.t0 vss 1.01862e-14
Cpar1 a_1684_2750.t4 vss 5.09290e-15
Cpar2 a_2212_10012.t0 vss 5.48961e-15
Cpar3 a_2212_10012.t1 vss 1.40659e-15
Cpar4 a_2212_10012.t4 vss 7.93519e-16
Cpar5 a_3234_5927.t0 vss 3.68149e-14
Cpar6 a_3234_5927.t1 vss 3.23782e-15
Cpar7 a_3234_5927.t4 vss 1.20921e-14
Cpar8 a_4114_8512.t0 vss 6.60863e-15
Cpar9 a_4114_8512.t3 vss 3.75274e-15
Cpar10 a_4114_8512.t5 vss 4.17531e-15
Cpar11 a_6254_8512.t0 vss 6.67128e-15
Cpar12 a_6254_8512.t2 vss 3.78831e-15
Cpar13 a_6254_8512.t4 vss 4.21490e-15
Cpar14 ib inn 3.19200e-17
Cpar15 ib inp 1.68900e-17
Cpar16 ib out 2.62230e-16
Cpar17 ib vdd 8.28803e-15
Cpar18 ib vss 4.83083e-14
Cpar19 ib.t0 vss 1.85783e-14
Cpar20 ib.t1 vss 2.47819e-15
Cpar21 ib.t10 vss 5.28866e-15
Cpar22 inn inp 5.19700e-17
Cpar23 inn vss 8.28185e-15
Cpar24 inn.t0 vss 5.28307e-16
Cpar25 inp vss 8.20496e-15
Cpar26 inp.t0 vss 5.36463e-16
Cpar27 out vdd 5.41863e-15
Cpar28 out vss 2.07939e-14
Cpar29 out.t0 vss 4.07251e-16
Cpar31 out.t4 vss 1.16370e-14
Cpar32 vdd vss 1.03707e-13
Cpar33 vdd.t0 vss 2.65204e-14
Cpar34 vdd.t1 vss 1.75689e-14
Cpar35 vdd.t11 vss 1.35951e-14
.ends opamp_dut

Vdd vdd 0 1.800000
Vss vss 0 0
Ibias vdd ib 1.400000e-09
Vinp inp 0 DC 0.985000 AC 1 PWL(0 0.985000 2.007969e-05 0.985000 2.208766e-05 0.995000)
Rfb out inn 1m
Cload out 0 2.000000e-13
Xdut vdd vss inp inn out ib opamp_dut
.end
