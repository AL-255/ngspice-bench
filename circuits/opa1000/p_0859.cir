* opa1000[0859]: 200f/telescopic_nmos_3v3_0p1u_1u_weak (telescopic_nmos, VDD=3.3V, CL=0.2pF, Iref=0.1625uA)
.include "pdk_opa.inc"
.temp 27
.option gmin=1e-12 rshunt=1e12 reltol=1e-3 abstol=1e-12 vntol=1e-5 method=gear
* Post-PEX R+C extracted netlist for telescopic_nmos_3v3_0p1u_1u_weak
.subckt opamp_dut vdd vss inp inn out ib
XMpar0 a_2834_7848.t1 a_1765_7640.t4 out.t1 vdd.t2 pfet_03v3 w=1.79u l=4u ad=1.0740e-12 pd=4.7800e-06 as=6.9213e-13 ps=3.1600e-06 nf=1 m=6 par=6
XMpar1 a_3884_5875.t1 inn.t0 a_850_4224.t0 vss.t1 nfet_03v3 w=1.6u l=4u ad=4.4800e-13 pd=2.1600e-06 as=7.0400e-13 ps=3.2800e-06 nf=1 m=4 par=4
XMpar2 a_1645_7848.t0 a_1765_7640.t4 a_1765_7640.t5 vdd.t2 pfet_03v3 w=1.79u l=4u ad=1.0740e-12 pd=4.7800e-06 as=6.9213e-13 ps=3.1600e-06 nf=1 m=6 par=6
XMpar3 a_850_4224.t4 ib.t0 vss.t7 vss.t6 nfet_03v3 w=0.4u l=4u ad=1.1200e-13 pd=9.6000e-07 as=2.0800e-13 ps=1.7400e-06 nf=1 m=8 par=8
XMpar4 a_1645_7848.t1 a_1765_7640.t24 vdd.t1 vdd.t0 pfet_03v3 w=1.64u l=4u ad=9.8400e-13 pd=4.4800e-06 as=4.5920e-13 ps=2.2000e-06 nf=1 m=2 par=2
XMpar5 a_1770_4224.t1 inp.t0 a_850_4224.t0 vss.t1 nfet_03v3 w=1.6u l=4u ad=4.4800e-13 pd=2.1600e-06 as=7.0400e-13 ps=3.2800e-06 nf=1 m=4 par=4
XMpar6 ib.t1 ib.t0 vss.t7 vss.t6 nfet_03v3 w=0.4u l=4u ad=2.4000e-13 pd=2.0000e-06 as=1.1200e-13 ps=9.6000e-07 nf=1 m=2 par=2
XMpar7 a_1765_7640.t1 a_1765_7640.t0 a_1770_4224.t0 vss.t0 nfet_03v3 w=1.39u l=4u ad=8.3400e-13 pd=3.9800e-06 as=8.3400e-13 ps=3.9800e-06 nf=1 m=2 par=2
XMpar8 a_2834_7848.t0 a_1765_7640.t24 vdd.t1 vdd.t0 pfet_03v3 w=1.64u l=4u ad=4.5920e-13 pd=2.2000e-06 as=4.5920e-13 ps=2.2000e-06 nf=1 m=2 par=2
XMpar9 a_3884_5875.t0 a_1765_7640.t0 out.t0 vss.t0 nfet_03v3 w=1.39u l=4u ad=8.3400e-13 pd=3.9800e-06 as=3.8920e-13 ps=1.9500e-06 nf=1 m=2 par=2
Rpar0 a_1645_7848.t0 a_1645_7848.t1 60.1466
Rpar1 a_1765_7640.t0 a_1765_7640.t1 22.9785
Rpar2 a_1765_7640.t0 a_1765_7640.t4 787.5056
Rpar3 a_1765_7640.t0 a_1765_7640.t5 385.3959
Rpar4 a_1765_7640.t0 a_1765_7640.t24 252.5009
Rpar5 a_1765_7640.t1 a_1765_7640.t4 508.1376
Rpar6 a_1765_7640.t1 a_1765_7640.t5 248.6765
Rpar7 a_1765_7640.t1 a_1765_7640.t24 162.9261
Rpar8 a_1765_7640.t4 a_1765_7640.t5 9.7808
Rpar9 a_1765_7640.t4 a_1765_7640.t24 178.0244
Rpar10 a_1765_7640.t5 a_1765_7640.t24 87.1230
Rpar11 a_1770_4224.t0 a_1770_4224.t1 43.2558
Rpar12 a_2834_7848.t0 a_2834_7848.t1 45.4143
Rpar13 a_3884_5875.t0 a_3884_5875.t1 44.0205
Rpar14 a_850_4224.t0 a_850_4224.t4 29.4223
Rpar15 ib ib.t0 12.4886
Rpar16 ib ib.t1 13.9253
Rpar17 ib.t0 ib.t1 34.1867
Rpar18 inn inn.t0 2.0529
Rpar19 inp inp.t0 2.1015
Rpar20 out out.t0 91.8629
Rpar21 out out.t1 5.5404
Rpar22 vdd vdd.t0 39.1327
Rpar23 vdd vdd.t1 78.9822
Rpar24 vdd vdd.t2 74.9826
Rpar25 vdd.t0 vdd.t1 11.4916
Rpar26 vdd.t0 vdd.t2 61.1343
Rpar27 vdd.t1 vdd.t2 123.3883
Rpar28 vss vss.t0 120.7177
Rpar29 vss vss.t1 92.0463
Rpar30 vss vss.t6 98.2846
Rpar31 vss vss.t7 1199.1471
Rpar32 vss.t0 vss.t1 2.0914
Rpar33 vss.t0 vss.t6 3.7744
Rpar34 vss.t0 vss.t7 39.8080
Rpar35 vss.t1 vss.t6 2.8220
Rpar36 vss.t1 vss.t7 33.0182
Rpar37 vss.t6 vss.t7 33.9924
Cpar0 a_1645_7848.t0 vss 1.64172e-14
Cpar1 a_1645_7848.t1 vss 6.29586e-15
Cpar2 a_1765_7640.t0 vss 1.02870e-14
Cpar3 a_1765_7640.t1 vss 3.61075e-15
Cpar4 a_1765_7640.t24 vss 1.14349e-14
Cpar5 a_1765_7640.t4 vss 3.18504e-14
Cpar6 a_1765_7640.t5 vss 8.86237e-15
Cpar7 a_1770_4224.t0 vss 3.50511e-15
Cpar8 a_1770_4224.t1 vss 3.55489e-15
Cpar9 a_2834_7848.t0 vss 5.52361e-15
Cpar10 a_2834_7848.t1 vss 1.88501e-14
Cpar11 a_3884_5875.t0 vss 4.02296e-15
Cpar12 a_3884_5875.t1 vss 4.07295e-15
Cpar13 a_850_4224.t0 vss 6.23799e-15
Cpar14 a_850_4224.t4 vss 7.31208e-15
Cpar15 ib inn 1.66100e-17
Cpar16 ib inp 1.83800e-17
Cpar17 ib out 2.38870e-16
Cpar18 ib vss 3.19733e-14
Cpar19 ib.t0 vss 4.68698e-15
Cpar20 ib.t1 vss 4.17187e-16
Cpar21 inn inp 5.13900e-17
Cpar22 inn out 9.32500e-17
Cpar23 inn vss 8.65728e-15
Cpar24 inn.t0 vss 1.22229e-15
Cpar25 inp vss 8.83175e-15
Cpar26 inp.t0 vss 1.18733e-15
Cpar27 out vdd 8.70130e-15
Cpar28 out vss 2.62354e-14
Cpar29 out.t0 vss 6.98181e-15
Cpar30 out.t1 vss 5.31891e-15
Cpar31 vdd vss 1.13434e-13
Cpar32 vdd.t0 vss 7.44606e-15
Cpar33 vdd.t1 vss 3.79126e-15
Cpar34 vdd.t2 vss 3.88333e-14
.ends opamp_dut

Vdd vdd 0 3.300000
Vss vss 0 0
Ibias vdd ib 1.625000e-07
Vinp inp 0 DC 1.711000 AC 1 PWL(0 1.711000 4.053393e-08 1.711000 4.458732e-08 1.721000)
Rfb out inn 1m
Cload out 0 2.000000e-13
Xdut vdd vss inp inn out ib opamp_dut
.end
