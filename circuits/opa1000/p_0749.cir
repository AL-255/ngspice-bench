* opa1000[0749]: 2p/rail_to_rail_3v3_i500u_weak (rail_to_rail, VDD=3.3V, CL=2.0pF, Iref=62.5uA)
.include "pdk_opa.inc"
.temp 27
.option gmin=1e-12 rshunt=1e12 reltol=1e-3 abstol=1e-12 vntol=1e-5 method=gear
* Post-PEX R+C extracted netlist for rail_to_rail_3v3_i500u_weak
.subckt opamp_dut vdd vss inp inn out ib
XMpar0 out.t0 a_1712_6342.t45 vdd.t1 vdd.t0 pfet_03v3 w=5.33u l=0.32u ad=1.5457e-12 pd=6.0766e-06 as=1.5990e-12 ps=6.2631e-06 nf=1 m=64 par=64
XMpar1 a_10686_21226.t43 a_10686_21226.t42 vss.t1 vss.t0 nfet_03v3 w=0.56u l=0.5u ad=1.5680e-13 pd=1.1200e-06 as=1.7920e-13 ps=1.2700e-06 nf=1 m=16 par=16
XMpar2 out.t63 ib.t0 vss.t110 vss.t109 nfet_03v3 w=1.43u l=0.45u ad=4.0040e-13 pd=1.9900e-06 as=4.5760e-13 ps=2.2487e-06 nf=1 m=64 par=64
XMpar3 a_7994_13496.t0 inp.t12 a_8186_13496.t0 vdd.t42 pfet_03v3 w=1.94u l=0.36u ad=5.7276e-13 pd=2.6229e-06 as=5.7276e-13 ps=2.6229e-06 nf=1 m=42 par=42
XMpar4 a_10754_8451.t24 ib.t0 vss.t110 vss.t109 nfet_03v3 w=1.43u l=0.45u ad=4.0040e-13 pd=1.9900e-06 as=4.0040e-13 ps=1.9900e-06 nf=1 m=16 par=16
XMpar5 a_9408_11353.t29 a_9408_11353.t28 vdd.t1 vdd.t0 pfet_03v3 w=5.33u l=0.32u ad=1.4924e-12 pd=5.8900e-06 as=1.7056e-12 ps=6.6362e-06 nf=1 m=16 par=16
XMpar6 a_9408_11353.t12 a_8186_13496.t42 vss.t1 vss.t0 nfet_03v3 w=0.56u l=0.5u ad=1.5680e-13 pd=1.1200e-06 as=1.5680e-13 ps=1.1200e-06 nf=1 m=16 par=16
XMpar7 a_10686_21226.t0 inn.t12 a_7994_13496.t0 vdd.t42 pfet_03v3 w=1.94u l=0.36u ad=5.7276e-13 pd=2.6229e-06 as=5.7276e-13 ps=2.6229e-06 nf=1 m=42 par=42
XMpar8 a_20617_996.t1 a_20617_996.t0 vdd.t13 vdd.t12 pfet_03v3 w=4.99u l=0.45u ad=1.5968e-12 pd=6.2537e-06 as=1.3972e-12 ps=5.5500e-06 nf=1 m=16 par=16
XMpar9 a_7994_13496.t42 a_20617_996.t0 vdd.t13 vdd.t12 pfet_03v3 w=4.99u l=0.45u ad=1.7964e-12 pd=6.9575e-06 as=1.3972e-12 ps=5.5500e-06 nf=1 m=16 par=16
XMpar10 a_8186_13496.t43 a_8186_13496.t42 vss.t1 vss.t0 nfet_03v3 w=0.56u l=0.5u ad=1.5680e-13 pd=1.1200e-06 as=1.7920e-13 ps=1.2700e-06 nf=1 m=16 par=16
XMpar11 a_10754_8451.t0 inn.t0 a_9408_11353.t0 vss.t0 nfet_03v3 w=2.05u l=0.36u ad=7.9267e-13 pd=3.5067e-06 as=5.7400e-13 ps=2.6100e-06 nf=1 m=12 par=12
XMpar12 a_1712_6342.t29 a_9408_11353.t28 vdd.t1 vdd.t0 pfet_03v3 w=5.33u l=0.32u ad=1.4924e-12 pd=5.8900e-06 as=1.7056e-12 ps=6.6362e-06 nf=1 m=16 par=16
XMpar13 a_20617_996.t32 ib.t0 vss.t110 vss.t109 nfet_03v3 w=1.43u l=0.45u ad=4.5760e-13 pd=2.2487e-06 as=5.1480e-13 ps=2.5075e-06 nf=1 m=16 par=16
XMpar14 a_1712_6342.t0 a_10686_21226.t42 vss.t1 vss.t0 nfet_03v3 w=0.56u l=0.5u ad=1.5680e-13 pd=1.1200e-06 as=1.7920e-13 ps=1.2700e-06 nf=1 m=16 par=16
XMpar15 ib.t1 ib.t0 vss.t110 vss.t109 nfet_03v3 w=1.43u l=0.45u ad=4.0040e-13 pd=1.9900e-06 as=4.0040e-13 ps=1.9900e-06 nf=1 m=16 par=16
XMpar16 a_10754_8451.t0 inp.t0 a_1712_6342.t13 vss.t0 nfet_03v3 w=2.05u l=0.36u ad=7.9267e-13 pd=3.5067e-06 as=5.7400e-13 ps=2.6100e-06 nf=1 m=12 par=12
X198 a_6366_16484.t1 out.t20 cap_mim_2f0fF c_width=18.03u c_length=18.03u
X286 a_6366_16484.t1 out.t20 cap_mim_2f0fF c_width=18.03u c_length=18.03u
X337 a_1712_6342.t6 a_6366_16484.t0 vss.t42 ppolyf_u_1k r_width=1u r_length=1u
Rpar0 a_10686_21226.t0 a_10686_21226.t42 236.0064
Rpar1 a_10686_21226.t0 a_10686_21226.t43 49.2073
Rpar2 a_10686_21226.t42 a_10686_21226.t43 8.3392
Rpar3 a_10754_8451.t0 a_10754_8451.t24 56.9849
Rpar4 a_1712_6342.t0 a_1712_6342.t45 506.4304
Rpar5 a_1712_6342.t0 a_1712_6342.t13 747.8477
Rpar6 a_1712_6342.t0 a_1712_6342.t29 43.6720
Rpar7 a_1712_6342.t0 a_1712_6342.t6 158.2717
Rpar8 a_1712_6342.t45 a_1712_6342.t13 68.0128
Rpar9 a_1712_6342.t45 a_1712_6342.t29 458.3475
Rpar10 a_1712_6342.t45 a_1712_6342.t6 265.5329
Rpar11 a_1712_6342.t13 a_1712_6342.t29 676.8434
Rpar12 a_1712_6342.t13 a_1712_6342.t6 392.1135
Rpar13 a_1712_6342.t29 a_1712_6342.t6 143.2446
Rpar14 a_20617_996.t0 a_20617_996.t1 6.7908
Rpar15 a_20617_996.t0 a_20617_996.t32 415.3418
Rpar16 a_20617_996.t1 a_20617_996.t32 40.7138
Rpar17 a_6366_16484.t0 a_6366_16484.t1 108.7509
Rpar18 a_7994_13496.t0 a_7994_13496.t42 49.2490
Rpar19 a_8186_13496.t0 a_8186_13496.t42 262.7443
Rpar20 a_8186_13496.t0 a_8186_13496.t43 86.8269
Rpar21 a_8186_13496.t42 a_8186_13496.t43 14.9269
Rpar22 a_9408_11353.t0 a_9408_11353.t12 68.4391
Rpar23 a_9408_11353.t0 a_9408_11353.t28 2699.1856
Rpar24 a_9408_11353.t0 a_9408_11353.t29 191.3675
Rpar25 a_9408_11353.t12 a_9408_11353.t28 1772.7583
Rpar26 a_9408_11353.t12 a_9408_11353.t29 125.6854
Rpar27 a_9408_11353.t28 a_9408_11353.t29 9.6306
Rpar28 ib ib.t0 12.9438
Rpar29 ib ib.t1 5.4759
Rpar30 ib.t0 ib.t1 6.4341
Rpar31 inn inn.t0 6.4161
Rpar32 inn inn.t12 37.2111
Rpar33 inp inp.t0 6.4161
Rpar34 inp inp.t12 37.1625
Rpar35 out out.t0 259.3976
Rpar36 out out.t63 92.7378
Rpar37 out out.t20 22.4751
Rpar38 out.t0 out.t63 90.0286
Rpar39 out.t0 out.t20 1417.6533
Rpar40 out.t63 out.t20 506.8285
Rpar41 vdd vdd.t0 1306.1028
Rpar42 vdd vdd.t1 74.9945
Rpar43 vdd vdd.t13 1934.3438
Rpar44 vdd vdd.t42 115.8098
Rpar45 vdd.t0 vdd.t1 5.2121
Rpar46 vdd.t0 vdd.t42 1024.0374
Rpar47 vdd.t1 vdd.t12 1566.7567
Rpar48 vdd.t1 vdd.t13 105.3396
Rpar49 vdd.t1 vdd.t42 50.1045
Rpar50 vdd.t12 vdd.t13 10.7602
Rpar51 vdd.t13 vdd.t42 658.1576
Rpar52 vss vss.t0 201.6495
Rpar53 vss vss.t1 1550.7570
Rpar54 vss vss.t109 1018.3212
Rpar55 vss vss.t110 58.4913
Rpar56 vss.t0 vss.t1 2.6472
Rpar57 vss.t0 vss.t109 4.8800
Rpar58 vss.t0 vss.t110 25.7965
Rpar59 vss.t0 vss.t42 82.0621
Rpar60 vss.t1 vss.t109 105.9329
Rpar61 vss.t1 vss.t110 257.8593
Rpar62 vss.t1 vss.t42 641.0659
Rpar63 vss.t109 vss.t110 5.4756
Rpar64 vss.t109 vss.t42 10061.4979
Rpar65 vss.t110 vss.t42 2551.9976
Cpar0 a_10686_21226.t0 vss 2.11544e-14
Cpar1 a_10686_21226.t42 vss 1.20805e-14
Cpar2 a_10686_21226.t43 vss 8.80028e-15
Cpar3 a_10754_8451.t0 vss 2.01202e-14
Cpar4 a_10754_8451.t24 vss 2.11715e-14
Cpar5 a_1712_6342.t0 vss 1.06574e-14
Cpar6 a_1712_6342.t13 vss 1.07769e-14
Cpar7 a_1712_6342.t29 vss 2.37630e-14
Cpar8 a_1712_6342.t45 vss 4.60725e-14
Cpar9 a_1712_6342.t6 vss 4.42591e-15
Cpar10 a_20617_996.t0 vss 1.92939e-14
Cpar11 a_20617_996.t1 vss 2.37661e-14
Cpar12 a_20617_996.t32 vss 7.08343e-15
Cpar13 a_6366_16484.t0 vss 3.14372e-16
Cpar14 a_6366_16484.t1 vss 1.37104e-14
Cpar15 a_7994_13496.t0 vss 5.90145e-14
Cpar16 a_7994_13496.t42 vss 3.80707e-14
Cpar17 a_8186_13496.t0 vss 2.37660e-14
Cpar18 a_8186_13496.t42 vss 1.27260e-14
Cpar19 a_8186_13496.t43 vss 7.09862e-15
Cpar20 a_9408_11353.t0 vss 9.83512e-15
Cpar21 a_9408_11353.t12 vss 9.20824e-15
Cpar22 a_9408_11353.t28 vss 1.81923e-14
Cpar23 a_9408_11353.t29 vss 2.74867e-14
Cpar24 ib out 7.47552e-15
Cpar25 ib vdd 3.45810e-16
Cpar26 ib vss 8.57556e-14
Cpar27 ib.t0 vss 1.57749e-14
Cpar28 ib.t1 vss 3.42717e-15
Cpar29 inn inp 2.07240e-16
Cpar30 inn vdd 1.42907e-14
Cpar31 inn vss 1.24085e-14
Cpar32 inn.t0 vss 3.09348e-15
Cpar33 inn.t12 vss 1.91931e-14
Cpar34 inp out 4.71230e-16
Cpar35 inp vdd 1.69574e-14
Cpar36 inp vss 1.24070e-14
Cpar37 inp.t0 vss 3.42598e-15
Cpar38 inp.t12 vss 2.12525e-14
Cpar39 out vdd 9.93668e-14
Cpar40 out vss 5.83040e-14
Cpar41 out.t0 vss 6.73275e-14
Cpar42 out.t20 vss 3.05857e-14
Cpar43 out.t63 vss 2.48119e-14
Cpar44 vdd vss 3.49292e-13
Cpar45 vdd.t0 vss 1.19447e-13
Cpar46 vdd.t1 vss 4.64363e-14
Cpar47 vdd.t12 vss 5.80119e-14
Cpar48 vdd.t13 vss 1.68281e-14
Cpar49 vdd.t42 vss 6.40453e-14
.ends opamp_dut

Vdd vdd 0 3.300000
Vss vss 0 0
Ibias vdd ib 6.250000e-05
Vinp inp 0 DC 1.645000 AC 1 PWL(0 1.645000 3.000000e-09 1.645000 3.300000e-09 1.655000)
Rfb out inn 1m
Cload out 0 2.000000e-12
Xdut vdd vss inp inn out ib opamp_dut
.end
