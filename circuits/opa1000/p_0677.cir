* opa1000[0677]: 200f/rail_to_rail_1v8_i2u_subth (rail_to_rail, VDD=1.8V, CL=0.2pF, Iref=0.325uA)
.include "pdk_opa.inc"
.temp 27
.option gmin=1e-12 rshunt=1e12 reltol=1e-3 abstol=1e-12 vntol=1e-5 method=gear
* Post-PEX R+C extracted netlist for rail_to_rail_1v8_i2u_subth
.subckt opamp_dut vdd vss inp inn out ib
XMpar0 a_1479_7274.t2 inp.t2 a_5486_15228.t0 vdd.t0 pfet_03v3 w=1.87u l=1.14u ad=6.7320e-13 pd=3.0575e-06 as=5.2360e-13 ps=2.4300e-06 nf=1 m=8 par=8
XMpar1 a_1479_7274.t2 inn.t2 a_7726_4141.t4 vdd.t0 pfet_03v3 w=1.87u l=1.14u ad=6.7320e-13 pd=3.0575e-06 as=5.2360e-13 ps=2.4300e-06 nf=1 m=8 par=8
XMpar2 a_5486_15228.t9 a_5486_15228.t8 vss.t1 vss.t0 nfet_03v3 w=0.44u l=2.72u ad=2.6400e-13 pd=2.0800e-06 as=1.2320e-13 ps=1.0000e-06 nf=1 m=2 par=2
XMpar3 out.t0 ib.t0 vss.t11 vss.t10 nfet_03v3 w=1.88u l=3.9u ad=5.2640e-13 pd=2.4400e-06 as=9.7760e-13 ps=4.3300e-06 nf=1 m=8 par=8
XMpar4 out.t2 a_1247_1290.t7 vdd.t11 vdd.t10 pfet_03v3 w=6.18u l=1.08u ad=1.7304e-12 pd=6.7400e-06 as=2.2248e-12 ps=8.4450e-06 nf=1 m=8 par=8
XMpar5 a_1599_7065.t4 ib.t0 vss.t11 vss.t10 nfet_03v3 w=1.88u l=3.9u ad=1.1280e-12 pd=4.9600e-06 as=5.2640e-13 ps=2.4400e-06 nf=1 m=2 par=2
XMpar6 ib.t1 ib.t0 vss.t11 vss.t10 nfet_03v3 w=1.88u l=3.9u ad=1.1280e-12 pd=4.9600e-06 as=5.2640e-13 ps=2.4400e-06 nf=1 m=2 par=2
XMpar7 a_1247_1290.t3 a_7620_1041.t3 vdd.t11 vdd.t10 pfet_03v3 w=6.18u l=1.08u ad=3.7080e-12 pd=1.3560e-05 as=1.7304e-12 ps=6.7400e-06 nf=1 m=2 par=2
XMpar8 a_1247_1290.t1 inp.t0 a_7178_13347.t0 vss.t4 nfet_03v3 w=0.95u l=1.14u ad=2.6600e-13 pd=1.5100e-06 as=5.7000e-13 ps=3.1000e-06 nf=1 m=2 par=2
XMpar9 a_1479_7274.t0 a_1599_7065.t0 vdd.t9 vdd.t8 pfet_03v3 w=8.17u l=3.9u ad=4.9020e-12 pd=1.7540e-05 as=2.2876e-12 ps=8.7300e-06 nf=1 m=2 par=2
XMpar10 a_7178_13347.t2 ib.t0 vss.t11 vss.t10 nfet_03v3 w=1.88u l=3.9u ad=1.1280e-12 pd=4.9600e-06 as=5.2640e-13 ps=2.4400e-06 nf=1 m=2 par=2
XMpar11 a_7620_1041.t4 a_7620_1041.t3 vdd.t11 vdd.t10 pfet_03v3 w=6.18u l=1.08u ad=1.7304e-12 pd=6.7400e-06 as=1.7304e-12 ps=6.7400e-06 nf=1 m=2 par=2
XMpar12 a_7178_13347.t0 inn.t0 a_7620_1041.t0 vss.t4 nfet_03v3 w=0.95u l=1.14u ad=5.7000e-13 pd=3.1000e-06 as=2.6600e-13 ps=1.5100e-06 nf=1 m=2 par=2
XMpar13 a_7620_1041.t2 a_5486_15228.t8 vss.t1 vss.t0 nfet_03v3 w=0.44u l=2.72u ad=1.2320e-13 pd=1.0000e-06 as=1.2320e-13 ps=1.0000e-06 nf=1 m=2 par=2
XMpar14 a_1599_7065.t1 a_1599_7065.t0 vdd.t9 vdd.t8 pfet_03v3 w=8.17u l=3.9u ad=2.2876e-12 pd=8.7300e-06 as=2.2876e-12 ps=8.7300e-06 nf=1 m=2 par=2
XMpar15 a_1247_1290.t0 a_7726_4141.t0 vss.t1 vss.t0 nfet_03v3 w=0.44u l=2.72u ad=2.6400e-13 pd=2.0800e-06 as=1.2320e-13 ps=1.0000e-06 nf=1 m=2 par=2
XMpar16 a_7726_4141.t1 a_7726_4141.t0 vss.t1 vss.t0 nfet_03v3 w=0.44u l=2.72u ad=2.6400e-13 pd=2.0800e-06 as=1.2320e-13 ps=1.0000e-06 nf=1 m=2 par=2
X24 a_1247_1290.t6 a_5273_1290.t0 vss.t33 ppolyf_u_1k r_width=1u r_length=19.47u
X45 a_1247_2850.t1 out.t7 cap_mim_2f0fF c_width=15u c_length=15u
X50 a_1247_2850.t0 a_5273_2330.t0 vss.t33 ppolyf_u_1k r_width=1u r_length=19.47u
X58 a_1247_1810.t0 a_5273_2330.t0 vss.t33 ppolyf_u_1k r_width=1u r_length=19.47u
X62 a_1247_1810.t0 a_5273_1290.t0 vss.t33 ppolyf_u_1k r_width=1u r_length=19.47u
Rpar0 a_1247_1290.t0 a_1247_1290.t1 171.9436
Rpar1 a_1247_1290.t0 a_1247_1290.t7 119.0532
Rpar2 a_1247_1290.t0 a_1247_1290.t3 93.1395
Rpar3 a_1247_1290.t0 a_1247_1290.t6 258.5478
Rpar4 a_1247_1290.t1 a_1247_1290.t7 276.2723
Rpar5 a_1247_1290.t1 a_1247_1290.t3 354.9492
Rpar6 a_1247_1290.t1 a_1247_1290.t6 985.3107
Rpar7 a_1247_1290.t7 a_1247_1290.t3 245.7656
Rpar8 a_1247_1290.t7 a_1247_1290.t6 682.2256
Rpar9 a_1247_1290.t3 a_1247_1290.t6 98.0665
Rpar10 a_1247_2850.t0 a_1247_2850.t1 74.0465
Rpar11 a_1479_7274.t0 a_1479_7274.t2 68.5062
Rpar12 a_1599_7065.t0 a_1599_7065.t1 25.1121
Rpar13 a_1599_7065.t0 a_1599_7065.t4 169.8867
Rpar14 a_1599_7065.t1 a_1599_7065.t4 61.2238
Rpar15 a_5486_15228.t0 a_5486_15228.t8 164.7681
Rpar16 a_5486_15228.t0 a_5486_15228.t9 117.4893
Rpar17 a_5486_15228.t8 a_5486_15228.t9 20.9744
Rpar18 a_7178_13347.t0 a_7178_13347.t2 62.9191
Rpar19 a_7620_1041.t0 a_7620_1041.t2 82.1072
Rpar20 a_7620_1041.t0 a_7620_1041.t3 831.0067
Rpar21 a_7620_1041.t0 a_7620_1041.t4 301.4652
Rpar22 a_7620_1041.t2 a_7620_1041.t3 468.1937
Rpar23 a_7620_1041.t2 a_7620_1041.t4 169.8471
Rpar24 a_7620_1041.t3 a_7620_1041.t4 27.5489
Rpar25 a_7726_4141.t0 a_7726_4141.t1 15.8196
Rpar26 a_7726_4141.t0 a_7726_4141.t4 140.9500
Rpar27 a_7726_4141.t1 a_7726_4141.t4 147.0758
Rpar28 ib ib.t0 16.9304
Rpar29 ib ib.t1 10.7505
Rpar30 ib.t0 ib.t1 21.4420
Rpar31 inn inn.t0 8.8406
Rpar32 inn inn.t2 43.0257
Rpar33 inp inp.t0 8.8892
Rpar34 inp inp.t2 42.4011
Rpar35 out out.t0 129.0213
Rpar36 out out.t2 2.3083
Rpar37 out out.t7 106.1217
Rpar38 out.t0 out.t7 108.8345
Rpar39 vdd vdd.t0 33.3731
Rpar40 vdd vdd.t10 186.4642
Rpar41 vdd vdd.t11 514.6159
Rpar42 vdd vdd.t8 626.8850
Rpar43 vdd vdd.t9 1227.4708
Rpar44 vdd.t0 vdd.t10 903.6962
Rpar45 vdd.t0 vdd.t11 2494.0796
Rpar46 vdd.t0 vdd.t8 3038.1906
Rpar47 vdd.t0 vdd.t9 5948.9223
Rpar48 vdd.t10 vdd.t11 3.2062
Rpar49 vdd.t10 vdd.t8 154.6687
Rpar50 vdd.t10 vdd.t9 302.8487
Rpar51 vdd.t11 vdd.t8 426.8647
Rpar52 vdd.t11 vdd.t9 835.8214
Rpar53 vdd.t8 vdd.t9 9.8978
Rpar54 vss vss.t0 212.1418
Rpar55 vss vss.t1 1825.0670
Rpar56 vss vss.t10 416.3730
Rpar57 vss vss.t11 209.4787
Rpar58 vss vss.t33 323.5480
Rpar59 vss vss.t4 423.9327
Rpar60 vss.t0 vss.t1 12.9834
Rpar61 vss.t0 vss.t10 2.0449
Rpar62 vss.t0 vss.t11 21.7705
Rpar63 vss.t0 vss.t33 422.6684
Rpar64 vss.t0 vss.t4 2.4805
Rpar65 vss.t1 vss.t10 26.4394
Rpar66 vss.t1 vss.t11 262.4781
Rpar67 vss.t1 vss.t33 3590.4960
Rpar68 vss.t1 vss.t4 20.3697
Rpar69 vss.t10 vss.t11 22.7566
Rpar70 vss.t10 vss.t33 819.1048
Rpar71 vss.t10 vss.t4 4.2067
Rpar72 vss.t11 vss.t33 427.3454
Rpar73 vss.t11 vss.t4 48.4699
Rpar74 vss.t33 vss.t4 837.4814
Cpar0 a_1247_1290.t0 vss 5.08973e-15
Cpar1 a_1247_1290.t1 vss 2.80103e-15
Cpar2 a_1247_1290.t3 vss 5.84817e-15
Cpar3 a_1247_1290.t6 vss 2.68861e-15
Cpar4 a_1247_1290.t7 vss 1.24351e-14
Cpar5 a_1247_1810.t0 vss 3.46800e-17
Cpar6 a_1247_2850.t0 vss 4.56750e-16
Cpar7 a_1247_2850.t1 vss 7.39411e-15
Cpar8 a_1479_7274.t0 vss 1.01425e-14
Cpar9 a_1479_7274.t2 vss 1.29441e-14
Cpar10 a_1599_7065.t0 vss 1.65631e-14
Cpar11 a_1599_7065.t1 vss 3.73095e-15
Cpar12 a_1599_7065.t4 vss 5.93011e-15
Cpar13 a_5273_1290.t0 vss 3.60000e-17
Cpar14 a_5273_2330.t0 vss 3.21200e-17
Cpar15 a_5486_15228.t0 vss 4.58752e-15
Cpar16 a_5486_15228.t8 vss 4.88211e-15
Cpar17 a_5486_15228.t9 vss 2.10305e-15
Cpar18 a_7178_13347.t0 vss 5.22210e-15
Cpar19 a_7178_13347.t2 vss 1.44028e-14
Cpar20 a_7620_1041.t0 vss 2.19480e-15
Cpar21 a_7620_1041.t2 vss 3.37702e-15
Cpar22 a_7620_1041.t3 vss 4.65559e-15
Cpar23 a_7620_1041.t4 vss 4.70169e-15
Cpar24 a_7726_4141.t0 vss 4.73082e-15
Cpar25 a_7726_4141.t1 vss 2.38178e-15
Cpar26 a_7726_4141.t4 vss 4.33128e-15
Cpar27 ib out 2.54812e-15
Cpar28 ib vss 3.73646e-14
Cpar29 ib.t0 vss 1.40423e-14
Cpar30 ib.t1 vss 1.41751e-15
Cpar31 inn inp 1.10060e-16
Cpar32 inn vdd 5.80757e-15
Cpar33 inn vss 5.13378e-15
Cpar34 inn.t0 vss 5.11471e-16
Cpar35 inn.t2 vss 6.74255e-15
Cpar36 inp vdd 5.83536e-15
Cpar37 inp vss 4.63511e-15
Cpar38 inp.t0 vss 6.21770e-16
Cpar39 inp.t2 vss 8.03724e-15
Cpar40 out vdd 9.95555e-15
Cpar41 out vss 1.90100e-14
Cpar42 out.t0 vss 8.68835e-15
Cpar43 out.t2 vss 4.96513e-15
Cpar44 out.t7 vss 9.68253e-15
Cpar45 vdd vss 1.37170e-13
Cpar46 vdd.t0 vss 1.55526e-14
Cpar47 vdd.t10 vss 1.87361e-14
Cpar48 vdd.t11 vss 8.83157e-15
Cpar49 vdd.t8 vss 1.41902e-14
Cpar50 vdd.t9 vss 7.56035e-15
.ends opamp_dut

Vdd vdd 0 1.800000
Vss vss 0 0
Ibias vdd ib 3.250000e-07
Vinp inp 0 DC 0.895000 AC 1 PWL(0 0.895000 4.157298e-08 0.895000 4.573027e-08 0.905000)
Rfb out inn 1m
Cload out 0 2.000000e-13
Xdut vdd vss inp inn out ib opamp_dut
.end
