* opa1000[0930]: 200f/telescopic_pmos_1v8_i10u_subth (telescopic_pmos, VDD=1.8V, CL=0.2pF, Iref=2.3uA)
.include "pdk_opa.inc"
.temp 27
.option gmin=1e-12 rshunt=1e12 reltol=1e-3 abstol=1e-12 vntol=1e-5 method=gear
* Post-PEX R+C extracted netlist for telescopic_pmos_1v8_i10u_subth
.subckt opamp_dut vdd vss inp inn out ib
XMpar0 a_1524_1204.t0 inp.t0 a_2894_10111.t0 vdd.t5 pfet_03v3 w=2.08u l=0.54u ad=6.2400e-13 pd=2.8100e-06 as=6.0320e-13 ps=2.7250e-06 nf=1 m=64 par=64
XMpar1 a_1524_1204.t128 a_1224_996.t2 vdd.t3 vdd.t2 pfet_03v3 w=10u l=1.5u ad=2.8000e-12 pd=1.0560e-05 as=3.6000e-12 ps=1.3220e-05 nf=1 m=8 par=8
XMpar2 a_1524_1204.t0 inn.t0 a_8974_10111.t0 vdd.t5 pfet_03v3 w=2.08u l=0.54u ad=6.2400e-13 pd=2.8100e-06 as=6.0320e-13 ps=2.7250e-06 nf=1 m=64 par=64
XMpar3 a_8974_10111.t64 vss.t70 out.t0 vdd.t0 pfet_03v3 w=2.6u l=0.75u ad=7.8000e-13 pd=3.3625e-06 as=7.5400e-13 ps=3.2612e-06 nf=1 m=64 par=64
XMpar4 a_2894_10111.t64 vss.t70 a_3164_10111.t28 vdd.t0 pfet_03v3 w=2.6u l=0.75u ad=7.8000e-13 pd=3.3625e-06 as=7.5400e-13 ps=3.2612e-06 nf=1 m=64 par=64
XMpar5 a_6464_6094.t6 a_3164_10111.t0 out.t5 vss.t0 nfet_03v3 w=2.06u l=0.75u ad=6.7097e-13 pd=3.0057e-06 as=5.7680e-13 ps=2.6200e-06 nf=1 m=14 par=14
XMpar6 a_3164_10111.t1 a_3164_10111.t0 a_5011_8004.t0 vss.t0 nfet_03v3 w=2.06u l=0.75u ad=6.7097e-13 pd=3.0057e-06 as=6.7097e-13 ps=3.0057e-06 nf=1 m=14 par=14
XMpar7 a_5011_8004.t1 a_3164_10111.t92 vss.t1 vss.t0 nfet_03v3 w=1.87u l=1.8u ad=5.2360e-13 pd=2.4300e-06 as=5.9840e-13 ps=2.7438e-06 nf=1 m=8 par=8
XMpar8 ib.t1 ib.t0 vss.t62 vss.t0 nfet_03v3 w=4.56u l=1.5u ad=2.7360e-12 pd=1.0320e-05 as=1.2768e-12 ps=5.1200e-06 nf=1 m=2 par=2
XMpar9 a_6464_6094.t0 a_3164_10111.t92 vss.t1 vss.t0 nfet_03v3 w=1.87u l=1.8u ad=5.2360e-13 pd=2.4300e-06 as=5.9840e-13 ps=2.7438e-06 nf=1 m=8 par=8
XMpar10 a_1224_996.t3 a_1224_996.t2 vdd.t3 vdd.t2 pfet_03v3 w=10u l=1.5u ad=2.8000e-12 pd=1.0560e-05 as=2.8000e-12 ps=1.0560e-05 nf=1 m=2 par=2
XMpar11 a_1224_996.t0 ib.t0 vss.t62 vss.t0 nfet_03v3 w=4.56u l=1.5u ad=1.2768e-12 pd=5.1200e-06 as=1.2768e-12 ps=5.1200e-06 nf=1 m=2 par=2
X206 out.t78 vss.t21 cap_mim_2f0fF c_width=16.21u c_length=16.2u
X213 out.t78 vss.t21 cap_mim_2f0fF c_width=16.21u c_length=16.2u
Rpar0 a_1224_996.t0 a_1224_996.t2 129.4738
Rpar1 a_1224_996.t0 a_1224_996.t3 45.3206
Rpar2 a_1224_996.t2 a_1224_996.t3 26.7622
Rpar3 a_1524_1204.t0 a_1524_1204.t128 54.8954
Rpar4 a_2894_10111.t0 a_2894_10111.t64 46.5789
Rpar5 a_3164_10111.t0 a_3164_10111.t1 15.4697
Rpar6 a_3164_10111.t0 a_3164_10111.t92 227.0045
Rpar7 a_3164_10111.t0 a_3164_10111.t28 452.9189
Rpar8 a_3164_10111.t1 a_3164_10111.t92 49.0463
Rpar9 a_3164_10111.t1 a_3164_10111.t28 97.8572
Rpar10 a_3164_10111.t92 a_3164_10111.t28 157.1943
Rpar11 a_5011_8004.t0 a_5011_8004.t1 43.8482
Rpar12 a_6464_6094.t0 a_6464_6094.t6 58.0870
Rpar13 a_8974_10111.t0 a_8974_10111.t64 46.5789
Rpar14 ib ib.t0 15.4665
Rpar15 ib ib.t1 3.5273
Rpar16 inn inn.t0 2.0216
Rpar17 inp inp.t0 2.0216
Rpar18 out out.t0 413.1532
Rpar19 out out.t5 4.0992
Rpar20 out out.t78 470.4451
Rpar21 out.t0 out.t5 90.0553
Rpar22 out.t0 out.t78 185.0047
Rpar23 out.t5 out.t78 102.5432
Rpar24 vdd vdd.t0 107.5775
Rpar25 vdd vdd.t5 25.8659
Rpar26 vdd vdd.t2 1022.0430
Rpar27 vdd.t0 vdd.t5 51.0385
Rpar28 vdd.t0 vdd.t2 167.1103
Rpar29 vdd.t0 vdd.t3 666.7526
Rpar30 vdd.t5 vdd.t2 484.8922
Rpar31 vdd.t5 vdd.t3 1934.6694
Rpar32 vdd.t2 vdd.t3 5.6027
Rpar33 vss vss.t0 43.7524
Rpar34 vss vss.t1 1582.1400
Rpar35 vss vss.t70 1303.8918
Rpar36 vss vss.t21 88.5965
Rpar37 vss vss.t62 556.4733
Rpar38 vss.t0 vss.t1 3.7653
Rpar39 vss.t0 vss.t70 48.1916
Rpar40 vss.t0 vss.t21 74.9668
Rpar41 vss.t0 vss.t62 6.5348
Rpar42 vss.t1 vss.t70 947.3397
Rpar43 vss.t1 vss.t21 2710.8897
Rpar44 vss.t1 vss.t62 293.7982
Rpar45 vss.t70 vss.t21 2234.1303
Rpar46 vss.t70 vss.t62 1946.9606
Rpar47 vss.t21 vss.t62 953.4793
Cpar0 a_1224_996.t0 vss 2.01915e-15
Cpar1 a_1224_996.t2 vss 1.97641e-14
Cpar2 a_1224_996.t3 vss 3.91078e-15
Cpar3 a_1524_1204.t0 vss 8.44045e-14
Cpar4 a_1524_1204.t128 vss 2.34527e-14
Cpar5 a_2894_10111.t0 vss 4.22638e-14
Cpar6 a_2894_10111.t64 vss 4.59991e-14
Cpar7 a_3164_10111.t0 vss 1.30063e-14
Cpar8 a_3164_10111.t1 vss 8.75746e-15
Cpar9 a_3164_10111.t28 vss 2.70040e-14
Cpar10 a_3164_10111.t92 vss 1.56824e-14
Cpar11 a_5011_8004.t0 vss 1.01208e-14
Cpar12 a_5011_8004.t1 vss 7.50611e-15
Cpar13 a_6464_6094.t0 vss 9.03506e-15
Cpar14 a_6464_6094.t6 vss 1.24913e-14
Cpar15 a_8974_10111.t0 vss 4.14193e-14
Cpar16 a_8974_10111.t64 vss 4.50799e-14
Cpar17 ib out 1.57400e-17
Cpar18 ib vdd 4.14330e-16
Cpar19 ib vss 8.69857e-15
Cpar20 ib.t0 vss 1.09858e-15
Cpar21 ib.t1 vss 4.07160e-16
Cpar22 inn inp 1.02880e-16
Cpar23 inn out 1.26300e-17
Cpar24 inn vdd 2.41204e-14
Cpar25 inn vss 7.22805e-15
Cpar26 inn.t0 vss 3.37296e-14
Cpar27 inp vdd 2.43920e-14
Cpar28 inp vss 7.27972e-15
Cpar29 inp.t0 vss 3.39836e-14
Cpar30 out vdd 8.67517e-15
Cpar31 out vss 3.64185e-14
Cpar32 out.t0 vss 7.98393e-15
Cpar33 out.t5 vss 2.15967e-15
Cpar34 out.t78 vss 4.15991e-14
Cpar35 vdd vss 4.43920e-13
Cpar36 vdd.t0 vss 5.74628e-14
Cpar37 vdd.t2 vss 1.58225e-14
Cpar38 vdd.t3 vss 6.39708e-15
Cpar39 vdd.t5 vss 4.60616e-14
.ends opamp_dut

Vdd vdd 0 1.800000
Vss vss 0 0
Ibias vdd ib 2.300000e-06
Vinp inp 0 DC 0.805000 AC 1 PWL(0 0.805000 1.015605e-08 0.805000 1.117166e-08 0.815000)
Rfb out inn 1m
Cload out 0 2.000000e-13
Xdut vdd vss inp inn out ib opamp_dut
.end
