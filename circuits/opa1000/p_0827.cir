* opa1000[0827]: 2p/symmetrical_ota_3v3_i20u_weak (symmetrical_ota, VDD=3.3V, CL=2.0pF, Iref=3.8333uA)
.include "pdk_opa.inc"
.temp 27
.option gmin=1e-12 rshunt=1e12 reltol=1e-3 abstol=1e-12 vntol=1e-5 method=gear
* Post-PEX R+C extracted netlist for symmetrical_ota_3v3_i20u_weak
.subckt opamp_dut vdd vss inp inn out ib
XMpar0 ib.t1 ib.t0 vss.t10 vss.t9 nfet_03v3 w=3.06u l=1.8u ad=8.5680e-13 pd=3.6200e-06 as=8.5680e-13 ps=3.6200e-06 nf=1 m=2 par=2
XMpar1 out.t0 a_2590_4774.t2 vdd.t1 vdd.t0 pfet_03v3 w=10u l=2.03u ad=2.8000e-12 pd=1.0560e-05 as=4.4000e-12 ps=1.5880e-05 nf=1 m=4 par=4
XMpar2 a_5426_996.t5 a_5426_996.t4 vss.t1 vss.t0 nfet_03v3 w=2.52u l=2.03u ad=7.0560e-13 pd=3.0800e-06 as=7.0560e-13 ps=3.0800e-06 nf=1 m=4 par=4
XMpar3 a_6554_8472.t1 a_6554_8472.t0 vdd.t1 vdd.t0 pfet_03v3 w=10u l=2.03u ad=2.8000e-12 pd=1.0560e-05 as=2.8000e-12 ps=1.0560e-05 nf=1 m=2 par=2
XMpar4 out.t2 a_5426_996.t4 vss.t1 vss.t0 nfet_03v3 w=2.52u l=2.03u ad=1.5120e-12 pd=6.2400e-06 as=7.0560e-13 ps=3.0800e-06 nf=1 m=4 par=4
XMpar5 a_1568_8472.t4 ib.t0 vss.t10 vss.t9 nfet_03v3 w=3.06u l=1.8u ad=8.5680e-13 pd=3.6200e-06 as=1.3464e-12 ps=5.4700e-06 nf=1 m=4 par=4
XMpar6 a_5426_996.t0 a_6554_8472.t0 vdd.t1 vdd.t0 pfet_03v3 w=10u l=2.03u ad=2.8000e-12 pd=1.0560e-05 as=4.4000e-12 ps=1.5880e-05 nf=1 m=4 par=4
XMpar7 a_1568_8472.t0 inp.t0 a_2590_4774.t0 vss.t2 nfet_03v3 w=2.28u l=0.9u ad=1.3680e-12 pd=5.7600e-06 as=6.3840e-13 ps=2.8400e-06 nf=1 m=2 par=2
XMpar8 a_2590_4774.t3 a_2590_4774.t2 vdd.t1 vdd.t0 pfet_03v3 w=10u l=2.03u ad=2.8000e-12 pd=1.0560e-05 as=2.8000e-12 ps=1.0560e-05 nf=1 m=2 par=2
XMpar9 a_1568_8472.t0 inn.t0 a_6554_8472.t4 vss.t2 nfet_03v3 w=2.28u l=0.9u ad=1.3680e-12 pd=5.7600e-06 as=6.3840e-13 ps=2.8400e-06 nf=1 m=2 par=2
X17 out.t8 vss.t26 cap_mim_2f0fF c_width=9u c_length=9u
Rpar0 a_1568_8472.t0 a_1568_8472.t4 35.3163
Rpar1 a_2590_4774.t0 a_2590_4774.t2 177.1650
Rpar2 a_2590_4774.t0 a_2590_4774.t3 86.3541
Rpar3 a_2590_4774.t2 a_2590_4774.t3 25.8793
Rpar4 a_5426_996.t0 a_5426_996.t4 183.6827
Rpar5 a_5426_996.t0 a_5426_996.t5 90.0877
Rpar6 a_5426_996.t4 a_5426_996.t5 11.2772
Rpar7 a_6554_8472.t0 a_6554_8472.t1 25.8793
Rpar8 a_6554_8472.t0 a_6554_8472.t4 177.1650
Rpar9 a_6554_8472.t1 a_6554_8472.t4 86.3541
Rpar10 ib ib.t0 12.8691
Rpar11 ib ib.t1 8.1818
Rpar12 inn inn.t0 14.4827
Rpar13 inp inp.t0 14.5313
Rpar14 out out.t0 78.7908
Rpar15 out out.t2 65.9532
Rpar16 out out.t8 15.0073
Rpar17 out.t0 out.t2 79.2779
Rpar18 out.t0 out.t8 1103.7444
Rpar19 out.t2 out.t8 923.9082
Rpar20 vdd vdd.t0 25.8095
Rpar21 vdd vdd.t1 84.4662
Rpar22 vdd.t0 vdd.t1 3.3877
Rpar23 vss vss.t0 482.1133
Rpar24 vss vss.t1 92.5477
Rpar25 vss vss.t10 235.0209
Rpar26 vss vss.t9 174.6783
Rpar27 vss vss.t2 496.7412
Rpar28 vss vss.t26 53.4743
Rpar29 vss.t0 vss.t1 15.1974
Rpar30 vss.t0 vss.t10 1791.6960
Rpar31 vss.t0 vss.t9 1303.3443
Rpar32 vss.t0 vss.t2 3022.0562
Rpar33 vss.t0 vss.t26 1254.1074
Rpar34 vss.t1 vss.t10 367.1068
Rpar35 vss.t1 vss.t9 272.5731
Rpar36 vss.t1 vss.t2 770.4865
Rpar37 vss.t1 vss.t26 240.7417
Rpar38 vss.t10 vss.t9 6.2446
Rpar39 vss.t10 vss.t2 216.7057
Rpar40 vss.t10 vss.t26 611.3531
Rpar41 vss.t9 vss.t2 158.8180
Rpar42 vss.t9 vss.t26 454.3857
Rpar43 vss.t2 vss.t26 1292.1585
Cpar0 a_1568_8472.t0 vss 2.88561e-15
Cpar1 a_1568_8472.t4 vss 2.59818e-15
Cpar2 a_2590_4774.t0 vss 2.05971e-15
Cpar3 a_2590_4774.t2 vss 1.43343e-14
Cpar4 a_2590_4774.t3 vss 3.99466e-15
Cpar5 a_5426_996.t0 vss 3.81162e-15
Cpar6 a_5426_996.t4 vss 6.09019e-15
Cpar7 a_5426_996.t5 vss 2.53524e-15
Cpar8 a_6554_8472.t0 vss 1.38934e-14
Cpar9 a_6554_8472.t1 vss 3.87180e-15
Cpar10 a_6554_8472.t4 vss 1.99637e-15
Cpar11 ib vdd 8.89000e-17
Cpar12 ib vss 1.09721e-14
Cpar13 ib.t0 vss 1.78791e-15
Cpar14 ib.t1 vss 1.90280e-16
Cpar15 inn inp 5.16000e-17
Cpar16 inn vdd 1.23800e-17
Cpar17 inn vss 1.74510e-15
Cpar18 inn.t0 vss 2.98146e-16
Cpar19 inp vdd 2.82000e-17
Cpar20 inp vss 1.69851e-15
Cpar21 inp.t0 vss 3.11108e-16
Cpar22 out vdd 6.77302e-15
Cpar23 out vss 1.56543e-14
Cpar24 out.t0 vss 2.73332e-15
Cpar25 out.t2 vss 2.38748e-15
Cpar26 out.t8 vss 8.93309e-15
Cpar27 vdd vss 1.00830e-13
Cpar28 vdd.t0 vss 2.32546e-14
Cpar29 vdd.t1 vss 1.12887e-14
.ends opamp_dut

Vdd vdd 0 3.300000
Vss vss 0 0
Ibias vdd ib 3.833300e-06
Vinp inp 0 DC 1.645000 AC 1 PWL(0 1.645000 1.317815e-08 1.645000 1.449597e-08 1.655000)
Rfb out inn 1m
Cload out 0 2.000000e-12
Xdut vdd vss inp inn out ib opamp_dut
.end
