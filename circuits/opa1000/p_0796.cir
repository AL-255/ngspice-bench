* opa1000[0796]: 2p/symmetrical_ota_1v8_i200n_subth (symmetrical_ota, VDD=1.8V, CL=2.0pF, Iref=0.0433uA)
.include "pdk_opa.inc"
.temp 27
.option gmin=1e-12 rshunt=1e12 reltol=1e-3 abstol=1e-12 vntol=1e-5 method=gear
* Post-PEX R+C extracted netlist for symmetrical_ota_1v8_i200n_subth
.subckt opamp_dut vdd vss inp inn out ib
XMpar0 a_2450_6290.t16 ib.t0 vss.t11 vss.t10 nfet_03v3 w=0.51u l=7.5u ad=1.4280e-13 pd=1.0700e-06 as=2.2440e-13 ps=1.6450e-06 nf=1 m=4 par=4
XMpar1 out.t1 a_1508_4503.t3 vss.t5 vss.t4 nfet_03v3 w=0.44u l=6.5u ad=1.2320e-13 pd=1.0000e-06 as=1.9360e-13 ps=1.5400e-06 nf=1 m=4 par=4
XMpar2 a_1508_4503.t0 a_7796_996.t8 vdd.t1 vdd.t0 pfet_03v3 w=1.84u l=6.5u ad=1.1040e-12 pd=4.8800e-06 as=8.0960e-13 ps=3.6400e-06 nf=1 m=4 par=4
XMpar3 a_1724_996.t0 inp.t0 a_2450_6290.t0 vss.t0 nfet_03v3 w=6.4u l=4.8u ad=1.7920e-12 pd=6.9600e-06 as=2.8160e-12 ps=1.0480e-05 nf=1 m=8 par=8
XMpar4 a_2450_6290.t0 inn.t0 a_7796_996.t0 vss.t0 nfet_03v3 w=6.4u l=4.8u ad=2.8160e-12 pd=1.0480e-05 as=1.7920e-12 ps=6.9600e-06 nf=1 m=8 par=8
XMpar5 a_1508_4503.t4 a_1508_4503.t3 vss.t5 vss.t4 nfet_03v3 w=0.44u l=6.5u ad=1.2320e-13 pd=1.0000e-06 as=1.2320e-13 ps=1.0000e-06 nf=1 m=4 par=4
XMpar6 a_7796_996.t9 a_7796_996.t8 vdd.t1 vdd.t0 pfet_03v3 w=1.84u l=6.5u ad=1.1040e-12 pd=4.8800e-06 as=5.1520e-13 ps=2.4000e-06 nf=1 m=2 par=2
XMpar7 ib.t1 ib.t0 vss.t11 vss.t10 nfet_03v3 w=0.51u l=7.5u ad=1.4280e-13 pd=1.0700e-06 as=1.4280e-13 ps=1.0700e-06 nf=1 m=2 par=2
XMpar8 a_1724_996.t9 a_1724_996.t8 vdd.t1 vdd.t0 pfet_03v3 w=1.84u l=6.5u ad=1.1040e-12 pd=4.8800e-06 as=5.1520e-13 ps=2.4000e-06 nf=1 m=2 par=2
XMpar9 out.t0 a_1724_996.t8 vdd.t1 vdd.t0 pfet_03v3 w=1.84u l=6.5u ad=1.1040e-12 pd=4.8800e-06 as=8.0960e-13 ps=3.6400e-06 nf=1 m=4 par=4
Rpar0 a_1508_4503.t0 a_1508_4503.t4 86.0238
Rpar1 a_1508_4503.t0 a_1508_4503.t3 230.4978
Rpar2 a_1508_4503.t4 a_1508_4503.t3 24.0509
Rpar3 a_1724_996.t0 a_1724_996.t8 89.8658
Rpar4 a_1724_996.t0 a_1724_996.t9 83.4512
Rpar5 a_1724_996.t8 a_1724_996.t9 13.0043
Rpar6 a_2450_6290.t0 a_2450_6290.t16 51.3011
Rpar7 a_7796_996.t0 a_7796_996.t8 89.8655
Rpar8 a_7796_996.t0 a_7796_996.t9 83.4514
Rpar9 a_7796_996.t8 a_7796_996.t9 13.0042
Rpar10 ib ib.t0 11.3649
Rpar11 ib ib.t1 17.5050
Rpar12 inn inn.t0 2.6868
Rpar13 inp inp.t0 2.6868
Rpar14 out out.t0 4.4448
Rpar15 out out.t1 58.4687
Rpar16 vdd vdd.t0 454.5525
Rpar17 vdd vdd.t1 136.4301
Rpar18 vdd.t0 vdd.t1 6.8572
Rpar19 vss vss.t0 152.6096
Rpar20 vss vss.t10 145.1386
Rpar21 vss vss.t11 925.9223
Rpar22 vss vss.t4 147.6534
Rpar23 vss vss.t5 1245.2251
Rpar24 vss.t0 vss.t10 2.2268
Rpar25 vss.t0 vss.t11 20.5958
Rpar26 vss.t0 vss.t4 2.4513
Rpar27 vss.t0 vss.t5 19.8792
Rpar28 vss.t10 vss.t11 19.5039
Rpar29 vss.t10 vss.t4 2.1517
Rpar30 vss.t10 vss.t5 18.9641
Rpar31 vss.t11 vss.t4 21.1800
Rpar32 vss.t11 vss.t5 216.1275
Rpar33 vss.t4 vss.t5 18.3844
Cpar0 a_1508_4503.t0 vss 5.72486e-15
Cpar1 a_1508_4503.t3 vss 1.25338e-14
Cpar2 a_1508_4503.t4 vss 2.76833e-15
Cpar3 a_1724_996.t0 vss 1.48247e-14
Cpar4 a_1724_996.t8 vss 2.83148e-14
Cpar5 a_1724_996.t9 vss 6.87840e-15
Cpar6 a_2450_6290.t0 vss 2.63128e-14
Cpar7 a_2450_6290.t16 vss 4.14254e-15
Cpar8 a_7796_996.t0 vss 1.39192e-14
Cpar9 a_7796_996.t8 vss 2.65852e-14
Cpar10 a_7796_996.t9 vss 6.45823e-15
Cpar11 ib inn 1.55400e-17
Cpar12 ib inp 2.00100e-17
Cpar13 ib vdd 2.67580e-16
Cpar14 ib vss 3.00805e-14
Cpar15 ib.t0 vss 3.92811e-15
Cpar16 ib.t1 vss 2.23081e-16
Cpar17 inn inp 1.02820e-16
Cpar18 inn vss 1.90477e-14
Cpar19 inn.t0 vss 9.11760e-15
Cpar20 inp vdd 6.87500e-17
Cpar21 inp vss 1.85632e-14
Cpar22 inp.t0 vss 9.18314e-15
Cpar23 out vdd 8.72931e-15
Cpar24 out vss 1.59273e-14
Cpar25 out.t0 vss 6.51081e-15
Cpar26 out.t1 vss 7.91092e-15
Cpar27 vdd vss 1.36336e-13
Cpar28 vdd.t0 vss 5.35663e-14
Cpar29 vdd.t1 vss 1.34713e-14
.ends opamp_dut

Vdd vdd 0 1.800000
Vss vss 0 0
Ibias vdd ib 4.330000e-08
Vinp inp 0 DC 0.895000 AC 1 PWL(0 0.895000 5.818754e-07 0.895000 6.400629e-07 0.905000)
Rfb out inn 1m
Cload out 0 2.000000e-12
Xdut vdd vss inp inn out ib opamp_dut
.end
