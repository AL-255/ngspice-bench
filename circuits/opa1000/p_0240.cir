* opa1000[0240]: 2p/folded_cascode_nmos_3v3_1u_10u_weak (folded_cascode_nmos, VDD=3.3V, CL=2.0pF, Iref=1.2778uA)
.include "pdk_opa.inc"
.temp 27
.option gmin=1e-12 rshunt=1e12 reltol=1e-3 abstol=1e-12 vntol=1e-5 method=gear
* Post-PEX R+C extracted netlist for folded_cascode_nmos_3v3_1u_10u_weak
.subckt opamp_dut vdd vss inp inn out ib
XMpar0 a_1842_7927.t0 inp.t0 a_2370_1205.t0 vss.t0 nfet_03v3 w=1.77u l=2.5u ad=4.9560e-13 pd=2.3300e-06 as=7.7880e-13 ps=3.5350e-06 nf=1 m=8 par=8
XMpar1 a_5134_7927.t1 ib.t10 out.t1 vdd.t12 pfet_03v3 w=1.64u l=1.3u ad=5.9040e-13 pd=2.7700e-06 as=4.5920e-13 ps=2.2000e-06 nf=1 m=8 par=8
XMpar2 a_1842_7927.t12 ib.t10 a_2222_7927.t4 vdd.t12 pfet_03v3 w=1.64u l=1.3u ad=5.9040e-13 pd=2.7700e-06 as=4.5920e-13 ps=2.2000e-06 nf=1 m=8 par=8
XMpar3 a_2222_7927.t1 a_2222_7927.t0 vss.t1 vss.t0 nfet_03v3 w=1.53u l=2.5u ad=9.1800e-13 pd=4.2600e-06 as=4.2840e-13 ps=2.0900e-06 nf=1 m=2 par=2
XMpar4 a_2370_1205.t0 inn.t0 a_5134_7927.t12 vss.t0 nfet_03v3 w=1.77u l=2.5u ad=7.7880e-13 pd=3.5350e-06 as=4.9560e-13 ps=2.3300e-06 nf=1 m=8 par=8
XMpar5 a_1842_7927.t8 a_2490_9468.t0 vdd.t1 vdd.t0 pfet_03v3 w=5.67u l=2.5u ad=1.5876e-12 pd=6.2300e-06 as=2.4948e-12 ps=9.3850e-06 nf=1 m=4 par=4
XMpar6 ib.t1 ib.t0 vss.t1 vss.t0 nfet_03v3 w=1.53u l=2.5u ad=9.1800e-13 pd=4.2600e-06 as=4.2840e-13 ps=2.0900e-06 nf=1 m=2 par=2
XMpar7 a_5134_7927.t0 a_2490_9468.t0 vdd.t1 vdd.t0 pfet_03v3 w=5.67u l=2.5u ad=1.5876e-12 pd=6.2300e-06 as=2.4948e-12 ps=9.3850e-06 nf=1 m=4 par=4
XMpar8 a_2490_9468.t1 a_2490_9468.t0 vdd.t1 vdd.t0 pfet_03v3 w=5.67u l=2.5u ad=1.5876e-12 pd=6.2300e-06 as=3.4020e-12 ps=1.2540e-05 nf=1 m=2 par=2
XMpar9 a_2370_1205.t8 ib.t0 vss.t1 vss.t0 nfet_03v3 w=1.53u l=2.5u ad=4.2840e-13 pd=2.0900e-06 as=4.2840e-13 ps=2.0900e-06 nf=1 m=4 par=4
XMpar10 a_2490_9468.t4 ib.t0 vss.t1 vss.t0 nfet_03v3 w=1.53u l=2.5u ad=4.2840e-13 pd=2.0900e-06 as=4.2840e-13 ps=2.0900e-06 nf=1 m=2 par=2
XMpar11 out.t0 a_2222_7927.t0 vss.t1 vss.t0 nfet_03v3 w=1.53u l=2.5u ad=4.2840e-13 pd=2.0900e-06 as=4.2840e-13 ps=2.0900e-06 nf=1 m=2 par=2
Rpar0 a_1842_7927.t0 a_1842_7927.t8 183.6793
Rpar1 a_1842_7927.t0 a_1842_7927.t12 63.7045
Rpar2 a_1842_7927.t8 a_1842_7927.t12 57.3629
Rpar3 a_2222_7927.t0 a_2222_7927.t1 18.4152
Rpar4 a_2222_7927.t0 a_2222_7927.t4 191.3773
Rpar5 a_2222_7927.t1 a_2222_7927.t4 80.8219
Rpar6 a_2370_1205.t0 a_2370_1205.t8 58.7088
Rpar7 a_2490_9468.t0 a_2490_9468.t1 22.4387
Rpar8 a_2490_9468.t0 a_2490_9468.t4 85.2583
Rpar9 a_2490_9468.t1 a_2490_9468.t4 77.5291
Rpar10 a_5134_7927.t0 a_5134_7927.t1 57.3629
Rpar11 a_5134_7927.t0 a_5134_7927.t12 183.6793
Rpar12 a_5134_7927.t1 a_5134_7927.t12 63.7045
Rpar13 ib ib.t0 21.8137
Rpar14 ib ib.t1 6.1275
Rpar15 ib ib.t10 100.5840
Rpar16 ib.t0 ib.t1 45.8277
Rpar17 ib.t0 ib.t10 254.3930
Rpar18 ib.t1 ib.t10 211.3141
Rpar19 inn inn.t0 2.3407
Rpar20 inp inp.t0 2.3407
Rpar21 out out.t0 10.1980
Rpar22 out out.t1 63.8971
Rpar23 out.t0 out.t1 482.1796
Rpar24 vdd vdd.t0 32.4409
Rpar25 vdd vdd.t1 69.6310
Rpar26 vdd vdd.t12 52.3550
Rpar27 vdd.t0 vdd.t1 5.1340
Rpar28 vdd.t0 vdd.t12 137.3007
Rpar29 vdd.t1 vdd.t12 131.3289
Rpar30 vss vss.t0 52.1466
Rpar31 vss vss.t1 345.5570
Rpar32 vss.t0 vss.t1 3.2292
Cpar0 a_1842_7927.t0 vss 7.26822e-15
Cpar1 a_1842_7927.t12 vss 5.54846e-15
Cpar2 a_1842_7927.t8 vss 7.27683e-15
Cpar3 a_2222_7927.t0 vss 4.79622e-15
Cpar4 a_2222_7927.t1 vss 2.04496e-15
Cpar5 a_2222_7927.t4 vss 2.57541e-15
Cpar6 a_2370_1205.t0 vss 1.41606e-14
Cpar7 a_2370_1205.t8 vss 5.76356e-15
Cpar8 a_2490_9468.t0 vss 2.45047e-14
Cpar9 a_2490_9468.t1 vss 3.17545e-15
Cpar10 a_2490_9468.t4 vss 2.26589e-15
Cpar11 a_5134_7927.t0 vss 7.31300e-15
Cpar12 a_5134_7927.t1 vss 5.57605e-15
Cpar13 a_5134_7927.t12 vss 7.30433e-15
Cpar14 ib out 8.88380e-16
Cpar15 ib vdd 1.27341e-14
Cpar16 ib vss 2.04670e-14
Cpar17 ib.t0 vss 8.58823e-15
Cpar18 ib.t1 vss 8.34711e-16
Cpar19 ib.t10 vss 1.06109e-14
Cpar20 inn inp 1.04260e-16
Cpar21 inn vss 1.09674e-14
Cpar22 inn.t0 vss 3.31680e-15
Cpar23 inp vss 1.11212e-14
Cpar24 inp.t0 vss 3.32232e-15
Cpar25 out vdd 4.12391e-15
Cpar26 out vss 7.31122e-15
Cpar27 out.t0 vss 8.34383e-16
Cpar28 out.t1 vss 6.11572e-15
Cpar29 vdd vss 1.00475e-13
Cpar30 vdd.t0 vss 1.70860e-14
Cpar31 vdd.t1 vss 1.37309e-14
Cpar32 vdd.t12 vss 1.67999e-14
.ends opamp_dut

Vdd vdd 0 3.300000
Vss vss 0 0
Ibias vdd ib 1.277800e-06
Vinp inp 0 DC 1.810000 AC 1 PWL(0 1.810000 5.136287e-08 1.810000 5.649916e-08 1.820000)
Rfb out inn 1m
Cload out 0 2.000000e-12
Xdut vdd vss inp inn out ib opamp_dut
.end
