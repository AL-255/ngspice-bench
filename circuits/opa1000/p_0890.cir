* opa1000[0890]: 2p/telescopic_nmos_1v8_i20u_subth (telescopic_nmos, VDD=1.8V, CL=2.0pF, Iref=4.25uA)
.include "pdk_opa.inc"
.temp 27
.option gmin=1e-12 rshunt=1e12 reltol=1e-3 abstol=1e-12 vntol=1e-5 method=gear
* Post-PEX R+C extracted netlist for telescopic_nmos_1v8_i20u_subth
.subckt opamp_dut vdd vss inp inn out ib
XMpar0 a_3852_13683.t0 a_3112_13475.t32 out.t0 vdd.t0 pfet_03v3 w=6.33u l=0.9u ad=2.4054e-12 pd=9.0681e-06 as=2.2788e-12 ps=8.6325e-06 nf=1 m=64 par=64
XMpar1 a_11214_1205.t0 inn.t0 a_1600_1204.t8 vss.t20 nfet_03v3 w=1.98u l=0.65u ad=6.1200e-13 pd=2.7782e-06 as=6.1200e-13 ps=2.7782e-06 nf=1 m=44 par=44
XMpar2 a_1600_1204.t8 inp.t0 a_6226_6239.t0 vss.t20 nfet_03v3 w=1.98u l=0.65u ad=6.1200e-13 pd=2.7782e-06 as=6.1200e-13 ps=2.7782e-06 nf=1 m=44 par=44
XMpar3 a_2992_13683.t0 a_3112_13475.t32 a_3112_13475.t33 vdd.t0 pfet_03v3 w=6.33u l=0.9u ad=2.4054e-12 pd=9.0681e-06 as=2.2155e-12 ps=8.4147e-06 nf=1 m=64 par=64
XMpar4 a_3852_13683.t6 a_3112_13475.t160 vdd.t7 vdd.t6 pfet_03v3 w=2.04u l=0.81u ad=5.7120e-13 pd=2.6000e-06 as=5.7120e-13 ps=2.6000e-06 nf=1 m=22 par=22
XMpar5 a_2992_13683.t9 a_3112_13475.t160 vdd.t7 vdd.t6 pfet_03v3 w=2.04u l=0.81u ad=6.3055e-13 pd=2.8436e-06 as=5.7120e-13 ps=2.6000e-06 nf=1 m=22 par=22
XMpar6 a_3112_13475.t0 vdd.t174 a_6226_6239.t44 vss.t20 nfet_03v3 w=2.01u l=0.9u ad=5.6280e-13 pd=2.5700e-06 as=6.4320e-13 ps=2.9012e-06 nf=1 m=32 par=32
XMpar7 a_11214_1205.t44 vdd.t174 out.t8 vss.t20 nfet_03v3 w=2.01u l=0.9u ad=6.4320e-13 pd=2.9012e-06 as=5.6280e-13 ps=2.5700e-06 nf=1 m=32 par=32
XMpar8 a_1600_1204.t0 ib.t0 vss.t1 vss.t0 nfet_03v3 w=10u l=1.8u ad=2.8000e-12 pd=1.0560e-05 as=3.6000e-12 ps=1.3220e-05 nf=1 m=8 par=8
XMpar9 ib.t1 ib.t0 vss.t1 vss.t0 nfet_03v3 w=10u l=1.8u ad=2.8000e-12 pd=1.0560e-05 as=2.8000e-12 ps=1.0560e-05 nf=1 m=2 par=2
X328 out.t96 vss.t74 cap_mim_2f0fF c_width=9u c_length=9u
Rpar0 a_11214_1205.t0 a_11214_1205.t44 46.5400
Rpar1 a_1600_1204.t0 a_1600_1204.t8 42.8914
Rpar2 a_2992_13683.t0 a_2992_13683.t9 60.0778
Rpar3 a_3112_13475.t0 a_3112_13475.t32 1120.9590
Rpar4 a_3112_13475.t0 a_3112_13475.t33 241.4238
Rpar5 a_3112_13475.t0 a_3112_13475.t160 35.9676
Rpar6 a_3112_13475.t32 a_3112_13475.t33 5.6928
Rpar7 a_3112_13475.t32 a_3112_13475.t160 526.9140
Rpar8 a_3112_13475.t33 a_3112_13475.t160 113.4828
Rpar9 a_3852_13683.t0 a_3852_13683.t6 37.7833
Rpar10 a_6226_6239.t0 a_6226_6239.t44 46.5400
Rpar11 ib ib.t0 14.6742
Rpar12 ib ib.t1 8.3055
Rpar13 inn inn.t0 2.4543
Rpar14 inp inp.t0 2.4543
Rpar15 out out.t0 3.0759
Rpar16 out out.t8 188.2856
Rpar17 out out.t96 52.8325
Rpar18 out.t8 out.t96 196.5760
Rpar19 vdd vdd.t0 29.5173
Rpar20 vdd vdd.t7 3051.0353
Rpar21 vdd vdd.t6 467.0442
Rpar22 vdd vdd.t174 199.7567
Rpar23 vdd.t0 vdd.t7 691.0158
Rpar24 vdd.t0 vdd.t6 105.7788
Rpar25 vdd.t0 vdd.t174 128.7617
Rpar26 vdd.t7 vdd.t6 3.3966
Rpar27 vdd.t7 vdd.t174 13309.3527
Rpar28 vdd.t6 vdd.t174 2037.3596
Rpar29 vss vss.t0 47.8763
Rpar30 vss vss.t1 313.0080
Rpar31 vss vss.t20 42.8547
Rpar32 vss vss.t74 287.7935
Rpar33 vss.t0 vss.t1 6.4761
Rpar34 vss.t0 vss.t20 5.1593
Rpar35 vss.t0 vss.t74 81.4686
Rpar36 vss.t1 vss.t20 32.3114
Rpar37 vss.t1 vss.t74 533.6109
Rpar38 vss.t20 vss.t74 310.8428
Cpar0 a_11214_1205.t0 vss 2.98938e-14
Cpar1 a_11214_1205.t44 vss 2.11676e-14
Cpar2 a_1600_1204.t0 vss 1.50874e-14
Cpar3 a_1600_1204.t8 vss 4.53045e-14
Cpar4 a_2992_13683.t0 vss 1.22137e-13
Cpar5 a_2992_13683.t9 vss 1.89297e-14
Cpar6 a_3112_13475.t0 vss 1.52320e-14
Cpar7 a_3112_13475.t160 vss 2.77028e-14
Cpar8 a_3112_13475.t32 vss 1.62040e-13
Cpar9 a_3112_13475.t33 vss 9.51924e-14
Cpar10 a_3852_13683.t0 vss 1.30338e-13
Cpar11 a_3852_13683.t6 vss 1.86973e-14
Cpar12 a_6226_6239.t0 vss 2.97223e-14
Cpar13 a_6226_6239.t44 vss 2.10462e-14
Cpar14 ib vss 2.15690e-14
Cpar15 ib.t0 vss 5.02364e-15
Cpar16 ib.t1 vss 4.41180e-16
Cpar17 inn inp 2.06490e-16
Cpar18 inn out 1.83040e-16
Cpar19 inn vdd 1.49000e-17
Cpar20 inn vss 2.14735e-14
Cpar21 inn.t0 vss 1.15733e-14
Cpar22 inp out 1.61830e-16
Cpar23 inp vss 2.14121e-14
Cpar24 inp.t0 vss 1.15573e-14
Cpar25 out vdd 3.87199e-14
Cpar26 out vss 3.42121e-14
Cpar27 out.t0 vss 9.34438e-14
Cpar28 out.t8 vss 2.16275e-14
Cpar29 out.t96 vss 3.24501e-14
Cpar30 vdd vss 5.50242e-13
Cpar31 vdd.t0 vss 1.83547e-13
Cpar32 vdd.t174 vss 1.25720e-14
Cpar33 vdd.t6 vss 2.83278e-14
Cpar34 vdd.t7 vss 6.89601e-15
.ends opamp_dut

Vdd vdd 0 1.800000
Vss vss 0 0
Ibias vdd ib 4.250000e-06
Vinp inp 0 DC 0.931000 AC 1 PWL(0 0.931000 1.211700e-08 0.931000 1.332870e-08 0.941000)
Rfb out inn 1m
Cload out 0 2.000000e-12
Xdut vdd vss inp inn out ib opamp_dut
.end
