* opa1000[0121]: 200f/current_reuse_3v3_10u_100u_weak (current_reuse, VDD=3.3V, CL=0.2pF, Iref=7.1429uA)
.include "pdk_opa.inc"
.temp 27
.option gmin=1e-12 rshunt=1e12 reltol=1e-3 abstol=1e-12 vntol=1e-5 method=gear
* Post-PEX R+C extracted netlist for current_reuse_3v3_10u_100u_weak
.subckt opamp_dut vdd vss inp inn out ib
XMpar0 a_4242_9448.t0 inn.t4 a_6624_6372.t0 vdd.t4 pfet_03v3 w=2.04u l=0.8u ad=7.3440e-13 pd=3.2700e-06 as=5.7120e-13 ps=2.6000e-06 nf=1 m=8 par=8
XMpar1 out.t1 a_956_1290.t14 vdd.t1 vdd.t0 pfet_03v3 w=6.44u l=0.5u ad=1.8032e-12 pd=7.0000e-06 as=2.2154e-12 ps=8.4160e-06 nf=1 m=10 par=10
XMpar2 a_4242_9448.t0 inp.t4 a_956_1290.t0 vdd.t4 pfet_03v3 w=2.04u l=0.8u ad=7.3440e-13 pd=3.2700e-06 as=5.7120e-13 ps=2.6000e-06 nf=1 m=8 par=8
XMpar3 a_6624_6372.t13 a_6624_6372.t12 vdd.t1 vdd.t0 pfet_03v3 w=6.44u l=0.5u ad=3.8640e-12 pd=1.4080e-05 as=1.8032e-12 ps=7.0000e-06 nf=1 m=1
XMpar4 a_4242_9448.t16 a_6624_6372.t12 vdd.t1 vdd.t0 pfet_03v3 w=6.44u l=0.5u ad=1.8032e-12 pd=7.0000e-06 as=3.8640e-12 ps=1.4080e-05 nf=1 m=2 par=2
XMpar5 a_956_1290.t13 a_6624_6372.t12 vdd.t1 vdd.t0 pfet_03v3 w=6.44u l=0.5u ad=3.8640e-12 pd=1.4080e-05 as=1.8032e-12 ps=7.0000e-06 nf=1 m=1
XMpar6 a_4602_1204.t0 inp.t0 a_956_1290.t3 vss.t0 nfet_03v3 w=1.92u l=0.8u ad=1.1520e-12 pd=5.0400e-06 as=5.3760e-13 ps=2.4800e-06 nf=1 m=4 par=4
XMpar7 out.t0 ib.t0 vss.t3 vss.t2 nfet_03v3 w=3.93u l=1.25u ad=1.3519e-12 pd=5.4040e-06 as=1.1004e-12 ps=4.4900e-06 nf=1 m=10 par=10
XMpar8 a_4602_1204.t4 ib.t0 vss.t3 vss.t2 nfet_03v3 w=3.93u l=1.25u ad=1.1004e-12 pd=4.4900e-06 as=1.1004e-12 ps=4.4900e-06 nf=1 m=4 par=4
XMpar9 ib.t1 ib.t0 vss.t3 vss.t2 nfet_03v3 w=3.93u l=1.25u ad=1.1004e-12 pd=4.4900e-06 as=1.1004e-12 ps=4.4900e-06 nf=1 m=2 par=2
XMpar10 a_4602_1204.t0 inn.t0 a_6624_6372.t4 vss.t0 nfet_03v3 w=1.92u l=0.8u ad=1.1520e-12 pd=5.0400e-06 as=5.3760e-13 ps=2.4800e-06 nf=1 m=4 par=4
X1 a_956_1290.t12 a_1628_1290.t0 vss.t36 ppolyf_u_1k r_width=1u r_length=2.7u
X31 a_1628_1290.t1 out.t14 cap_mim_2f0fF c_width=15u c_length=15u
Rpar0 a_1628_1290.t0 a_1628_1290.t1 51.6247
Rpar1 a_4242_9448.t0 a_4242_9448.t16 50.6704
Rpar2 a_4602_1204.t0 a_4602_1204.t4 56.8235
Rpar3 a_6624_6372.t0 a_6624_6372.t12 333.7974
Rpar4 a_6624_6372.t0 a_6624_6372.t13 79.2863
Rpar5 a_6624_6372.t0 a_6624_6372.t4 121.7320
Rpar6 a_6624_6372.t12 a_6624_6372.t13 64.1440
Rpar7 a_6624_6372.t12 a_6624_6372.t4 125.7689
Rpar8 a_6624_6372.t13 a_6624_6372.t4 93.0909
Rpar9 a_956_1290.t0 a_956_1290.t12 231.7070
Rpar10 a_956_1290.t0 a_956_1290.t13 170.0819
Rpar11 a_956_1290.t0 a_956_1290.t14 232.5182
Rpar12 a_956_1290.t0 a_956_1290.t3 88.1740
Rpar13 a_956_1290.t12 a_956_1290.t13 447.2810
Rpar14 a_956_1290.t12 a_956_1290.t14 1094.8904
Rpar15 a_956_1290.t12 a_956_1290.t3 231.8799
Rpar16 a_956_1290.t13 a_956_1290.t14 803.6917
Rpar17 a_956_1290.t13 a_956_1290.t3 79.6924
Rpar18 a_956_1290.t14 a_956_1290.t3 416.6507
Rpar19 ib ib.t0 12.2690
Rpar20 ib ib.t1 9.4700
Rpar21 inn inn.t0 9.4281
Rpar22 inn inn.t4 44.5432
Rpar23 inp inp.t0 9.4281
Rpar24 inp inp.t4 44.4946
Rpar25 out out.t0 59.6162
Rpar26 out out.t1 1.5914
Rpar27 out out.t14 286.7934
Rpar28 out.t0 out.t1 82.7820
Rpar29 out.t0 out.t14 339.1988
Rpar30 out.t1 out.t14 398.2362
Rpar31 vdd vdd.t0 99.2676
Rpar32 vdd vdd.t1 125.8223
Rpar33 vdd vdd.t4 22.3989
Rpar34 vdd.t0 vdd.t1 3.3174
Rpar35 vdd.t0 vdd.t4 326.2964
Rpar36 vdd.t1 vdd.t4 413.5827
Rpar37 vss vss.t0 117.8914
Rpar38 vss vss.t2 34.5357
Rpar39 vss vss.t3 120.9636
Rpar40 vss vss.t36 63.7863
Rpar41 vss.t0 vss.t2 2.6430
Rpar42 vss.t0 vss.t3 21.9927
Rpar43 vss.t0 vss.t36 706.6271
Rpar44 vss.t2 vss.t3 5.4744
Rpar45 vss.t2 vss.t36 202.6366
Rpar46 vss.t3 vss.t36 722.0969
Cpar0 a_1628_1290.t0 vss 1.70620e-16
Cpar1 a_1628_1290.t1 vss 5.02767e-15
Cpar2 a_4242_9448.t0 vss 1.11111e-14
Cpar3 a_4242_9448.t16 vss 4.64207e-15
Cpar4 a_4602_1204.t0 vss 9.02130e-15
Cpar5 a_4602_1204.t4 vss 6.08427e-15
Cpar6 a_6624_6372.t0 vss 7.00305e-15
Cpar7 a_6624_6372.t12 vss 4.96168e-15
Cpar8 a_6624_6372.t13 vss 6.26273e-15
Cpar9 a_6624_6372.t4 vss 6.54343e-15
Cpar10 a_956_1290.t0 vss 7.03403e-15
Cpar11 a_956_1290.t12 vss 3.26495e-15
Cpar12 a_956_1290.t13 vss 3.77178e-15
Cpar13 a_956_1290.t14 vss 1.13301e-14
Cpar14 a_956_1290.t3 vss 5.56728e-15
Cpar15 ib out 1.99983e-15
Cpar16 ib vss 2.16103e-14
Cpar17 ib.t0 vss 4.46065e-15
Cpar18 ib.t1 vss 3.56900e-16
Cpar19 inn inp 1.55610e-16
Cpar20 inn out 5.01760e-16
Cpar21 inn vdd 5.43585e-15
Cpar22 inn vss 8.01577e-15
Cpar23 inn.t0 vss 1.79004e-15
Cpar24 inn.t4 vss 6.66992e-15
Cpar25 inp out 9.80780e-16
Cpar26 inp vdd 4.65095e-15
Cpar27 inp vss 7.91706e-15
Cpar28 inp.t0 vss 1.60678e-15
Cpar29 inp.t4 vss 5.98540e-15
Cpar30 out vdd 1.49097e-14
Cpar31 out vss 1.68179e-14
Cpar32 out.t0 vss 7.72275e-15
Cpar33 out.t1 vss 6.99570e-15
Cpar34 out.t14 vss 1.02417e-14
Cpar35 vdd vss 8.76300e-14
Cpar36 vdd.t0 vss 1.68454e-14
Cpar37 vdd.t1 vss 1.43594e-14
Cpar38 vdd.t4 vss 1.47341e-14
.ends opamp_dut

Vdd vdd 0 3.300000
Vss vss 0 0
Ibias vdd ib 7.142900e-06
Vinp inp 0 DC 1.645000 AC 1 PWL(0 1.645000 3.000000e-09 1.645000 3.300000e-09 1.655000)
Rfb out inn 1m
Cload out 0 2.000000e-13
Xdut vdd vss inp inn out ib opamp_dut
.end
