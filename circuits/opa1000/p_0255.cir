* opa1000[0255]: 200f/folded_cascode_pmos_1v8_i200n_weak (folded_cascode_pmos, VDD=1.8V, CL=0.2pF, Iref=0.0578uA)
.include "pdk_opa.inc"
.temp 27
.option gmin=1e-12 rshunt=1e12 reltol=1e-3 abstol=1e-12 vntol=1e-5 method=gear
* Post-PEX R+C extracted netlist for folded_cascode_pmos_1v8_i200n_weak
.subckt opamp_dut vdd vss inp inn out ib
XMpar0 a_1494_1205.t4 a_1662_5277.t0 vdd.t1 vdd.t0 pfet_03v3 w=0.4u l=3.9u ad=2.4000e-13 pd=2.0000e-06 as=1.7600e-13 ps=1.4800e-06 nf=1 m=4 par=4
XMpar1 a_5934_8415.t0 a_1662_5277.t10 out.t0 vss.t0 nfet_03v3 w=0.4u l=1.68u ad=2.4000e-13 pd=2.0000e-06 as=1.1200e-13 ps=9.6000e-07 nf=1 m=2 par=2
XMpar2 a_3490_4074.t4 ib.t0 vss.t3 vss.t2 nfet_03v3 w=0.4u l=3u ad=1.1200e-13 pd=9.6000e-07 as=1.7600e-13 ps=1.4800e-06 nf=1 m=4 par=4
XMpar3 a_3490_4074.t8 a_1662_5277.t10 a_4132_9871.t0 vss.t0 nfet_03v3 w=0.4u l=1.68u ad=2.4000e-13 pd=2.0000e-06 as=1.1200e-13 ps=9.6000e-07 nf=1 m=2 par=2
XMpar4 a_1494_1205.t0 inp.t0 a_3490_4074.t0 vdd.t2 pfet_03v3 w=2.08u l=9.75u ad=1.2480e-12 pd=5.3600e-06 as=5.8240e-13 ps=2.6400e-06 nf=1 m=4 par=4
XMpar5 a_1662_5277.t1 a_1662_5277.t0 vdd.t1 vdd.t0 pfet_03v3 w=0.4u l=3.9u ad=2.4000e-13 pd=2.0000e-06 as=1.1200e-13 ps=9.6000e-07 nf=1 m=2 par=2
XMpar6 a_1494_1205.t0 inn.t0 a_5934_8415.t2 vdd.t2 pfet_03v3 w=2.08u l=9.75u ad=1.2480e-12 pd=5.3600e-06 as=5.8240e-13 ps=2.6400e-06 nf=1 m=4 par=4
XMpar7 a_5934_8415.t6 ib.t0 vss.t3 vss.t2 nfet_03v3 w=0.4u l=3u ad=1.1200e-13 pd=9.6000e-07 as=1.7600e-13 ps=1.4800e-06 nf=1 m=4 par=4
XMpar8 a_4132_9871.t3 a_4132_9871.t2 vdd.t1 vdd.t0 pfet_03v3 w=0.4u l=3.9u ad=2.4000e-13 pd=2.0000e-06 as=1.1200e-13 ps=9.6000e-07 nf=1 m=2 par=2
XMpar9 ib.t1 ib.t0 vss.t3 vss.t2 nfet_03v3 w=0.4u l=3u ad=2.4000e-13 pd=2.0000e-06 as=1.1200e-13 ps=9.6000e-07 nf=1 m=2 par=2
XMpar10 a_1662_5277.t4 ib.t0 vss.t3 vss.t2 nfet_03v3 w=0.4u l=3u ad=1.1200e-13 pd=9.6000e-07 as=1.1200e-13 ps=9.6000e-07 nf=1 m=2 par=2
XMpar11 out.t2 a_4132_9871.t2 vdd.t1 vdd.t0 pfet_03v3 w=0.4u l=3.9u ad=1.1200e-13 pd=9.6000e-07 as=1.1200e-13 ps=9.6000e-07 nf=1 m=2 par=2
Rpar0 a_1494_1205.t0 a_1494_1205.t4 49.9208
Rpar1 a_1662_5277.t0 a_1662_5277.t1 15.9124
Rpar2 a_1662_5277.t0 a_1662_5277.t10 233.3839
Rpar3 a_1662_5277.t0 a_1662_5277.t4 118.8007
Rpar4 a_1662_5277.t1 a_1662_5277.t10 253.3742
Rpar5 a_1662_5277.t1 a_1662_5277.t4 128.9765
Rpar6 a_1662_5277.t10 a_1662_5277.t4 121.6835
Rpar7 a_3490_4074.t0 a_3490_4074.t4 84.8333
Rpar8 a_3490_4074.t0 a_3490_4074.t8 124.2878
Rpar9 a_3490_4074.t4 a_3490_4074.t8 132.9143
Rpar10 a_4132_9871.t0 a_4132_9871.t2 138.1749
Rpar11 a_4132_9871.t0 a_4132_9871.t3 99.5800
Rpar12 a_4132_9871.t2 a_4132_9871.t3 21.3274
Rpar13 a_5934_8415.t0 a_5934_8415.t2 102.1532
Rpar14 a_5934_8415.t0 a_5934_8415.t6 140.7447
Rpar15 a_5934_8415.t2 a_5934_8415.t6 70.4949
Rpar16 ib ib.t0 12.2962
Rpar17 ib ib.t1 9.0272
Rpar18 ib.t0 ib.t1 98.6297
Rpar19 inn inn.t0 3.3160
Rpar20 inp inp.t0 3.3160
Rpar21 out out.t0 13.9720
Rpar22 out out.t2 53.4208
Rpar23 vdd vdd.t0 42.8695
Rpar24 vdd vdd.t1 52.1768
Rpar25 vdd vdd.t2 186.1291
Rpar26 vdd.t0 vdd.t1 8.0332
Rpar27 vdd.t0 vdd.t2 146.1821
Rpar28 vdd.t1 vdd.t2 97.4872
Rpar29 vss vss.t0 157.5973
Rpar30 vss vss.t2 68.2374
Rpar31 vss vss.t3 249.4155
Rpar32 vss.t0 vss.t2 3.2026
Rpar33 vss.t0 vss.t3 15.2708
Rpar34 vss.t2 vss.t3 6.1104
Cpar0 a_1494_1205.t0 vss 2.18589e-14
Cpar1 a_1494_1205.t4 vss 8.67297e-15
Cpar2 a_1662_5277.t0 vss 1.44285e-14
Cpar3 a_1662_5277.t1 vss 4.14973e-15
Cpar4 a_1662_5277.t10 vss 6.58572e-15
Cpar5 a_1662_5277.t4 vss 3.56369e-15
Cpar6 a_3490_4074.t0 vss 8.08290e-15
Cpar7 a_3490_4074.t4 vss 3.90951e-15
Cpar8 a_3490_4074.t8 vss 3.51055e-15
Cpar9 a_4132_9871.t0 vss 2.13433e-15
Cpar10 a_4132_9871.t2 vss 1.02561e-14
Cpar11 a_4132_9871.t3 vss 3.35045e-15
Cpar12 a_5934_8415.t0 vss 3.27112e-15
Cpar13 a_5934_8415.t2 vss 7.97766e-15
Cpar14 a_5934_8415.t6 vss 3.37555e-15
Cpar15 ib inn 4.06400e-17
Cpar16 ib inp 2.75800e-17
Cpar17 ib vdd 2.32020e-16
Cpar18 ib vss 2.64749e-14
Cpar19 ib.t0 vss 3.02131e-15
Cpar20 ib.t1 vss 6.48507e-17
Cpar21 inn inp 1.02860e-16
Cpar22 inn vdd 1.54902e-14
Cpar23 inn vss 4.43090e-15
Cpar24 inn.t0 vss 1.63566e-14
Cpar25 inp vdd 1.52612e-14
Cpar26 inp vss 4.42530e-15
Cpar27 inp.t0 vss 1.61668e-14
Cpar28 out vdd 3.23949e-15
Cpar29 out vss 4.74776e-15
Cpar30 out.t0 vss 1.64088e-16
Cpar31 out.t2 vss 3.34673e-15
Cpar32 vdd vss 1.67700e-13
Cpar33 vdd.t0 vss 2.46468e-14
Cpar34 vdd.t1 vss 1.02578e-14
Cpar35 vdd.t2 vss 4.08221e-14
.ends opamp_dut

Vdd vdd 0 1.800000
Vss vss 0 0
Ibias vdd ib 5.780000e-08
Vinp inp 0 DC 0.751000 AC 1 PWL(0 0.751000 1.273642e-07 0.751000 1.401007e-07 0.761000)
Rfb out inn 1m
Cload out 0 2.000000e-13
Xdut vdd vss inp inn out ib opamp_dut
.end
