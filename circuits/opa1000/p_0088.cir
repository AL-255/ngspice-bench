* opa1000[0088]: 200f/current_reuse_1v8_i200n_weak (current_reuse, VDD=1.8V, CL=0.2pF, Iref=0.0371uA)
.include "pdk_opa.inc"
.temp 27
.option gmin=1e-12 rshunt=1e12 reltol=1e-3 abstol=1e-12 vntol=1e-5 method=gear
* Post-PEX R+C extracted netlist for current_reuse_1v8_i200n_weak
.subckt opamp_dut vdd vss inp inn out ib
XMpar0 a_3742_12335.t2 ib.t0 vss.t8 vss.t7 nfet_03v3 w=0.4u l=6.25u ad=2.4000e-13 pd=2.0000e-06 as=1.1200e-13 ps=9.6000e-07 nf=1 m=4 par=4
XMpar1 a_1432_1041.t1 inp.t2 a_3742_12335.t0 vss.t2 nfet_03v3 w=0.57u l=8.13u ad=1.5960e-13 pd=1.1300e-06 as=3.4200e-13 ps=2.3400e-06 nf=1 m=2 par=2
XMpar2 out.t0 ib.t0 vss.t8 vss.t7 nfet_03v3 w=0.4u l=6.25u ad=1.8880e-13 pd=1.5840e-06 as=1.6320e-13 ps=1.3760e-06 nf=1 m=10 par=10
XMpar3 out.t1 a_1432_1041.t6 vdd.t1 vdd.t0 pfet_03v3 w=0.4u l=2.56u ad=1.3760e-13 pd=1.1680e-06 as=1.6320e-13 ps=1.3760e-06 nf=1 m=10 par=10
XMpar4 a_3742_10690.t0 inn.t0 a_5361_13617.t3 vdd.t8 pfet_03v3 w=1.12u l=8.13u ad=6.7200e-13 pd=3.4400e-06 as=3.1360e-13 ps=1.6800e-06 nf=1 m=2 par=2
XMpar5 a_3742_10690.t2 a_5361_13617.t0 vdd.t1 vdd.t0 pfet_03v3 w=0.4u l=2.56u ad=1.1200e-13 pd=9.6000e-07 as=2.4000e-13 ps=2.0000e-06 nf=1 m=2 par=2
XMpar6 ib.t1 ib.t0 vss.t8 vss.t7 nfet_03v3 w=0.4u l=6.25u ad=2.4000e-13 pd=2.0000e-06 as=1.1200e-13 ps=9.6000e-07 nf=1 m=2 par=2
XMpar7 a_3742_12335.t0 inn.t2 a_5361_13617.t2 vss.t2 nfet_03v3 w=0.57u l=8.13u ad=3.4200e-13 pd=2.3400e-06 as=1.5960e-13 ps=1.1300e-06 nf=1 m=2 par=2
XMpar8 a_1432_1041.t2 inp.t0 a_3742_10690.t0 vdd.t8 pfet_03v3 w=1.12u l=8.13u ad=3.1360e-13 pd=1.6800e-06 as=6.7200e-13 ps=3.4400e-06 nf=1 m=2 par=2
XMpar9 a_5361_13617.t1 a_5361_13617.t0 vdd.t1 vdd.t0 pfet_03v3 w=0.4u l=2.56u ad=2.4000e-13 pd=2.0000e-06 as=1.1200e-13 ps=9.6000e-07 nf=1 m=1
XMpar10 a_1432_1041.t0 a_5361_13617.t0 vdd.t1 vdd.t0 pfet_03v3 w=0.4u l=2.56u ad=2.4000e-13 pd=2.0000e-06 as=1.1200e-13 ps=9.6000e-07 nf=1 m=1
X4 a_5424_5970.t0 a_9402_6490.t0 vss.t0 ppolyf_u_1k r_width=1u r_length=19.23u
X6 a_5424_2850.t0 a_9402_3370.t0 vss.t0 ppolyf_u_1k r_width=1u r_length=19.23u
X10 a_5424_5970.t0 a_9402_5450.t0 vss.t0 ppolyf_u_1k r_width=1u r_length=19.23u
X13 a_5424_2850.t0 a_9402_2330.t0 vss.t0 ppolyf_u_1k r_width=1u r_length=19.23u
X16 a_5424_4930.t0 a_9402_5450.t0 vss.t0 ppolyf_u_1k r_width=1u r_length=19.23u
X20 a_5424_1810.t0 a_9402_2330.t0 vss.t0 ppolyf_u_1k r_width=1u r_length=19.23u
X26 a_5424_4930.t0 a_9402_4410.t0 vss.t0 ppolyf_u_1k r_width=1u r_length=19.23u
X27 a_9402_7530.t1 out.t16 cap_mim_2f0fF c_width=15u c_length=15u
X29 a_5424_1810.t0 a_9402_1290.t0 vss.t0 ppolyf_u_1k r_width=1u r_length=19.23u
X32 a_5424_7010.t0 a_9402_7530.t0 vss.t0 ppolyf_u_1k r_width=1u r_length=19.23u
X35 a_5424_3890.t0 a_9402_4410.t0 vss.t0 ppolyf_u_1k r_width=1u r_length=19.23u
X39 a_5424_7010.t0 a_9402_6490.t0 vss.t0 ppolyf_u_1k r_width=1u r_length=19.23u
X46 a_1432_1041.t5 a_9402_1290.t0 vss.t0 ppolyf_u_1k r_width=1u r_length=19.23u
X51 a_5424_3890.t0 a_9402_3370.t0 vss.t0 ppolyf_u_1k r_width=1u r_length=19.23u
Rpar0 a_1432_1041.t0 a_1432_1041.t1 284.7316
Rpar1 a_1432_1041.t0 a_1432_1041.t6 275.4441
Rpar2 a_1432_1041.t0 a_1432_1041.t2 159.0460
Rpar3 a_1432_1041.t0 a_1432_1041.t5 273.1987
Rpar4 a_1432_1041.t1 a_1432_1041.t6 528.4191
Rpar5 a_1432_1041.t1 a_1432_1041.t2 120.4240
Rpar6 a_1432_1041.t1 a_1432_1041.t5 524.1116
Rpar7 a_1432_1041.t6 a_1432_1041.t2 295.1655
Rpar8 a_1432_1041.t6 a_1432_1041.t5 53.9479
Rpar9 a_1432_1041.t2 a_1432_1041.t5 292.7594
Rpar10 a_3742_10690.t0 a_3742_10690.t2 69.3404
Rpar11 a_3742_12335.t0 a_3742_12335.t2 55.9900
Rpar12 a_5361_13617.t0 a_5361_13617.t1 32.7885
Rpar13 a_5361_13617.t0 a_5361_13617.t2 89.3638
Rpar14 a_5361_13617.t0 a_5361_13617.t3 106.5268
Rpar15 a_5361_13617.t1 a_5361_13617.t2 302.5573
Rpar16 a_5361_13617.t1 a_5361_13617.t3 247.8286
Rpar17 a_5361_13617.t2 a_5361_13617.t3 120.6596
Rpar18 a_9402_7530.t0 a_9402_7530.t1 58.1426
Rpar19 ib ib.t0 18.1486
Rpar20 ib ib.t1 15.7665
Rpar21 ib.t0 ib.t1 34.3541
Rpar22 inn inn.t0 42.8340
Rpar23 inn inn.t2 3.3895
Rpar24 inp inp.t0 42.4974
Rpar25 inp inp.t2 3.4381
Rpar26 out out.t0 373.6662
Rpar27 out out.t1 5.0198
Rpar28 out out.t16 579.6029
Rpar29 out.t0 out.t1 140.7300
Rpar30 out.t0 out.t16 153.0777
Rpar31 out.t1 out.t16 218.2899
Rpar32 vdd vdd.t0 98.9541
Rpar33 vdd vdd.t1 163.7899
Rpar34 vdd vdd.t8 460.3251
Rpar35 vdd.t0 vdd.t1 5.7529
Rpar36 vdd.t0 vdd.t8 80.1066
Rpar37 vdd.t1 vdd.t8 86.5226
Rpar38 vss vss.t0 27.5687
Rpar39 vss vss.t8 1770.3020
Rpar40 vss vss.t7 187.3074
Rpar41 vss vss.t2 539.4400
Rpar42 vss.t0 vss.t8 1822.1985
Rpar43 vss.t0 vss.t7 191.8686
Rpar44 vss.t0 vss.t2 552.4418
Rpar45 vss.t8 vss.t7 16.8062
Rpar46 vss.t8 vss.t2 51.0152
Rpar47 vss.t7 vss.t2 4.8994
Cpar0 a_1432_1041.t0 vss 3.49662e-15
Cpar1 a_1432_1041.t1 vss 3.42925e-15
Cpar2 a_1432_1041.t2 vss 4.29658e-15
Cpar3 a_1432_1041.t5 vss 4.21752e-15
Cpar4 a_1432_1041.t6 vss 1.40771e-14
Cpar5 a_3742_10690.t0 vss 8.13240e-15
Cpar6 a_3742_10690.t2 vss 3.13036e-15
Cpar7 a_3742_12335.t0 vss 8.89299e-15
Cpar8 a_3742_12335.t2 vss 1.99533e-14
Cpar9 a_5361_13617.t0 vss 9.70575e-15
Cpar10 a_5361_13617.t1 vss 2.01098e-15
Cpar11 a_5361_13617.t2 vss 3.78653e-15
Cpar12 a_5361_13617.t3 vss 3.78194e-15
Cpar13 a_5424_1810.t0 vss 4.17600e-17
Cpar14 a_5424_2850.t0 vss 4.07000e-17
Cpar15 a_5424_3890.t0 vss 3.90800e-17
Cpar16 a_5424_4930.t0 vss 3.48600e-17
Cpar17 a_5424_5970.t0 vss 3.56000e-17
Cpar18 a_5424_7010.t0 vss 3.64400e-17
Cpar19 a_9402_1290.t0 vss 3.10400e-17
Cpar20 a_9402_2330.t0 vss 3.60200e-17
Cpar21 a_9402_3370.t0 vss 3.52800e-17
Cpar22 a_9402_4410.t0 vss 3.84400e-17
Cpar23 a_9402_5450.t0 vss 3.38000e-17
Cpar24 a_9402_6490.t0 vss 3.46400e-17
Cpar25 a_9402_7530.t0 vss 1.41060e-16
Cpar26 a_9402_7530.t1 vss 3.30669e-15
Cpar27 ib out 2.33902e-15
Cpar28 ib vdd 4.55710e-16
Cpar29 ib vss 6.87180e-14
Cpar30 ib.t0 vss 1.11718e-14
Cpar31 ib.t1 vss 8.29198e-16
Cpar32 inn inp 1.03000e-16
Cpar33 inn vdd 8.37460e-15
Cpar34 inn vss 1.21385e-14
Cpar35 inn.t0 vss 6.17392e-15
Cpar36 inn.t2 vss 2.46406e-15
Cpar37 inp vdd 7.56426e-15
Cpar38 inp vss 1.13045e-14
Cpar39 inp.t0 vss 5.96096e-15
Cpar40 inp.t2 vss 2.41566e-15
Cpar41 out vdd 1.67376e-14
Cpar42 out vss 3.47008e-14
Cpar43 out.t0 vss 1.38529e-14
Cpar44 out.t1 vss 5.64978e-15
Cpar45 out.t16 vss 1.18492e-14
Cpar46 vdd vss 1.16686e-13
Cpar47 vdd.t0 vss 2.90341e-14
Cpar48 vdd.t1 vss 1.23335e-14
Cpar49 vdd.t8 vss 2.03789e-14
.ends opamp_dut

Vdd vdd 0 1.800000
Vss vss 0 0
Ibias vdd ib 3.710000e-08
Vinp inp 0 DC 0.895000 AC 1 PWL(0 0.895000 3.119490e-07 0.895000 3.431439e-07 0.905000)
Rfb out inn 1m
Cload out 0 2.000000e-13
Xdut vdd vss inp inn out ib opamp_dut
.end
