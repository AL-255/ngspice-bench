* opa1000[0695]: 200f/rail_to_rail_3v3_i1u_weak (rail_to_rail, VDD=3.3V, CL=0.2pF, Iref=0.125uA)
.include "pdk_opa.inc"
.temp 27
.option gmin=1e-12 rshunt=1e12 reltol=1e-3 abstol=1e-12 vntol=1e-5 method=gear
* Post-PEX R+C extracted netlist for rail_to_rail_3v3_i1u_weak
.subckt opamp_dut vdd vss inp inn out ib
XMpar0 a_1000_5538.t1 a_7932_12703.t4 vdd.t1 vdd.t0 pfet_03v3 w=1.21u l=2.7u ad=7.2600e-13 pd=3.6200e-06 as=3.3880e-13 ps=1.7700e-06 nf=1 m=2 par=2
XMpar1 a_7932_12703.t0 a_7714_8219.t0 vss.t2 vss.t1 nfet_03v3 w=0.4u l=5.63u ad=2.4000e-13 pd=2.0000e-06 as=1.1200e-13 ps=9.6000e-07 nf=1 m=2 par=2
XMpar2 out.t0 ib.t0 vss.t10 vss.t9 nfet_03v3 w=0.4u l=2.8u ad=1.1200e-13 pd=9.6000e-07 as=2.0800e-13 ps=1.7400e-06 nf=1 m=8 par=8
XMpar3 out.t1 a_1000_5538.t7 vdd.t1 vdd.t0 pfet_03v3 w=1.21u l=2.7u ad=3.3880e-13 pd=1.7700e-06 as=5.3240e-13 ps=2.6950e-06 nf=1 m=8 par=8
XMpar4 a_6594_6714.t2 ib.t0 vss.t10 vss.t9 nfet_03v3 w=0.4u l=2.8u ad=2.4000e-13 pd=2.0000e-06 as=1.1200e-13 ps=9.6000e-07 nf=1 m=2 par=2
XMpar5 a_6594_6714.t0 inn.t0 a_7932_12703.t2 vss.t3 nfet_03v3 w=0.42u l=5u ad=2.5200e-13 pd=2.0400e-06 as=1.1760e-13 ps=9.8000e-07 nf=1 m=2 par=2
XMpar6 ib.t1 ib.t0 vss.t10 vss.t9 nfet_03v3 w=0.4u l=2.8u ad=2.4000e-13 pd=2.0000e-06 as=1.1200e-13 ps=9.6000e-07 nf=1 m=2 par=2
XMpar7 a_6683_4834.t0 ib.t0 vss.t10 vss.t9 nfet_03v3 w=0.4u l=2.8u ad=2.4000e-13 pd=2.0000e-06 as=1.1200e-13 ps=9.6000e-07 nf=1 m=2 par=2
XMpar8 a_1000_5538.t3 inp.t0 a_6594_6714.t0 vss.t3 nfet_03v3 w=0.42u l=5u ad=1.1760e-13 pd=9.8000e-07 as=2.5200e-13 ps=2.0400e-06 nf=1 m=2 par=2
XMpar9 a_7714_8219.t1 a_7714_8219.t0 vss.t2 vss.t1 nfet_03v3 w=0.4u l=5.63u ad=2.4000e-13 pd=2.0000e-06 as=1.1200e-13 ps=9.6000e-07 nf=1 m=2 par=2
XMpar10 a_6563_5042.t0 inn.t2 a_6760_14526.t0 vdd.t4 pfet_03v3 w=1.71u l=5u ad=1.0260e-12 pd=4.6200e-06 as=4.7880e-13 ps=2.2700e-06 nf=1 m=2 par=2
XMpar11 a_6760_14526.t3 a_6760_14526.t2 vss.t2 vss.t1 nfet_03v3 w=0.4u l=5.63u ad=1.1200e-13 pd=9.6000e-07 as=1.1200e-13 ps=9.6000e-07 nf=1 m=2 par=2
XMpar12 a_7932_12703.t5 a_7932_12703.t4 vdd.t1 vdd.t0 pfet_03v3 w=1.21u l=2.7u ad=3.3880e-13 pd=1.7700e-06 as=3.3880e-13 ps=1.7700e-06 nf=1 m=2 par=2
XMpar13 a_6563_5042.t4 a_6683_4834.t2 vdd.t11 vdd.t10 pfet_03v3 w=0.68u l=2.8u ad=4.0800e-13 pd=2.5600e-06 as=1.9040e-13 ps=1.2400e-06 nf=1 m=2 par=2
XMpar14 a_6563_5042.t0 inp.t2 a_7714_8219.t4 vdd.t4 pfet_03v3 w=1.71u l=5u ad=1.0260e-12 pd=4.6200e-06 as=4.7880e-13 ps=2.2700e-06 nf=1 m=2 par=2
XMpar15 a_6683_4834.t3 a_6683_4834.t2 vdd.t11 vdd.t10 pfet_03v3 w=0.68u l=2.8u ad=1.9040e-13 pd=1.2400e-06 as=1.9040e-13 ps=1.2400e-06 nf=1 m=2 par=2
XMpar16 a_1000_5538.t0 a_6760_14526.t2 vss.t2 vss.t1 nfet_03v3 w=0.4u l=5.63u ad=2.4000e-13 pd=2.0000e-06 as=1.1200e-13 ps=9.6000e-07 nf=1 m=2 par=2
X5 a_1000_10218.t0 a_5060_10738.t0 vss.t0 ppolyf_u_1k r_width=1u r_length=19.64u
X6 a_1000_9178.t0 a_5060_9698.t0 vss.t0 ppolyf_u_1k r_width=1u r_length=19.64u
X8 a_1000_6058.t0 a_5060_6578.t0 vss.t0 ppolyf_u_1k r_width=1u r_length=19.64u
X13 a_1000_10218.t0 a_5060_9698.t0 vss.t0 ppolyf_u_1k r_width=1u r_length=19.64u
X14 a_1000_9178.t0 a_5060_8658.t0 vss.t0 ppolyf_u_1k r_width=1u r_length=19.64u
X16 a_1000_6058.t0 a_5060_5538.t0 vss.t0 ppolyf_u_1k r_width=1u r_length=19.64u
X20 a_5060_10738.t1 out.t9 cap_mim_2f0fF c_width=12.99u c_length=12.99u
X21 a_1000_8138.t0 a_5060_8658.t0 vss.t0 ppolyf_u_1k r_width=1u r_length=19.64u
X26 a_1000_5538.t6 a_5060_5538.t0 vss.t0 ppolyf_u_1k r_width=1u r_length=19.64u
X36 a_1000_8138.t0 a_5060_7618.t0 vss.t0 ppolyf_u_1k r_width=1u r_length=19.64u
X41 a_1000_7098.t0 a_5060_7618.t0 vss.t0 ppolyf_u_1k r_width=1u r_length=19.64u
X55 a_1000_7098.t0 a_5060_6578.t0 vss.t0 ppolyf_u_1k r_width=1u r_length=19.64u
Rpar0 a_1000_5538.t0 a_1000_5538.t1 96.9988
Rpar1 a_1000_5538.t0 a_1000_5538.t7 598.6195
Rpar2 a_1000_5538.t0 a_1000_5538.t3 293.2194
Rpar3 a_1000_5538.t0 a_1000_5538.t6 440.4235
Rpar4 a_1000_5538.t1 a_1000_5538.t7 292.9391
Rpar5 a_1000_5538.t1 a_1000_5538.t3 143.4892
Rpar6 a_1000_5538.t1 a_1000_5538.t6 215.5246
Rpar7 a_1000_5538.t7 a_1000_5538.t3 145.0891
Rpar8 a_1000_5538.t7 a_1000_5538.t6 217.9277
Rpar9 a_1000_5538.t3 a_1000_5538.t6 101.4021
Rpar10 a_5060_10738.t0 a_5060_10738.t1 63.8856
Rpar11 a_6563_5042.t0 a_6563_5042.t4 62.3404
Rpar12 a_6594_6714.t0 a_6594_6714.t2 129.4996
Rpar13 a_6683_4834.t0 a_6683_4834.t2 92.5323
Rpar14 a_6683_4834.t0 a_6683_4834.t3 103.8419
Rpar15 a_6683_4834.t2 a_6683_4834.t3 28.5646
Rpar16 a_6760_14526.t0 a_6760_14526.t2 127.2216
Rpar17 a_6760_14526.t0 a_6760_14526.t3 122.5306
Rpar18 a_6760_14526.t2 a_6760_14526.t3 30.9410
Rpar19 a_7714_8219.t0 a_7714_8219.t1 15.6560
Rpar20 a_7714_8219.t0 a_7714_8219.t4 80.1633
Rpar21 a_7714_8219.t1 a_7714_8219.t4 98.3592
Rpar22 a_7932_12703.t0 a_7932_12703.t2 119.5107
Rpar23 a_7932_12703.t0 a_7932_12703.t4 128.1227
Rpar24 a_7932_12703.t0 a_7932_12703.t5 105.9887
Rpar25 a_7932_12703.t2 a_7932_12703.t4 364.2062
Rpar26 a_7932_12703.t2 a_7932_12703.t5 301.2874
Rpar27 a_7932_12703.t4 a_7932_12703.t5 28.5368
Rpar28 ib ib.t0 13.0308
Rpar29 ib ib.t1 15.1277
Rpar30 ib.t0 ib.t1 31.0557
Rpar31 inn inn.t0 3.1115
Rpar32 inn inn.t2 42.6344
Rpar33 inp inp.t0 3.1602
Rpar34 inp inp.t2 42.7567
Rpar35 out out.t0 222.7702
Rpar36 out out.t1 5.8416
Rpar37 out out.t9 796.8297
Rpar38 out.t0 out.t1 78.3335
Rpar39 out.t0 out.t9 96.4523
Rpar40 out.t1 out.t9 280.1921
Rpar41 vdd vdd.t0 113.0919
Rpar42 vdd vdd.t1 181.6085
Rpar43 vdd vdd.t10 727.4848
Rpar44 vdd vdd.t11 1357.6060
Rpar45 vdd vdd.t4 122.4930
Rpar46 vdd.t0 vdd.t1 5.9866
Rpar47 vdd.t0 vdd.t10 490.4005
Rpar48 vdd.t0 vdd.t11 915.1679
Rpar49 vdd.t0 vdd.t4 112.6038
Rpar50 vdd.t1 vdd.t10 240.9873
Rpar51 vdd.t1 vdd.t11 449.7219
Rpar52 vdd.t1 vdd.t4 95.0451
Rpar53 vdd.t10 vdd.t11 12.3165
Rpar54 vdd.t10 vdd.t4 195.9407
Rpar55 vdd.t11 vdd.t4 365.6575
Rpar56 vss vss.t0 164.4658
Rpar57 vss vss.t1 2651.7774
Rpar58 vss vss.t10 730.9938
Rpar59 vss vss.t9 67.2237
Rpar60 vss vss.t2 3721.4730
Rpar61 vss vss.t3 278.2411
Rpar62 vss.t0 vss.t1 347.9245
Rpar63 vss.t0 vss.t10 518.7719
Rpar64 vss.t0 vss.t9 47.0150
Rpar65 vss.t0 vss.t2 471.5752
Rpar66 vss.t0 vss.t3 181.9053
Rpar67 vss.t1 vss.t9 224.7017
Rpar68 vss.t1 vss.t2 9.1887
Rpar69 vss.t1 vss.t3 700.9335
Rpar70 vss.t10 vss.t9 15.2065
Rpar71 vss.t10 vss.t3 66.9377
Rpar72 vss.t9 vss.t2 319.5783
Rpar73 vss.t9 vss.t3 6.2351
Rpar74 vss.t2 vss.t3 998.3494
Cpar0 a_1000_10218.t0 vss 3.76800e-17
Cpar1 a_1000_5538.t0 vss 4.16980e-15
Cpar2 a_1000_5538.t1 vss 4.35073e-15
Cpar3 a_1000_5538.t3 vss 3.82794e-15
Cpar4 a_1000_5538.t6 vss 3.87091e-15
Cpar5 a_1000_5538.t7 vss 1.52127e-14
Cpar6 a_1000_6058.t0 vss 4.08200e-17
Cpar7 a_1000_7098.t0 vss 3.66800e-17
Cpar8 a_1000_8138.t0 vss 3.66800e-17
Cpar9 a_1000_9178.t0 vss 3.74200e-17
Cpar10 a_5060_10738.t0 vss 2.86650e-16
Cpar11 a_5060_10738.t1 vss 4.64151e-15
Cpar12 a_5060_5538.t0 vss 4.56600e-17
Cpar13 a_5060_6578.t0 vss 4.24200e-17
Cpar14 a_5060_7618.t0 vss 4.21800e-17
Cpar15 a_5060_8658.t0 vss 4.07400e-17
Cpar16 a_5060_9698.t0 vss 3.86000e-17
Cpar17 a_6563_5042.t0 vss 7.59975e-15
Cpar18 a_6563_5042.t4 vss 4.91131e-15
Cpar19 a_6594_6714.t0 vss 9.31837e-15
Cpar20 a_6594_6714.t2 vss 1.20282e-14
Cpar21 a_6683_4834.t0 vss 7.59040e-15
Cpar22 a_6683_4834.t2 vss 7.26334e-15
Cpar23 a_6683_4834.t3 vss 2.29226e-15
Cpar24 a_6760_14526.t0 vss 1.94900e-15
Cpar25 a_6760_14526.t2 vss 5.83024e-15
Cpar26 a_6760_14526.t3 vss 1.41579e-15
Cpar27 a_7714_8219.t0 vss 5.79727e-15
Cpar28 a_7714_8219.t1 vss 1.57141e-15
Cpar29 a_7714_8219.t4 vss 1.15037e-15
Cpar30 a_7932_12703.t0 vss 5.64437e-15
Cpar31 a_7932_12703.t2 vss 3.27222e-15
Cpar32 a_7932_12703.t4 vss 7.36794e-15
Cpar33 a_7932_12703.t5 vss 2.27643e-15
Cpar34 ib out 1.97782e-15
Cpar35 ib vss 2.94569e-14
Cpar36 ib.t0 vss 9.79740e-15
Cpar37 ib.t1 vss 9.13218e-16
Cpar38 inn inp 1.02520e-16
Cpar39 inn vdd 5.05997e-15
Cpar40 inn vss 8.48882e-15
Cpar41 inn.t0 vss 1.46044e-15
Cpar42 inn.t2 vss 5.11056e-15
Cpar43 inp vdd 4.84163e-15
Cpar44 inp vss 8.01597e-15
Cpar45 inp.t0 vss 1.50310e-15
Cpar46 inp.t2 vss 5.18043e-15
Cpar47 out vdd 8.77608e-15
Cpar48 out vss 1.90565e-14
Cpar49 out.t0 vss 6.48438e-15
Cpar50 out.t1 vss 2.72624e-15
Cpar51 out.t9 vss 8.37127e-15
Cpar52 vdd vss 1.19927e-13
Cpar53 vdd.t0 vss 2.48733e-14
Cpar54 vdd.t1 vss 7.62782e-15
Cpar55 vdd.t10 vss 7.57436e-15
Cpar56 vdd.t11 vss 3.60888e-15
Cpar57 vdd.t4 vss 1.21720e-14
.ends opamp_dut

Vdd vdd 0 3.300000
Vss vss 0 0
Ibias vdd ib 1.250000e-07
Vinp inp 0 DC 1.645000 AC 1 PWL(0 1.645000 1.048911e-07 1.645000 1.153803e-07 1.655000)
Rfb out inn 1m
Cload out 0 2.000000e-13
Xdut vdd vss inp inn out ib opamp_dut
.end
