* opa1000[0095]: 200f/current_reuse_1v8_1u_10u_subth (current_reuse, VDD=1.8V, CL=0.2pF, Iref=0.9286uA)
.include "pdk_opa.inc"
.temp 27
.option gmin=1e-12 rshunt=1e12 reltol=1e-3 abstol=1e-12 vntol=1e-5 method=gear
* Post-PEX R+C extracted netlist for current_reuse_1v8_1u_10u_subth
.subckt opamp_dut vdd vss inp inn out ib
XMpar0 a_4050_12084.t1 inp.t4 a_995_6909.t0 vdd.t4 pfet_03v3 w=1.85u l=0.8u ad=6.0257e-13 pd=2.7657e-06 as=5.1800e-13 ps=2.4100e-06 nf=1 m=14 par=14
XMpar1 a_4050_12084.t1 inn.t4 a_7864_13666.t0 vdd.t4 pfet_03v3 w=1.85u l=0.8u ad=6.0257e-13 pd=2.7657e-06 as=5.1800e-13 ps=2.4100e-06 nf=1 m=14 par=14
XMpar2 a_6770_6868.t0 inn.t0 a_7864_13666.t14 vss.t0 nfet_03v3 w=1.88u l=0.8u ad=8.2720e-13 pd=3.7000e-06 as=5.2640e-13 ps=2.4400e-06 nf=1 m=4 par=4
XMpar3 out.t11 ib.t0 vss.t10 vss.t0 nfet_03v3 w=2u l=1.6u ad=6.8800e-13 pd=3.0880e-06 as=5.6000e-13 ps=2.5600e-06 nf=1 m=10 par=10
XMpar4 out.t0 a_995_6909.t20 vdd.t1 vdd.t0 pfet_03v3 w=10u l=1.5u ad=2.8000e-12 pd=1.0560e-05 as=3.4400e-12 ps=1.2688e-05 nf=1 m=10 par=10
XMpar5 ib.t1 ib.t0 vss.t10 vss.t0 nfet_03v3 w=2u l=1.6u ad=5.6000e-13 pd=2.5600e-06 as=5.6000e-13 ps=2.5600e-06 nf=1 m=2 par=2
XMpar6 a_995_6909.t19 a_7864_13666.t18 vdd.t1 vdd.t0 pfet_03v3 w=10u l=1.5u ad=6.0000e-12 pd=2.1200e-05 as=2.8000e-12 ps=1.0560e-05 nf=1 m=1
XMpar7 a_6770_6868.t0 inp.t0 a_995_6909.t14 vss.t0 nfet_03v3 w=1.88u l=0.8u ad=8.2720e-13 pd=3.7000e-06 as=5.2640e-13 ps=2.4400e-06 nf=1 m=4 par=4
XMpar8 a_4050_12084.t0 a_7864_13666.t18 vdd.t1 vdd.t0 pfet_03v3 w=10u l=1.5u ad=2.8000e-12 pd=1.0560e-05 as=6.0000e-12 ps=2.1200e-05 nf=1 m=2 par=2
XMpar9 a_6770_6868.t8 ib.t0 vss.t10 vss.t0 nfet_03v3 w=2u l=1.6u ad=5.6000e-13 pd=2.5600e-06 as=5.6000e-13 ps=2.5600e-06 nf=1 m=4 par=4
XMpar10 a_7864_13666.t19 a_7864_13666.t18 vdd.t1 vdd.t0 pfet_03v3 w=10u l=1.5u ad=6.0000e-12 pd=2.1200e-05 as=2.8000e-12 ps=1.0560e-05 nf=1 m=1
X12 a_995_7429.t0 a_3423_6909.t0 vss.t8 ppolyf_u_1k r_width=1u r_length=11.48u
X19 a_995_6909.t18 a_3423_6909.t0 vss.t8 ppolyf_u_1k r_width=1u r_length=11.48u
X50 a_995_7429.t1 out.t2 cap_mim_2f0fF c_width=19.85u c_length=19.84u
Rpar0 a_4050_12084.t0 a_4050_12084.t1 49.7043
Rpar1 a_6770_6868.t0 a_6770_6868.t8 56.6247
Rpar2 a_7864_13666.t0 a_7864_13666.t14 127.1602
Rpar3 a_7864_13666.t0 a_7864_13666.t18 98.3829
Rpar4 a_7864_13666.t0 a_7864_13666.t19 74.7272
Rpar5 a_7864_13666.t14 a_7864_13666.t18 106.5569
Rpar6 a_7864_13666.t14 a_7864_13666.t19 503.7432
Rpar7 a_7864_13666.t18 a_7864_13666.t19 36.7192
Rpar8 a_995_6909.t0 a_995_6909.t14 314.5550
Rpar9 a_995_6909.t0 a_995_6909.t18 236.0125
Rpar10 a_995_6909.t0 a_995_6909.t19 66.9769
Rpar11 a_995_6909.t0 a_995_6909.t20 83.4608
Rpar12 a_995_6909.t14 a_995_6909.t18 216.9797
Rpar13 a_995_6909.t14 a_995_6909.t19 1092.0806
Rpar14 a_995_6909.t14 a_995_6909.t20 96.8604
Rpar15 a_995_6909.t18 a_995_6909.t19 819.3947
Rpar16 a_995_6909.t18 a_995_6909.t20 72.6750
Rpar17 a_995_6909.t19 a_995_6909.t20 289.7614
Rpar18 a_995_7429.t0 a_995_7429.t1 56.9037
Rpar19 ib ib.t0 23.7168
Rpar20 ib ib.t1 12.7253
Rpar21 ib.t0 ib.t1 58.6742
Rpar22 inn inn.t0 5.9410
Rpar23 inn inn.t4 45.3908
Rpar24 inp inp.t0 5.9896
Rpar25 inp inp.t4 45.3422
Rpar26 out out.t0 2.3541
Rpar27 out out.t11 130.5612
Rpar28 out out.t2 184.2747
Rpar29 out.t11 out.t2 61.9970
Rpar30 vdd vdd.t0 36.9374
Rpar31 vdd vdd.t1 75.0019
Rpar32 vdd vdd.t4 151.1730
Rpar33 vdd.t0 vdd.t1 3.1911
Rpar34 vdd.t0 vdd.t4 57.9507
Rpar35 vdd.t1 vdd.t4 108.9576
Rpar36 vss vss.t0 31.8575
Rpar37 vss vss.t10 224.7582
Rpar38 vss vss.t8 103.1492
Rpar39 vss.t0 vss.t10 4.2030
Rpar40 vss.t0 vss.t8 42.9343
Rpar41 vss.t10 vss.t8 797.0139
Cpar0 a_3423_6909.t0 vss 2.95200e-17
Cpar1 a_4050_12084.t0 vss 5.55606e-15
Cpar2 a_4050_12084.t1 vss 1.57422e-14
Cpar3 a_6770_6868.t0 vss 7.12340e-15
Cpar4 a_6770_6868.t8 vss 6.78967e-15
Cpar5 a_7864_13666.t0 vss 8.38042e-15
Cpar6 a_7864_13666.t14 vss 3.84989e-15
Cpar7 a_7864_13666.t18 vss 1.20300e-14
Cpar8 a_7864_13666.t19 vss 5.69625e-15
Cpar9 a_995_6909.t0 vss 6.54951e-15
Cpar10 a_995_6909.t14 vss 2.57639e-15
Cpar11 a_995_6909.t18 vss 2.01499e-15
Cpar12 a_995_6909.t19 vss 3.77123e-15
Cpar13 a_995_6909.t20 vss 2.29025e-14
Cpar14 a_995_7429.t0 vss 4.63300e-17
Cpar15 a_995_7429.t1 vss 2.36466e-15
Cpar16 ib out 1.60569e-15
Cpar17 ib vss 2.31580e-14
Cpar18 ib.t0 vss 4.50162e-15
Cpar19 ib.t1 vss 3.17308e-16
Cpar20 inn inp 1.02790e-16
Cpar21 inn out 8.45300e-17
Cpar22 inn vdd 8.44975e-15
Cpar23 inn vss 7.44052e-15
Cpar24 inn.t0 vss 1.24539e-15
Cpar25 inn.t4 vss 1.01751e-14
Cpar26 inp out 2.93990e-16
Cpar27 inp vdd 8.07061e-15
Cpar28 inp vss 8.72858e-15
Cpar29 inp.t0 vss 1.28583e-15
Cpar30 inp.t4 vss 1.04267e-14
Cpar31 out vdd 1.27134e-14
Cpar32 out vss 2.15180e-14
Cpar33 out.t0 vss 7.96096e-15
Cpar34 out.t11 vss 5.91436e-15
Cpar35 out.t2 vss 9.55559e-15
Cpar36 vdd vss 1.40877e-13
Cpar37 vdd.t0 vss 2.73843e-14
Cpar38 vdd.t1 vss 1.56449e-14
Cpar39 vdd.t4 vss 1.95113e-14
.ends opamp_dut

Vdd vdd 0 1.800000
Vss vss 0 0
Ibias vdd ib 9.286000e-07
Vinp inp 0 DC 0.895000 AC 1 PWL(0 0.895000 1.746188e-08 0.895000 1.920807e-08 0.905000)
Rfb out inn 1m
Cload out 0 2.000000e-13
Xdut vdd vss inp inn out ib opamp_dut
.end
