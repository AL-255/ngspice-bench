* opa1000[0959]: 2p/telescopic_pmos_1v8_ulp_lt0p1uw_weak (telescopic_pmos, VDD=1.8V, CL=2.0pF, Iref=0.0009uA)
.include "pdk_opa.inc"
.temp 27
.option gmin=1e-12 rshunt=1e12 reltol=1e-3 abstol=1e-12 vntol=1e-5 method=gear
* Post-PEX R+C extracted netlist for telescopic_pmos_1v8_ulp_lt0p1uw_weak
.subckt opamp_dut vdd vss inp inn out ib
XMpar0 a_7054_5817.t2 vss.t20 out.t0 vdd.t8 pfet_03v3 w=0.4u l=4u ad=2.4000e-13 pd=2.0000e-06 as=1.1200e-13 ps=9.6000e-07 nf=1 m=2 par=2
XMpar1 a_1592_11732.t4 ib.t0 vss.t14 vss.t13 nfet_03v3 w=0.4u l=5u ad=2.4000e-13 pd=2.0000e-06 as=1.1200e-13 ps=9.6000e-07 nf=1 m=2 par=2
XMpar2 ib.t1 ib.t0 vss.t14 vss.t13 nfet_03v3 w=0.4u l=5u ad=2.4000e-13 pd=2.0000e-06 as=1.1200e-13 ps=9.6000e-07 nf=1 m=2 par=2
XMpar3 a_2592_11940.t1 inn.t0 a_7054_5817.t0 vdd.t4 pfet_03v3 w=0.4u l=8u ad=2.4000e-13 pd=2.0000e-06 as=1.1200e-13 ps=9.6000e-07 nf=1 m=2 par=2
XMpar4 a_2592_11940.t0 a_1592_11732.t0 vdd.t1 vdd.t0 pfet_03v3 w=0.4u l=5u ad=1.1200e-13 pd=9.6000e-07 as=2.0800e-13 ps=1.7400e-06 nf=1 m=8 par=8
XMpar5 a_1592_11732.t1 a_1592_11732.t0 vdd.t1 vdd.t0 pfet_03v3 w=0.4u l=5u ad=2.4000e-13 pd=2.0000e-06 as=1.1200e-13 ps=9.6000e-07 nf=1 m=2 par=2
XMpar6 a_2992_7019.t4 vss.t20 a_4914_5817.t2 vdd.t8 pfet_03v3 w=0.4u l=4u ad=1.1200e-13 pd=9.6000e-07 as=2.4000e-13 ps=2.0000e-06 nf=1 m=2 par=2
XMpar7 a_2872_7227.t0 a_2992_7019.t0 a_2992_7019.t1 vss.t0 nfet_03v3 w=0.4u l=4u ad=2.4000e-13 pd=2.0000e-06 as=2.4000e-13 ps=2.0000e-06 nf=1 m=2 par=2
XMpar8 a_2872_7227.t2 a_2992_7019.t6 vss.t3 vss.t2 nfet_03v3 w=0.4u l=9.5u ad=2.4000e-13 pd=2.0000e-06 as=1.1200e-13 ps=9.6000e-07 nf=1 m=2 par=2
XMpar9 a_6124_10210.t2 a_2992_7019.t0 out.t1 vss.t0 nfet_03v3 w=0.4u l=4u ad=2.4000e-13 pd=2.0000e-06 as=1.1200e-13 ps=9.6000e-07 nf=1 m=2 par=2
XMpar10 a_6124_10210.t0 a_2992_7019.t6 vss.t3 vss.t2 nfet_03v3 w=0.4u l=9.5u ad=1.1200e-13 pd=9.6000e-07 as=1.1200e-13 ps=9.6000e-07 nf=1 m=2 par=2
XMpar11 a_2592_11940.t1 inp.t0 a_4914_5817.t0 vdd.t4 pfet_03v3 w=0.4u l=8u ad=2.4000e-13 pd=2.0000e-06 as=1.1200e-13 ps=9.6000e-07 nf=1 m=2 par=2
X9 out.t4 vss.t10 cap_mim_2f0fF c_width=14.82u c_length=14.81u
X13 out.t4 vss.t10 cap_mim_2f0fF c_width=14.82u c_length=14.81u
Rpar0 a_1592_11732.t0 a_1592_11732.t1 15.7133
Rpar1 a_1592_11732.t0 a_1592_11732.t4 137.8411
Rpar2 a_1592_11732.t1 a_1592_11732.t4 142.0508
Rpar3 a_2592_11940.t0 a_2592_11940.t1 54.0819
Rpar4 a_2872_7227.t0 a_2872_7227.t2 71.3375
Rpar5 a_2992_7019.t0 a_2992_7019.t1 24.6633
Rpar6 a_2992_7019.t0 a_2992_7019.t4 516.7697
Rpar7 a_2992_7019.t0 a_2992_7019.t6 133.6990
Rpar8 a_2992_7019.t1 a_2992_7019.t4 409.9356
Rpar9 a_2992_7019.t1 a_2992_7019.t6 106.0588
Rpar10 a_2992_7019.t4 a_2992_7019.t6 67.8506
Rpar11 a_4914_5817.t0 a_4914_5817.t2 64.9594
Rpar12 a_6124_10210.t0 a_6124_10210.t2 77.8258
Rpar13 a_7054_5817.t0 a_7054_5817.t2 64.9594
Rpar14 ib ib.t0 13.7002
Rpar15 ib ib.t1 16.8245
Rpar16 ib.t0 ib.t1 26.6249
Rpar17 inn inn.t0 3.3924
Rpar18 inp inp.t0 3.4410
Rpar19 out out.t0 80.8687
Rpar20 out out.t1 162.5694
Rpar21 out out.t4 16.4443
Rpar22 out.t0 out.t1 127.9501
Rpar23 vdd vdd.t0 269.9871
Rpar24 vdd vdd.t1 30.1696
Rpar25 vdd vdd.t4 114.9104
Rpar26 vdd vdd.t8 260.7039
Rpar27 vdd.t0 vdd.t1 13.1605
Rpar28 vdd.t0 vdd.t4 3867.6507
Rpar29 vdd.t1 vdd.t4 432.1887
Rpar30 vdd.t1 vdd.t8 980.5318
Rpar31 vdd.t4 vdd.t8 46.1442
Rpar32 vss vss.t0 1149.2403
Rpar33 vss vss.t10 66.9513
Rpar34 vss vss.t13 435.6654
Rpar35 vss vss.t14 181.3082
Rpar36 vss vss.t2 1505.6193
Rpar37 vss vss.t20 126.3057
Rpar38 vss vss.t3 957.2496
Rpar39 vss.t0 vss.t10 2772.8428
Rpar40 vss.t0 vss.t13 2492.4054
Rpar41 vss.t0 vss.t14 1157.4047
Rpar42 vss.t0 vss.t2 244.4787
Rpar43 vss.t0 vss.t20 196.8724
Rpar44 vss.t0 vss.t3 155.3220
Rpar45 vss.t10 vss.t13 1051.1566
Rpar46 vss.t10 vss.t14 437.4535
Rpar47 vss.t10 vss.t2 3632.7004
Rpar48 vss.t10 vss.t20 304.7455
Rpar49 vss.t10 vss.t3 2309.6149
Rpar50 vss.t13 vss.t14 24.6814
Rpar51 vss.t13 vss.t2 1953.0383
Rpar52 vss.t13 vss.t20 307.8841
Rpar53 vss.t13 vss.t3 1198.8453
Rpar54 vss.t14 vss.t2 1377.2477
Rpar55 vss.t14 vss.t20 129.3470
Rpar56 vss.t14 vss.t3 868.5455
Rpar57 vss.t2 vss.t20 259.1039
Rpar58 vss.t2 vss.t3 31.9704
Rpar59 vss.t20 vss.t3 164.8014
Cpar0 a_1592_11732.t0 vss 3.01642e-14
Cpar1 a_1592_11732.t1 vss 7.39062e-15
Cpar2 a_1592_11732.t4 vss 9.54199e-15
Cpar3 a_2592_11940.t0 vss 1.49339e-14
Cpar4 a_2592_11940.t1 vss 8.81399e-15
Cpar5 a_2872_7227.t0 vss 5.14863e-15
Cpar6 a_2872_7227.t2 vss 6.77876e-15
Cpar7 a_2992_7019.t0 vss 3.18155e-15
Cpar8 a_2992_7019.t1 vss 1.14637e-15
Cpar9 a_2992_7019.t4 vss 9.13189e-16
Cpar10 a_2992_7019.t6 vss 6.81868e-15
Cpar11 a_4914_5817.t0 vss 3.92535e-15
Cpar12 a_4914_5817.t2 vss 4.24525e-15
Cpar13 a_6124_10210.t0 vss 6.14758e-15
Cpar14 a_6124_10210.t2 vss 5.81617e-15
Cpar15 a_7054_5817.t0 vss 4.17691e-15
Cpar16 a_7054_5817.t2 vss 4.51732e-15
Cpar17 ib vss 1.73713e-14
Cpar18 ib.t0 vss 2.73847e-15
Cpar19 ib.t1 vss 4.36940e-16
Cpar20 inn inp 5.19700e-17
Cpar21 inn vdd 7.43112e-15
Cpar22 inn vss 4.64566e-15
Cpar23 inn.t0 vss 4.18592e-15
Cpar24 inp vdd 7.40306e-15
Cpar25 inp vss 4.57285e-15
Cpar26 inp.t0 vss 4.23769e-15
Cpar27 out vdd 2.15701e-15
Cpar28 out vss 1.88134e-14
Cpar29 out.t0 vss 2.08693e-16
Cpar30 out.t1 vss 2.48914e-16
Cpar31 out.t4 vss 9.51117e-15
Cpar32 vdd vss 1.39235e-13
Cpar33 vdd.t0 vss 3.10307e-14
Cpar34 vdd.t1 vss 5.73916e-15
Cpar35 vdd.t4 vss 1.53250e-14
Cpar36 vdd.t8 vss 1.30639e-14
.ends opamp_dut

Vdd vdd 0 1.800000
Vss vss 0 0
Ibias vdd ib 9.000000e-10
Vinp inp 0 DC 0.805000 AC 1 PWL(0 0.805000 4.550101e-05 0.805000 5.005111e-05 0.815000)
Rfb out inn 1m
Cload out 0 2.000000e-12
Xdut vdd vss inp inn out ib opamp_dut
.end
