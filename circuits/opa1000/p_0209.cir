* opa1000[0209]: 2p/folded_cascode_nmos_1v8_ulp_lt0p1uw_weak (folded_cascode_nmos, VDD=1.8V, CL=2.0pF, Iref=0.006uA)
.include "pdk_opa.inc"
.temp 27
.option gmin=1e-12 rshunt=1e12 reltol=1e-3 abstol=1e-12 vntol=1e-5 method=gear
* Post-PEX R+C extracted netlist for folded_cascode_nmos_1v8_ulp_lt0p1uw_weak
.subckt opamp_dut vdd vss inp inn out ib
XMpar0 a_4114_6915.t0 ib.t0 vss.t1 vss.t0 nfet_03v3 w=0.4u l=9.5u ad=2.4000e-13 pd=2.0000e-06 as=1.1200e-13 ps=9.6000e-07 nf=1 m=4 par=4
XMpar1 out.t0 a_4612_11417.t0 vss.t1 vss.t0 nfet_03v3 w=0.4u l=9.5u ad=1.1200e-13 pd=9.6000e-07 as=1.1200e-13 ps=9.6000e-07 nf=1 m=2 par=2
XMpar2 a_4110_8506.t2 a_2810_8298.t2 vdd.t1 vdd.t0 pfet_03v3 w=0.4u l=6.5u ad=1.1200e-13 pd=9.6000e-07 as=1.7600e-13 ps=1.4800e-06 nf=1 m=4 par=4
XMpar3 ib.t1 ib.t0 vss.t1 vss.t0 nfet_03v3 w=0.4u l=9.5u ad=2.4000e-13 pd=2.0000e-06 as=1.1200e-13 ps=9.6000e-07 nf=1 m=2 par=2
XMpar4 a_4114_6915.t4 inn.t0 a_8654_9962.t6 vss.t21 nfet_03v3 w=0.4u l=10u ad=2.4000e-13 pd=2.0000e-06 as=1.1200e-13 ps=9.6000e-07 nf=1 m=2 par=2
XMpar5 a_8654_9962.t2 a_2810_8298.t2 vdd.t1 vdd.t0 pfet_03v3 w=0.4u l=6.5u ad=1.1200e-13 pd=9.6000e-07 as=1.7600e-13 ps=1.4800e-06 nf=1 m=4 par=4
XMpar6 a_4110_8506.t0 ib.t10 a_4612_11417.t4 vdd.t6 pfet_03v3 w=0.4u l=8.5u ad=2.4000e-13 pd=2.0000e-06 as=1.1200e-13 ps=9.6000e-07 nf=1 m=2 par=2
XMpar7 a_2810_8298.t3 a_2810_8298.t2 vdd.t1 vdd.t0 pfet_03v3 w=0.4u l=6.5u ad=1.1200e-13 pd=9.6000e-07 as=2.4000e-13 ps=2.0000e-06 nf=1 m=2 par=2
XMpar8 a_4612_11417.t1 a_4612_11417.t0 vss.t1 vss.t0 nfet_03v3 w=0.4u l=9.5u ad=2.4000e-13 pd=2.0000e-06 as=1.1200e-13 ps=9.6000e-07 nf=1 m=2 par=2
XMpar9 a_8654_9962.t0 ib.t10 out.t2 vdd.t6 pfet_03v3 w=0.4u l=8.5u ad=2.4000e-13 pd=2.0000e-06 as=1.1200e-13 ps=9.6000e-07 nf=1 m=2 par=2
XMpar10 a_4110_8506.t6 inp.t0 a_4114_6915.t4 vss.t21 nfet_03v3 w=0.4u l=10u ad=1.1200e-13 pd=9.6000e-07 as=2.4000e-13 ps=2.0000e-06 nf=1 m=2 par=2
XMpar11 a_2810_8298.t0 ib.t0 vss.t1 vss.t0 nfet_03v3 w=0.4u l=9.5u ad=2.4000e-13 pd=2.0000e-06 as=1.1200e-13 ps=9.6000e-07 nf=1 m=2 par=2
X7 out.t4 vss.t6 cap_mim_2f0fF c_width=19.62u c_length=19.63u
Rpar0 a_2810_8298.t0 a_2810_8298.t2 104.3220
Rpar1 a_2810_8298.t0 a_2810_8298.t3 273.1676
Rpar2 a_2810_8298.t2 a_2810_8298.t3 26.2165
Rpar3 a_4110_8506.t0 a_4110_8506.t2 58.6991
Rpar4 a_4110_8506.t0 a_4110_8506.t6 152.4463
Rpar5 a_4110_8506.t2 a_4110_8506.t6 90.6409
Rpar6 a_4114_6915.t0 a_4114_6915.t4 94.8456
Rpar7 a_4612_11417.t0 a_4612_11417.t1 23.4077
Rpar8 a_4612_11417.t0 a_4612_11417.t4 110.3321
Rpar9 a_4612_11417.t1 a_4612_11417.t4 87.3203
Rpar10 a_8654_9962.t0 a_8654_9962.t2 58.6991
Rpar11 a_8654_9962.t0 a_8654_9962.t6 152.4463
Rpar12 a_8654_9962.t2 a_8654_9962.t6 90.6409
Rpar13 ib ib.t0 16.3663
Rpar14 ib ib.t1 15.9074
Rpar15 ib ib.t10 489.0977
Rpar16 ib.t0 ib.t1 32.5712
Rpar17 ib.t0 ib.t10 265.0872
Rpar18 ib.t1 ib.t10 521.8473
Rpar19 inn inn.t0 3.7031
Rpar20 inp inp.t0 3.7517
Rpar21 out out.t0 52.2003
Rpar22 out out.t2 14.3437
Rpar23 out out.t4 132.5117
Rpar24 out.t0 out.t4 298.8319
Rpar25 vdd vdd.t0 118.5953
Rpar26 vdd vdd.t1 261.6289
Rpar27 vdd vdd.t6 69.8326
Rpar28 vdd.t0 vdd.t1 6.0361
Rpar29 vdd.t0 vdd.t6 65.4655
Rpar30 vdd.t1 vdd.t6 144.4212
Rpar31 vss vss.t0 256.4057
Rpar32 vss vss.t1 131.7542
Rpar33 vss vss.t21 280.9518
Rpar34 vss vss.t6 107.0056
Rpar35 vss.t0 vss.t1 10.0471
Rpar36 vss.t0 vss.t21 6.8537
Rpar37 vss.t0 vss.t6 251.6111
Rpar38 vss.t1 vss.t21 30.2988
Rpar39 vss.t1 vss.t6 129.2905
Rpar40 vss.t21 vss.t6 275.6983
Cpar0 a_2810_8298.t0 vss 1.35986e-14
Cpar1 a_2810_8298.t2 vss 3.47928e-14
Cpar2 a_2810_8298.t3 vss 3.62469e-15
Cpar3 a_4110_8506.t0 vss 4.37562e-15
Cpar4 a_4110_8506.t2 vss 5.86530e-15
Cpar5 a_4110_8506.t6 vss 3.97202e-15
Cpar6 a_4114_6915.t0 vss 1.28945e-14
Cpar7 a_4114_6915.t4 vss 8.77034e-15
Cpar8 a_4612_11417.t0 vss 6.24854e-15
Cpar9 a_4612_11417.t1 vss 1.52914e-15
Cpar10 a_4612_11417.t4 vss 9.75647e-16
Cpar11 a_8654_9962.t0 vss 4.55828e-15
Cpar12 a_8654_9962.t2 vss 6.11012e-15
Cpar13 a_8654_9962.t6 vss 4.13782e-15
Cpar14 ib out 3.34900e-16
Cpar15 ib vdd 1.58651e-14
Cpar16 ib vss 5.55990e-14
Cpar17 ib.t0 vss 2.28539e-14
Cpar18 ib.t1 vss 2.83941e-15
Cpar19 ib.t10 vss 1.25521e-14
Cpar20 inn inp 5.19700e-17
Cpar21 inn out 1.54370e-16
Cpar22 inn vdd 1.78400e-17
Cpar23 inn vss 1.01052e-14
Cpar24 inn.t0 vss 7.11843e-16
Cpar25 inp out 9.97800e-17
Cpar26 inp vdd 1.63300e-17
Cpar27 inp vss 1.01025e-14
Cpar28 inp.t0 vss 7.31606e-16
Cpar29 out vdd 5.67937e-15
Cpar30 out vss 1.90405e-14
Cpar31 out.t0 vss 4.67595e-16
Cpar32 out.t2 vss 2.45768e-17
Cpar33 out.t4 vss 1.39386e-14
Cpar34 vdd vss 1.23304e-13
Cpar35 vdd.t0 vss 3.12375e-14
Cpar36 vdd.t1 vss 1.55981e-14
Cpar37 vdd.t6 vss 1.74408e-14
.ends opamp_dut

Vdd vdd 0 1.800000
Vss vss 0 0
Ibias vdd ib 6.000000e-09
Vinp inp 0 DC 0.985000 AC 1 PWL(0 0.985000 1.353186e-05 0.985000 1.488504e-05 0.995000)
Rfb out inn 1m
Cload out 0 2.000000e-12
Xdut vdd vss inp inn out ib opamp_dut
.end
