* opa1000[0414]: 2p/nmos_5t_3v3_i150u_weak (nmos_5t, VDD=3.3V, CL=2.0pF, Iref=48.75uA)
.include "pdk_opa.inc"
.temp 27
.option gmin=1e-12 rshunt=1e12 reltol=1e-3 abstol=1e-12 vntol=1e-5 method=gear
* Post-PEX R+C extracted netlist for nmos_5t_3v3_i150u_weak
.subckt opamp_dut vdd vss inp inn out ib
XMpar0 a_1307_1249.t0 inn.t0 out.t23 vss.t0 nfet_03v3 w=2.01u l=0.56u ad=6.0386e-13 pd=2.7391e-06 as=5.9017e-13 ps=2.6828e-06 nf=1 m=94 par=94
XMpar1 a_1307_1249.t0 inp.t0 a_1568_12622.t0 vss.t0 nfet_03v3 w=2.01u l=0.56u ad=6.0386e-13 pd=2.7391e-06 as=5.9017e-13 ps=2.6828e-06 nf=1 m=94 par=94
XMpar2 out.t0 a_1568_12622.t94 vdd.t1 vdd.t0 pfet_03v3 w=1.98u l=1.05u ad=6.5340e-13 pd=2.9494e-06 as=5.9400e-13 ps=2.7037e-06 nf=1 m=128 par=128
XMpar3 a_1307_1249.t188 ib.t0 vss.t75 vss.t0 nfet_03v3 w=2.64u l=0.39u ad=7.3920e-13 pd=3.2000e-06 as=8.0960e-13 ps=3.4733e-06 nf=1 m=24 par=24
XMpar4 a_1568_12622.t95 a_1568_12622.t94 vdd.t1 vdd.t0 pfet_03v3 w=1.98u l=1.05u ad=6.3360e-13 pd=2.8675e-06 as=5.9400e-13 ps=2.7037e-06 nf=1 m=128 par=128
XMpar5 ib.t1 ib.t0 vss.t75 vss.t0 nfet_03v3 w=2.64u l=0.39u ad=7.3920e-13 pd=3.2000e-06 as=7.3920e-13 ps=3.2000e-06 nf=1 m=6 par=6
X429 out.t222 vss.t134 cap_mim_2f0fF c_width=7.75u c_length=7.75u
Rpar0 a_1307_1249.t0 a_1307_1249.t188 46.0500
Rpar1 a_1568_12622.t0 a_1568_12622.t94 267.5873
Rpar2 a_1568_12622.t0 a_1568_12622.t95 70.8821
Rpar3 a_1568_12622.t94 a_1568_12622.t95 2.3904
Rpar4 ib ib.t0 12.3514
Rpar5 ib ib.t1 4.1149
Rpar6 inn inn.t0 1.8994
Rpar7 inp inp.t0 1.8994
Rpar8 out out.t0 3.0396
Rpar9 out.t0 out.t23 132.1072
Rpar10 out.t0 out.t222 82.5650
Rpar11 out.t23 out.t222 288.0777
Rpar12 vdd vdd.t0 18.9113
Rpar13 vdd.t0 vdd.t1 8.8274
Rpar14 vss vss.t0 25.8854
Rpar15 vss vss.t75 553.8975
Rpar16 vss vss.t134 495.9896
Rpar17 vss.t0 vss.t75 2.0246
Rpar18 vss.t0 vss.t134 54.7847
Rpar19 vss.t75 vss.t134 761.6164
Cpar0 a_1307_1249.t0 vss 1.01480e-13
Cpar1 a_1307_1249.t188 vss 1.71648e-14
Cpar2 a_1568_12622.t0 vss 5.75090e-14
Cpar3 a_1568_12622.t94 vss 2.57781e-13
Cpar4 a_1568_12622.t95 vss 1.20119e-13
Cpar5 ib inp 1.35100e-17
Cpar6 ib vss 2.34643e-14
Cpar7 ib.t0 vss 3.23483e-15
Cpar8 ib.t1 vss 9.14298e-16
Cpar9 inn inp 2.32160e-16
Cpar10 inn out 1.57811e-14
Cpar11 inn vdd 1.55000e-17
Cpar12 inn vss 3.75874e-14
Cpar13 inn.t0 vss 2.32300e-14
Cpar14 inp vdd 1.55000e-17
Cpar15 inp vss 3.77624e-14
Cpar16 inp.t0 vss 2.33183e-14
Cpar17 out vdd 9.52013e-14
Cpar18 out vss 2.96879e-14
Cpar19 out.t0 vss 1.24884e-13
Cpar20 out.t222 vss 3.40343e-14
Cpar21 out.t23 vss 6.51895e-14
Cpar22 vdd vss 4.84769e-13
Cpar23 vdd.t0 vss 3.42897e-13
Cpar24 vdd.t1 vss 4.54309e-14
.ends opamp_dut

Vdd vdd 0 3.300000
Vss vss 0 0
Ibias vdd ib 4.875000e-05
Vinp inp 0 DC 1.645000 AC 1 PWL(0 1.645000 3.000000e-09 1.645000 3.300000e-09 1.655000)
Rfb out inn 1m
Cload out 0 2.000000e-12
Xdut vdd vss inp inn out ib opamp_dut
.end
