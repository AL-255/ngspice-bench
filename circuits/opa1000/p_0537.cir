* opa1000[0537]: 200f/pmos_5t_3v3_10u_100u_subth (pmos_5t, VDD=3.3V, CL=0.2pF, Iref=13.0uA)
.include "pdk_opa.inc"
.temp 27
.option gmin=1e-12 rshunt=1e12 reltol=1e-3 abstol=1e-12 vntol=1e-5 method=gear
* Post-PEX R+C extracted netlist for pmos_5t_3v3_10u_100u_subth
.subckt opamp_dut vdd vss inp inn out ib
XMpar0 a_1116_6630.t0 inp.t0 a_1954_8549.t0 vdd.t2 pfet_03v3 w=8u l=0.6u ad=2.3200e-12 pd=8.8300e-06 as=2.4000e-12 ps=9.1000e-06 nf=1 m=64 par=64
XMpar1 a_1954_8549.t0 inn.t0 out.t2 vdd.t2 pfet_03v3 w=8u l=0.6u ad=2.4000e-12 pd=9.1000e-06 as=2.3200e-12 ps=8.8300e-06 nf=1 m=64 par=64
XMpar2 out.t0 a_1116_6630.t64 vss.t1 vss.t0 nfet_03v3 w=1.92u l=1u ad=5.3760e-13 pd=2.4800e-06 as=5.3760e-13 ps=2.4800e-06 nf=1 m=20 par=20
XMpar3 a_1954_8549.t128 a_1982_1249.t2 vdd.t1 vdd.t0 pfet_03v3 w=10u l=1.25u ad=2.8000e-12 pd=1.0560e-05 as=3.6000e-12 ps=1.3220e-05 nf=1 m=8 par=8
XMpar4 a_1116_6630.t65 a_1116_6630.t64 vss.t1 vss.t0 nfet_03v3 w=1.92u l=1u ad=5.9904e-13 pd=2.7360e-06 as=5.3760e-13 ps=2.4800e-06 nf=1 m=20 par=20
XMpar5 a_1982_1249.t0 ib.t0 vss.t66 vss.t65 nfet_03v3 w=10u l=1.25u ad=2.8000e-12 pd=1.0560e-05 as=2.8000e-12 ps=1.0560e-05 nf=1 m=2 par=2
XMpar6 ib.t1 ib.t0 vss.t66 vss.t65 nfet_03v3 w=10u l=1.25u ad=6.0000e-12 pd=2.1200e-05 as=2.8000e-12 ps=1.0560e-05 nf=1 m=2 par=2
XMpar7 a_1982_1249.t3 a_1982_1249.t2 vdd.t1 vdd.t0 pfet_03v3 w=10u l=1.25u ad=2.8000e-12 pd=1.0560e-05 as=2.8000e-12 ps=1.0560e-05 nf=1 m=2 par=2
X145 out.t84 vss.t26 cap_mim_2f0fF c_width=18.88u c_length=18.88u
Rpar0 a_1116_6630.t0 a_1116_6630.t64 284.1548
Rpar1 a_1116_6630.t0 a_1116_6630.t65 70.4608
Rpar2 a_1116_6630.t64 a_1116_6630.t65 13.7402
Rpar3 a_1954_8549.t0 a_1954_8549.t128 72.9474
Rpar4 a_1982_1249.t0 a_1982_1249.t2 119.7829
Rpar5 a_1982_1249.t0 a_1982_1249.t3 61.0885
Rpar6 a_1982_1249.t2 a_1982_1249.t3 27.0701
Rpar7 ib ib.t0 21.5365
Rpar8 ib ib.t1 3.3405
Rpar9 inn inn.t0 2.9313
Rpar10 inp inp.t0 2.9313
Rpar11 out out.t0 54.5347
Rpar12 out out.t2 109.2866
Rpar13 out out.t84 16.1409
Rpar14 out.t0 out.t2 51.8386
Rpar15 out.t0 out.t84 419.4952
Rpar16 out.t2 out.t84 840.6610
Rpar17 vdd vdd.t0 90.2629
Rpar18 vdd vdd.t1 548.9977
Rpar19 vdd vdd.t2 20.4392
Rpar20 vdd.t0 vdd.t1 5.4789
Rpar21 vdd.t0 vdd.t2 276.4188
Rpar22 vdd.t1 vdd.t2 1681.2367
Rpar23 vss vss.t0 91.1823
Rpar24 vss vss.t1 595.9666
Rpar25 vss vss.t26 94.2512
Rpar26 vss vss.t65 78.4489
Rpar27 vss vss.t66 120.7968
Rpar28 vss.t0 vss.t1 3.6617
Rpar29 vss.t0 vss.t26 97.3026
Rpar30 vss.t0 vss.t65 41.8724
Rpar31 vss.t0 vss.t66 679.7113
Rpar32 vss.t1 vss.t26 633.9456
Rpar33 vss.t1 vss.t65 415.3440
Rpar34 vss.t26 vss.t65 836.0083
Rpar35 vss.t26 vss.t66 1370.2677
Rpar36 vss.t65 vss.t66 10.9410
Cpar0 a_1116_6630.t0 vss 7.69401e-14
Cpar1 a_1116_6630.t64 vss 2.74696e-14
Cpar2 a_1116_6630.t65 vss 1.26490e-14
Cpar3 a_1954_8549.t0 vss 1.93218e-13
Cpar4 a_1954_8549.t128 vss 1.81876e-14
Cpar5 a_1982_1249.t0 vss 2.88200e-15
Cpar6 a_1982_1249.t2 vss 1.69767e-14
Cpar7 a_1982_1249.t3 vss 3.90019e-15
Cpar8 ib vss 1.12491e-14
Cpar9 ib.t0 vss 8.60740e-16
Cpar10 ib.t1 vss 5.00710e-16
Cpar11 inn inp 1.01040e-16
Cpar12 inn out 1.86112e-14
Cpar13 inn vdd 2.68774e-14
Cpar14 inn vss 1.06698e-14
Cpar15 inn.t0 vss 5.13225e-14
Cpar16 inp vdd 2.69173e-14
Cpar17 inp vss 1.06783e-14
Cpar18 inp.t0 vss 5.13684e-14
Cpar19 out vdd 9.13292e-15
Cpar20 out vss 2.59035e-14
Cpar21 out.t0 vss 6.86565e-15
Cpar22 out.t2 vss 4.26536e-14
Cpar23 out.t84 vss 6.26380e-14
Cpar24 vdd vss 3.45623e-13
Cpar25 vdd.t0 vss 1.38465e-14
Cpar26 vdd.t1 vss 5.64546e-15
Cpar27 vdd.t2 vss 8.44231e-14
.ends opamp_dut

Vdd vdd 0 3.300000
Vss vss 0 0
Ibias vdd ib 1.300000e-05
Vinp inp 0 DC 1.480000 AC 1 PWL(0 1.480000 3.000000e-09 1.480000 3.300000e-09 1.490000)
Rfb out inn 1m
Cload out 0 2.000000e-13
Xdut vdd vss inp inn out ib opamp_dut
.end
