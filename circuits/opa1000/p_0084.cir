* opa1000[0084]: 200f/current_reuse_1v8_ulp_lt0p1uw_subth (current_reuse, VDD=1.8V, CL=0.2pF, Iref=0.0004uA)
.include "pdk_opa.inc"
.temp 27
.option gmin=1e-12 rshunt=1e12 reltol=1e-3 abstol=1e-12 vntol=1e-5 method=gear
* Post-PEX R+C extracted netlist for current_reuse_1v8_ulp_lt0p1uw_subth
.subckt opamp_dut vdd vss inp inn out ib
XMpar0 out.t3 ib.t0 vss.t2 vss.t1 nfet_03v3 w=0.4u l=8u ad=1.8880e-13 pd=1.5840e-06 as=1.6320e-13 ps=1.3760e-06 nf=1 m=10 par=10
XMpar1 ib.t1 ib.t0 vss.t2 vss.t1 nfet_03v3 w=0.4u l=8u ad=2.4000e-13 pd=2.0000e-06 as=1.1200e-13 ps=9.6000e-07 nf=1 m=2 par=2
XMpar2 a_1630_1086.t2 inp.t0 a_2622_9030.t0 vdd.t15 pfet_03v3 w=0.75u l=9.5u ad=2.1000e-13 pd=1.3100e-06 as=4.5000e-13 ps=2.7000e-06 nf=1 m=4 par=4
XMpar3 a_1022_8822.t0 inn.t4 a_5149_13047.t4 vss.t28 nfet_03v3 w=0.4u l=9.5u ad=2.4000e-13 pd=2.0000e-06 as=2.4000e-13 ps=2.0000e-06 nf=1 m=2 par=2
XMpar4 a_2622_9030.t4 a_1022_8822.t6 vdd.t1 vdd.t0 pfet_03v3 w=0.4u l=8u ad=1.1200e-13 pd=9.6000e-07 as=2.4000e-13 ps=2.0000e-06 nf=1 m=2 par=2
XMpar5 out.t0 a_1630_1086.t8 vdd.t1 vdd.t0 pfet_03v3 w=0.4u l=8u ad=1.3760e-13 pd=1.1680e-06 as=1.6320e-13 ps=1.3760e-06 nf=1 m=10 par=10
XMpar6 a_1630_1086.t0 inp.t4 a_5149_13047.t4 vss.t28 nfet_03v3 w=0.4u l=9.5u ad=2.4000e-13 pd=2.0000e-06 as=2.4000e-13 ps=2.0000e-06 nf=1 m=2 par=2
XMpar7 a_5149_13047.t0 ib.t0 vss.t2 vss.t1 nfet_03v3 w=0.4u l=8u ad=2.4000e-13 pd=2.0000e-06 as=1.1200e-13 ps=9.6000e-07 nf=1 m=4 par=4
XMpar8 a_1022_8822.t7 a_1022_8822.t6 vdd.t1 vdd.t0 pfet_03v3 w=0.4u l=8u ad=2.4000e-13 pd=2.0000e-06 as=1.1200e-13 ps=9.6000e-07 nf=1 m=1
XMpar9 a_1022_8822.t2 inn.t0 a_2622_9030.t0 vdd.t15 pfet_03v3 w=0.75u l=9.5u ad=2.1000e-13 pd=1.3100e-06 as=4.5000e-13 ps=2.7000e-06 nf=1 m=4 par=4
XMpar10 a_1630_1086.t6 a_1022_8822.t6 vdd.t1 vdd.t0 pfet_03v3 w=0.4u l=8u ad=2.4000e-13 pd=2.0000e-06 as=1.1200e-13 ps=9.6000e-07 nf=1 m=1
X5 a_1630_1086.t7 a_19289_1290.t0 vss.t0 ppolyf_u_1k r_width=1u r_length=19.23u
X7 a_15311_3890.t0 a_19289_3370.t0 vss.t0 ppolyf_u_1k r_width=1u r_length=19.23u
X11 a_19289_7530.t1 out.t9 cap_mim_2f0fF c_width=19.85u c_length=19.84u
X12 a_15311_5970.t0 a_19289_6490.t0 vss.t0 ppolyf_u_1k r_width=1u r_length=19.23u
X13 a_15311_2850.t0 a_19289_3370.t0 vss.t0 ppolyf_u_1k r_width=1u r_length=19.23u
X16 a_15311_5970.t0 a_19289_5450.t0 vss.t0 ppolyf_u_1k r_width=1u r_length=19.23u
X19 a_15311_2850.t0 a_19289_2330.t0 vss.t0 ppolyf_u_1k r_width=1u r_length=19.23u
X29 a_15311_4930.t0 a_19289_5450.t0 vss.t0 ppolyf_u_1k r_width=1u r_length=19.23u
X30 a_15311_1810.t0 a_19289_2330.t0 vss.t0 ppolyf_u_1k r_width=1u r_length=19.23u
X34 a_15311_4930.t0 a_19289_4410.t0 vss.t0 ppolyf_u_1k r_width=1u r_length=19.23u
X36 a_15311_1810.t0 a_19289_1290.t0 vss.t0 ppolyf_u_1k r_width=1u r_length=19.23u
X39 a_15311_7010.t0 a_19289_7530.t0 vss.t0 ppolyf_u_1k r_width=1u r_length=19.23u
X44 a_15311_3890.t0 a_19289_4410.t0 vss.t0 ppolyf_u_1k r_width=1u r_length=19.23u
X52 a_15311_7010.t0 a_19289_6490.t0 vss.t0 ppolyf_u_1k r_width=1u r_length=19.23u
Rpar0 a_1022_8822.t0 a_1022_8822.t6 383.8181
Rpar1 a_1022_8822.t0 a_1022_8822.t2 108.7152
Rpar2 a_1022_8822.t0 a_1022_8822.t7 1146.0955
Rpar3 a_1022_8822.t6 a_1022_8822.t2 143.8386
Rpar4 a_1022_8822.t6 a_1022_8822.t7 30.9718
Rpar5 a_1022_8822.t2 a_1022_8822.t7 429.5075
Rpar6 a_1630_1086.t0 a_1630_1086.t8 597.4838
Rpar7 a_1630_1086.t0 a_1630_1086.t2 130.7564
Rpar8 a_1630_1086.t0 a_1630_1086.t6 396.7302
Rpar9 a_1630_1086.t0 a_1630_1086.t7 2918.2370
Rpar10 a_1630_1086.t8 a_1630_1086.t2 213.6013
Rpar11 a_1630_1086.t8 a_1630_1086.t6 137.5276
Rpar12 a_1630_1086.t8 a_1630_1086.t7 81.3383
Rpar13 a_1630_1086.t2 a_1630_1086.t6 141.8316
Rpar14 a_1630_1086.t2 a_1630_1086.t7 1043.2740
Rpar15 a_1630_1086.t6 a_1630_1086.t7 671.7140
Rpar16 a_19289_7530.t0 a_19289_7530.t1 60.8481
Rpar17 a_2622_9030.t0 a_2622_9030.t4 57.3438
Rpar18 a_5149_13047.t0 a_5149_13047.t4 68.7199
Rpar19 ib ib.t0 20.7159
Rpar20 ib ib.t1 16.3704
Rpar21 ib.t0 ib.t1 34.8774
Rpar22 inn inn.t0 60.3735
Rpar23 inn inn.t4 4.0671
Rpar24 inp inp.t0 82.9329
Rpar25 inp inp.t4 4.0668
Rpar26 out out.t0 5.8137
Rpar27 out out.t3 634.6816
Rpar28 out out.t9 289.1647
Rpar29 out.t0 out.t3 196.3743
Rpar30 out.t0 out.t9 89.4693
Rpar31 out.t3 out.t9 182.1247
Rpar32 vdd vdd.t0 101.2772
Rpar33 vdd vdd.t1 266.6310
Rpar34 vdd vdd.t15 548.3986
Rpar35 vdd.t0 vdd.t1 5.4278
Rpar36 vdd.t0 vdd.t15 76.0469
Rpar37 vdd.t1 vdd.t15 203.0622
Rpar38 vss vss.t0 30.2174
Rpar39 vss vss.t1 99.7474
Rpar40 vss vss.t2 1248.8292
Rpar41 vss vss.t28 439.0830
Rpar42 vss.t0 vss.t1 192.2791
Rpar43 vss.t0 vss.t2 2372.8763
Rpar44 vss.t0 vss.t28 854.1655
Rpar45 vss.t1 vss.t2 15.6315
Rpar46 vss.t1 vss.t28 6.4349
Rpar47 vss.t2 vss.t28 74.4657
Cpar0 a_1022_8822.t0 vss 8.04061e-15
Cpar1 a_1022_8822.t2 vss 1.13964e-14
Cpar2 a_1022_8822.t6 vss 2.25519e-14
Cpar3 a_1022_8822.t7 vss 3.64874e-15
Cpar4 a_15311_1810.t0 vss 3.60600e-17
Cpar5 a_15311_2850.t0 vss 3.34000e-17
Cpar6 a_15311_3890.t0 vss 3.34000e-17
Cpar7 a_15311_4930.t0 vss 3.28800e-17
Cpar8 a_15311_5970.t0 vss 4.01600e-17
Cpar9 a_15311_7010.t0 vss 3.85200e-17
Cpar10 a_1630_1086.t0 vss 8.93359e-15
Cpar11 a_1630_1086.t2 vss 1.17979e-14
Cpar12 a_1630_1086.t6 vss 6.23277e-15
Cpar13 a_1630_1086.t7 vss 5.45799e-15
Cpar14 a_1630_1086.t8 vss 4.33181e-14
Cpar15 a_19289_1290.t0 vss 2.64400e-17
Cpar16 a_19289_2330.t0 vss 3.00800e-17
Cpar17 a_19289_3370.t0 vss 2.93600e-17
Cpar18 a_19289_4410.t0 vss 2.93600e-17
Cpar19 a_19289_5450.t0 vss 2.93600e-17
Cpar20 a_19289_6490.t0 vss 3.20200e-17
Cpar21 a_19289_7530.t0 vss 7.87400e-17
Cpar22 a_19289_7530.t1 vss 3.23157e-15
Cpar23 a_2622_9030.t0 vss 1.82234e-14
Cpar24 a_2622_9030.t4 vss 3.96076e-15
Cpar25 a_5149_13047.t0 vss 2.48371e-14
Cpar26 a_5149_13047.t4 vss 1.34229e-14
Cpar27 ib inn 5.42700e-17
Cpar28 ib inp 8.71900e-17
Cpar29 ib out 2.34599e-15
Cpar30 ib vdd 3.31720e-16
Cpar31 ib vss 8.44824e-14
Cpar32 ib.t0 vss 1.34920e-14
Cpar33 ib.t1 vss 9.89176e-16
Cpar34 inn inp 2.08150e-16
Cpar35 inn out 1.11475e-15
Cpar36 inn vdd 1.55328e-14
Cpar37 inn vss 2.08758e-14
Cpar38 inn.t0 vss 1.55441e-14
Cpar39 inn.t4 vss 3.45988e-15
Cpar40 inp out 1.56600e-17
Cpar41 inp vdd 1.68328e-14
Cpar42 inp vss 1.84004e-14
Cpar43 inp.t0 vss 1.71286e-14
Cpar44 inp.t4 vss 3.56761e-15
Cpar45 out vdd 2.29218e-14
Cpar46 out vss 3.55602e-14
Cpar47 out.t0 vss 8.53769e-15
Cpar48 out.t3 vss 1.82516e-14
Cpar49 out.t9 vss 1.59868e-14
Cpar50 vdd vss 2.25779e-13
Cpar51 vdd.t0 vss 7.37542e-14
Cpar52 vdd.t1 vss 1.76570e-14
Cpar53 vdd.t15 vss 4.11274e-14
.ends opamp_dut

Vdd vdd 0 1.800000
Vss vss 0 0
Ibias vdd ib 4.000000e-10
Vinp inp 0 DC 0.895000 AC 1 PWL(0 0.895000 3.015155e-05 0.895000 3.316670e-05 0.905000)
Rfb out inn 1m
Cload out 0 2.000000e-13
Xdut vdd vss inp inn out ib opamp_dut
.end
