* opa1000[0991]: 2p/telescopic_pmos_3v3_i10u_subth (telescopic_pmos, VDD=3.3V, CL=2.0pF, Iref=1.7uA)
.include "pdk_opa.inc"
.temp 27
.option gmin=1e-12 rshunt=1e12 reltol=1e-3 abstol=1e-12 vntol=1e-5 method=gear
* Post-PEX R+C extracted netlist for telescopic_pmos_3v3_i10u_subth
.subckt opamp_dut vdd vss inp inn out ib
XMpar0 a_2738_13957.t0 inp.t0 a_2966_13957.t60 vdd.t9 pfet_03v3 w=8u l=0.54u ad=2.4000e-12 pd=9.1000e-06 as=2.2400e-12 ps=8.5600e-06 nf=1 m=64 par=64
XMpar1 a_4403_4812.t61 a_4403_4812.t60 a_6656_3011.t0 vss.t0 nfet_03v3 w=1.79u l=0.75u ad=5.0120e-13 pd=2.3500e-06 as=6.9213e-13 ps=3.1600e-06 nf=1 m=12 par=12
XMpar2 a_2738_13957.t0 inn.t0 a_5869_5020.t0 vdd.t9 pfet_03v3 w=8u l=0.54u ad=2.4000e-12 pd=9.1000e-06 as=2.2400e-12 ps=8.5600e-06 nf=1 m=64 par=64
XMpar3 a_2966_13957.t0 a_4403_4812.t0 a_4403_4812.t1 vdd.t2 pfet_03v3 w=2.02u l=0.75u ad=6.9488e-13 pd=3.1120e-06 as=6.3024e-13 ps=2.8460e-06 nf=1 m=60 par=60
XMpar4 a_5869_5020.t64 a_4403_4812.t0 out.t0 vdd.t2 pfet_03v3 w=2.02u l=0.75u ad=6.9488e-13 pd=3.1120e-06 as=5.6560e-13 ps=2.5800e-06 nf=1 m=60 par=60
XMpar5 a_8344_1204.t0 a_4403_4812.t60 out.t22 vss.t0 nfet_03v3 w=1.79u l=0.75u ad=5.9667e-13 pd=2.7550e-06 as=5.0120e-13 ps=2.3500e-06 nf=1 m=12 par=12
XMpar6 a_1662_5020.t3 a_1662_5020.t2 vdd.t1 vdd.t0 pfet_03v3 w=8.54u l=0.9u ad=2.3912e-12 pd=9.1000e-06 as=2.3912e-12 ps=9.1000e-06 nf=1 m=2 par=2
XMpar7 a_2738_13957.t128 a_1662_5020.t2 vdd.t1 vdd.t0 pfet_03v3 w=8.54u l=0.9u ad=2.3912e-12 pd=9.1000e-06 as=3.0744e-12 ps=1.1395e-05 nf=1 m=8 par=8
XMpar8 a_8344_1204.t12 a_4403_4812.t144 vss.t31 vss.t30 nfet_03v3 w=1.58u l=1.44u ad=4.4240e-13 pd=2.1400e-06 as=4.4240e-13 ps=2.1400e-06 nf=1 m=6 par=6
XMpar9 a_6656_3011.t12 a_4403_4812.t144 vss.t31 vss.t30 nfet_03v3 w=1.58u l=1.44u ad=6.1093e-13 pd=2.8800e-06 as=4.4240e-13 ps=2.1400e-06 nf=1 m=6 par=6
XMpar10 ib.t1 ib.t0 vss.t4 vss.t3 nfet_03v3 w=1.79u l=0.9u ad=1.0740e-12 pd=4.7800e-06 as=5.0120e-13 ps=2.3500e-06 nf=1 m=2 par=2
XMpar11 a_1662_5020.t0 ib.t0 vss.t4 vss.t3 nfet_03v3 w=1.79u l=0.9u ad=5.0120e-13 pd=2.3500e-06 as=5.0120e-13 ps=2.3500e-06 nf=1 m=2 par=2
Rpar0 a_1662_5020.t0 a_1662_5020.t2 181.4192
Rpar1 a_1662_5020.t0 a_1662_5020.t3 86.2706
Rpar2 a_1662_5020.t2 a_1662_5020.t3 25.9098
Rpar3 a_2738_13957.t0 a_2738_13957.t128 47.0055
Rpar4 a_2966_13957.t0 a_2966_13957.t60 62.7396
Rpar5 a_4403_4812.t0 a_4403_4812.t1 4.8352
Rpar6 a_4403_4812.t0 a_4403_4812.t144 870.3546
Rpar7 a_4403_4812.t0 a_4403_4812.t60 1594.5275
Rpar8 a_4403_4812.t0 a_4403_4812.t61 401.8538
Rpar9 a_4403_4812.t1 a_4403_4812.t144 193.3428
Rpar10 a_4403_4812.t1 a_4403_4812.t60 354.2124
Rpar11 a_4403_4812.t1 a_4403_4812.t61 89.2688
Rpar12 a_4403_4812.t144 a_4403_4812.t60 279.0118
Rpar13 a_4403_4812.t144 a_4403_4812.t61 70.3167
Rpar14 a_4403_4812.t60 a_4403_4812.t61 16.1799
Rpar15 a_5869_5020.t0 a_5869_5020.t64 41.4475
Rpar16 a_6656_3011.t0 a_6656_3011.t12 62.9720
Rpar17 a_8344_1204.t0 a_8344_1204.t12 58.7574
Rpar18 ib ib.t0 15.1858
Rpar19 ib ib.t1 4.8066
Rpar20 inn inn.t0 2.6319
Rpar21 inp inp.t0 2.6319
Rpar22 out out.t0 3.0387
Rpar23 out out.t22 63.7296
Rpar24 vdd vdd.t0 873.3859
Rpar25 vdd vdd.t1 2671.9877
Rpar26 vdd vdd.t9 20.4466
Rpar27 vdd vdd.t2 242.4658
Rpar28 vdd.t0 vdd.t1 5.5104
Rpar29 vdd.t0 vdd.t9 311.9548
Rpar30 vdd.t0 vdd.t2 63.9431
Rpar31 vdd.t1 vdd.t9 954.3770
Rpar32 vdd.t1 vdd.t2 195.6238
Rpar33 vdd.t9 vdd.t2 86.6036
Rpar34 vss vss.t0 45.1065
Rpar35 vss vss.t4 369.8306
Rpar36 vss vss.t3 305.0157
Rpar37 vss vss.t30 196.0688
Rpar38 vss vss.t31 283.7787
Rpar39 vss.t0 vss.t4 218.9973
Rpar40 vss.t0 vss.t3 174.8810
Rpar41 vss.t0 vss.t30 1.9118
Rpar42 vss.t0 vss.t31 5.7166
Rpar43 vss.t4 vss.t3 11.6509
Rpar44 vss.t4 vss.t30 892.7555
Rpar45 vss.t4 vss.t31 1421.6337
Rpar46 vss.t3 vss.t30 710.7442
Rpar47 vss.t3 vss.t31 1137.0328
Rpar48 vss.t30 vss.t31 21.1328
Cpar0 a_1662_5020.t0 vss 2.38336e-15
Cpar1 a_1662_5020.t2 vss 1.34208e-14
Cpar2 a_1662_5020.t3 vss 4.90007e-15
Cpar3 a_2738_13957.t0 vss 1.99796e-13
Cpar4 a_2738_13957.t128 vss 1.51139e-14
Cpar5 a_2966_13957.t0 vss 5.62470e-14
Cpar6 a_2966_13957.t60 vss 1.10725e-13
Cpar7 a_4403_4812.t0 vss 8.39108e-14
Cpar8 a_4403_4812.t1 vss 5.04165e-14
Cpar9 a_4403_4812.t144 vss 1.43107e-14
Cpar10 a_4403_4812.t60 vss 1.63431e-14
Cpar11 a_4403_4812.t61 vss 8.00192e-15
Cpar12 a_5869_5020.t0 vss 1.17912e-13
Cpar13 a_5869_5020.t64 vss 6.29964e-14
Cpar14 a_6656_3011.t0 vss 7.80758e-15
Cpar15 a_6656_3011.t12 vss 6.01444e-15
Cpar16 a_8344_1204.t0 vss 1.04874e-14
Cpar17 a_8344_1204.t12 vss 7.33773e-15
Cpar18 ib vss 6.03890e-15
Cpar19 ib.t0 vss 4.84035e-16
Cpar20 ib.t1 vss 8.10600e-17
Cpar21 inn inp 1.02250e-16
Cpar22 inn vdd 2.60247e-14
Cpar23 inn vss 1.16596e-14
Cpar24 inn.t0 vss 4.48834e-14
Cpar25 inp vdd 2.56632e-14
Cpar26 inp vss 1.15262e-14
Cpar27 inp.t0 vss 4.46088e-14
Cpar28 out vdd 2.52990e-14
Cpar29 out vss 2.12702e-14
Cpar30 out.t0 vss 5.93923e-14
Cpar31 out.t22 vss 1.40384e-14
Cpar32 vdd vss 5.21938e-13
Cpar33 vdd.t0 vss 1.27306e-14
Cpar34 vdd.t1 vss 6.27232e-15
Cpar35 vdd.t2 vss 9.50307e-14
Cpar36 vdd.t9 vss 9.63114e-14
.ends opamp_dut

Vdd vdd 0 3.300000
Vss vss 0 0
Ibias vdd ib 1.700000e-06
Vinp inp 0 DC 1.480000 AC 1 PWL(0 1.480000 1.621542e-08 1.480000 1.783696e-08 1.490000)
Rfb out inn 1m
Cload out 0 2.000000e-12
Xdut vdd vss inp inn out ib opamp_dut
.end
