* opa1000[0969]: 2p/telescopic_pmos_1v8_i2u_subth (telescopic_pmos, VDD=1.8V, CL=2.0pF, Iref=0.46uA)
.include "pdk_opa.inc"
.temp 27
.option gmin=1e-12 rshunt=1e12 reltol=1e-3 abstol=1e-12 vntol=1e-5 method=gear
* Post-PEX R+C extracted netlist for telescopic_pmos_1v8_i2u_subth
.subckt opamp_dut vdd vss inp inn out ib
XMpar0 a_1846_13194.t64 vss.t28 a_6010_1204.t12 vdd.t0 pfet_03v3 w=2u l=1.3u ad=6.3111e-13 pd=2.8533e-06 as=6.3111e-13 ps=2.8533e-06 nf=1 m=36 par=36
XMpar1 a_1498_13194.t128 a_2344_6254.t2 vdd.t5 vdd.t4 pfet_03v3 w=7.67u l=2.6u ad=2.1476e-12 pd=8.2300e-06 as=2.7612e-12 ps=1.0307e-05 nf=1 m=8 par=8
XMpar2 a_1498_13194.t0 inp.t0 a_1846_13194.t0 vdd.t6 pfet_03v3 w=8u l=1.14u ad=2.4000e-12 pd=9.1000e-06 as=2.3200e-12 ps=8.8300e-06 nf=1 m=64 par=64
XMpar3 a_1498_13194.t0 inn.t0 a_9464_15500.t0 vdd.t6 pfet_03v3 w=8u l=1.14u ad=2.4000e-12 pd=9.1000e-06 as=2.3200e-12 ps=8.8300e-06 nf=1 m=64 par=64
XMpar4 a_6010_1204.t1 a_6010_1204.t0 a_6768_8173.t0 vss.t0 nfet_03v3 w=1.73u l=1.3u ad=6.6893e-13 pd=3.0800e-06 as=6.6893e-13 ps=3.0800e-06 nf=1 m=6 par=6
XMpar5 a_8160_8173.t6 a_6010_1204.t48 vss.t6 vss.t0 nfet_03v3 w=2.14u l=2.72u ad=5.9920e-13 pd=2.7000e-06 as=5.9920e-13 ps=2.7000e-06 nf=1 m=2 par=2
XMpar6 a_2344_6254.t0 ib.t0 vss.t10 vss.t9 nfet_03v3 w=1.69u l=2.6u ad=4.7320e-13 pd=2.2500e-06 as=4.7320e-13 ps=2.2500e-06 nf=1 m=2 par=2
XMpar7 a_8160_8173.t0 a_6010_1204.t0 out.t1 vss.t0 nfet_03v3 w=1.73u l=1.3u ad=6.6893e-13 pd=3.0800e-06 as=4.8440e-13 ps=2.2900e-06 nf=1 m=6 par=6
XMpar8 a_9464_15500.t64 vss.t28 out.t0 vdd.t0 pfet_03v3 w=2u l=1.3u ad=6.3111e-13 pd=2.8533e-06 as=6.3111e-13 ps=2.8533e-06 nf=1 m=36 par=36
XMpar9 a_6768_8173.t2 a_6010_1204.t48 vss.t6 vss.t0 nfet_03v3 w=2.14u l=2.72u ad=1.2840e-12 pd=5.4800e-06 as=5.9920e-13 ps=2.7000e-06 nf=1 m=2 par=2
XMpar10 ib.t1 ib.t0 vss.t10 vss.t9 nfet_03v3 w=1.69u l=2.6u ad=1.0140e-12 pd=4.5800e-06 as=4.7320e-13 ps=2.2500e-06 nf=1 m=2 par=2
XMpar11 a_2344_6254.t3 a_2344_6254.t2 vdd.t5 vdd.t4 pfet_03v3 w=7.67u l=2.6u ad=2.1476e-12 pd=8.2300e-06 as=2.1476e-12 ps=8.2300e-06 nf=1 m=2 par=2
Rpar0 a_1498_13194.t0 a_1498_13194.t128 50.6467
Rpar1 a_1846_13194.t0 a_1846_13194.t64 57.9316
Rpar2 a_2344_6254.t0 a_2344_6254.t2 139.6047
Rpar3 a_2344_6254.t0 a_2344_6254.t3 97.6638
Rpar4 a_2344_6254.t2 a_2344_6254.t3 24.4602
Rpar5 a_6010_1204.t0 a_6010_1204.t1 17.4561
Rpar6 a_6010_1204.t0 a_6010_1204.t12 249.2736
Rpar7 a_6010_1204.t0 a_6010_1204.t48 238.1745
Rpar8 a_6010_1204.t1 a_6010_1204.t12 78.1619
Rpar9 a_6010_1204.t1 a_6010_1204.t48 74.6817
Rpar10 a_6010_1204.t12 a_6010_1204.t48 53.3500
Rpar11 a_6768_8173.t0 a_6768_8173.t2 71.3870
Rpar12 a_8160_8173.t0 a_8160_8173.t6 63.6246
Rpar13 a_9464_15500.t0 a_9464_15500.t64 57.9316
Rpar14 ib ib.t0 12.4590
Rpar15 ib ib.t1 5.0884
Rpar16 inn inn.t0 2.0133
Rpar17 inp inp.t0 2.0133
Rpar18 out out.t0 89.2245
Rpar19 out out.t1 5.1190
Rpar20 out.t0 out.t1 105.9086
Rpar21 vdd vdd.t0 383.7120
Rpar22 vdd vdd.t6 20.1757
Rpar23 vdd vdd.t4 588.4889
Rpar24 vdd vdd.t5 1588.5900
Rpar25 vdd.t0 vdd.t6 137.7069
Rpar26 vdd.t0 vdd.t4 98.9604
Rpar27 vdd.t0 vdd.t5 267.1376
Rpar28 vdd.t6 vdd.t4 211.1975
Rpar29 vdd.t6 vdd.t5 570.1147
Rpar30 vdd.t4 vdd.t5 5.9490
Rpar31 vss vss.t0 75.2157
Rpar32 vss vss.t10 247.0517
Rpar33 vss vss.t9 148.5025
Rpar34 vss vss.t6 504.6473
Rpar35 vss vss.t28 51.8475
Rpar36 vss.t0 vss.t10 281.2828
Rpar37 vss.t0 vss.t9 168.9884
Rpar38 vss.t0 vss.t6 7.6605
Rpar39 vss.t0 vss.t28 112.5371
Rpar40 vss.t10 vss.t9 10.7878
Rpar41 vss.t10 vss.t6 1928.8476
Rpar42 vss.t10 vss.t28 369.6368
Rpar43 vss.t9 vss.t6 1159.2669
Rpar44 vss.t9 vss.t28 222.1883
Rpar45 vss.t6 vss.t28 755.0495
Cpar0 a_1498_13194.t0 vss 1.67042e-13
Cpar1 a_1498_13194.t128 vss 1.29278e-14
Cpar2 a_1846_13194.t0 vss 8.86054e-14
Cpar3 a_1846_13194.t64 vss 2.38482e-14
Cpar4 a_2344_6254.t0 vss 2.08202e-15
Cpar5 a_2344_6254.t2 vss 2.62983e-14
Cpar6 a_2344_6254.t3 vss 3.74913e-15
Cpar7 a_6010_1204.t0 vss 8.21656e-15
Cpar8 a_6010_1204.t1 vss 3.62795e-15
Cpar9 a_6010_1204.t12 vss 1.65624e-14
Cpar10 a_6010_1204.t48 vss 6.52353e-15
Cpar11 a_6768_8173.t0 vss 5.00787e-15
Cpar12 a_6768_8173.t2 vss 4.59377e-15
Cpar13 a_8160_8173.t0 vss 6.85910e-15
Cpar14 a_8160_8173.t6 vss 4.50683e-15
Cpar15 a_9464_15500.t0 vss 8.92448e-14
Cpar16 a_9464_15500.t64 vss 2.40200e-14
Cpar17 ib vss 9.79485e-15
Cpar18 ib.t0 vss 1.10492e-15
Cpar19 ib.t1 vss 8.65500e-17
Cpar20 inn inp 9.18300e-17
Cpar21 inn vdd 3.76036e-14
Cpar22 inn vss 1.08903e-14
Cpar23 inn.t0 vss 7.86786e-14
Cpar24 inp vdd 3.75470e-14
Cpar25 inp vss 1.08656e-14
Cpar26 inp.t0 vss 7.87173e-14
Cpar27 out vdd 7.41355e-15
Cpar28 out vss 1.69090e-14
Cpar29 out.t0 vss 2.43438e-14
Cpar30 out.t1 vss 2.48750e-15
Cpar31 vdd vss 6.48893e-13
Cpar32 vdd.t0 vss 3.57471e-14
Cpar33 vdd.t4 vss 1.37631e-14
Cpar34 vdd.t5 vss 6.49501e-15
Cpar35 vdd.t6 vss 9.87528e-14
.ends opamp_dut

Vdd vdd 0 1.800000
Vss vss 0 0
Ibias vdd ib 4.600000e-07
Vinp inp 0 DC 0.805000 AC 1 PWL(0 0.805000 5.792695e-08 0.805000 6.371965e-08 0.815000)
Rfb out inn 1m
Cload out 0 2.000000e-12
Xdut vdd vss inp inn out ib opamp_dut
.end
