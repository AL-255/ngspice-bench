* opa1000[0988]: 2p/telescopic_pmos_3v3_i2u_weak (telescopic_pmos, VDD=3.3V, CL=2.0pF, Iref=0.4uA)
.include "pdk_opa.inc"
.temp 27
.option gmin=1e-12 rshunt=1e12 reltol=1e-3 abstol=1e-12 vntol=1e-5 method=gear
* Post-PEX R+C extracted netlist for telescopic_pmos_3v3_i2u_weak
.subckt opamp_dut vdd vss inp inn out ib
XMpar0 a_1466_13669.t0 inp.t0 a_2486_13669.t0 vdd.t3 pfet_03v3 w=2.02u l=4.5u ad=7.1477e-13 pd=3.1938e-06 as=6.6505e-13 ps=2.9892e-06 nf=1 m=26 par=26
XMpar1 a_1466_13669.t0 inn.t0 a_6694_9748.t0 vdd.t3 pfet_03v3 w=2.02u l=4.5u ad=7.1477e-13 pd=3.1938e-06 as=6.6505e-13 ps=2.9892e-06 nf=1 m=26 par=26
XMpar2 a_6694_9748.t26 a_6035_9540.t4 out.t0 vdd.t2 pfet_03v3 w=2.08u l=1.95u ad=1.2480e-12 pd=5.3600e-06 as=8.0427e-13 ps=3.5467e-06 nf=1 m=6 par=6
XMpar3 a_2486_13669.t26 a_6035_9540.t4 a_6035_9540.t5 vdd.t2 pfet_03v3 w=2.08u l=1.95u ad=1.2480e-12 pd=5.3600e-06 as=8.0427e-13 ps=3.5467e-06 nf=1 m=6 par=6
XMpar4 a_7334_1205.t2 a_6035_9540.t18 vss.t1 vss.t0 nfet_03v3 w=0.72u l=3.4u ad=2.0160e-13 pd=1.2800e-06 as=2.0160e-13 ps=1.2800e-06 nf=1 m=2 par=2
XMpar5 a_1160_2937.t0 ib.t0 vss.t14 vss.t13 nfet_03v3 w=0.8u l=3.9u ad=2.2400e-13 pd=1.3600e-06 as=2.2400e-13 ps=1.3600e-06 nf=1 m=2 par=2
XMpar6 a_6112_8113.t0 a_6035_9540.t18 vss.t1 vss.t0 nfet_03v3 w=0.72u l=3.4u ad=4.3200e-13 pd=2.6400e-06 as=2.0160e-13 ps=1.2800e-06 nf=1 m=2 par=2
XMpar7 a_1466_13669.t52 a_1160_2937.t2 vdd.t1 vdd.t0 pfet_03v3 w=3.13u l=3.9u ad=8.7640e-13 pd=3.6900e-06 as=1.1268e-12 ps=4.6325e-06 nf=1 m=8 par=8
XMpar8 ib.t1 ib.t0 vss.t14 vss.t13 nfet_03v3 w=0.8u l=3.9u ad=4.8000e-13 pd=2.8000e-06 as=2.2400e-13 ps=1.3600e-06 nf=1 m=2 par=2
XMpar9 a_7334_1205.t0 a_6035_9540.t0 out.t2 vss.t4 nfet_03v3 w=1.45u l=1.95u ad=8.7000e-13 pd=4.1000e-06 as=4.0600e-13 ps=2.0100e-06 nf=1 m=2 par=2
XMpar10 a_1160_2937.t3 a_1160_2937.t2 vdd.t1 vdd.t0 pfet_03v3 w=3.13u l=3.9u ad=8.7640e-13 pd=3.6900e-06 as=8.7640e-13 ps=3.6900e-06 nf=1 m=2 par=2
XMpar11 a_6035_9540.t1 a_6035_9540.t0 a_6112_8113.t2 vss.t4 nfet_03v3 w=1.45u l=1.95u ad=8.7000e-13 pd=4.1000e-06 as=8.7000e-13 ps=4.1000e-06 nf=1 m=2 par=2
X72 out.t8 vss.t7 cap_mim_2f0fF c_width=16.58u c_length=16.59u
Rpar0 a_1160_2937.t0 a_1160_2937.t2 82.8071
Rpar1 a_1160_2937.t0 a_1160_2937.t3 78.8224
Rpar2 a_1160_2937.t2 a_1160_2937.t3 26.0162
Rpar3 a_1466_13669.t0 a_1466_13669.t52 55.3876
Rpar4 a_2486_13669.t0 a_2486_13669.t26 52.7191
Rpar5 a_6035_9540.t0 a_6035_9540.t1 21.4726
Rpar6 a_6035_9540.t0 a_6035_9540.t4 2971.3346
Rpar7 a_6035_9540.t0 a_6035_9540.t5 1153.3175
Rpar8 a_6035_9540.t0 a_6035_9540.t18 689.6115
Rpar9 a_6035_9540.t1 a_6035_9540.t4 1685.8566
Rpar10 a_6035_9540.t1 a_6035_9540.t5 654.3618
Rpar11 a_6035_9540.t1 a_6035_9540.t18 391.2673
Rpar12 a_6035_9540.t4 a_6035_9540.t5 9.4264
Rpar13 a_6035_9540.t4 a_6035_9540.t18 137.6223
Rpar14 a_6035_9540.t5 a_6035_9540.t18 53.4178
Rpar15 a_6112_8113.t0 a_6112_8113.t2 77.0885
Rpar16 a_6694_9748.t0 a_6694_9748.t26 61.1023
Rpar17 a_7334_1205.t0 a_7334_1205.t2 83.1654
Rpar18 ib ib.t0 11.7368
Rpar19 ib ib.t1 7.4113
Rpar20 inn inn.t0 1.9139
Rpar21 inp inp.t0 1.9139
Rpar22 out out.t0 65.0144
Rpar23 out out.t2 137.4257
Rpar24 out out.t8 15.6926
Rpar25 out.t0 out.t2 229.0581
Rpar26 out.t0 out.t8 570.8660
Rpar27 out.t2 out.t8 1206.6817
Rpar28 vdd vdd.t0 692.4196
Rpar29 vdd vdd.t1 1911.6772
Rpar30 vdd vdd.t3 24.8849
Rpar31 vdd vdd.t2 140.9674
Rpar32 vdd.t0 vdd.t1 5.5227
Rpar33 vdd.t0 vdd.t3 324.9049
Rpar34 vdd.t0 vdd.t2 70.1533
Rpar35 vdd.t1 vdd.t3 897.0188
Rpar36 vdd.t1 vdd.t2 193.6839
Rpar37 vdd.t3 vdd.t2 66.1463
Rpar38 vss vss.t0 252.1978
Rpar39 vss vss.t1 259.9268
Rpar40 vss vss.t4 38.3638
Rpar41 vss vss.t13 234.9965
Rpar42 vss vss.t14 600.9273
Rpar43 vss vss.t7 71.4560
Rpar44 vss.t0 vss.t1 17.7136
Rpar45 vss.t0 vss.t4 1130.8699
Rpar46 vss.t0 vss.t13 157.2155
Rpar47 vss.t0 vss.t14 402.0627
Rpar48 vss.t0 vss.t7 393.7337
Rpar49 vss.t1 vss.t4 1173.4980
Rpar50 vss.t1 vss.t13 163.0101
Rpar51 vss.t1 vss.t14 416.8786
Rpar52 vss.t1 vss.t7 405.7163
Rpar53 vss.t4 vss.t13 1110.1760
Rpar54 vss.t4 vss.t14 2839.1457
Rpar55 vss.t4 vss.t7 350.2732
Rpar56 vss.t13 vss.t14 12.2178
Rpar57 vss.t13 vss.t7 366.5095
Rpar58 vss.t14 vss.t7 937.2255
Cpar0 a_1160_2937.t0 vss 2.17792e-15
Cpar1 a_1160_2937.t2 vss 3.05273e-14
Cpar2 a_1160_2937.t3 vss 4.00677e-15
Cpar3 a_1466_13669.t0 vss 6.89985e-14
Cpar4 a_1466_13669.t52 vss 1.34194e-14
Cpar5 a_2486_13669.t0 vss 4.07949e-14
Cpar6 a_2486_13669.t26 vss 1.72202e-14
Cpar7 a_6035_9540.t0 vss 6.60733e-15
Cpar8 a_6035_9540.t1 vss 5.40069e-15
Cpar9 a_6035_9540.t18 vss 9.49049e-15
Cpar10 a_6035_9540.t4 vss 1.61957e-14
Cpar11 a_6035_9540.t5 vss 9.45683e-15
Cpar12 a_6112_8113.t0 vss 6.75146e-15
Cpar13 a_6112_8113.t2 vss 7.31825e-15
Cpar14 a_6694_9748.t0 vss 3.98333e-14
Cpar15 a_6694_9748.t26 vss 1.69590e-14
Cpar16 a_7334_1205.t0 vss 8.96498e-15
Cpar17 a_7334_1205.t2 vss 6.89902e-15
Cpar18 ib vdd 8.99700e-17
Cpar19 ib vss 1.23929e-14
Cpar20 ib.t0 vss 1.54067e-15
Cpar21 ib.t1 vss 9.23600e-17
Cpar22 inn inp 7.80800e-17
Cpar23 inn out 2.32500e-17
Cpar24 inn vdd 4.27257e-14
Cpar25 inn vss 5.01894e-15
Cpar26 inn.t0 vss 6.16402e-14
Cpar27 inp vdd 4.31598e-14
Cpar28 inp vss 5.05633e-15
Cpar29 inp.t0 vss 6.20120e-14
Cpar30 out vdd 6.60442e-15
Cpar31 out vss 1.55720e-14
Cpar32 out.t0 vss 2.36142e-15
Cpar33 out.t2 vss 1.12508e-15
Cpar34 out.t8 vss 2.01231e-14
Cpar35 vdd vss 3.96527e-13
Cpar36 vdd.t0 vss 2.18916e-14
Cpar37 vdd.t1 vss 9.71954e-15
Cpar38 vdd.t2 vss 2.96493e-14
Cpar39 vdd.t3 vss 1.13666e-13
.ends opamp_dut

Vdd vdd 0 3.300000
Vss vss 0 0
Ibias vdd ib 4.000000e-07
Vinp inp 0 DC 1.480000 AC 1 PWL(0 1.480000 1.103209e-07 1.480000 1.213530e-07 1.490000)
Rfb out inn 1m
Cload out 0 2.000000e-12
Xdut vdd vss inp inn out ib opamp_dut
.end
