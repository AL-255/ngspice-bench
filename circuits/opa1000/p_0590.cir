* opa1000[0590]: 200f/pmos_miller_1v8_0p1u_1u_subth (pmos_miller, VDD=1.8V, CL=0.2pF, Iref=0.0625uA)
.include "pdk_opa.inc"
.temp 27
.option gmin=1e-12 rshunt=1e12 reltol=1e-3 abstol=1e-12 vntol=1e-5 method=gear
* Post-PEX R+C extracted netlist for pmos_miller_1v8_0p1u_1u_subth
.subckt opamp_dut vdd vss inp inn out ib
XMpar0 out.t1 a_1021_13921.t47 vss.t1 vss.t0 nfet_03v3 w=0.56u l=2.5u ad=1.5680e-13 pd=1.1200e-06 as=1.9264e-13 ps=1.3600e-06 nf=1 m=10 par=10
XMpar1 a_2002_1204.t1 inn.t0 a_8492_8283.t0 vdd.t14 pfet_03v3 w=2.02u l=4u ad=6.8313e-13 pd=3.0636e-06 as=6.2436e-13 ps=2.8218e-06 nf=1 m=44 par=44
XMpar2 a_1837_9931.t0 ib.t0 vss.t5 vss.t4 nfet_03v3 w=0.48u l=5u ad=1.3440e-13 pd=1.0400e-06 as=1.3440e-13 ps=1.0400e-06 nf=1 m=2 par=2
XMpar3 a_1021_13921.t0 inp.t0 a_2002_1204.t1 vdd.t14 pfet_03v3 w=2.02u l=4u ad=6.2436e-13 pd=2.8218e-06 as=6.8313e-13 ps=3.0636e-06 nf=1 m=44 par=44
XMpar4 out.t0 a_1837_9931.t2 vdd.t1 vdd.t0 pfet_03v3 w=2.03u l=5u ad=9.5816e-13 pd=4.1920e-06 as=8.2824e-13 ps=3.6580e-06 nf=1 m=10 par=10
XMpar5 a_1021_13921.t45 a_8492_8283.t44 vss.t1 vss.t0 nfet_03v3 w=0.56u l=2.5u ad=3.3600e-13 pd=2.3200e-06 as=1.5680e-13 ps=1.1200e-06 nf=1 m=2 par=2
XMpar6 ib.t1 ib.t0 vss.t5 vss.t4 nfet_03v3 w=0.48u l=5u ad=2.8800e-13 pd=2.1600e-06 as=1.3440e-13 ps=1.0400e-06 nf=1 m=2 par=2
XMpar7 a_1837_9931.t3 a_1837_9931.t2 vdd.t1 vdd.t0 pfet_03v3 w=2.03u l=5u ad=1.2180e-12 pd=5.2600e-06 as=5.6840e-13 ps=2.5900e-06 nf=1 m=2 par=2
XMpar8 a_8492_8283.t45 a_8492_8283.t44 vss.t1 vss.t0 nfet_03v3 w=0.56u l=2.5u ad=1.5680e-13 pd=1.1200e-06 as=1.5680e-13 ps=1.1200e-06 nf=1 m=2 par=2
XMpar9 a_2002_1204.t0 a_1837_9931.t2 vdd.t1 vdd.t0 pfet_03v3 w=2.03u l=5u ad=1.2180e-12 pd=5.2600e-06 as=5.6840e-13 ps=2.5900e-06 nf=1 m=4 par=4
X6 a_13465_14933.t0 a_17597_15453.t0 vss.t18 ppolyf_u_1k r_width=1u r_length=20u
X13 a_13465_11813.t0 a_17597_12333.t0 vss.t18 ppolyf_u_1k r_width=1u r_length=20u
X26 a_13465_14933.t0 a_17597_14413.t0 vss.t18 ppolyf_u_1k r_width=1u r_length=20u
X34 a_13465_11813.t0 a_17597_11293.t0 vss.t18 ppolyf_u_1k r_width=1u r_length=20u
X48 a_13465_13893.t0 a_17597_14413.t0 vss.t18 ppolyf_u_1k r_width=1u r_length=20u
X84 a_13465_10773.t0 a_17597_11293.t0 vss.t18 ppolyf_u_1k r_width=1u r_length=20u
X90 a_13465_13893.t0 a_17597_13373.t0 vss.t18 ppolyf_u_1k r_width=1u r_length=20u
X95 a_13465_10773.t0 a_17597_10253.t0 vss.t18 ppolyf_u_1k r_width=1u r_length=20u
X103 a_13465_15973.t1 out.t16 cap_mim_2f0fF c_width=18.71u c_length=18.71u
X118 a_13465_12853.t0 a_17597_13373.t0 vss.t18 ppolyf_u_1k r_width=1u r_length=20u
X123 a_1021_13921.t44 a_17597_10253.t0 vss.t18 ppolyf_u_1k r_width=1u r_length=20u
X130 a_13465_15973.t0 a_17597_15453.t0 vss.t18 ppolyf_u_1k r_width=1u r_length=20u
X131 a_13465_12853.t0 a_17597_12333.t0 vss.t18 ppolyf_u_1k r_width=1u r_length=20u
Rpar0 a_1021_13921.t0 a_1021_13921.t44 321.3426
Rpar1 a_1021_13921.t0 a_1021_13921.t45 149.2320
Rpar2 a_1021_13921.t0 a_1021_13921.t47 53.9418
Rpar3 a_1021_13921.t44 a_1021_13921.t45 542.8020
Rpar4 a_1021_13921.t44 a_1021_13921.t47 108.5284
Rpar5 a_1021_13921.t45 a_1021_13921.t47 91.1168
Rpar6 a_13465_15973.t0 a_13465_15973.t1 75.0323
Rpar7 a_1837_9931.t0 a_1837_9931.t2 165.8013
Rpar8 a_1837_9931.t0 a_1837_9931.t3 75.5241
Rpar9 a_1837_9931.t2 a_1837_9931.t3 13.5147
Rpar10 a_2002_1204.t0 a_2002_1204.t1 61.4806
Rpar11 a_8492_8283.t0 a_8492_8283.t44 134.4195
Rpar12 a_8492_8283.t0 a_8492_8283.t45 131.8085
Rpar13 a_8492_8283.t44 a_8492_8283.t45 28.8630
Rpar14 ib ib.t0 18.8296
Rpar15 ib ib.t1 9.1531
Rpar16 ib.t0 ib.t1 69.7356
Rpar17 inn inn.t0 1.7031
Rpar18 inp inp.t0 1.7031
Rpar19 out out.t0 3.3837
Rpar20 out out.t1 324.0882
Rpar21 out out.t16 419.2004
Rpar22 out.t0 out.t1 82.8422
Rpar23 out.t0 out.t16 107.1544
Rpar24 out.t1 out.t16 82.2140
Rpar25 vdd vdd.t0 3375.4723
Rpar26 vdd vdd.t1 87.0171
Rpar27 vdd vdd.t14 128.1955
Rpar28 vdd.t0 vdd.t1 11.9584
Rpar29 vdd.t0 vdd.t14 3147.7830
Rpar30 vdd.t1 vdd.t14 81.1475
Rpar31 vss vss.t0 301.1597
Rpar32 vss vss.t1 192.9566
Rpar33 vss vss.t4 192.7569
Rpar34 vss vss.t5 1046.9570
Rpar35 vss vss.t18 364.4130
Rpar36 vss.t0 vss.t1 14.3995
Rpar37 vss.t0 vss.t4 97.7235
Rpar38 vss.t0 vss.t5 529.5732
Rpar39 vss.t0 vss.t18 17.9553
Rpar40 vss.t1 vss.t4 64.9413
Rpar41 vss.t1 vss.t5 351.8757
Rpar42 vss.t1 vss.t18 15.8586
Rpar43 vss.t4 vss.t5 14.5407
Rpar44 vss.t4 vss.t18 7.9294
Rpar45 vss.t5 vss.t18 44.7495
Cpar0 a_1021_13921.t0 vss 4.06207e-14
Cpar1 a_1021_13921.t44 vss 5.70061e-15
Cpar2 a_1021_13921.t45 vss 4.43066e-15
Cpar3 a_1021_13921.t47 vss 1.75220e-14
Cpar4 a_13465_10773.t0 vss 4.24400e-17
Cpar5 a_13465_11813.t0 vss 3.95400e-17
Cpar6 a_13465_12853.t0 vss 3.73400e-17
Cpar7 a_13465_13893.t0 vss 3.57800e-17
Cpar8 a_13465_14933.t0 vss 3.20200e-17
Cpar9 a_13465_15973.t0 vss 1.75870e-16
Cpar10 a_13465_15973.t1 vss 3.69970e-15
Cpar11 a_17597_10253.t0 vss 2.71200e-17
Cpar12 a_17597_11293.t0 vss 3.00800e-17
Cpar13 a_17597_12333.t0 vss 2.93600e-17
Cpar14 a_17597_13373.t0 vss 2.93600e-17
Cpar15 a_17597_14413.t0 vss 3.00800e-17
Cpar16 a_17597_15453.t0 vss 2.64400e-17
Cpar17 a_1837_9931.t0 vss 3.31549e-15
Cpar18 a_1837_9931.t2 vss 5.91455e-14
Cpar19 a_1837_9931.t3 vss 9.76381e-15
Cpar20 a_2002_1204.t0 vss 2.01730e-14
Cpar21 a_2002_1204.t1 vss 1.03658e-13
Cpar22 a_8492_8283.t0 vss 5.13398e-14
Cpar23 a_8492_8283.t44 vss 8.26577e-15
Cpar24 a_8492_8283.t45 vss 3.03455e-15
Cpar25 ib inn 2.52000e-17
Cpar26 ib vdd 8.24500e-17
Cpar27 ib vss 1.49417e-14
Cpar28 ib.t0 vss 1.95195e-15
Cpar29 ib.t1 vss 1.23176e-16
Cpar30 inn inp 1.44000e-16
Cpar31 inn vdd 6.19684e-14
Cpar32 inn vss 5.72871e-15
Cpar33 inn.t0 vss 9.33605e-14
Cpar34 inp vdd 6.19134e-14
Cpar35 inp vss 5.47546e-15
Cpar36 inp.t0 vss 9.31674e-14
Cpar37 out vdd 1.40999e-14
Cpar38 out vss 1.78087e-14
Cpar39 out.t0 vss 1.07099e-14
Cpar40 out.t1 vss 4.23643e-15
Cpar41 out.t16 vss 1.24899e-14
Cpar42 vdd vss 5.15340e-13
Cpar43 vdd.t0 vss 5.97036e-14
Cpar44 vdd.t1 vss 9.94442e-15
Cpar45 vdd.t14 vss 1.63988e-13
.ends opamp_dut

Vdd vdd 0 1.800000
Vss vss 0 0
Ibias vdd ib 6.250000e-08
Vinp inp 0 DC 0.805000 AC 1 PWL(0 0.805000 2.957179e-07 0.805000 3.252897e-07 0.815000)
Rfb out inn 1m
Cload out 0 2.000000e-13
Xdut vdd vss inp inn out ib opamp_dut
.end
