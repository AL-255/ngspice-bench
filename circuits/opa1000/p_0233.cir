* opa1000[0233]: 2p/folded_cascode_nmos_3v3_i200n_weak (folded_cascode_nmos, VDD=3.3V, CL=2.0pF, Iref=0.0444uA)
.include "pdk_opa.inc"
.temp 27
.option gmin=1e-12 rshunt=1e12 reltol=1e-3 abstol=1e-12 vntol=1e-5 method=gear
* Post-PEX R+C extracted netlist for folded_cascode_nmos_3v3_i200n_weak
.subckt opamp_dut vdd vss inp inn out ib
XMpar0 a_6254_6229.t0 a_1315_6020.t2 vdd.t1 vdd.t0 pfet_03v3 w=0.4u l=3.9u ad=1.1200e-13 pd=9.6000e-07 as=1.7600e-13 ps=1.4800e-06 nf=1 m=4 par=4
XMpar1 ib.t1 ib.t0 vss.t3 vss.t2 nfet_03v3 w=0.4u l=7.5u ad=2.4000e-13 pd=2.0000e-06 as=1.1200e-13 ps=9.6000e-07 nf=1 m=2 par=2
XMpar2 a_1315_6020.t3 a_1315_6020.t2 vdd.t1 vdd.t0 pfet_03v3 w=0.4u l=3.9u ad=1.1200e-13 pd=9.6000e-07 as=2.4000e-13 ps=2.0000e-06 nf=1 m=2 par=2
XMpar3 a_1702_1249.t4 ib.t0 vss.t3 vss.t2 nfet_03v3 w=0.4u l=7.5u ad=2.4000e-13 pd=2.0000e-06 as=1.1200e-13 ps=9.6000e-07 nf=1 m=4 par=4
XMpar4 a_1315_6020.t0 ib.t0 vss.t3 vss.t2 nfet_03v3 w=0.4u l=7.5u ad=2.4000e-13 pd=2.0000e-06 as=1.1200e-13 ps=9.6000e-07 nf=1 m=2 par=2
XMpar5 out.t0 a_3012_9364.t0 vss.t3 vss.t2 nfet_03v3 w=0.4u l=7.5u ad=1.1200e-13 pd=9.6000e-07 as=1.1200e-13 ps=9.6000e-07 nf=1 m=2 par=2
XMpar6 a_1702_1249.t0 inn.t0 a_6254_6229.t2 vss.t0 nfet_03v3 w=0.42u l=3.9u ad=2.5200e-13 pd=2.0400e-06 as=1.1760e-13 ps=9.8000e-07 nf=1 m=2 par=2
XMpar7 a_3270_7819.t0 a_1315_6020.t2 vdd.t1 vdd.t0 pfet_03v3 w=0.4u l=3.9u ad=1.1200e-13 pd=9.6000e-07 as=1.7600e-13 ps=1.4800e-06 nf=1 m=4 par=4
XMpar8 a_6254_6229.t5 ib.t10 out.t1 vdd.t14 pfet_03v3 w=0.4u l=1.68u ad=2.4000e-13 pd=2.0000e-06 as=1.1200e-13 ps=9.6000e-07 nf=1 m=2 par=2
XMpar9 a_3012_9364.t1 a_3012_9364.t0 vss.t3 vss.t2 nfet_03v3 w=0.4u l=7.5u ad=2.4000e-13 pd=2.0000e-06 as=1.1200e-13 ps=9.6000e-07 nf=1 m=2 par=2
XMpar10 a_3012_9364.t4 ib.t10 a_3270_7819.t5 vdd.t14 pfet_03v3 w=0.4u l=1.68u ad=1.1200e-13 pd=9.6000e-07 as=2.4000e-13 ps=2.0000e-06 nf=1 m=2 par=2
XMpar11 a_1702_1249.t0 inp.t0 a_3270_7819.t2 vss.t0 nfet_03v3 w=0.42u l=3.9u ad=2.5200e-13 pd=2.0400e-06 as=1.1760e-13 ps=9.8000e-07 nf=1 m=2 par=2
X4 out.t4 vss.t8 cap_mim_2f0fF c_width=6.71u c_length=6.71u
Rpar0 a_1315_6020.t0 a_1315_6020.t2 63.3178
Rpar1 a_1315_6020.t0 a_1315_6020.t3 162.8767
Rpar2 a_1315_6020.t2 a_1315_6020.t3 25.2700
Rpar3 a_1702_1249.t0 a_1702_1249.t4 43.0843
Rpar4 a_3012_9364.t0 a_3012_9364.t1 21.3070
Rpar5 a_3012_9364.t0 a_3012_9364.t4 253.1694
Rpar6 a_3012_9364.t1 a_3012_9364.t4 200.7267
Rpar7 a_3270_7819.t0 a_3270_7819.t2 156.2270
Rpar8 a_3270_7819.t0 a_3270_7819.t5 91.9610
Rpar9 a_3270_7819.t2 a_3270_7819.t5 80.0932
Rpar10 a_6254_6229.t0 a_6254_6229.t2 93.9890
Rpar11 a_6254_6229.t0 a_6254_6229.t5 102.4318
Rpar12 a_6254_6229.t2 a_6254_6229.t5 88.7891
Rpar13 ib ib.t0 14.8743
Rpar14 ib ib.t1 15.6618
Rpar15 ib ib.t10 131.1488
Rpar16 ib.t0 ib.t1 32.4776
Rpar17 ib.t0 ib.t10 278.4867
Rpar18 ib.t1 ib.t10 293.2321
Rpar19 inn inn.t0 3.2682
Rpar20 inp inp.t0 3.3168
Rpar21 out out.t0 74.8312
Rpar22 out out.t1 66.9643
Rpar23 out out.t4 14.7464
Rpar24 out.t0 out.t1 289.7290
Rpar25 out.t0 out.t4 1355.4201
Rpar26 out.t1 out.t4 1212.9268
Rpar27 vdd vdd.t0 70.5045
Rpar28 vdd vdd.t1 123.4932
Rpar29 vdd vdd.t14 152.5065
Rpar30 vdd.t0 vdd.t1 7.2863
Rpar31 vdd.t0 vdd.t14 77.6706
Rpar32 vdd.t1 vdd.t14 73.1450
Rpar33 vss vss.t0 155.6719
Rpar34 vss vss.t3 45.4465
Rpar35 vss vss.t2 166.7083
Rpar36 vss vss.t8 181.1122
Rpar37 vss.t0 vss.t3 24.1497
Rpar38 vss.t0 vss.t2 6.2148
Rpar39 vss.t0 vss.t8 137.9354
Rpar40 vss.t3 vss.t2 10.5616
Rpar41 vss.t3 vss.t8 168.7993
Rpar42 vss.t2 vss.t8 151.9324
Cpar0 a_1315_6020.t0 vss 9.70020e-15
Cpar1 a_1315_6020.t2 vss 2.34827e-14
Cpar2 a_1315_6020.t3 vss 2.39578e-15
Cpar3 a_1702_1249.t0 vss 3.52674e-15
Cpar4 a_1702_1249.t4 vss 8.19872e-15
Cpar5 a_3012_9364.t0 vss 5.56361e-15
Cpar6 a_3012_9364.t1 vss 1.96541e-15
Cpar7 a_3012_9364.t4 vss 1.45925e-15
Cpar8 a_3270_7819.t0 vss 4.44632e-15
Cpar9 a_3270_7819.t2 vss 2.58919e-15
Cpar10 a_3270_7819.t5 vss 3.11704e-15
Cpar11 a_6254_6229.t0 vss 5.02168e-15
Cpar12 a_6254_6229.t2 vss 3.07701e-15
Cpar13 a_6254_6229.t5 vss 3.08738e-15
Cpar14 ib inn 2.13000e-17
Cpar15 ib inp 1.84700e-17
Cpar16 ib out 2.08870e-16
Cpar17 ib vdd 4.11196e-15
Cpar18 ib vss 4.20215e-14
Cpar19 ib.t0 vss 1.40771e-14
Cpar20 ib.t1 vss 1.37888e-15
Cpar21 ib.t10 vss 3.01346e-15
Cpar22 inn inp 5.23500e-17
Cpar23 inn vss 4.45355e-15
Cpar24 inn.t0 vss 3.59220e-16
Cpar25 inp vss 4.40504e-15
Cpar26 inp.t0 vss 3.54423e-16
Cpar27 out vdd 3.02378e-15
Cpar28 out vss 1.03513e-14
Cpar29 out.t0 vss 1.32608e-15
Cpar30 out.t1 vss 6.59586e-16
Cpar31 out.t4 vss 6.02093e-15
Cpar32 vdd vss 7.49964e-14
Cpar33 vdd.t0 vss 1.70618e-14
Cpar34 vdd.t1 vss 1.20243e-14
Cpar35 vdd.t14 vss 7.62585e-15
.ends opamp_dut

Vdd vdd 0 3.300000
Vss vss 0 0
Ibias vdd ib 4.440000e-08
Vinp inp 0 DC 1.810000 AC 1 PWL(0 1.810000 1.549579e-06 1.810000 1.704537e-06 1.820000)
Rfb out inn 1m
Cload out 0 2.000000e-12
Xdut vdd vss inp inn out ib opamp_dut
.end
