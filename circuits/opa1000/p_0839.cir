* opa1000[0839]: 200f/telescopic_nmos_1v8_0p1u_1u_weak (telescopic_nmos, VDD=1.8V, CL=0.2pF, Iref=0.1625uA)
.include "pdk_opa.inc"
.temp 27
.option gmin=1e-12 rshunt=1e12 reltol=1e-3 abstol=1e-12 vntol=1e-5 method=gear
* Post-PEX R+C extracted netlist for telescopic_nmos_1v8_0p1u_1u_weak
.subckt opamp_dut vdd vss inp inn out ib
XMpar0 a_1554_1204.t0 inp.t0 a_3674_1204.t0 vss.t0 nfet_03v3 w=2.06u l=10u ad=1.2360e-12 pd=5.3200e-06 as=5.7680e-13 ps=2.6200e-06 nf=1 m=6 par=6
XMpar1 a_4572_6735.t0 a_1832_10178.t0 out.t0 vdd.t2 pfet_03v3 w=2.15u l=3.2u ad=9.4600e-13 pd=4.1050e-06 as=6.0200e-13 ps=2.7100e-06 nf=1 m=4 par=4
XMpar2 a_1554_1204.t6 ib.t0 vss.t3 vss.t2 nfet_03v3 w=0.4u l=3u ad=1.1200e-13 pd=9.6000e-07 as=1.4400e-13 ps=1.2200e-06 nf=1 m=8 par=8
XMpar3 a_1554_1204.t0 inn.t0 a_6094_5184.t0 vss.t0 nfet_03v3 w=2.06u l=10u ad=1.2360e-12 pd=5.3200e-06 as=5.7680e-13 ps=2.6200e-06 nf=1 m=6 par=6
XMpar4 a_1712_10386.t3 a_1832_10178.t0 a_1832_10178.t1 vdd.t2 pfet_03v3 w=2.15u l=3.2u ad=1.2900e-12 pd=5.5000e-06 as=6.0200e-13 ps=2.7100e-06 nf=1 m=4 par=4
XMpar5 a_1832_10178.t8 vdd.t24 a_3674_1204.t6 vss.t24 nfet_03v3 w=1.1u l=3.2u ad=3.0800e-13 pd=1.6600e-06 as=6.6000e-13 ps=3.4000e-06 nf=1 m=2 par=2
XMpar6 ib.t1 ib.t0 vss.t3 vss.t2 nfet_03v3 w=0.4u l=3u ad=1.1200e-13 pd=9.6000e-07 as=1.1200e-13 ps=9.6000e-07 nf=1 m=2 par=2
XMpar7 a_6094_5184.t6 vdd.t24 out.t2 vss.t24 nfet_03v3 w=1.1u l=3.2u ad=6.6000e-13 pd=3.4000e-06 as=3.0800e-13 ps=1.6600e-06 nf=1 m=2 par=2
XMpar8 a_4572_6735.t1 a_1832_10178.t14 vdd.t1 vdd.t0 pfet_03v3 w=1.62u l=10u ad=4.5360e-13 pd=2.1800e-06 as=4.5360e-13 ps=2.1800e-06 nf=1 m=6 par=6
XMpar9 a_1712_10386.t0 a_1832_10178.t14 vdd.t1 vdd.t0 pfet_03v3 w=1.62u l=10u ad=9.7200e-13 pd=4.4400e-06 as=4.5360e-13 ps=2.1800e-06 nf=1 m=6 par=6
Rpar0 a_1554_1204.t0 a_1554_1204.t6 51.9767
Rpar1 a_1712_10386.t0 a_1712_10386.t3 59.0134
Rpar2 a_1832_10178.t0 a_1832_10178.t1 18.9576
Rpar3 a_1832_10178.t0 a_1832_10178.t14 236.0705
Rpar4 a_1832_10178.t0 a_1832_10178.t8 344.3576
Rpar5 a_1832_10178.t1 a_1832_10178.t14 110.4335
Rpar6 a_1832_10178.t1 a_1832_10178.t8 161.0900
Rpar7 a_1832_10178.t14 a_1832_10178.t8 173.1484
Rpar8 a_3674_1204.t0 a_3674_1204.t6 45.5454
Rpar9 a_4572_6735.t0 a_4572_6735.t1 53.2954
Rpar10 a_6094_5184.t0 a_6094_5184.t6 45.5454
Rpar11 ib ib.t0 20.8755
Rpar12 ib ib.t1 19.8838
Rpar13 ib.t0 ib.t1 86.3451
Rpar14 inn inn.t0 3.0527
Rpar15 inp inp.t0 3.0528
Rpar16 out out.t0 6.5701
Rpar17 out out.t2 126.1455
Rpar18 out.t0 out.t2 146.3698
Rpar19 vdd vdd.t0 42.7962
Rpar20 vdd vdd.t1 329.1445
Rpar21 vdd vdd.t2 108.6870
Rpar22 vdd vdd.t24 571.4814
Rpar23 vdd.t0 vdd.t1 12.6352
Rpar24 vdd.t0 vdd.t2 119.8889
Rpar25 vdd.t0 vdd.t24 630.3811
Rpar26 vdd.t1 vdd.t2 922.0617
Rpar27 vdd.t1 vdd.t24 4848.2416
Rpar28 vdd.t2 vdd.t24 201.4309
Rpar29 vss vss.t0 105.8641
Rpar30 vss vss.t2 593.0130
Rpar31 vss vss.t3 1211.0161
Rpar32 vss vss.t24 163.6176
Rpar33 vss.t0 vss.t2 51.0309
Rpar34 vss.t0 vss.t3 107.1482
Rpar35 vss.t0 vss.t24 6.0936
Rpar36 vss.t2 vss.t3 7.4423
Rpar37 vss.t2 vss.t24 78.7583
Rpar38 vss.t3 vss.t24 165.1496
Cpar0 a_1554_1204.t0 vss 2.31128e-14
Cpar1 a_1554_1204.t6 vss 5.82902e-15
Cpar2 a_1712_10386.t0 vss 2.97325e-14
Cpar3 a_1712_10386.t3 vss 1.33393e-14
Cpar4 a_1832_10178.t0 vss 1.75605e-14
Cpar5 a_1832_10178.t1 vss 5.52260e-15
Cpar6 a_1832_10178.t14 vss 6.75826e-14
Cpar7 a_1832_10178.t8 vss 2.46845e-15
Cpar8 a_3674_1204.t0 vss 1.31740e-14
Cpar9 a_3674_1204.t6 vss 3.57570e-15
Cpar10 a_4572_6735.t0 vss 1.23093e-14
Cpar11 a_4572_6735.t1 vss 2.70307e-14
Cpar12 a_6094_5184.t0 vss 1.21691e-14
Cpar13 a_6094_5184.t6 vss 3.30296e-15
Cpar14 ib vdd 2.40770e-16
Cpar15 ib vss 2.23999e-14
Cpar16 ib.t0 vss 3.44145e-15
Cpar17 ib.t1 vss 1.57222e-16
Cpar18 inn inp 1.55910e-16
Cpar19 inn vdd 2.45620e-16
Cpar20 inn vss 2.38639e-14
Cpar21 inn.t0 vss 7.56022e-15
Cpar22 inp vdd 3.48810e-16
Cpar23 inp vss 2.36739e-14
Cpar24 inp.t0 vss 7.65428e-15
Cpar25 out vdd 5.13662e-15
Cpar26 out vss 6.93855e-15
Cpar27 out.t0 vss 4.31765e-15
Cpar28 out.t2 vss 3.22962e-15
Cpar29 vdd vss 2.17412e-13
Cpar30 vdd.t0 vss 6.98024e-14
Cpar31 vdd.t1 vss 1.28664e-14
Cpar32 vdd.t2 vss 2.61772e-14
Cpar33 vdd.t24 vss 4.61810e-15
.ends opamp_dut

Vdd vdd 0 1.800000
Vss vss 0 0
Ibias vdd ib 1.625000e-07
Vinp inp 0 DC 0.931000 AC 1 PWL(0 0.931000 4.764286e-08 0.931000 5.240715e-08 0.941000)
Rfb out inn 1m
Cload out 0 2.000000e-13
Xdut vdd vss inp inn out ib opamp_dut
.end
