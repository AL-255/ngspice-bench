* opa1000[0993]: 2p/telescopic_pmos_3v3_i20u_subth (telescopic_pmos, VDD=3.3V, CL=2.0pF, Iref=2.8uA)
.include "pdk_opa.inc"
.temp 27
.option gmin=1e-12 rshunt=1e12 reltol=1e-3 abstol=1e-12 vntol=1e-5 method=gear
* Post-PEX R+C extracted netlist for telescopic_pmos_3v3_i20u_subth
.subckt opamp_dut vdd vss inp inn out ib
XMpar0 a_1554_8667.t0 inp.t0 a_4352_15080.t64 vdd.t3 pfet_03v3 w=8u l=0.81u ad=2.4000e-12 pd=9.1000e-06 as=2.3200e-12 ps=8.8300e-06 nf=1 m=64 par=64
XMpar1 a_7430_5262.t64 a_6810_5054.t0 out.t0 vdd.t0 pfet_03v3 w=2.28u l=0.6u ad=8.8920e-13 pd=3.8438e-06 as=6.8400e-13 ps=3.0225e-06 nf=1 m=64 par=64
XMpar2 a_1554_8667.t0 inn.t0 a_7430_5262.t0 vdd.t3 pfet_03v3 w=8u l=0.81u ad=2.4000e-12 pd=9.1000e-06 as=2.3200e-12 ps=8.8300e-06 nf=1 m=64 par=64
XMpar3 a_6810_5054.t37 a_6810_5054.t36 a_6871_3074.t0 vss.t0 nfet_03v3 w=2.02u l=0.6u ad=6.5794e-13 pd=2.9600e-06 as=6.5794e-13 ps=2.9600e-06 nf=1 m=14 par=14
XMpar4 a_4352_15080.t0 a_6810_5054.t0 a_6810_5054.t1 vdd.t0 pfet_03v3 w=2.28u l=0.6u ad=9.1200e-13 pd=3.9350e-06 as=6.8400e-13 ps=3.0225e-06 nf=1 m=64 par=64
XMpar5 a_6871_3074.t1 a_6810_5054.t156 vss.t2 vss.t0 nfet_03v3 w=1.67u l=0.81u ad=4.6760e-13 pd=2.2300e-06 as=7.3480e-13 ps=3.3850e-06 nf=1 m=4 par=4
XMpar6 a_1362_8459.t0 ib.t0 vss.t15 vss.t14 nfet_03v3 w=3.18u l=0.96u ad=8.9040e-13 pd=3.7400e-06 as=8.9040e-13 ps=3.7400e-06 nf=1 m=2 par=2
XMpar7 a_8772_3074.t4 a_6810_5054.t36 out.t12 vss.t0 nfet_03v3 w=2.02u l=0.6u ad=6.5794e-13 pd=2.9600e-06 as=5.6560e-13 ps=2.5800e-06 nf=1 m=14 par=14
XMpar8 a_8772_3074.t0 a_6810_5054.t156 vss.t2 vss.t0 nfet_03v3 w=1.67u l=0.81u ad=4.6760e-13 pd=2.2300e-06 as=4.6760e-13 ps=2.2300e-06 nf=1 m=4 par=4
XMpar9 a_1362_8459.t3 a_1362_8459.t2 vdd.t47 vdd.t46 pfet_03v3 w=10u l=0.96u ad=2.8000e-12 pd=1.0560e-05 as=2.8000e-12 ps=1.0560e-05 nf=1 m=2 par=2
XMpar10 a_1554_8667.t128 a_1362_8459.t2 vdd.t47 vdd.t46 pfet_03v3 w=10u l=0.96u ad=2.8000e-12 pd=1.0560e-05 as=3.6000e-12 ps=1.3220e-05 nf=1 m=8 par=8
XMpar11 ib.t1 ib.t0 vss.t15 vss.t14 nfet_03v3 w=3.18u l=0.96u ad=1.9080e-12 pd=7.5600e-06 as=8.9040e-13 ps=3.7400e-06 nf=1 m=2 par=2
X248 out.t78 vss.t52 cap_mim_2f0fF c_width=9u c_length=9u
Rpar0 a_1362_8459.t0 a_1362_8459.t2 105.9770
Rpar1 a_1362_8459.t0 a_1362_8459.t3 49.2574
Rpar2 a_1362_8459.t2 a_1362_8459.t3 28.7298
Rpar3 a_1554_8667.t0 a_1554_8667.t128 69.2628
Rpar4 a_4352_15080.t0 a_4352_15080.t64 91.0155
Rpar5 a_6810_5054.t0 a_6810_5054.t1 3.1785
Rpar6 a_6810_5054.t0 a_6810_5054.t156 1083.7895
Rpar7 a_6810_5054.t0 a_6810_5054.t36 2081.8304
Rpar8 a_6810_5054.t0 a_6810_5054.t37 428.1916
Rpar9 a_6810_5054.t1 a_6810_5054.t156 257.7922
Rpar10 a_6810_5054.t1 a_6810_5054.t36 495.1880
Rpar11 a_6810_5054.t1 a_6810_5054.t37 101.8504
Rpar12 a_6810_5054.t156 a_6810_5054.t36 330.5185
Rpar13 a_6810_5054.t156 a_6810_5054.t37 67.9812
Rpar14 a_6810_5054.t36 a_6810_5054.t37 15.3009
Rpar15 a_6871_3074.t0 a_6871_3074.t1 51.5389
Rpar16 a_7430_5262.t0 a_7430_5262.t64 40.0167
Rpar17 a_8772_3074.t0 a_8772_3074.t4 60.3758
Rpar18 ib ib.t0 16.6816
Rpar19 ib ib.t1 3.7126
Rpar20 inn inn.t0 2.3652
Rpar21 inp inp.t0 2.3652
Rpar22 out out.t0 72.0823
Rpar23 out out.t12 94.1060
Rpar24 out out.t78 14.9571
Rpar25 out.t0 out.t12 185.5109
Rpar26 out.t0 out.t78 1009.7684
Rpar27 out.t12 out.t78 1318.2882
Rpar28 vdd vdd.t0 158.1947
Rpar29 vdd vdd.t3 29.4321
Rpar30 vdd vdd.t46 452.7203
Rpar31 vdd vdd.t47 1639.3828
Rpar32 vdd.t0 vdd.t3 93.5024
Rpar33 vdd.t0 vdd.t46 75.2091
Rpar34 vdd.t0 vdd.t47 272.3459
Rpar35 vdd.t3 vdd.t46 267.5844
Rpar36 vdd.t3 vdd.t47 968.9721
Rpar37 vdd.t46 vdd.t47 5.6529
Rpar38 vss vss.t0 35.8810
Rpar39 vss vss.t2 246.6049
Rpar40 vss vss.t14 679.1347
Rpar41 vss vss.t15 372.1332
Rpar42 vss vss.t52 157.1388
Rpar43 vss.t0 vss.t2 4.8369
Rpar44 vss.t0 vss.t14 538.9793
Rpar45 vss.t0 vss.t15 295.4862
Rpar46 vss.t0 vss.t52 127.2037
Rpar47 vss.t2 vss.t52 1408.8747
Rpar48 vss.t14 vss.t15 15.7822
Rpar49 vss.t14 vss.t52 513.5180
Rpar50 vss.t15 vss.t52 281.3816
Cpar0 a_1362_8459.t0 vss 1.96899e-15
Cpar1 a_1362_8459.t2 vss 1.39754e-14
Cpar2 a_1362_8459.t3 vss 4.17706e-15
Cpar3 a_1554_8667.t0 vss 1.78212e-13
Cpar4 a_1554_8667.t128 vss 1.60158e-14
Cpar5 a_4352_15080.t0 vss 6.59351e-14
Cpar6 a_4352_15080.t64 vss 1.11179e-13
Cpar7 a_6810_5054.t0 vss 8.33936e-14
Cpar8 a_6810_5054.t1 vss 6.08275e-14
Cpar9 a_6810_5054.t156 vss 7.49490e-15
Cpar10 a_6810_5054.t36 vss 1.76100e-14
Cpar11 a_6810_5054.t37 vss 1.39762e-14
Cpar12 a_6871_3074.t0 vss 1.00911e-14
Cpar13 a_6871_3074.t1 vss 3.45443e-15
Cpar14 a_7430_5262.t0 vss 1.14820e-13
Cpar15 a_7430_5262.t64 vss 7.01948e-14
Cpar16 a_8772_3074.t0 vss 4.64967e-15
Cpar17 a_8772_3074.t4 vss 1.37226e-14
Cpar18 ib vdd 2.05700e-17
Cpar19 ib vss 6.85666e-15
Cpar20 ib.t0 vss 5.98875e-16
Cpar21 ib.t1 vss 2.79680e-16
Cpar22 inn inp 9.68500e-17
Cpar23 inn vdd 3.10163e-14
Cpar24 inn vss 1.05927e-14
Cpar25 inn.t0 vss 6.27973e-14
Cpar26 inp vdd 3.14712e-14
Cpar27 inp vss 1.06419e-14
Cpar28 inp.t0 vss 6.30476e-14
Cpar29 out vdd 2.88738e-14
Cpar30 out vss 2.14084e-14
Cpar31 out.t0 vss 5.36912e-14
Cpar32 out.t12 vss 1.29466e-14
Cpar33 out.t78 vss 3.03632e-14
Cpar34 vdd vss 6.22276e-13
Cpar35 vdd.t0 vss 1.01379e-13
Cpar36 vdd.t3 vss 1.12584e-13
Cpar37 vdd.t46 vss 1.36672e-14
Cpar38 vdd.t47 vss 6.34999e-15
.ends opamp_dut

Vdd vdd 0 3.300000
Vss vss 0 0
Ibias vdd ib 2.800000e-06
Vinp inp 0 DC 1.480000 AC 1 PWL(0 1.480000 1.149207e-08 1.480000 1.264127e-08 1.490000)
Rfb out inn 1m
Cload out 0 2.000000e-12
Xdut vdd vss inp inn out ib opamp_dut
.end
