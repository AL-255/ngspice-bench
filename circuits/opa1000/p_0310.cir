* opa1000[0310]: 2p/folded_cascode_pmos_1v8_i150u_weak (folded_cascode_pmos, VDD=1.8V, CL=2.0pF, Iref=28.3333uA)
.include "pdk_opa.inc"
.temp 27
.option gmin=1e-12 rshunt=1e12 reltol=1e-3 abstol=1e-12 vntol=1e-5 method=gear
* Post-PEX R+C extracted netlist for folded_cascode_pmos_1v8_i150u_weak
.subckt opamp_dut vdd vss inp inn out ib
XMpar0 a_1351_9914.t2 inp.t0 a_2522_1205.t2 vdd.t6 pfet_03v3 w=3.63u l=0.56u ad=1.0890e-12 pd=4.4569e-06 as=1.0527e-12 ps=4.3234e-06 nf=1 m=64 par=64
XMpar1 a_1351_9914.t2 inn.t0 a_7534_8146.t19 vdd.t6 pfet_03v3 w=3.63u l=0.56u ad=1.0890e-12 pd=4.4569e-06 as=1.0527e-12 ps=4.3234e-06 nf=1 m=64 par=64
XMpar2 a_6004_13906.t9 a_6004_13906.t8 vdd.t1 vdd.t0 pfet_03v3 w=8.53u l=0.7u ad=3.2983e-12 pd=1.2147e-05 as=2.3884e-12 ps=9.0900e-06 nf=1 m=6 par=6
XMpar3 out.t2 a_6004_13906.t8 vdd.t1 vdd.t0 pfet_03v3 w=8.53u l=0.7u ad=2.3884e-12 pd=9.0900e-06 as=2.3884e-12 ps=9.0900e-06 nf=1 m=6 par=6
XMpar4 a_2522_1205.t0 a_1211_9706.t18 a_6004_13906.t0 vss.t0 nfet_03v3 w=1.96u l=0.31u ad=7.0560e-13 pd=3.1700e-06 as=5.4880e-13 ps=2.5200e-06 nf=1 m=8 par=8
XMpar5 a_1211_9706.t0 ib.t0 vss.t11 vss.t0 nfet_03v3 w=3.22u l=0.81u ad=9.0160e-13 pd=3.7800e-06 as=9.0160e-13 ps=3.7800e-06 nf=1 m=6 par=6
XMpar6 a_1211_9706.t7 a_1211_9706.t6 vdd.t1 vdd.t0 pfet_03v3 w=8.53u l=0.7u ad=2.3884e-12 pd=9.0900e-06 as=2.3884e-12 ps=9.0900e-06 nf=1 m=6 par=6
XMpar7 a_1351_9914.t0 a_1211_9706.t6 vdd.t1 vdd.t0 pfet_03v3 w=8.53u l=0.7u ad=2.3884e-12 pd=9.0900e-06 as=2.8433e-12 ps=1.0618e-05 nf=1 m=12 par=12
XMpar8 a_7534_8146.t4 ib.t0 vss.t11 vss.t0 nfet_03v3 w=3.22u l=0.81u ad=9.0160e-13 pd=3.7800e-06 as=1.0733e-12 ps=4.4233e-06 nf=1 m=12 par=12
XMpar9 a_2522_1205.t69 ib.t0 vss.t11 vss.t0 nfet_03v3 w=3.22u l=0.81u ad=9.0160e-13 pd=3.7800e-06 as=1.0733e-12 ps=4.4233e-06 nf=1 m=12 par=12
XMpar10 a_7534_8146.t0 a_1211_9706.t18 out.t0 vss.t0 nfet_03v3 w=1.96u l=0.31u ad=7.0560e-13 pd=3.1700e-06 as=5.4880e-13 ps=2.5200e-06 nf=1 m=8 par=8
XMpar11 ib.t1 ib.t0 vss.t11 vss.t0 nfet_03v3 w=3.22u l=0.81u ad=1.2451e-12 pd=5.0667e-06 as=9.0160e-13 ps=3.7800e-06 nf=1 m=6 par=6
X154 out.t14 vss.t8 cap_mim_2f0fF c_width=11.49u c_length=11.49u
Rpar0 a_1211_9706.t0 a_1211_9706.t6 1104.4386
Rpar1 a_1211_9706.t0 a_1211_9706.t7 97.7342
Rpar2 a_1211_9706.t0 a_1211_9706.t18 56.1897
Rpar3 a_1211_9706.t6 a_1211_9706.t7 19.0164
Rpar4 a_1211_9706.t6 a_1211_9706.t18 2945.6985
Rpar5 a_1211_9706.t7 a_1211_9706.t18 260.6713
Rpar6 a_1351_9914.t0 a_1351_9914.t2 49.6836
Rpar7 a_2522_1205.t0 a_2522_1205.t2 100.5303
Rpar8 a_2522_1205.t0 a_2522_1205.t69 45.4252
Rpar9 a_2522_1205.t2 a_2522_1205.t69 49.3150
Rpar10 a_6004_13906.t0 a_6004_13906.t8 584.4108
Rpar11 a_6004_13906.t0 a_6004_13906.t9 75.0093
Rpar12 a_6004_13906.t8 a_6004_13906.t9 19.3808
Rpar13 a_7534_8146.t0 a_7534_8146.t4 45.4252
Rpar14 a_7534_8146.t0 a_7534_8146.t19 100.5303
Rpar15 a_7534_8146.t4 a_7534_8146.t19 49.3150
Rpar16 ib ib.t0 1.5707
Rpar17 ib ib.t1 153.5395
Rpar18 ib.t0 ib.t1 14.2485
Rpar19 inn inn.t0 2.2582
Rpar20 inp inp.t0 2.2582
Rpar21 out out.t0 2.1670
Rpar22 out out.t2 182.0331
Rpar23 out out.t14 137.5880
Rpar24 out.t2 out.t14 85.8308
Rpar25 vdd vdd.t0 23.4023
Rpar26 vdd vdd.t1 129.6011
Rpar27 vdd vdd.t6 951.4616
Rpar28 vdd.t0 vdd.t1 2.4884
Rpar29 vdd.t0 vdd.t6 90.1764
Rpar30 vdd.t1 vdd.t6 460.4755
Rpar31 vss vss.t0 78.2436
Rpar32 vss vss.t11 765.2728
Rpar33 vss vss.t8 1069.0320
Rpar34 vss.t0 vss.t11 2.2963
Rpar35 vss.t0 vss.t8 43.1363
Rpar36 vss.t11 vss.t8 440.5917
Cpar0 a_1211_9706.t0 vss 5.47530e-15
Cpar1 a_1211_9706.t18 vss 5.08372e-15
Cpar2 a_1211_9706.t6 vss 1.79452e-14
Cpar3 a_1211_9706.t7 vss 1.02171e-14
Cpar4 a_1351_9914.t0 vss 2.45869e-14
Cpar5 a_1351_9914.t2 vss 1.13123e-13
Cpar6 a_2522_1205.t0 vss 6.16840e-15
Cpar7 a_2522_1205.t2 vss 5.70664e-14
Cpar8 a_2522_1205.t69 vss 1.11411e-14
Cpar9 a_6004_13906.t0 vss 6.25683e-15
Cpar10 a_6004_13906.t8 vss 1.24462e-14
Cpar11 a_6004_13906.t9 vss 1.32764e-14
Cpar12 a_7534_8146.t0 vss 6.14678e-15
Cpar13 a_7534_8146.t19 vss 5.68658e-14
Cpar14 a_7534_8146.t4 vss 1.11020e-14
Cpar15 ib inn 3.71200e-17
Cpar16 ib inp 1.64400e-17
Cpar17 ib out 1.60720e-15
Cpar18 ib vdd 3.75780e-16
Cpar19 ib vss 3.97543e-14
Cpar20 ib.t0 vss 5.96194e-15
Cpar21 ib.t1 vss 2.17752e-15
Cpar22 inn inp 1.02120e-16
Cpar23 inn vdd 2.48906e-14
Cpar24 inn vss 8.16721e-15
Cpar25 inn.t0 vss 3.83056e-14
Cpar26 inp vdd 2.49875e-14
Cpar27 inp vss 8.07683e-15
Cpar28 inp.t0 vss 3.83781e-14
Cpar29 out vdd 8.96408e-15
Cpar30 out vss 1.30010e-14
Cpar31 out.t0 vss 5.30577e-16
Cpar32 out.t14 vss 1.54691e-14
Cpar33 out.t2 vss 3.58676e-15
Cpar34 vdd vss 2.85374e-13
Cpar35 vdd.t0 vss 3.95462e-14
Cpar36 vdd.t1 vss 1.69455e-14
Cpar37 vdd.t6 vss 8.23238e-14
.ends opamp_dut

Vdd vdd 0 1.800000
Vss vss 0 0
Ibias vdd ib 2.833330e-05
Vinp inp 0 DC 0.751000 AC 1 PWL(0 0.751000 3.188034e-09 0.751000 3.506837e-09 0.761000)
Rfb out inn 1m
Cload out 0 2.000000e-12
Xdut vdd vss inp inn out ib opamp_dut
.end
