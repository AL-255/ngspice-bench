* opa1000[0788]: 200f/symmetrical_ota_3v3_10u_100u_weak (symmetrical_ota, VDD=3.3V, CL=0.2pF, Iref=8.3333uA)
.include "pdk_opa.inc"
.temp 27
.option gmin=1e-12 rshunt=1e12 reltol=1e-3 abstol=1e-12 vntol=1e-5 method=gear
* Post-PEX R+C extracted netlist for symmetrical_ota_3v3_10u_100u_weak
.subckt opamp_dut vdd vss inp inn out ib
XMpar0 ib.t1 ib.t0 vss.t17 vss.t16 nfet_03v3 w=2.03u l=0.6u ad=5.6840e-13 pd=2.5900e-06 as=5.6840e-13 ps=2.5900e-06 nf=1 m=2 par=2
XMpar1 a_4468_1042.t5 a_4468_1042.t4 vss.t1 vss.t0 nfet_03v3 w=1.53u l=0.8u ad=4.2840e-13 pd=2.0900e-06 as=4.2840e-13 ps=2.0900e-06 nf=1 m=4 par=4
XMpar2 a_4468_1042.t0 a_5664_3136.t2 vdd.t1 vdd.t0 pfet_03v3 w=6.25u l=0.8u ad=1.7500e-12 pd=6.8100e-06 as=2.7500e-12 ps=1.0255e-05 nf=1 m=4 par=4
XMpar3 a_1251_1041.t0 inp.t0 a_4734_3136.t0 vss.t2 nfet_03v3 w=2.42u l=0.45u ad=6.7760e-13 pd=2.9800e-06 as=1.4520e-12 ps=6.0400e-06 nf=1 m=2 par=2
XMpar4 a_4734_3136.t0 inn.t0 a_5664_3136.t0 vss.t2 nfet_03v3 w=2.42u l=0.45u ad=1.4520e-12 pd=6.0400e-06 as=6.7760e-13 ps=2.9800e-06 nf=1 m=2 par=2
XMpar5 out.t1 a_4468_1042.t4 vss.t1 vss.t0 nfet_03v3 w=1.53u l=0.8u ad=4.2840e-13 pd=2.0900e-06 as=6.7320e-13 ps=3.1750e-06 nf=1 m=4 par=4
XMpar6 a_1251_1041.t3 a_1251_1041.t2 vdd.t1 vdd.t0 pfet_03v3 w=6.25u l=0.8u ad=1.7500e-12 pd=6.8100e-06 as=1.7500e-12 ps=6.8100e-06 nf=1 m=2 par=2
XMpar7 out.t0 a_1251_1041.t2 vdd.t1 vdd.t0 pfet_03v3 w=6.25u l=0.8u ad=1.7500e-12 pd=6.8100e-06 as=2.7500e-12 ps=1.0255e-05 nf=1 m=4 par=4
XMpar8 a_4734_3136.t4 ib.t0 vss.t17 vss.t16 nfet_03v3 w=2.03u l=0.6u ad=5.6840e-13 pd=2.5900e-06 as=8.9320e-13 ps=3.9250e-06 nf=1 m=4 par=4
XMpar9 a_5664_3136.t3 a_5664_3136.t2 vdd.t1 vdd.t0 pfet_03v3 w=6.25u l=0.8u ad=1.7500e-12 pd=6.8100e-06 as=1.7500e-12 ps=6.8100e-06 nf=1 m=2 par=2
X13 out.t8 vss.t30 cap_mim_2f0fF c_width=18.88u c_length=18.88u
Rpar0 a_1251_1041.t0 a_1251_1041.t2 161.0556
Rpar1 a_1251_1041.t0 a_1251_1041.t3 63.4008
Rpar2 a_1251_1041.t2 a_1251_1041.t3 27.9501
Rpar3 a_4468_1042.t0 a_4468_1042.t4 153.7210
Rpar4 a_4468_1042.t0 a_4468_1042.t5 47.8904
Rpar5 a_4468_1042.t4 a_4468_1042.t5 19.8886
Rpar6 a_4734_3136.t0 a_4734_3136.t4 50.9107
Rpar7 a_5664_3136.t0 a_5664_3136.t2 161.0556
Rpar8 a_5664_3136.t0 a_5664_3136.t3 63.4008
Rpar9 a_5664_3136.t2 a_5664_3136.t3 27.9501
Rpar10 ib ib.t0 19.2450
Rpar11 ib ib.t1 8.6895
Rpar12 ib.t0 ib.t1 215.0966
Rpar13 inn inn.t0 30.7408
Rpar14 inp inp.t0 30.7894
Rpar15 out out.t0 83.2800
Rpar16 out out.t1 217.2009
Rpar17 out out.t8 15.8214
Rpar18 out.t0 out.t1 57.2739
Rpar19 out.t0 out.t8 640.6112
Rpar20 out.t1 out.t8 1670.7655
Rpar21 vdd vdd.t0 105.2263
Rpar22 vdd vdd.t1 183.9348
Rpar23 vdd.t0 vdd.t1 3.1866
Rpar24 vss vss.t0 122.9548
Rpar25 vss vss.t1 117.2969
Rpar26 vss vss.t2 106.1619
Rpar27 vss vss.t16 329.3480
Rpar28 vss vss.t17 616.3633
Rpar29 vss vss.t30 543.7765
Rpar30 vss.t0 vss.t1 12.4260
Rpar31 vss.t0 vss.t2 3.8060
Rpar32 vss.t0 vss.t16 39.6436
Rpar33 vss.t0 vss.t17 68.8982
Rpar34 vss.t0 vss.t30 248.1116
Rpar35 vss.t1 vss.t2 16.7608
Rpar36 vss.t1 vss.t16 78.1457
Rpar37 vss.t1 vss.t17 169.1469
Rpar38 vss.t1 vss.t30 366.7512
Rpar39 vss.t2 vss.t16 13.0587
Rpar40 vss.t2 vss.t17 22.9446
Rpar41 vss.t2 vss.t30 102.8357
Rpar42 vss.t16 vss.t17 8.5014
Rpar43 vss.t16 vss.t30 182.2522
Rpar44 vss.t17 vss.t30 292.2357
Cpar0 a_1251_1041.t0 vss 2.20694e-15
Cpar1 a_1251_1041.t2 vss 6.59915e-15
Cpar2 a_1251_1041.t3 vss 4.05556e-15
Cpar3 a_4468_1042.t0 vss 3.45004e-15
Cpar4 a_4468_1042.t4 vss 3.47842e-15
Cpar5 a_4468_1042.t5 vss 1.52609e-15
Cpar6 a_4734_3136.t0 vss 4.17145e-15
Cpar7 a_4734_3136.t4 vss 3.13401e-15
Cpar8 a_5664_3136.t0 vss 2.12116e-15
Cpar9 a_5664_3136.t2 vss 6.34268e-15
Cpar10 a_5664_3136.t3 vss 3.89792e-15
Cpar11 ib vdd 4.07500e-17
Cpar12 ib vss 6.54988e-15
Cpar13 ib.t0 vss 8.25113e-16
Cpar14 ib.t1 vss 1.91519e-16
Cpar15 inn inp 5.17800e-17
Cpar16 inn vss 1.27533e-15
Cpar17 inn.t0 vss 2.02012e-16
Cpar18 inp vss 1.30921e-15
Cpar19 inp.t0 vss 1.99472e-16
Cpar20 out vdd 5.70775e-15
Cpar21 out vss 1.68282e-14
Cpar22 out.t0 vss 5.66407e-16
Cpar23 out.t1 vss 2.25420e-16
Cpar24 out.t8 vss 9.42796e-15
Cpar25 vdd vss 5.98466e-14
Cpar26 vdd.t0 vss 1.48184e-14
Cpar27 vdd.t1 vss 9.42961e-15
.ends opamp_dut

Vdd vdd 0 3.300000
Vss vss 0 0
Ibias vdd ib 8.333300e-06
Vinp inp 0 DC 1.645000 AC 1 PWL(0 1.645000 3.000000e-09 1.645000 3.300000e-09 1.655000)
Rfb out inn 1m
Cload out 0 2.000000e-13
Xdut vdd vss inp inn out ib opamp_dut
.end
