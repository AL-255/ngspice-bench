* opa1000[0498]: 2p/nmos_miller_3v3_i500u_subth (nmos_miller, VDD=3.3V, CL=2.0pF, Iref=50.0uA)
.include "pdk_opa.inc"
.temp 27
.option gmin=1e-12 rshunt=1e12 reltol=1e-3 abstol=1e-12 vntol=1e-5 method=gear
* Post-PEX R+C extracted netlist for nmos_miller_3v3_i500u_subth
.subckt opamp_dut vdd vss inp inn out ib
XMpar0 out.t9 a_872_10474.t101 vdd.t1 vdd.t0 pfet_03v3 w=10u l=0.35u ad=2.8000e-12 pd=1.0560e-05 as=2.8800e-12 ps=1.0826e-05 nf=1 m=80 par=80
XMpar1 out.t0 ib.t0 vss.t29 vss.t28 nfet_03v3 w=4.71u l=0.68u ad=1.3188e-12 pd=5.2700e-06 as=1.4695e-12 ps=5.8050e-06 nf=1 m=80 par=80
XMpar2 a_4034_17299.t84 ib.t0 vss.t29 vss.t28 nfet_03v3 w=4.71u l=0.68u ad=1.3188e-12 pd=5.2700e-06 as=1.3188e-12 ps=5.2700e-06 nf=1 m=32 par=32
XMpar3 a_4034_17299.t0 inn.t0 a_7924_13555.t0 vss.t0 nfet_03v3 w=1.97u l=0.28u ad=8.9213e-13 pd=3.0164e-06 as=8.4710e-13 ps=2.8300e-06 nf=1 m=84 par=84
XMpar4 ib.t1 ib.t0 vss.t29 vss.t28 nfet_03v3 w=4.71u l=0.68u ad=1.5072e-12 pd=5.9387e-06 as=1.6956e-12 ps=6.6075e-06 nf=1 m=16 par=16
XMpar5 a_4034_17299.t0 inp.t0 a_872_10474.t1 vss.t0 nfet_03v3 w=1.97u l=0.28u ad=8.9213e-13 pd=3.0164e-06 as=8.4710e-13 ps=2.8300e-06 nf=1 m=84 par=84
XMpar6 a_872_10474.t85 a_7924_13555.t84 vdd.t1 vdd.t0 pfet_03v3 w=10u l=0.35u ad=2.8000e-12 pd=1.0560e-05 as=3.2000e-12 ps=1.1890e-05 nf=1 m=16 par=16
XMpar7 a_7924_13555.t85 a_7924_13555.t84 vdd.t1 vdd.t0 pfet_03v3 w=10u l=0.35u ad=2.8000e-12 pd=1.0560e-05 as=2.8000e-12 ps=1.0560e-05 nf=1 m=16 par=16
X70 a_1204_10474.t1 out.t77 cap_mim_2f0fF c_width=17.39u c_length=17.4u
X75 a_1204_10474.t1 out.t77 cap_mim_2f0fF c_width=17.39u c_length=17.4u
X159 a_1204_10474.t1 out.t77 cap_mim_2f0fF c_width=17.39u c_length=17.4u
X162 a_1204_10474.t1 out.t77 cap_mim_2f0fF c_width=17.39u c_length=17.4u
X260 a_872_10474.t0 a_1204_10474.t0 vss.t195 ppolyf_u_1k r_width=1u r_length=1u
Rpar0 a_1204_10474.t0 a_1204_10474.t1 67.7539
Rpar1 a_4034_17299.t0 a_4034_17299.t84 68.0066
Rpar2 a_7924_13555.t0 a_7924_13555.t84 2951.0652
Rpar3 a_7924_13555.t0 a_7924_13555.t85 57.9959
Rpar4 a_7924_13555.t84 a_7924_13555.t85 18.1526
Rpar5 a_872_10474.t0 a_872_10474.t1 168.9698
Rpar6 a_872_10474.t0 a_872_10474.t85 230.0095
Rpar7 a_872_10474.t0 a_872_10474.t101 129.0981
Rpar8 a_872_10474.t1 a_872_10474.t85 147.9744
Rpar9 a_872_10474.t1 a_872_10474.t101 128.8988
Rpar10 a_872_10474.t85 a_872_10474.t101 175.4630
Rpar11 ib ib.t0 2.1947
Rpar12 ib ib.t1 875.4524
Rpar13 ib.t0 ib.t1 6.6021
Rpar14 inn inn.t0 2.0608
Rpar15 inp inp.t0 2.0608
Rpar16 out out.t0 2.0795
Rpar17 out out.t9 8512.3569
Rpar18 out.t0 out.t9 67.6597
Rpar19 out.t0 out.t77 98.5468
Rpar20 out.t9 out.t77 144.6842
Rpar21 vdd vdd.t0 61.0321
Rpar22 vdd vdd.t1 514.7904
Rpar23 vdd.t0 vdd.t1 1.5219
Rpar24 vss vss.t0 1442.3208
Rpar25 vss vss.t28 2889.5710
Rpar26 vss vss.t29 154.5664
Rpar27 vss vss.t195 168.1726
Rpar28 vss.t0 vss.t28 39.1067
Rpar29 vss.t0 vss.t29 35.8046
Rpar30 vss.t0 vss.t195 1181.9777
Rpar31 vss.t28 vss.t29 5.4576
Rpar32 vss.t28 vss.t195 2787.7804
Rpar33 vss.t29 vss.t195 203.8379
Cpar0 a_1204_10474.t0 vss 5.32275e-17
Cpar1 a_1204_10474.t1 vss 1.02129e-14
Cpar2 a_4034_17299.t0 vss 7.55305e-14
Cpar3 a_4034_17299.t84 vss 3.95529e-14
Cpar4 a_7924_13555.t0 vss 4.88541e-14
Cpar5 a_7924_13555.t84 vss 2.84443e-14
Cpar6 a_7924_13555.t85 vss 3.53872e-14
Cpar7 a_872_10474.t0 vss 3.41420e-15
Cpar8 a_872_10474.t1 vss 4.64674e-14
Cpar9 a_872_10474.t101 vss 7.33502e-14
Cpar10 a_872_10474.t85 vss 3.05552e-14
Cpar11 ib out 1.57030e-14
Cpar12 ib vdd 2.23590e-16
Cpar13 ib vss 1.20642e-13
Cpar14 ib.t0 vss 1.61774e-14
Cpar15 ib.t1 vss 3.31479e-15
Cpar16 inn inp 1.50130e-16
Cpar17 inn vdd 8.56700e-17
Cpar18 inn vss 3.49390e-14
Cpar19 inn.t0 vss 1.37961e-14
Cpar20 inp vdd 2.41010e-16
Cpar21 inp vss 3.48447e-14
Cpar22 inp.t0 vss 1.38390e-14
Cpar23 out vdd 1.78940e-13
Cpar24 out vss 9.09344e-14
Cpar25 out.t0 vss 6.67839e-14
Cpar26 out.t77 vss 4.77224e-14
Cpar27 out.t9 vss 1.14587e-13
Cpar28 vdd vss 2.46187e-13
Cpar29 vdd.t0 vss 1.95157e-13
Cpar30 vdd.t1 vss 9.95992e-14
.ends opamp_dut

Vdd vdd 0 3.300000
Vss vss 0 0
Ibias vdd ib 5.000000e-05
Vinp inp 0 DC 1.645000 AC 1 PWL(0 1.645000 3.000000e-09 1.645000 3.300000e-09 1.655000)
Rfb out inn 1m
Cload out 0 2.000000e-12
Xdut vdd vss inp inn out ib opamp_dut
.end
