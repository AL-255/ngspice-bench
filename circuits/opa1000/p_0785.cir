* opa1000[0785]: 200f/symmetrical_ota_3v3_i20u_subth (symmetrical_ota, VDD=3.3V, CL=0.2pF, Iref=2.8333uA)
.include "pdk_opa.inc"
.temp 27
.option gmin=1e-12 rshunt=1e12 reltol=1e-3 abstol=1e-12 vntol=1e-5 method=gear
* Post-PEX R+C extracted netlist for symmetrical_ota_3v3_i20u_subth
.subckt opamp_dut vdd vss inp inn out ib
XMpar0 a_1120_996.t1 a_1120_996.t0 vdd.t1 vdd.t0 pfet_03v3 w=9.08u l=0.81u ad=2.5424e-12 pd=9.6400e-06 as=2.5424e-12 ps=9.6400e-06 nf=1 m=2 par=2
XMpar1 a_1120_996.t4 inp.t0 a_3130_5664.t0 vss.t0 nfet_03v3 w=2u l=0.81u ad=5.6000e-13 pd=2.5600e-06 as=6.6667e-13 ps=3.0000e-06 nf=1 m=36 par=36
XMpar2 a_3130_5664.t0 inn.t0 a_7016_5664.t0 vss.t0 nfet_03v3 w=2u l=0.81u ad=6.6667e-13 pd=3.0000e-06 as=5.6000e-13 ps=2.5600e-06 nf=1 m=36 par=36
XMpar3 out.t0 a_1120_996.t0 vdd.t1 vdd.t0 pfet_03v3 w=9.08u l=0.81u ad=2.5424e-12 pd=9.6400e-06 as=3.9952e-12 ps=1.4500e-05 nf=1 m=4 par=4
XMpar4 out.t2 a_5740_1041.t4 vss.t13 vss.t0 nfet_03v3 w=2.07u l=0.81u ad=5.7960e-13 pd=2.6300e-06 as=9.1080e-13 ps=3.9850e-06 nf=1 m=4 par=4
XMpar5 a_3130_5664.t36 ib.t0 vss.t23 vss.t0 nfet_03v3 w=4.2u l=1.2u ad=1.1760e-12 pd=4.7600e-06 as=1.8480e-12 ps=7.1800e-06 nf=1 m=4 par=4
XMpar6 a_5740_1041.t0 a_7016_5664.t36 vdd.t1 vdd.t0 pfet_03v3 w=9.08u l=0.81u ad=2.5424e-12 pd=9.6400e-06 as=3.9952e-12 ps=1.4500e-05 nf=1 m=4 par=4
XMpar7 a_5740_1041.t5 a_5740_1041.t4 vss.t13 vss.t0 nfet_03v3 w=2.07u l=0.81u ad=5.7960e-13 pd=2.6300e-06 as=5.7960e-13 ps=2.6300e-06 nf=1 m=4 par=4
XMpar8 ib.t1 ib.t0 vss.t23 vss.t0 nfet_03v3 w=4.2u l=1.2u ad=1.1760e-12 pd=4.7600e-06 as=1.1760e-12 ps=4.7600e-06 nf=1 m=2 par=2
XMpar9 a_7016_5664.t37 a_7016_5664.t36 vdd.t1 vdd.t0 pfet_03v3 w=9.08u l=0.81u ad=2.5424e-12 pd=9.6400e-06 as=2.5424e-12 ps=9.6400e-06 nf=1 m=2 par=2
X22 out.t8 vss.t16 cap_mim_2f0fF c_width=17.39u c_length=17.4u
X53 out.t8 vss.t16 cap_mim_2f0fF c_width=17.39u c_length=17.4u
Rpar0 a_1120_996.t0 a_1120_996.t1 31.4777
Rpar1 a_1120_996.t0 a_1120_996.t4 159.8512
Rpar2 a_1120_996.t1 a_1120_996.t4 55.0122
Rpar3 a_3130_5664.t0 a_3130_5664.t36 37.5226
Rpar4 a_5740_1041.t0 a_5740_1041.t4 227.9740
Rpar5 a_5740_1041.t0 a_5740_1041.t5 59.6663
Rpar6 a_5740_1041.t4 a_5740_1041.t5 19.1426
Rpar7 a_7016_5664.t0 a_7016_5664.t36 159.8512
Rpar8 a_7016_5664.t0 a_7016_5664.t37 55.0122
Rpar9 a_7016_5664.t36 a_7016_5664.t37 31.4777
Rpar10 ib ib.t0 19.1101
Rpar11 ib ib.t1 7.8905
Rpar12 ib.t0 ib.t1 121.8527
Rpar13 inn inn.t0 1.8752
Rpar14 inp inp.t0 1.8752
Rpar15 out out.t0 3.4978
Rpar16 out out.t2 72.9314
Rpar17 out out.t8 99.7334
Rpar18 out.t2 out.t8 207.7925
Rpar19 vdd vdd.t0 102.2769
Rpar20 vdd vdd.t1 225.7419
Rpar21 vdd.t0 vdd.t1 3.3139
Rpar22 vss vss.t0 51.4380
Rpar23 vss vss.t13 228.3063
Rpar24 vss vss.t16 1436.3697
Rpar25 vss vss.t23 430.0499
Rpar26 vss.t0 vss.t13 5.9568
Rpar27 vss.t0 vss.t16 44.3626
Rpar28 vss.t0 vss.t23 5.8535
Rpar29 vss.t13 vss.t16 2577.1259
Rpar30 vss.t13 vss.t23 57.1712
Rpar31 vss.t16 vss.t23 2472.3745
Cpar0 a_1120_996.t0 vss 1.02699e-14
Cpar1 a_1120_996.t1 vss 6.42648e-15
Cpar2 a_1120_996.t4 vss 2.03001e-14
Cpar3 a_3130_5664.t0 vss 3.94451e-14
Cpar4 a_3130_5664.t36 vss 4.73807e-15
Cpar5 a_5740_1041.t0 vss 4.10696e-15
Cpar6 a_5740_1041.t4 vss 3.36142e-15
Cpar7 a_5740_1041.t5 vss 2.17512e-15
Cpar8 a_7016_5664.t0 vss 1.88922e-14
Cpar9 a_7016_5664.t36 vss 9.55770e-15
Cpar10 a_7016_5664.t37 vss 5.98081e-15
Cpar11 ib inp 1.04300e-17
Cpar12 ib vdd 6.03400e-17
Cpar13 ib vss 9.35343e-15
Cpar14 ib.t0 vss 1.50848e-15
Cpar15 ib.t1 vss 2.60703e-16
Cpar16 inn inp 1.55240e-16
Cpar17 inn vdd 3.12300e-17
Cpar18 inn vss 1.97627e-14
Cpar19 inn.t0 vss 9.84357e-15
Cpar20 inp vss 1.99641e-14
Cpar21 inp.t0 vss 9.87162e-15
Cpar22 out vdd 6.94171e-15
Cpar23 out vss 2.37189e-14
Cpar24 out.t0 vss 2.88167e-16
Cpar25 out.t2 vss 3.12742e-16
Cpar26 out.t8 vss 1.27464e-14
Cpar27 vdd vss 7.42875e-14
Cpar28 vdd.t0 vss 1.58544e-14
Cpar29 vdd.t1 vss 9.33313e-15
.ends opamp_dut

Vdd vdd 0 3.300000
Vss vss 0 0
Ibias vdd ib 2.833300e-06
Vinp inp 0 DC 1.645000 AC 1 PWL(0 1.645000 6.980620e-09 1.645000 7.678682e-09 1.655000)
Rfb out inn 1m
Cload out 0 2.000000e-13
Xdut vdd vss inp inn out ib opamp_dut
.end
