* opa1000[0814]: 2p/symmetrical_ota_3v3_i50n_subth (symmetrical_ota, VDD=3.3V, CL=2.0pF, Iref=0.0108uA)
.include "pdk_opa.inc"
.temp 27
.option gmin=1e-12 rshunt=1e12 reltol=1e-3 abstol=1e-12 vntol=1e-5 method=gear
* Post-PEX R+C extracted netlist for symmetrical_ota_3v3_i50n_subth
.subckt opamp_dut vdd vss inp inn out ib
XMpar0 a_10011_6778.t4 inn.t0 a_2361_11676.t0 vss.t2 nfet_03v3 w=1.11u l=4.4u ad=3.1080e-13 pd=1.6700e-06 as=6.6600e-13 ps=3.4200e-06 nf=1 m=2 par=2
XMpar1 a_2361_11676.t4 ib.t0 vss.t13 vss.t12 nfet_03v3 w=0.4u l=6.25u ad=1.1200e-13 pd=9.6000e-07 as=1.7600e-13 ps=1.4800e-06 nf=1 m=4 par=4
XMpar2 ib.t1 ib.t0 vss.t13 vss.t12 nfet_03v3 w=0.4u l=6.25u ad=1.1200e-13 pd=9.6000e-07 as=1.1200e-13 ps=9.6000e-07 nf=1 m=2 par=2
XMpar3 a_7280_1041.t5 a_7280_1041.t4 vss.t1 vss.t0 nfet_03v3 w=0.4u l=9.75u ad=2.4000e-13 pd=2.0000e-06 as=1.1200e-13 ps=9.6000e-07 nf=1 m=4 par=4
XMpar4 a_7280_1041.t0 a_10011_6778.t0 vdd.t1 vdd.t0 pfet_03v3 w=0.58u l=9.75u ad=3.4800e-13 pd=2.3600e-06 as=2.5520e-13 ps=1.7500e-06 nf=1 m=4 par=4
XMpar5 a_1719_6778.t0 inp.t0 a_2361_11676.t0 vss.t2 nfet_03v3 w=1.11u l=4.4u ad=3.1080e-13 pd=1.6700e-06 as=6.6600e-13 ps=3.4200e-06 nf=1 m=2 par=2
XMpar6 out.t2 a_7280_1041.t4 vss.t1 vss.t0 nfet_03v3 w=0.4u l=9.75u ad=2.4000e-13 pd=2.0000e-06 as=1.1200e-13 ps=9.6000e-07 nf=1 m=4 par=4
XMpar7 a_1719_6778.t3 a_1719_6778.t2 vdd.t1 vdd.t0 pfet_03v3 w=0.58u l=9.75u ad=3.4800e-13 pd=2.3600e-06 as=1.6240e-13 ps=1.1400e-06 nf=1 m=2 par=2
XMpar8 a_10011_6778.t1 a_10011_6778.t0 vdd.t1 vdd.t0 pfet_03v3 w=0.58u l=9.75u ad=3.4800e-13 pd=2.3600e-06 as=1.6240e-13 ps=1.1400e-06 nf=1 m=2 par=2
XMpar9 out.t0 a_1719_6778.t2 vdd.t1 vdd.t0 pfet_03v3 w=0.58u l=9.75u ad=3.4800e-13 pd=2.3600e-06 as=2.5520e-13 ps=1.7500e-06 nf=1 m=4 par=4
X21 out.t8 vss.t25 cap_mim_2f0fF c_width=14.79u c_length=14.79u
Rpar0 a_10011_6778.t0 a_10011_6778.t1 16.0249
Rpar1 a_10011_6778.t0 a_10011_6778.t4 90.4268
Rpar2 a_10011_6778.t1 a_10011_6778.t4 129.9135
Rpar3 a_1719_6778.t0 a_1719_6778.t2 90.4272
Rpar4 a_1719_6778.t0 a_1719_6778.t3 129.9129
Rpar5 a_1719_6778.t2 a_1719_6778.t3 16.0250
Rpar6 a_2361_11676.t0 a_2361_11676.t4 63.1729
Rpar7 a_7280_1041.t0 a_7280_1041.t4 114.9279
Rpar8 a_7280_1041.t0 a_7280_1041.t5 104.3727
Rpar9 a_7280_1041.t4 a_7280_1041.t5 8.5758
Rpar10 ib ib.t0 11.3504
Rpar11 ib ib.t1 17.2948
Rpar12 inn inn.t0 3.4348
Rpar13 inp inp.t0 3.4834
Rpar14 out out.t0 57.0273
Rpar15 out out.t2 71.0762
Rpar16 out out.t8 15.7511
Rpar17 out.t0 out.t2 157.4345
Rpar18 out.t0 out.t8 539.1908
Rpar19 out.t2 out.t8 672.0220
Rpar20 vdd vdd.t0 218.1786
Rpar21 vdd vdd.t1 91.8533
Rpar22 vdd.t0 vdd.t1 7.5089
Rpar23 vss vss.t0 254.6964
Rpar24 vss vss.t1 75.3027
Rpar25 vss vss.t2 454.9772
Rpar26 vss vss.t12 191.6602
Rpar27 vss vss.t13 342.2669
Rpar28 vss vss.t25 71.2237
Rpar29 vss.t0 vss.t1 17.4880
Rpar30 vss.t0 vss.t2 2822.0751
Rpar31 vss.t0 vss.t12 1213.8596
Rpar32 vss.t0 vss.t13 2205.1230
Rpar33 vss.t0 vss.t25 876.2881
Rpar34 vss.t1 vss.t2 957.7542
Rpar35 vss.t1 vss.t12 404.3210
Rpar36 vss.t1 vss.t13 723.2848
Rpar37 vss.t1 vss.t25 259.0806
Rpar38 vss.t2 vss.t12 13.3808
Rpar39 vss.t2 vss.t13 31.0173
Rpar40 vss.t2 vss.t25 1565.3581
Rpar41 vss.t12 vss.t13 12.1920
Rpar42 vss.t12 vss.t25 659.4107
Rpar43 vss.t13 vss.t25 1177.5761
Cpar0 a_10011_6778.t0 vss 3.62604e-14
Cpar1 a_10011_6778.t1 vss 7.51871e-15
Cpar2 a_10011_6778.t4 vss 4.19765e-15
Cpar3 a_1719_6778.t0 vss 4.18472e-15
Cpar4 a_1719_6778.t2 vss 3.61490e-14
Cpar5 a_1719_6778.t3 vss 7.49555e-15
Cpar6 a_2361_11676.t0 vss 3.98785e-15
Cpar7 a_2361_11676.t4 vss 4.70942e-15
Cpar8 a_7280_1041.t0 vss 5.17417e-15
Cpar9 a_7280_1041.t4 vss 1.83384e-14
Cpar10 a_7280_1041.t5 vss 4.59196e-15
Cpar11 ib inp 1.03700e-17
Cpar12 ib vdd 2.56450e-16
Cpar13 ib vss 2.58375e-14
Cpar14 ib.t0 vss 3.14863e-15
Cpar15 ib.t1 vss 1.68085e-16
Cpar16 inn inp 5.19900e-17
Cpar17 inn vdd 4.96600e-17
Cpar18 inn vss 4.86369e-15
Cpar19 inn.t0 vss 5.46087e-16
Cpar20 inp vdd 1.99680e-16
Cpar21 inp vss 4.87945e-15
Cpar22 inp.t0 vss 6.27754e-16
Cpar23 out vdd 9.50722e-15
Cpar24 out vss 2.90780e-14
Cpar25 out.t0 vss 2.48804e-15
Cpar26 out.t2 vss 3.26727e-15
Cpar27 out.t8 vss 2.02834e-14
Cpar28 vdd vss 1.56915e-13
Cpar29 vdd.t0 vss 7.15450e-14
Cpar30 vdd.t1 vss 1.46362e-14
.ends opamp_dut

Vdd vdd 0 3.300000
Vss vss 0 0
Ibias vdd ib 1.080000e-08
Vinp inp 0 DC 1.645000 AC 1 PWL(0 1.645000 2.870398e-06 1.645000 3.157438e-06 1.655000)
Rfb out inn 1m
Cload out 0 2.000000e-12
Xdut vdd vss inp inn out ib opamp_dut
.end
