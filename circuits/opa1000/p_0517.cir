* opa1000[0517]: 200f/pmos_5t_1v8_10u_100u_subth (pmos_5t, VDD=1.8V, CL=0.2pF, Iref=11.5uA)
.include "pdk_opa.inc"
.temp 27
.option gmin=1e-12 rshunt=1e12 reltol=1e-3 abstol=1e-12 vntol=1e-5 method=gear
* Post-PEX R+C extracted netlist for pmos_5t_1v8_10u_100u_subth
.subckt opamp_dut vdd vss inp inn out ib
XMpar0 a_1634_1249.t4 inp.t0 a_1874_1249.t0 vdd.t10 pfet_03v3 w=8u l=0.6u ad=2.4000e-12 pd=9.1000e-06 as=2.3200e-12 ps=8.8300e-06 nf=1 m=64 par=64
XMpar1 a_1634_1249.t4 inn.t0 out.t8 vdd.t10 pfet_03v3 w=8u l=0.6u ad=2.4000e-12 pd=9.1000e-06 as=2.3200e-12 ps=8.8300e-06 nf=1 m=64 par=64
XMpar2 out.t0 a_1874_1249.t64 vss.t1 vss.t0 nfet_03v3 w=2.02u l=0.6u ad=5.6560e-13 pd=2.5800e-06 as=5.6560e-13 ps=2.5800e-06 nf=1 m=10 par=10
XMpar3 a_1634_1249.t0 a_1670_8881.t2 vdd.t1 vdd.t0 pfet_03v3 w=10u l=0.8u ad=2.8000e-12 pd=1.0560e-05 as=3.6000e-12 ps=1.3220e-05 nf=1 m=8 par=8
XMpar4 a_1874_1249.t65 a_1874_1249.t64 vss.t1 vss.t0 nfet_03v3 w=2.02u l=0.6u ad=6.9488e-13 pd=3.1120e-06 as=5.6560e-13 ps=2.5800e-06 nf=1 m=10 par=10
XMpar5 a_1670_8881.t3 a_1670_8881.t2 vdd.t1 vdd.t0 pfet_03v3 w=10u l=0.8u ad=2.8000e-12 pd=1.0560e-05 as=2.8000e-12 ps=1.0560e-05 nf=1 m=2 par=2
XMpar6 ib.t1 ib.t0 vss.t22 vss.t21 nfet_03v3 w=10u l=0.8u ad=6.0000e-12 pd=2.1200e-05 as=2.8000e-12 ps=1.0560e-05 nf=1 m=2 par=2
XMpar7 a_1670_8881.t0 ib.t0 vss.t22 vss.t21 nfet_03v3 w=10u l=0.8u ad=2.8000e-12 pd=1.0560e-05 as=2.8000e-12 ps=1.0560e-05 nf=1 m=2 par=2
X9 out.t74 vss.t2 cap_mim_2f0fF c_width=16.58u c_length=16.59u
Rpar0 a_1634_1249.t0 a_1634_1249.t4 60.6952
Rpar1 a_1670_8881.t0 a_1670_8881.t2 139.2928
Rpar2 a_1670_8881.t0 a_1670_8881.t3 60.3974
Rpar3 a_1670_8881.t2 a_1670_8881.t3 28.5223
Rpar4 a_1874_1249.t0 a_1874_1249.t64 438.5974
Rpar5 a_1874_1249.t0 a_1874_1249.t65 84.0599
Rpar6 a_1874_1249.t64 a_1874_1249.t65 14.4623
Rpar7 ib ib.t0 26.9491
Rpar8 ib ib.t1 3.2728
Rpar9 inn inn.t0 2.9313
Rpar10 inp inp.t0 2.9313
Rpar11 out out.t0 2.8314
Rpar12 out out.t8 73.6181
Rpar13 out out.t74 101.9802
Rpar14 out.t8 out.t74 126.2836
Rpar15 vdd vdd.t0 57.1866
Rpar16 vdd vdd.t1 201.5739
Rpar17 vdd vdd.t10 92.1746
Rpar18 vdd.t0 vdd.t1 5.6624
Rpar19 vdd.t0 vdd.t10 304.0985
Rpar20 vdd.t1 vdd.t10 1071.9005
Rpar21 vss vss.t0 139.2330
Rpar22 vss vss.t1 663.7578
Rpar23 vss vss.t2 691.3832
Rpar24 vss vss.t21 202.7760
Rpar25 vss vss.t22 401.5348
Rpar26 vss.t0 vss.t1 3.9064
Rpar27 vss.t0 vss.t2 55.8344
Rpar28 vss.t0 vss.t21 104.1167
Rpar29 vss.t0 vss.t22 206.1706
Rpar30 vss.t1 vss.t2 266.3410
Rpar31 vss.t1 vss.t21 492.3972
Rpar32 vss.t1 vss.t22 975.0389
Rpar33 vss.t2 vss.t21 531.1339
Rpar34 vss.t2 vss.t22 1051.7455
Rpar35 vss.t21 vss.t22 9.8525
Cpar0 a_1634_1249.t0 vss 1.75073e-14
Cpar1 a_1634_1249.t4 vss 1.94374e-13
Cpar2 a_1670_8881.t0 vss 3.62307e-15
Cpar3 a_1670_8881.t2 vss 1.29953e-14
Cpar4 a_1670_8881.t3 vss 4.63897e-15
Cpar5 a_1874_1249.t0 vss 9.16128e-14
Cpar6 a_1874_1249.t64 vss 1.12802e-14
Cpar7 a_1874_1249.t65 vss 9.88435e-15
Cpar8 ib vdd 2.61300e-17
Cpar9 ib vss 1.04284e-14
Cpar10 ib.t0 vss 6.33780e-16
Cpar11 ib.t1 vss 5.80540e-16
Cpar12 inn inp 1.01040e-16
Cpar13 inn out 1.85269e-14
Cpar14 inn vdd 2.68398e-14
Cpar15 inn vss 1.07494e-14
Cpar16 inn.t0 vss 5.11989e-14
Cpar17 inp vdd 2.69120e-14
Cpar18 inp vss 1.09195e-14
Cpar19 inp.t0 vss 5.12717e-14
Cpar20 out vdd 9.48665e-15
Cpar21 out vss 2.15949e-14
Cpar22 out.t0 vss 2.20760e-15
Cpar23 out.t74 vss 5.59584e-14
Cpar24 out.t8 vss 4.82067e-14
Cpar25 vdd vss 3.39631e-13
Cpar26 vdd.t0 vss 1.11074e-14
Cpar27 vdd.t1 vss 5.43361e-15
Cpar28 vdd.t10 vss 8.79129e-14
.ends opamp_dut

Vdd vdd 0 1.800000
Vss vss 0 0
Ibias vdd ib 1.150000e-05
Vinp inp 0 DC 0.805000 AC 1 PWL(0 0.805000 3.000000e-09 0.805000 3.300000e-09 0.815000)
Rfb out inn 1m
Cload out 0 2.000000e-13
Xdut vdd vss inp inn out ib opamp_dut
.end
