* opa1000[0178]: 200f/folded_cascode_nmos_1v8_1u_10u_subth (folded_cascode_nmos, VDD=1.8V, CL=0.2pF, Iref=1.1667uA)
.include "pdk_opa.inc"
.temp 27
.option gmin=1e-12 rshunt=1e12 reltol=1e-3 abstol=1e-12 vntol=1e-5 method=gear
* Post-PEX R+C extracted netlist for folded_cascode_nmos_1v8_1u_10u_subth
.subckt opamp_dut vdd vss inp inn out ib
XMpar0 a_2970_7484.t0 inn.t0 a_6094_5679.t1 vss.t2 nfet_03v3 w=2.03u l=1u ad=6.4058e-13 pd=2.8867e-06 as=6.4058e-13 ps=2.8867e-06 nf=1 m=18 par=18
XMpar1 a_2066_5679.t19 ib.t10 a_2306_5679.t0 vdd.t12 pfet_03v3 w=1.92u l=0.6u ad=6.1440e-13 pd=2.8000e-06 as=5.3760e-13 ps=2.4800e-06 nf=1 m=16 par=16
XMpar2 a_6094_5679.t21 ib.t10 out.t0 vdd.t12 pfet_03v3 w=1.92u l=0.6u ad=6.1440e-13 pd=2.8000e-06 as=5.3760e-13 ps=2.4800e-06 nf=1 m=16 par=16
XMpar3 a_2970_7484.t36 ib.t0 vss.t1 vss.t0 nfet_03v3 w=3.22u l=2u ad=9.0160e-13 pd=3.7800e-06 as=9.0160e-13 ps=3.7800e-06 nf=1 m=4 par=4
XMpar4 a_2066_5679.t0 inp.t0 a_2970_7484.t0 vss.t2 nfet_03v3 w=2.03u l=1u ad=6.4058e-13 pd=2.8867e-06 as=6.4058e-13 ps=2.8867e-06 nf=1 m=18 par=18
XMpar5 a_2066_5679.t18 a_1245_1041.t0 vdd.t1 vdd.t0 pfet_03v3 w=8.53u l=1.63u ad=2.3884e-12 pd=9.0900e-06 as=3.7532e-12 ps=1.3675e-05 nf=1 m=4 par=4
XMpar6 ib.t1 ib.t0 vss.t1 vss.t0 nfet_03v3 w=3.22u l=2u ad=1.9320e-12 pd=7.6400e-06 as=9.0160e-13 ps=3.7800e-06 nf=1 m=2 par=2
XMpar7 a_1245_1041.t1 a_1245_1041.t0 vdd.t1 vdd.t0 pfet_03v3 w=8.53u l=1.63u ad=2.3884e-12 pd=9.0900e-06 as=5.1180e-12 ps=1.8260e-05 nf=1 m=2 par=2
XMpar8 a_6094_5679.t0 a_1245_1041.t0 vdd.t1 vdd.t0 pfet_03v3 w=8.53u l=1.63u ad=2.3884e-12 pd=9.0900e-06 as=3.7532e-12 ps=1.3675e-05 nf=1 m=4 par=4
XMpar9 a_1245_1041.t4 ib.t0 vss.t1 vss.t0 nfet_03v3 w=3.22u l=2u ad=9.0160e-13 pd=3.7800e-06 as=9.0160e-13 ps=3.7800e-06 nf=1 m=2 par=2
XMpar10 out.t6 a_2306_5679.t16 vss.t1 vss.t0 nfet_03v3 w=3.22u l=2u ad=9.0160e-13 pd=3.7800e-06 as=9.0160e-13 ps=3.7800e-06 nf=1 m=2 par=2
XMpar11 a_2306_5679.t17 a_2306_5679.t16 vss.t1 vss.t0 nfet_03v3 w=3.22u l=2u ad=1.9320e-12 pd=7.6400e-06 as=9.0160e-13 ps=3.7800e-06 nf=1 m=2 par=2
X63 out.t18 vss.t20 cap_mim_2f0fF c_width=12.2u c_length=12.2u
Rpar0 a_1245_1041.t0 a_1245_1041.t1 24.1824
Rpar1 a_1245_1041.t0 a_1245_1041.t4 280.5126
Rpar2 a_1245_1041.t1 a_1245_1041.t4 183.9167
Rpar3 a_2066_5679.t0 a_2066_5679.t18 48.5667
Rpar4 a_2066_5679.t0 a_2066_5679.t19 59.9936
Rpar5 a_2066_5679.t18 a_2066_5679.t19 131.9632
Rpar6 a_2306_5679.t0 a_2306_5679.t16 285.6158
Rpar7 a_2306_5679.t0 a_2306_5679.t17 81.1095
Rpar8 a_2306_5679.t16 a_2306_5679.t17 18.3452
Rpar9 a_2970_7484.t0 a_2970_7484.t36 60.3918
Rpar10 a_6094_5679.t0 a_6094_5679.t1 48.5667
Rpar11 a_6094_5679.t0 a_6094_5679.t21 131.9632
Rpar12 a_6094_5679.t1 a_6094_5679.t21 59.9936
Rpar13 ib ib.t0 11.9773
Rpar14 ib ib.t1 4.1852
Rpar15 ib ib.t10 40.4612
Rpar16 inn inn.t0 2.2167
Rpar17 inp inp.t0 2.2167
Rpar18 out out.t0 65.7822
Rpar19 out out.t6 54.1652
Rpar20 out out.t18 15.4220
Rpar21 out.t0 out.t6 152.9124
Rpar22 out.t0 out.t18 748.1556
Rpar23 out.t6 out.t18 616.0325
Rpar24 vdd vdd.t0 123.9172
Rpar25 vdd vdd.t1 47.5103
Rpar26 vdd vdd.t12 78.0782
Rpar27 vdd.t0 vdd.t1 4.0861
Rpar28 vdd.t0 vdd.t12 47.4747
Rpar29 vdd.t1 vdd.t12 63.7800
Rpar30 vss vss.t0 29.5246
Rpar31 vss vss.t1 78.6694
Rpar32 vss vss.t2 177.1165
Rpar33 vss vss.t20 85.6568
Rpar34 vss.t0 vss.t1 3.5115
Rpar35 vss.t0 vss.t2 236.2144
Rpar36 vss.t0 vss.t20 124.5549
Rpar37 vss.t1 vss.t2 652.3163
Rpar38 vss.t1 vss.t20 303.5295
Rpar39 vss.t2 vss.t20 2166.3772
Cpar0 a_1245_1041.t0 vss 2.00131e-14
Cpar1 a_1245_1041.t1 vss 5.62797e-15
Cpar2 a_1245_1041.t4 vss 4.59627e-15
Cpar3 a_2066_5679.t0 vss 1.43614e-14
Cpar4 a_2066_5679.t18 vss 8.48095e-15
Cpar5 a_2066_5679.t19 vss 9.90826e-15
Cpar6 a_2306_5679.t0 vss 6.72641e-15
Cpar7 a_2306_5679.t16 vss 5.32728e-15
Cpar8 a_2306_5679.t17 vss 3.93017e-15
Cpar9 a_2970_7484.t0 vss 2.40513e-14
Cpar10 a_2970_7484.t36 vss 6.70960e-15
Cpar11 a_6094_5679.t0 vss 7.46195e-15
Cpar12 a_6094_5679.t1 vss 1.26359e-14
Cpar13 a_6094_5679.t21 vss 8.71780e-15
Cpar14 ib inn 1.42800e-17
Cpar15 ib inp 1.42800e-17
Cpar16 ib out 1.33371e-15
Cpar17 ib vdd 1.62357e-14
Cpar18 ib vss 2.00454e-14
Cpar19 ib.t0 vss 1.01263e-14
Cpar20 ib.t1 vss 1.37114e-15
Cpar21 ib.t10 vss 1.20715e-14
Cpar22 inn inp 1.03500e-16
Cpar23 inn vdd 5.25000e-17
Cpar24 inn vss 1.24064e-14
Cpar25 inn.t0 vss 4.60038e-15
Cpar26 inp vdd 8.17000e-17
Cpar27 inp vss 1.25264e-14
Cpar28 inp.t0 vss 4.61277e-15
Cpar29 out vdd 3.32078e-15
Cpar30 out vss 1.13465e-14
Cpar31 out.t0 vss 1.90578e-15
Cpar32 out.t18 vss 1.18788e-14
Cpar33 out.t6 vss 6.63522e-16
Cpar34 vdd vss 1.13474e-13
Cpar35 vdd.t0 vss 1.95570e-14
Cpar36 vdd.t1 vss 1.23852e-14
Cpar37 vdd.t12 vss 2.02231e-14
.ends opamp_dut

Vdd vdd 0 1.800000
Vss vss 0 0
Ibias vdd ib 1.166700e-06
Vinp inp 0 DC 0.985000 AC 1 PWL(0 0.985000 1.295810e-08 0.985000 1.425391e-08 0.995000)
Rfb out inn 1m
Cload out 0 2.000000e-13
Xdut vdd vss inp inn out ib opamp_dut
.end
