* opa1000[0114]: 200f/current_reuse_3v3_1u_10u_weak (current_reuse, VDD=3.3V, CL=0.2pF, Iref=0.75uA)
.include "pdk_opa.inc"
.temp 27
.option gmin=1e-12 rshunt=1e12 reltol=1e-3 abstol=1e-12 vntol=1e-5 method=gear
* Post-PEX R+C extracted netlist for current_reuse_3v3_1u_10u_weak
.subckt opamp_dut vdd vss inp inn out ib
XMpar0 out.t0 a_1041_1291.t8 vdd.t5 vdd.t4 pfet_03v3 w=2.25u l=1u ad=6.3000e-13 pd=2.8100e-06 as=7.7400e-13 ps=3.3880e-06 nf=1 m=10 par=10
XMpar1 a_1041_1291.t0 inp.t0 a_5394_4750.t0 vss.t0 nfet_03v3 w=1.44u l=1.6u ad=4.0320e-13 pd=2.0000e-06 as=8.6400e-13 ps=4.0800e-06 nf=1 m=2 par=2
XMpar2 a_1179_9120.t0 inn.t2 a_979_8912.t0 vdd.t0 pfet_03v3 w=1.59u l=1.6u ad=6.9960e-13 pd=3.2650e-06 as=4.4520e-13 ps=2.1500e-06 nf=1 m=4 par=4
XMpar3 a_1041_1291.t2 inp.t2 a_1179_9120.t0 vdd.t0 pfet_03v3 w=1.59u l=1.6u ad=4.4520e-13 pd=2.1500e-06 as=6.9960e-13 ps=3.2650e-06 nf=1 m=4 par=4
XMpar4 a_5394_4750.t2 ib.t0 vss.t3 vss.t2 nfet_03v3 w=0.69u l=2u ad=4.1400e-13 pd=2.5800e-06 as=1.9320e-13 ps=1.2500e-06 nf=1 m=4 par=4
XMpar5 out.t5 ib.t0 vss.t3 vss.t2 nfet_03v3 w=0.69u l=2u ad=3.2568e-13 pd=2.0480e-06 as=2.8152e-13 ps=1.7820e-06 nf=1 m=10 par=10
XMpar6 a_979_8912.t7 a_979_8912.t6 vdd.t5 vdd.t4 pfet_03v3 w=2.25u l=1u ad=1.3500e-12 pd=5.7000e-06 as=6.3000e-13 ps=2.8100e-06 nf=1 m=1
XMpar7 ib.t1 ib.t0 vss.t3 vss.t2 nfet_03v3 w=0.69u l=2u ad=4.1400e-13 pd=2.5800e-06 as=1.9320e-13 ps=1.2500e-06 nf=1 m=2 par=2
XMpar8 a_5394_4750.t0 inn.t0 a_979_8912.t4 vss.t0 nfet_03v3 w=1.44u l=1.6u ad=8.6400e-13 pd=4.0800e-06 as=4.0320e-13 ps=2.0000e-06 nf=1 m=2 par=2
XMpar9 a_1179_9120.t4 a_979_8912.t6 vdd.t5 vdd.t4 pfet_03v3 w=2.25u l=1u ad=6.3000e-13 pd=2.8100e-06 as=1.3500e-12 ps=5.7000e-06 nf=1 m=2 par=2
XMpar10 a_1041_1291.t6 a_979_8912.t6 vdd.t5 vdd.t4 pfet_03v3 w=2.25u l=1u ad=1.3500e-12 pd=5.7000e-06 as=6.3000e-13 ps=2.8100e-06 nf=1 m=1
X13 a_1041_1811.t0 a_3657_1291.t0 vss.t28 ppolyf_u_1k r_width=1u r_length=12.42u
X33 a_1041_1291.t7 a_3657_1291.t0 vss.t28 ppolyf_u_1k r_width=1u r_length=12.42u
X40 a_1041_1811.t1 out.t20 cap_mim_2f0fF c_width=13.83u c_length=13.83u
Rpar0 a_1041_1291.t0 a_1041_1291.t8 177.9426
Rpar1 a_1041_1291.t0 a_1041_1291.t2 192.9866
Rpar2 a_1041_1291.t0 a_1041_1291.t6 85.7328
Rpar3 a_1041_1291.t0 a_1041_1291.t7 150.2676
Rpar4 a_1041_1291.t8 a_1041_1291.t2 567.0369
Rpar5 a_1041_1291.t8 a_1041_1291.t6 251.9018
Rpar6 a_1041_1291.t8 a_1041_1291.t7 158.3206
Rpar7 a_1041_1291.t2 a_1041_1291.t6 136.5203
Rpar8 a_1041_1291.t2 a_1041_1291.t7 478.8471
Rpar9 a_1041_1291.t6 a_1041_1291.t7 212.7242
Rpar10 a_1041_1811.t0 a_1041_1811.t1 84.8924
Rpar11 a_1179_9120.t0 a_1179_9120.t4 49.1835
Rpar12 a_5394_4750.t0 a_5394_4750.t2 39.7939
Rpar13 a_979_8912.t0 a_979_8912.t6 98.1421
Rpar14 a_979_8912.t0 a_979_8912.t4 306.0884
Rpar15 a_979_8912.t0 a_979_8912.t7 249.0022
Rpar16 a_979_8912.t6 a_979_8912.t4 172.9217
Rpar17 a_979_8912.t6 a_979_8912.t7 31.6420
Rpar18 a_979_8912.t4 a_979_8912.t7 176.5480
Rpar19 ib ib.t0 13.1109
Rpar20 ib ib.t1 12.6555
Rpar21 ib.t0 ib.t1 32.1109
Rpar22 inn inn.t0 5.8786
Rpar23 inn inn.t2 63.3316
Rpar24 inp inp.t0 5.9272
Rpar25 inp inp.t2 65.0110
Rpar26 out out.t0 2.4514
Rpar27 out out.t5 71.9421
Rpar28 out out.t20 298.4733
Rpar29 out.t0 out.t5 58.4341
Rpar30 out.t0 out.t20 242.4311
Rpar31 out.t5 out.t20 183.3562
Rpar32 vdd vdd.t0 30.5326
Rpar33 vdd vdd.t4 64.7518
Rpar34 vdd vdd.t5 74.8273
Rpar35 vdd.t0 vdd.t4 216.6003
Rpar36 vdd.t0 vdd.t5 250.3037
Rpar37 vdd.t4 vdd.t5 3.3050
Rpar38 vss vss.t0 146.1478
Rpar39 vss vss.t2 173.7697
Rpar40 vss vss.t3 62.8552
Rpar41 vss vss.t28 92.3901
Rpar42 vss.t0 vss.t2 4.3863
Rpar43 vss.t0 vss.t3 23.4108
Rpar44 vss.t0 vss.t28 350.1279
Rpar45 vss.t2 vss.t3 21.9151
Rpar46 vss.t2 vss.t28 420.5328
Rpar47 vss.t3 vss.t28 166.2377
Cpar0 a_1041_1291.t0 vss 2.89154e-15
Cpar1 a_1041_1291.t2 vss 3.67248e-15
Cpar2 a_1041_1291.t6 vss 3.44984e-15
Cpar3 a_1041_1291.t7 vss 3.42144e-15
Cpar4 a_1041_1291.t8 vss 1.10364e-14
Cpar5 a_1041_1811.t0 vss 5.92100e-16
Cpar6 a_1041_1811.t1 vss 8.53592e-15
Cpar7 a_1179_9120.t0 vss 6.21879e-15
Cpar8 a_1179_9120.t4 vss 3.11345e-15
Cpar9 a_3657_1291.t0 vss 3.23400e-17
Cpar10 a_5394_4750.t0 vss 4.36014e-15
Cpar11 a_5394_4750.t2 vss 1.06515e-14
Cpar12 a_979_8912.t0 vss 5.53991e-15
Cpar13 a_979_8912.t4 vss 3.94065e-15
Cpar14 a_979_8912.t6 vss 8.08191e-15
Cpar15 a_979_8912.t7 vss 4.66918e-15
Cpar16 ib inn 1.02800e-17
Cpar17 ib out 2.30195e-15
Cpar18 ib vss 3.02824e-14
Cpar19 ib.t0 vss 5.57765e-15
Cpar20 ib.t1 vss 5.75037e-16
Cpar21 inn inp 1.03370e-16
Cpar22 inn out 6.54690e-16
Cpar23 inn vdd 3.83073e-15
Cpar24 inn vss 5.90623e-15
Cpar25 inn.t0 vss 9.65597e-16
Cpar26 inn.t2 vss 4.94656e-15
Cpar27 inp out 5.78030e-16
Cpar28 inp vdd 4.25415e-15
Cpar29 inp vss 7.18396e-15
Cpar30 inp.t0 vss 1.18965e-15
Cpar31 inp.t2 vss 6.48690e-15
Cpar32 out vdd 6.86962e-15
Cpar33 out vss 1.71731e-14
Cpar34 out.t0 vss 3.71256e-15
Cpar35 out.t20 vss 9.46369e-15
Cpar36 out.t5 vss 6.88021e-15
Cpar37 vdd vss 7.19490e-14
Cpar38 vdd.t0 vss 1.11416e-14
Cpar39 vdd.t4 vss 1.25813e-14
Cpar40 vdd.t5 vss 1.05374e-14
.ends opamp_dut

Vdd vdd 0 3.300000
Vss vss 0 0
Ibias vdd ib 7.500000e-07
Vinp inp 0 DC 1.645000 AC 1 PWL(0 1.645000 1.356027e-08 1.645000 1.491629e-08 1.655000)
Rfb out inn 1m
Cload out 0 2.000000e-13
Xdut vdd vss inp inn out ib opamp_dut
.end
