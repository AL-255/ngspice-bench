* opa1000[0566]: 2p/pmos_5t_3v3_i200n_weak (pmos_5t, VDD=3.3V, CL=2.0pF, Iref=0.046uA)
.include "pdk_opa.inc"
.temp 27
.option gmin=1e-12 rshunt=1e12 reltol=1e-3 abstol=1e-12 vntol=1e-5 method=gear
* Post-PEX R+C extracted netlist for pmos_5t_3v3_i200n_weak
.subckt opamp_dut vdd vss inp inn out ib
XMpar0 a_1834_4347.t0 a_1639_8052.t2 vdd.t1 vdd.t0 pfet_03v3 w=0.58u l=6.25u ad=1.6240e-13 pd=1.1400e-06 as=3.0160e-13 ps=2.0550e-06 nf=1 m=8 par=8
XMpar1 a_1834_4347.t4 inp.t0 a_2652_2775.t0 vdd.t9 pfet_03v3 w=1.95u l=6.5u ad=1.1700e-12 pd=5.1000e-06 as=5.4600e-13 ps=2.5100e-06 nf=1 m=6 par=6
XMpar2 a_1639_8052.t0 ib.t0 vss.t5 vss.t4 nfet_03v3 w=0.4u l=6.25u ad=1.1200e-13 pd=9.6000e-07 as=1.1200e-13 ps=9.6000e-07 nf=1 m=2 par=2
XMpar3 a_1834_4347.t4 inn.t0 out.t0 vdd.t9 pfet_03v3 w=1.95u l=6.5u ad=1.1700e-12 pd=5.1000e-06 as=5.4600e-13 ps=2.5100e-06 nf=1 m=6 par=6
XMpar4 a_2652_2775.t7 a_2652_2775.t6 vss.t1 vss.t0 nfet_03v3 w=0.4u l=5.2u ad=2.4000e-13 pd=2.0000e-06 as=1.1200e-13 ps=9.6000e-07 nf=1 m=2 par=2
XMpar5 ib.t1 ib.t0 vss.t5 vss.t4 nfet_03v3 w=0.4u l=6.25u ad=2.4000e-13 pd=2.0000e-06 as=1.1200e-13 ps=9.6000e-07 nf=1 m=2 par=2
XMpar6 out.t2 a_2652_2775.t6 vss.t1 vss.t0 nfet_03v3 w=0.4u l=5.2u ad=1.1200e-13 pd=9.6000e-07 as=1.1200e-13 ps=9.6000e-07 nf=1 m=2 par=2
XMpar7 a_1639_8052.t3 a_1639_8052.t2 vdd.t1 vdd.t0 pfet_03v3 w=0.58u l=6.25u ad=3.4800e-13 pd=2.3600e-06 as=1.6240e-13 ps=1.1400e-06 nf=1 m=2 par=2
Rpar0 a_1639_8052.t0 a_1639_8052.t2 127.6758
Rpar1 a_1639_8052.t0 a_1639_8052.t3 197.4792
Rpar2 a_1639_8052.t2 a_1639_8052.t3 15.1499
Rpar3 a_1834_4347.t0 a_1834_4347.t4 40.0212
Rpar4 a_2652_2775.t0 a_2652_2775.t6 141.5515
Rpar5 a_2652_2775.t0 a_2652_2775.t7 108.3825
Rpar6 a_2652_2775.t6 a_2652_2775.t7 21.7924
Rpar7 ib ib.t0 11.5933
Rpar8 ib ib.t1 8.8363
Rpar9 inn inn.t0 2.8667
Rpar10 inp inp.t0 2.8668
Rpar11 out out.t0 58.6368
Rpar12 out out.t2 16.2438
Rpar13 out.t0 out.t2 369.4999
Rpar14 vdd vdd.t0 24.2269
Rpar15 vdd vdd.t1 252.3608
Rpar16 vdd vdd.t9 147.2230
Rpar17 vdd.t0 vdd.t1 13.1065
Rpar18 vdd.t0 vdd.t9 68.4300
Rpar19 vdd.t1 vdd.t9 712.8052
Rpar20 vss vss.t0 60.3629
Rpar21 vss vss.t1 134.5723
Rpar22 vss vss.t4 59.5075
Rpar23 vss vss.t5 104.3456
Rpar24 vss.t0 vss.t1 27.4285
Rpar25 vss.t0 vss.t4 12.8632
Rpar26 vss.t0 vss.t5 30.3546
Rpar27 vss.t1 vss.t4 30.2939
Rpar28 vss.t1 vss.t5 77.2358
Rpar29 vss.t4 vss.t5 29.1268
Cpar0 a_1639_8052.t0 vss 6.41464e-15
Cpar1 a_1639_8052.t2 vss 4.08794e-14
Cpar2 a_1639_8052.t3 vss 8.00599e-15
Cpar3 a_1834_4347.t0 vss 1.41676e-14
Cpar4 a_1834_4347.t4 vss 2.90331e-14
Cpar5 a_2652_2775.t0 vss 7.26747e-15
Cpar6 a_2652_2775.t6 vss 7.73141e-15
Cpar7 a_2652_2775.t7 vss 2.49149e-15
Cpar8 ib vss 1.81428e-14
Cpar9 ib.t0 vss 1.97237e-15
Cpar10 ib.t1 vss 1.05990e-16
Cpar11 inn inp 1.54840e-16
Cpar12 inn out 3.96828e-15
Cpar13 inn vdd 1.55760e-14
Cpar14 inn vss 4.06623e-15
Cpar15 inn.t0 vss 1.87480e-14
Cpar16 inp vdd 1.53754e-14
Cpar17 inp vss 4.05990e-15
Cpar18 inp.t0 vss 1.85986e-14
Cpar19 out vdd 5.20396e-15
Cpar20 out vss 8.56464e-15
Cpar21 out.t0 vss 1.21859e-14
Cpar22 out.t2 vss 7.70492e-16
Cpar23 vdd vss 1.74279e-13
Cpar24 vdd.t0 vss 3.82898e-14
Cpar25 vdd.t1 vss 5.91534e-15
Cpar26 vdd.t9 vss 4.53226e-14
.ends opamp_dut

Vdd vdd 0 3.300000
Vss vss 0 0
Ibias vdd ib 4.600000e-08
Vinp inp 0 DC 1.480000 AC 1 PWL(0 1.480000 6.946433e-07 1.480000 7.641077e-07 1.490000)
Rfb out inn 1m
Cload out 0 2.000000e-12
Xdut vdd vss inp inn out ib opamp_dut
.end
