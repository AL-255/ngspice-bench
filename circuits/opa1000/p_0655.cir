* opa1000[0655]: 2p/pmos_miller_3v3_i2u_weak (pmos_miller, VDD=3.3V, CL=2.0pF, Iref=0.2625uA)
.include "pdk_opa.inc"
.temp 27
.option gmin=1e-12 rshunt=1e12 reltol=1e-3 abstol=1e-12 vntol=1e-5 method=gear
* Post-PEX R+C extracted netlist for pmos_miller_3v3_i2u_weak
.subckt opamp_dut vdd vss inp inn out ib
XMpar0 a_2989_7707.t0 inp.t0 a_815_1290.t0 vdd.t11 pfet_03v3 w=1.68u l=2.4u ad=7.3920e-13 pd=3.4000e-06 as=4.7040e-13 ps=2.2400e-06 nf=1 m=4 par=4
XMpar1 a_1837_7499.t0 ib.t0 vss.t4 vss.t3 nfet_03v3 w=0.4u l=2.6u ad=1.1200e-13 pd=9.6000e-07 as=1.1200e-13 ps=9.6000e-07 nf=1 m=2 par=2
XMpar2 out.t2 a_815_1290.t7 vss.t1 vss.t0 nfet_03v3 w=0.4u l=1.35u ad=1.3760e-13 pd=1.1680e-06 as=1.3760e-13 ps=1.1680e-06 nf=1 m=10 par=10
XMpar3 out.t0 a_1837_7499.t2 vdd.t1 vdd.t0 pfet_03v3 w=1.34u l=2.6u ad=6.3248e-13 pd=3.0880e-06 as=5.4672e-13 ps=2.6920e-06 nf=1 m=10 par=10
XMpar4 a_2989_7707.t8 a_1837_7499.t2 vdd.t1 vdd.t0 pfet_03v3 w=1.34u l=2.6u ad=8.0400e-13 pd=3.8800e-06 as=3.7520e-13 ps=1.9000e-06 nf=1 m=4 par=4
XMpar5 ib.t1 ib.t0 vss.t4 vss.t3 nfet_03v3 w=0.4u l=2.6u ad=2.4000e-13 pd=2.0000e-06 as=1.1200e-13 ps=9.6000e-07 nf=1 m=2 par=2
XMpar6 a_2989_7707.t0 inn.t0 a_6072_5794.t0 vdd.t11 pfet_03v3 w=1.68u l=2.4u ad=7.3920e-13 pd=3.4000e-06 as=4.7040e-13 ps=2.2400e-06 nf=1 m=4 par=4
XMpar7 a_815_1290.t4 a_6072_5794.t4 vss.t1 vss.t0 nfet_03v3 w=0.4u l=1.35u ad=2.4000e-13 pd=2.0000e-06 as=1.1200e-13 ps=9.6000e-07 nf=1 m=2 par=2
XMpar8 a_1837_7499.t3 a_1837_7499.t2 vdd.t1 vdd.t0 pfet_03v3 w=1.34u l=2.6u ad=8.0400e-13 pd=3.8800e-06 as=3.7520e-13 ps=1.9000e-06 nf=1 m=2 par=2
XMpar9 a_6072_5794.t5 a_6072_5794.t4 vss.t1 vss.t0 nfet_03v3 w=0.4u l=1.35u ad=1.1200e-13 pd=9.6000e-07 as=1.1200e-13 ps=9.6000e-07 nf=1 m=2 par=2
X7 a_815_2850.t0 a_4231_2330.t0 vss.t2 ppolyf_u_1k r_width=1u r_length=16.42u
X13 a_815_1810.t0 a_4231_2330.t0 vss.t2 ppolyf_u_1k r_width=1u r_length=16.42u
X17 a_815_1810.t0 a_4231_1290.t0 vss.t2 ppolyf_u_1k r_width=1u r_length=16.42u
X28 a_815_2850.t1 out.t14 cap_mim_2f0fF c_width=15.29u c_length=15.29u
X37 a_815_1290.t6 a_4231_1290.t0 vss.t2 ppolyf_u_1k r_width=1u r_length=16.42u
X39 a_815_2850.t1 out.t14 cap_mim_2f0fF c_width=15.29u c_length=15.29u
Rpar0 a_1837_7499.t0 a_1837_7499.t2 114.6053
Rpar1 a_1837_7499.t0 a_1837_7499.t3 89.4362
Rpar2 a_1837_7499.t2 a_1837_7499.t3 14.5583
Rpar3 a_2989_7707.t0 a_2989_7707.t8 49.8138
Rpar4 a_6072_5794.t0 a_6072_5794.t4 111.9077
Rpar5 a_6072_5794.t0 a_6072_5794.t5 110.9767
Rpar6 a_6072_5794.t4 a_6072_5794.t5 30.8856
Rpar7 a_815_1290.t0 a_815_1290.t7 123.8564
Rpar8 a_815_1290.t0 a_815_1290.t4 496.5919
Rpar9 a_815_1290.t0 a_815_1290.t6 541.6459
Rpar10 a_815_1290.t7 a_815_1290.t4 75.5182
Rpar11 a_815_1290.t7 a_815_1290.t6 90.7129
Rpar12 a_815_1290.t4 a_815_1290.t6 363.7060
Rpar13 a_815_2850.t0 a_815_2850.t1 60.9319
Rpar14 ib ib.t0 15.8947
Rpar15 ib ib.t1 8.9013
Rpar16 ib.t0 ib.t1 108.6432
Rpar17 inn inn.t0 2.4741
Rpar18 inp inp.t0 2.5227
Rpar19 out out.t0 72.9162
Rpar20 out out.t2 4.3693
Rpar21 out out.t14 142.8921
Rpar22 out.t0 out.t2 219.5759
Rpar23 out.t0 out.t14 319.6532
Rpar24 out.t2 out.t14 430.2976
Rpar25 vdd vdd.t0 87.5116
Rpar26 vdd vdd.t1 1219.0554
Rpar27 vdd vdd.t11 39.3380
Rpar28 vdd.t0 vdd.t1 11.9597
Rpar29 vdd.t0 vdd.t11 107.6834
Rpar30 vdd.t1 vdd.t11 1500.0533
Rpar31 vss vss.t0 184.9195
Rpar32 vss vss.t1 60.0014
Rpar33 vss vss.t4 671.0838
Rpar34 vss vss.t2 53.2391
Rpar35 vss vss.t3 685.4486
Rpar36 vss.t0 vss.t1 10.3837
Rpar37 vss.t0 vss.t4 164.1747
Rpar38 vss.t0 vss.t2 492.7541
Rpar39 vss.t0 vss.t3 165.3861
Rpar40 vss.t1 vss.t4 131.4598
Rpar41 vss.t1 vss.t2 263.9892
Rpar42 vss.t1 vss.t3 132.9230
Rpar43 vss.t4 vss.t2 4106.0001
Rpar44 vss.t4 vss.t3 19.6722
Rpar45 vss.t2 vss.t3 4185.5101
Cpar0 a_1837_7499.t0 vss 2.84969e-15
Cpar1 a_1837_7499.t2 vss 3.51095e-14
Cpar2 a_1837_7499.t3 vss 6.60638e-15
Cpar3 a_2989_7707.t0 vss 8.99848e-15
Cpar4 a_2989_7707.t8 vss 1.59279e-14
Cpar5 a_4231_1290.t0 vss 4.25800e-17
Cpar6 a_4231_2330.t0 vss 4.42800e-17
Cpar7 a_6072_5794.t0 vss 2.72093e-15
Cpar8 a_6072_5794.t4 vss 2.72357e-15
Cpar9 a_6072_5794.t5 vss 1.12251e-15
Cpar10 a_815_1290.t0 vss 2.19006e-15
Cpar11 a_815_1290.t4 vss 1.25388e-15
Cpar12 a_815_1290.t6 vss 1.60321e-15
Cpar13 a_815_1290.t7 vss 5.08442e-15
Cpar14 a_815_1810.t0 vss 3.78600e-17
Cpar15 a_815_2850.t0 vss 1.00257e-16
Cpar16 a_815_2850.t1 vss 5.03946e-15
Cpar17 ib vss 9.24969e-15
Cpar18 ib.t0 vss 1.02667e-15
Cpar19 ib.t1 vss 7.38642e-17
Cpar20 inn inp 5.14200e-17
Cpar21 inn vdd 5.07424e-15
Cpar22 inn vss 2.74048e-15
Cpar23 inn.t0 vss 4.00966e-15
Cpar24 inp vdd 5.18296e-15
Cpar25 inp vss 2.70464e-15
Cpar26 inp.t0 vss 4.11802e-15
Cpar27 out vdd 1.06630e-14
Cpar28 out vss 3.32287e-14
Cpar29 out.t0 vss 5.93509e-15
Cpar30 out.t14 vss 1.50151e-14
Cpar31 out.t2 vss 1.68615e-15
Cpar32 vdd vss 1.13843e-13
Cpar33 vdd.t0 vss 3.85342e-14
Cpar34 vdd.t1 vss 4.90707e-15
Cpar35 vdd.t11 vss 1.40892e-14
.ends opamp_dut

Vdd vdd 0 3.300000
Vss vss 0 0
Ibias vdd ib 2.625000e-07
Vinp inp 0 DC 1.480000 AC 1 PWL(0 1.480000 1.413271e-07 1.480000 1.554599e-07 1.490000)
Rfb out inn 1m
Cload out 0 2.000000e-12
Xdut vdd vss inp inn out ib opamp_dut
.end
