* opa1000[0767]: 200f/symmetrical_ota_1v8_10u_100u_subth (symmetrical_ota, VDD=1.8V, CL=0.2pF, Iref=9.5833uA)
.include "pdk_opa.inc"
.temp 27
.option gmin=1e-12 rshunt=1e12 reltol=1e-3 abstol=1e-12 vntol=1e-5 method=gear
* Post-PEX R+C extracted netlist for symmetrical_ota_1v8_10u_100u_subth
.subckt opamp_dut vdd vss inp inn out ib
XMpar0 ib.t1 ib.t0 vss.t47 vss.t46 nfet_03v3 w=10u l=1.25u ad=2.8000e-12 pd=1.0560e-05 as=2.8000e-12 ps=1.0560e-05 nf=1 m=2 par=2
XMpar1 a_1470_1205.t0 inp.t0 a_1676_1205.t0 vss.t0 nfet_03v3 w=2.01u l=0.28u ad=8.9493e-13 pd=2.9962e-06 as=8.9493e-13 ps=2.9962e-06 nf=1 m=42 par=42
XMpar2 a_1470_1205.t0 inn.t0 a_6574_1205.t0 vss.t0 nfet_03v3 w=2.01u l=0.28u ad=8.9493e-13 pd=2.9962e-06 as=8.9493e-13 ps=2.9962e-06 nf=1 m=42 par=42
XMpar3 a_5748_3838.t1 a_5748_3838.t0 vss.t43 vss.t0 nfet_03v3 w=4.61u l=0.6u ad=1.2908e-12 pd=5.1700e-06 as=1.2908e-12 ps=5.1700e-06 nf=1 m=4 par=4
XMpar4 a_5748_3838.t8 a_6574_1205.t42 vdd.t1 vdd.t0 pfet_03v3 w=10u l=0.6u ad=2.8000e-12 pd=1.0560e-05 as=4.4000e-12 ps=1.5880e-05 nf=1 m=4 par=4
XMpar5 out.t1 a_1676_1205.t42 vdd.t1 vdd.t0 pfet_03v3 w=10u l=0.6u ad=2.8000e-12 pd=1.0560e-05 as=4.4000e-12 ps=1.5880e-05 nf=1 m=4 par=4
XMpar6 a_1676_1205.t43 a_1676_1205.t42 vdd.t1 vdd.t0 pfet_03v3 w=10u l=0.6u ad=2.8000e-12 pd=1.0560e-05 as=2.8000e-12 ps=1.0560e-05 nf=1 m=2 par=2
XMpar7 a_1470_1205.t84 ib.t0 vss.t47 vss.t46 nfet_03v3 w=10u l=1.25u ad=2.8000e-12 pd=1.0560e-05 as=4.4000e-12 ps=1.5880e-05 nf=1 m=4 par=4
XMpar8 out.t0 a_5748_3838.t0 vss.t43 vss.t0 nfet_03v3 w=4.61u l=0.6u ad=1.2908e-12 pd=5.1700e-06 as=2.0284e-12 ps=7.7950e-06 nf=1 m=4 par=4
XMpar9 a_6574_1205.t43 a_6574_1205.t42 vdd.t1 vdd.t0 pfet_03v3 w=10u l=0.6u ad=2.8000e-12 pd=1.0560e-05 as=2.8000e-12 ps=1.0560e-05 nf=1 m=2 par=2
X10 out.t8 vss.t58 cap_mim_2f0fF c_width=16.2u c_length=16.21u
X78 out.t8 vss.t58 cap_mim_2f0fF c_width=16.2u c_length=16.21u
Rpar0 a_1470_1205.t0 a_1470_1205.t84 60.1359
Rpar1 a_1676_1205.t0 a_1676_1205.t42 183.8881
Rpar2 a_1676_1205.t0 a_1676_1205.t43 49.8652
Rpar3 a_1676_1205.t42 a_1676_1205.t43 37.8555
Rpar4 a_5748_3838.t0 a_5748_3838.t1 22.8438
Rpar5 a_5748_3838.t0 a_5748_3838.t8 250.9845
Rpar6 a_5748_3838.t1 a_5748_3838.t8 42.6240
Rpar7 a_6574_1205.t0 a_6574_1205.t42 227.4275
Rpar8 a_6574_1205.t0 a_6574_1205.t43 61.6719
Rpar9 a_6574_1205.t42 a_6574_1205.t43 36.7172
Rpar10 ib ib.t0 23.8657
Rpar11 ib ib.t1 7.4354
Rpar12 ib.t0 ib.t1 139.4728
Rpar13 inn inn.t0 2.6895
Rpar14 inp inp.t0 2.6895
Rpar15 out out.t0 64.7242
Rpar16 out out.t1 3.1254
Rpar17 out out.t8 223.2601
Rpar18 out.t0 out.t8 152.8274
Rpar19 vdd vdd.t0 112.7941
Rpar20 vdd vdd.t1 242.7577
Rpar21 vdd.t0 vdd.t1 3.4733
Rpar22 vss vss.t0 57.2796
Rpar23 vss vss.t43 1061.8710
Rpar24 vss vss.t46 1162.5345
Rpar25 vss vss.t47 2073.9672
Rpar26 vss vss.t58 126.6870
Rpar27 vss.t0 vss.t43 4.6533
Rpar28 vss.t0 vss.t46 43.9929
Rpar29 vss.t0 vss.t47 78.9329
Rpar30 vss.t0 vss.t58 72.6116
Rpar31 vss.t43 vss.t46 308.2860
Rpar32 vss.t43 vss.t47 550.2941
Rpar33 vss.t43 vss.t58 1346.1012
Rpar34 vss.t46 vss.t47 7.2404
Rpar35 vss.t46 vss.t58 1473.7091
Rpar36 vss.t47 vss.t58 2629.1043
Cpar0 a_1470_1205.t0 vss 4.38297e-14
Cpar1 a_1470_1205.t84 vss 9.07481e-15
Cpar2 a_1676_1205.t0 vss 2.30432e-14
Cpar3 a_1676_1205.t42 vss 7.68815e-15
Cpar4 a_1676_1205.t43 vss 6.19153e-15
Cpar5 a_5748_3838.t0 vss 3.77132e-15
Cpar6 a_5748_3838.t1 vss 3.29287e-15
Cpar7 a_5748_3838.t8 vss 4.39633e-15
Cpar8 a_6574_1205.t0 vss 2.43318e-14
Cpar9 a_6574_1205.t42 vss 7.96211e-15
Cpar10 a_6574_1205.t43 vss 6.30962e-15
Cpar11 ib out 2.29970e-16
Cpar12 ib vdd 4.13600e-17
Cpar13 ib vss 1.20553e-14
Cpar14 ib.t0 vss 2.15172e-15
Cpar15 ib.t1 vss 4.60709e-16
Cpar16 inn inp 1.00030e-16
Cpar17 inn out 3.47800e-17
Cpar18 inn vss 1.99313e-14
Cpar19 inn.t0 vss 5.27464e-15
Cpar20 inp vss 2.00510e-14
Cpar21 inp.t0 vss 5.25103e-15
Cpar22 out vdd 9.93192e-15
Cpar23 out vss 2.41839e-14
Cpar24 out.t0 vss 5.66572e-16
Cpar25 out.t1 vss 4.09690e-16
Cpar26 out.t8 vss 1.48659e-14
Cpar27 vdd vss 7.08611e-14
Cpar28 vdd.t0 vss 1.76235e-14
Cpar29 vdd.t1 vss 1.11128e-14
.ends opamp_dut

Vdd vdd 0 1.800000
Vss vss 0 0
Ibias vdd ib 9.583300e-06
Vinp inp 0 DC 0.895000 AC 1 PWL(0 0.895000 3.000000e-09 0.895000 3.300000e-09 0.905000)
Rfb out inn 1m
Cload out 0 2.000000e-13
Xdut vdd vss inp inn out ib opamp_dut
.end
