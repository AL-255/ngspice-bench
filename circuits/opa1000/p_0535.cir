* opa1000[0535]: 200f/pmos_5t_3v3_i20u_subth (pmos_5t, VDD=3.3V, CL=0.2pF, Iref=4.0uA)
.include "pdk_opa.inc"
.temp 27
.option gmin=1e-12 rshunt=1e12 reltol=1e-3 abstol=1e-12 vntol=1e-5 method=gear
* Post-PEX R+C extracted netlist for pmos_5t_3v3_i20u_subth
.subckt opamp_dut vdd vss inp inn out ib
XMpar0 a_1478_1204.t128 a_1238_996.t2 vdd.t1 vdd.t0 pfet_03v3 w=10u l=1.2u ad=2.8000e-12 pd=1.0560e-05 as=3.6000e-12 ps=1.3220e-05 nf=1 m=8 par=8
XMpar1 a_1478_1204.t0 inp.t0 a_1984_8310.t20 vdd.t4 pfet_03v3 w=8u l=0.65u ad=2.4000e-12 pd=9.1000e-06 as=2.3200e-12 ps=8.8300e-06 nf=1 m=64 par=64
XMpar2 a_1478_1204.t0 inn.t0 out.t0 vdd.t4 pfet_03v3 w=8u l=0.65u ad=2.4000e-12 pd=9.1000e-06 as=2.3200e-12 ps=8.8300e-06 nf=1 m=64 par=64
XMpar3 a_1984_8310.t1 a_1984_8310.t0 vss.t1 vss.t0 nfet_03v3 w=2.08u l=1.35u ad=7.1552e-13 pd=3.1840e-06 as=5.8240e-13 ps=2.6400e-06 nf=1 m=10 par=10
XMpar4 out.t12 a_1984_8310.t0 vss.t1 vss.t0 nfet_03v3 w=2.08u l=1.35u ad=5.8240e-13 pd=2.6400e-06 as=5.8240e-13 ps=2.6400e-06 nf=1 m=10 par=10
XMpar5 ib.t1 ib.t0 vss.t8 vss.t7 nfet_03v3 w=5.93u l=1.2u ad=3.5580e-12 pd=1.3060e-05 as=1.6604e-12 ps=6.4900e-06 nf=1 m=2 par=2
XMpar6 a_1238_996.t0 ib.t0 vss.t8 vss.t7 nfet_03v3 w=5.93u l=1.2u ad=1.6604e-12 pd=6.4900e-06 as=1.6604e-12 ps=6.4900e-06 nf=1 m=2 par=2
XMpar7 a_1238_996.t3 a_1238_996.t2 vdd.t1 vdd.t0 pfet_03v3 w=10u l=1.2u ad=2.8000e-12 pd=1.0560e-05 as=2.8000e-12 ps=1.0560e-05 nf=1 m=2 par=2
X137 out.t74 vss.t2 cap_mim_2f0fF c_width=17.75u c_length=17.75u
Rpar0 a_1238_996.t0 a_1238_996.t2 128.2070
Rpar1 a_1238_996.t0 a_1238_996.t3 43.9365
Rpar2 a_1238_996.t2 a_1238_996.t3 27.3184
Rpar3 a_1478_1204.t0 a_1478_1204.t128 58.7647
Rpar4 a_1984_8310.t0 a_1984_8310.t1 14.1625
Rpar5 a_1984_8310.t0 a_1984_8310.t20 295.0817
Rpar6 a_1984_8310.t1 a_1984_8310.t20 72.7107
Rpar7 ib ib.t0 18.2717
Rpar8 ib ib.t1 3.4112
Rpar9 inn inn.t0 2.8229
Rpar10 inp inp.t0 2.8229
Rpar11 out out.t0 112.0289
Rpar12 out out.t12 53.2345
Rpar13 out out.t74 16.0105
Rpar14 out.t0 out.t12 54.9828
Rpar15 out.t0 out.t74 908.4907
Rpar16 out.t12 out.t74 431.7016
Rpar17 vdd vdd.t0 248.3950
Rpar18 vdd vdd.t1 903.7374
Rpar19 vdd vdd.t4 22.8827
Rpar20 vdd.t0 vdd.t1 5.6661
Rpar21 vdd.t0 vdd.t4 110.9814
Rpar22 vdd.t1 vdd.t4 403.7845
Rpar23 vss vss.t0 58.5720
Rpar24 vss vss.t1 330.7200
Rpar25 vss vss.t8 388.0928
Rpar26 vss vss.t7 222.9533
Rpar27 vss vss.t2 100.5363
Rpar28 vss.t0 vss.t1 4.9935
Rpar29 vss.t0 vss.t8 10.5180
Rpar30 vss.t0 vss.t7 2.2426
Rpar31 vss.t0 vss.t2 88.2797
Rpar32 vss.t1 vss.t8 102.1677
Rpar33 vss.t1 vss.t7 25.3466
Rpar34 vss.t1 vss.t2 498.4611
Rpar35 vss.t8 vss.t7 24.4518
Rpar36 vss.t8 vss.t2 584.9334
Rpar37 vss.t7 vss.t2 336.0351
Cpar0 a_1238_996.t0 vss 2.26827e-15
Cpar1 a_1238_996.t2 vss 1.65764e-14
Cpar2 a_1238_996.t3 vss 3.94535e-15
Cpar3 a_1478_1204.t0 vss 1.89604e-13
Cpar4 a_1478_1204.t128 vss 1.71100e-14
Cpar5 a_1984_8310.t0 vss 2.00159e-14
Cpar6 a_1984_8310.t1 vss 9.15074e-15
Cpar7 a_1984_8310.t20 vss 8.34342e-14
Cpar8 ib out 2.53400e-17
Cpar9 ib vdd 2.13040e-16
Cpar10 ib vss 8.81742e-15
Cpar11 ib.t0 vss 8.63836e-16
Cpar12 ib.t1 vss 4.43210e-16
Cpar13 inn inp 1.00620e-16
Cpar14 inn out 1.94251e-14
Cpar15 inn vdd 2.79010e-14
Cpar16 inn vss 1.06461e-14
Cpar17 inn.t0 vss 5.41936e-14
Cpar18 inp vdd 2.79825e-14
Cpar19 inp vss 1.06781e-14
Cpar20 inp.t0 vss 5.41984e-14
Cpar21 out vdd 9.54585e-15
Cpar22 out vss 1.98876e-14
Cpar23 out.t0 vss 4.44413e-14
Cpar24 out.t12 vss 4.45671e-15
Cpar25 out.t74 vss 5.73338e-14
Cpar26 vdd vss 3.54382e-13
Cpar27 vdd.t0 vss 1.32508e-14
Cpar28 vdd.t1 vss 5.94797e-15
Cpar29 vdd.t4 vss 8.78850e-14
.ends opamp_dut

Vdd vdd 0 3.300000
Vss vss 0 0
Ibias vdd ib 4.000000e-06
Vinp inp 0 DC 1.480000 AC 1 PWL(0 1.480000 4.424843e-09 1.480000 4.867327e-09 1.490000)
Rfb out inn 1m
Cload out 0 2.000000e-13
Xdut vdd vss inp inn out ib opamp_dut
.end
