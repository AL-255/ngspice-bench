* opa1000[0806]: 2p/symmetrical_ota_1v8_i20u_weak (symmetrical_ota, VDD=1.8V, CL=2.0pF, Iref=3.3333uA)
.include "pdk_opa.inc"
.temp 27
.option gmin=1e-12 rshunt=1e12 reltol=1e-3 abstol=1e-12 vntol=1e-5 method=gear
* Post-PEX R+C extracted netlist for symmetrical_ota_1v8_i20u_weak
.subckt opamp_dut vdd vss inp inn out ib
XMpar0 a_1696_8034.t8 ib.t0 vss.t22 vss.t21 nfet_03v3 w=2.67u l=1.8u ad=7.4760e-13 pd=3.2300e-06 as=1.1748e-12 ps=4.8850e-06 nf=1 m=4 par=4
XMpar1 a_1696_8034.t0 inn.t0 a_5434_4284.t0 vss.t7 nfet_03v3 w=2.06u l=0.9u ad=9.0640e-13 pd=3.9700e-06 as=5.7680e-13 ps=2.6200e-06 nf=1 m=4 par=4
XMpar2 a_3164_5909.t1 a_3164_5909.t0 vss.t2 vss.t1 nfet_03v3 w=1.69u l=2.03u ad=4.7320e-13 pd=2.2500e-06 as=4.7320e-13 ps=2.2500e-06 nf=1 m=4 par=4
XMpar3 out.t1 a_3164_5909.t0 vss.t2 vss.t1 nfet_03v3 w=1.69u l=2.03u ad=4.7320e-13 pd=2.2500e-06 as=7.4360e-13 ps=3.4150e-06 nf=1 m=4 par=4
XMpar4 a_5434_4284.t5 a_5434_4284.t4 vdd.t1 vdd.t0 pfet_03v3 w=7.27u l=2.03u ad=2.0356e-12 pd=7.8300e-06 as=2.0356e-12 ps=7.8300e-06 nf=1 m=2 par=2
XMpar5 a_1336_1041.t5 a_1336_1041.t4 vdd.t1 vdd.t0 pfet_03v3 w=7.27u l=2.03u ad=2.0356e-12 pd=7.8300e-06 as=2.0356e-12 ps=7.8300e-06 nf=1 m=2 par=2
XMpar6 a_1336_1041.t0 inp.t0 a_1696_8034.t0 vss.t7 nfet_03v3 w=2.06u l=0.9u ad=5.7680e-13 pd=2.6200e-06 as=9.0640e-13 ps=3.9700e-06 nf=1 m=4 par=4
XMpar7 ib.t1 ib.t0 vss.t22 vss.t21 nfet_03v3 w=2.67u l=1.8u ad=7.4760e-13 pd=3.2300e-06 as=7.4760e-13 ps=3.2300e-06 nf=1 m=2 par=2
XMpar8 out.t0 a_1336_1041.t4 vdd.t1 vdd.t0 pfet_03v3 w=7.27u l=2.03u ad=2.0356e-12 pd=7.8300e-06 as=3.1988e-12 ps=1.1785e-05 nf=1 m=4 par=4
XMpar9 a_3164_5909.t8 a_5434_4284.t4 vdd.t1 vdd.t0 pfet_03v3 w=7.27u l=2.03u ad=2.0356e-12 pd=7.8300e-06 as=3.1988e-12 ps=1.1785e-05 nf=1 m=4 par=4
X20 out.t8 vss.t0 cap_mim_2f0fF c_width=9.69u c_length=9.68u
Rpar0 a_1336_1041.t0 a_1336_1041.t4 120.2878
Rpar1 a_1336_1041.t0 a_1336_1041.t5 63.6715
Rpar2 a_1336_1041.t4 a_1336_1041.t5 25.2787
Rpar3 a_1696_8034.t0 a_1696_8034.t8 54.8644
Rpar4 a_3164_5909.t0 a_3164_5909.t1 18.8273
Rpar5 a_3164_5909.t0 a_3164_5909.t8 260.5047
Rpar6 a_3164_5909.t1 a_3164_5909.t8 79.6748
Rpar7 a_5434_4284.t0 a_5434_4284.t4 120.2878
Rpar8 a_5434_4284.t0 a_5434_4284.t5 63.6715
Rpar9 a_5434_4284.t4 a_5434_4284.t5 25.2787
Rpar10 ib ib.t0 12.6663
Rpar11 ib ib.t1 8.5007
Rpar12 inn inn.t0 5.0511
Rpar13 inp inp.t0 5.4431
Rpar14 out out.t0 66.7903
Rpar15 out out.t1 5.6558
Rpar16 out out.t8 169.7692
Rpar17 out.t0 out.t1 143.4461
Rpar18 out.t0 out.t8 245.5592
Rpar19 out.t1 out.t8 364.6147
Rpar20 vdd vdd.t0 114.6686
Rpar21 vdd vdd.t1 247.4294
Rpar22 vdd.t0 vdd.t1 3.1847
Rpar23 vss vss.t0 482.1497
Rpar24 vss vss.t1 202.2078
Rpar25 vss vss.t7 217.8057
Rpar26 vss vss.t2 1130.5059
Rpar27 vss vss.t21 410.8561
Rpar28 vss vss.t22 1038.1945
Rpar29 vss.t0 vss.t1 189.9444
Rpar30 vss.t0 vss.t7 235.1299
Rpar31 vss.t0 vss.t2 1119.1734
Rpar32 vss.t0 vss.t21 214.4762
Rpar33 vss.t0 vss.t22 485.2551
Rpar34 vss.t1 vss.t7 1.9934
Rpar35 vss.t1 vss.t2 11.0381
Rpar36 vss.t1 vss.t21 2.0776
Rpar37 vss.t1 vss.t22 21.2744
Rpar38 vss.t7 vss.t2 10.5341
Rpar39 vss.t7 vss.t21 3.7316
Rpar40 vss.t7 vss.t22 27.3020
Rpar41 vss.t2 vss.t21 35.0892
Rpar42 vss.t2 vss.t22 117.6444
Rpar43 vss.t21 vss.t22 8.4726
Cpar0 a_1336_1041.t0 vss 2.33881e-15
Cpar1 a_1336_1041.t4 vss 1.31543e-14
Cpar2 a_1336_1041.t5 vss 3.42620e-15
Cpar3 a_1696_8034.t0 vss 5.85394e-15
Cpar4 a_1696_8034.t8 vss 4.30965e-15
Cpar5 a_3164_5909.t0 vss 6.05244e-15
Cpar6 a_3164_5909.t1 vss 2.05456e-15
Cpar7 a_3164_5909.t8 vss 3.96097e-15
Cpar8 a_5434_4284.t0 vss 2.37297e-15
Cpar9 a_5434_4284.t4 vss 1.33463e-14
Cpar10 a_5434_4284.t5 vss 3.47624e-15
Cpar11 ib out 7.20200e-17
Cpar12 ib vss 1.09142e-14
Cpar13 ib.t0 vss 1.62218e-15
Cpar14 ib.t1 vss 1.69097e-16
Cpar15 inn inp 5.21200e-17
Cpar16 inn vdd 9.22000e-17
Cpar17 inn vss 3.21790e-15
Cpar18 inn.t0 vss 5.32728e-16
Cpar19 inp out 4.90500e-17
Cpar20 inp vdd 1.65400e-17
Cpar21 inp vss 3.17678e-15
Cpar22 inp.t0 vss 5.60521e-16
Cpar23 out vdd 4.97684e-15
Cpar24 out vss 1.35161e-14
Cpar25 out.t0 vss 2.12140e-15
Cpar26 out.t1 vss 5.43021e-16
Cpar27 out.t8 vss 9.97594e-15
Cpar28 vdd vss 8.29375e-14
Cpar29 vdd.t0 vss 2.00205e-14
Cpar30 vdd.t1 vss 1.07823e-14
.ends opamp_dut

Vdd vdd 0 1.800000
Vss vss 0 0
Ibias vdd ib 3.333300e-06
Vinp inp 0 DC 0.895000 AC 1 PWL(0 0.895000 1.314243e-08 0.895000 1.445667e-08 0.905000)
Rfb out inn 1m
Cload out 0 2.000000e-12
Xdut vdd vss inp inn out ib opamp_dut
.end
