* opa1000[0904]: 2p/telescopic_nmos_3v3_i2u_weak (telescopic_nmos, VDD=3.3V, CL=2.0pF, Iref=0.575uA)
.include "pdk_opa.inc"
.temp 27
.option gmin=1e-12 rshunt=1e12 reltol=1e-3 abstol=1e-12 vntol=1e-5 method=gear
* Post-PEX R+C extracted netlist for telescopic_nmos_3v3_i2u_weak
.subckt opamp_dut vdd vss inp inn out ib
XMpar0 a_4526_9086.t0 a_1860_8878.t0 out.t0 vdd.t2 pfet_03v3 w=1.79u l=1.95u ad=6.1576e-13 pd=2.8360e-06 as=5.0120e-13 ps=2.3500e-06 nf=1 m=10 par=10
XMpar1 a_1678_1249.t8 inp.t0 a_2698_1249.t0 vss.t0 nfet_03v3 w=1.8u l=4.5u ad=6.6857e-13 pd=3.0571e-06 as=5.8629e-13 ps=2.7086e-06 nf=1 m=14 par=14
XMpar2 a_4526_9086.t2 a_1860_8878.t36 vdd.t1 vdd.t0 pfet_03v3 w=1.91u l=2.72u ad=5.3480e-13 pd=2.4700e-06 as=5.3480e-13 ps=2.4700e-06 nf=1 m=4 par=4
XMpar3 a_1678_1249.t8 inn.t0 a_6534_6930.t1 vss.t0 nfet_03v3 w=1.8u l=4.5u ad=6.6857e-13 pd=3.0571e-06 as=5.8629e-13 ps=2.7086e-06 nf=1 m=14 par=14
XMpar4 a_1678_1249.t0 ib.t0 vss.t1 vss.t0 nfet_03v3 w=0.93u l=3.25u ad=2.6040e-13 pd=1.4900e-06 as=3.3480e-13 ps=1.8825e-06 nf=1 m=8 par=8
XMpar5 a_1740_9086.t1 a_1860_8878.t0 a_1860_8878.t1 vdd.t2 pfet_03v3 w=1.79u l=1.95u ad=6.1576e-13 pd=2.8360e-06 as=6.1576e-13 ps=2.8360e-06 nf=1 m=10 par=10
XMpar6 ib.t1 ib.t0 vss.t1 vss.t0 nfet_03v3 w=0.93u l=3.25u ad=2.6040e-13 pd=1.4900e-06 as=2.6040e-13 ps=1.4900e-06 nf=1 m=2 par=2
XMpar7 a_1740_9086.t0 a_1860_8878.t36 vdd.t1 vdd.t0 pfet_03v3 w=1.91u l=2.72u ad=5.3480e-13 pd=2.4700e-06 as=8.4040e-13 ps=3.7450e-06 nf=1 m=4 par=4
XMpar8 a_6534_6930.t0 a_1860_8878.t20 out.t6 vss.t0 nfet_03v3 w=2.08u l=1.95u ad=1.2480e-12 pd=5.3600e-06 as=5.8240e-13 ps=2.6400e-06 nf=1 m=2 par=2
XMpar9 a_1860_8878.t21 a_1860_8878.t20 a_2698_1249.t14 vss.t0 nfet_03v3 w=2.08u l=1.95u ad=1.2480e-12 pd=5.3600e-06 as=1.2480e-12 ps=5.3600e-06 nf=1 m=2 par=2
X63 out.t12 vss.t30 cap_mim_2f0fF c_width=11.18u c_length=11.18u
Rpar0 a_1678_1249.t0 a_1678_1249.t8 38.9051
Rpar1 a_1740_9086.t0 a_1740_9086.t1 60.0589
Rpar2 a_1860_8878.t0 a_1860_8878.t1 16.0385
Rpar3 a_1860_8878.t0 a_1860_8878.t20 1174.0213
Rpar4 a_1860_8878.t0 a_1860_8878.t21 450.3167
Rpar5 a_1860_8878.t0 a_1860_8878.t36 222.5126
Rpar6 a_1860_8878.t1 a_1860_8878.t20 369.7123
Rpar7 a_1860_8878.t1 a_1860_8878.t21 141.8097
Rpar8 a_1860_8878.t1 a_1860_8878.t36 70.0717
Rpar9 a_1860_8878.t20 a_1860_8878.t21 20.2212
Rpar10 a_1860_8878.t20 a_1860_8878.t36 719.9475
Rpar11 a_1860_8878.t21 a_1860_8878.t36 276.1487
Rpar12 a_2698_1249.t0 a_2698_1249.t14 71.9672
Rpar13 a_4526_9086.t0 a_4526_9086.t2 53.5189
Rpar14 a_6534_6930.t0 a_6534_6930.t1 121.1022
Rpar15 ib ib.t0 11.1423
Rpar16 ib ib.t1 15.8001
Rpar17 inn inn.t0 1.7228
Rpar18 inp inp.t0 1.7228
Rpar19 out out.t0 29.7512
Rpar20 out out.t6 72.9521
Rpar21 out out.t12 14.7289
Rpar22 out.t0 out.t6 127.5721
Rpar23 vdd vdd.t0 41.0889
Rpar24 vdd vdd.t1 62.9143
Rpar25 vdd vdd.t2 81.8079
Rpar26 vdd.t0 vdd.t1 7.5242
Rpar27 vdd.t0 vdd.t2 64.8567
Rpar28 vdd.t1 vdd.t2 99.3070
Rpar29 vss vss.t0 47.8324
Rpar30 vss vss.t1 1077.0760
Rpar31 vss vss.t30 321.6743
Rpar32 vss.t0 vss.t1 4.9813
Rpar33 vss.t0 vss.t30 44.0612
Rpar34 vss.t1 vss.t30 992.1576
Cpar0 a_1678_1249.t0 vss 7.29512e-15
Cpar1 a_1678_1249.t8 vss 2.82269e-14
Cpar2 a_1740_9086.t0 vss 8.68538e-15
Cpar3 a_1740_9086.t1 vss 1.25817e-14
Cpar4 a_1860_8878.t0 vss 2.75232e-14
Cpar5 a_1860_8878.t1 vss 8.63614e-15
Cpar6 a_1860_8878.t20 vss 6.81733e-15
Cpar7 a_1860_8878.t21 vss 4.82935e-15
Cpar8 a_1860_8878.t36 vss 1.65508e-14
Cpar9 a_2698_1249.t0 vss 1.65953e-14
Cpar10 a_2698_1249.t14 vss 6.95092e-15
Cpar11 a_4526_9086.t0 vss 1.45997e-14
Cpar12 a_4526_9086.t2 vss 9.30419e-15
Cpar13 a_6534_6930.t0 vss 9.29797e-15
Cpar14 a_6534_6930.t1 vss 1.78365e-14
Cpar15 ib inp 3.46200e-17
Cpar16 ib vss 2.42663e-14
Cpar17 ib.t0 vss 3.60693e-15
Cpar18 ib.t1 vss 1.62472e-16
Cpar19 inn inp 1.12690e-16
Cpar20 inn vss 2.66245e-14
Cpar21 inn.t0 vss 1.00254e-14
Cpar22 inp vss 2.63908e-14
Cpar23 inp.t0 vss 1.00864e-14
Cpar24 out vdd 7.38077e-15
Cpar25 out vss 9.35624e-15
Cpar26 out.t0 vss 2.22831e-15
Cpar27 out.t12 vss 1.40244e-14
Cpar28 out.t6 vss 8.90750e-16
Cpar29 vdd vss 1.11122e-13
Cpar30 vdd.t0 vss 9.49892e-15
Cpar31 vdd.t1 vss 6.59620e-15
Cpar32 vdd.t2 vss 3.21220e-14
.ends opamp_dut

Vdd vdd 0 3.300000
Vss vss 0 0
Ibias vdd ib 5.750000e-07
Vinp inp 0 DC 1.711000 AC 1 PWL(0 1.711000 6.764453e-08 1.711000 7.440898e-08 1.721000)
Rfb out inn 1m
Cload out 0 2.000000e-12
Xdut vdd vss inp inn out ib opamp_dut
.end
