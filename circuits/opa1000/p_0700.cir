* opa1000[0700]: 200f/rail_to_rail_3v3_i10u_weak (rail_to_rail, VDD=3.3V, CL=0.2pF, Iref=1.25uA)
.include "pdk_opa.inc"
.temp 27
.option gmin=1e-12 rshunt=1e12 reltol=1e-3 abstol=1e-12 vntol=1e-5 method=gear
* Post-PEX R+C extracted netlist for rail_to_rail_3v3_i10u_weak
.subckt opamp_dut vdd vss inp inn out ib
XMpar0 out.t8 a_906_5717.t7 vdd.t5 vdd.t4 pfet_03v3 w=4.2u l=1.13u ad=1.1760e-12 pd=4.7600e-06 as=1.5120e-12 ps=5.9700e-06 nf=1 m=8 par=8
XMpar1 out.t0 ib.t0 vss.t3 vss.t2 nfet_03v3 w=1.3u l=2.25u ad=3.6400e-13 pd=1.8600e-06 as=4.6800e-13 ps=2.3450e-06 nf=1 m=8 par=8
XMpar2 a_6532_5422.t7 a_6532_5422.t6 vss.t1 vss.t0 nfet_03v3 w=0.44u l=1.8u ad=1.2320e-13 pd=1.0000e-06 as=1.2320e-13 ps=1.0000e-06 nf=1 m=2 par=2
XMpar3 a_5552_2896.t0 inn.t2 a_6532_5422.t0 vdd.t8 pfet_03v3 w=1.63u l=1.95u ad=6.3027e-13 pd=2.9467e-06 as=6.3027e-13 ps=2.9467e-06 nf=1 m=6 par=6
XMpar4 a_5552_2896.t0 inp.t2 a_6062_2896.t4 vdd.t8 pfet_03v3 w=1.63u l=1.95u ad=6.3027e-13 pd=2.9467e-06 as=6.3027e-13 ps=2.9467e-06 nf=1 m=6 par=6
XMpar5 a_6054_1249.t2 inn.t0 a_6800_13539.t2 vss.t33 nfet_03v3 w=1.13u l=1.95u ad=6.7800e-13 pd=3.4600e-06 as=3.1640e-13 ps=1.6900e-06 nf=1 m=2 par=2
XMpar6 a_906_5717.t2 a_6800_13539.t4 vdd.t5 vdd.t4 pfet_03v3 w=4.2u l=1.13u ad=2.5200e-12 pd=9.6000e-06 as=1.1760e-12 ps=4.7600e-06 nf=1 m=2 par=2
XMpar7 a_906_5717.t4 a_6532_5422.t6 vss.t1 vss.t0 nfet_03v3 w=0.44u l=1.8u ad=2.6400e-13 pd=2.0800e-06 as=1.2320e-13 ps=1.0000e-06 nf=1 m=2 par=2
XMpar8 a_6800_13539.t0 a_6062_2896.t0 vss.t1 vss.t0 nfet_03v3 w=0.44u l=1.8u ad=1.2320e-13 pd=1.0000e-06 as=1.2320e-13 ps=1.0000e-06 nf=1 m=2 par=2
XMpar9 a_9038_10873.t3 a_9038_10873.t2 vdd.t1 vdd.t0 pfet_03v3 w=5.43u l=2.25u ad=1.5204e-12 pd=5.9900e-06 as=1.5204e-12 ps=5.9900e-06 nf=1 m=2 par=2
XMpar10 a_9038_10873.t0 ib.t0 vss.t3 vss.t2 nfet_03v3 w=1.3u l=2.25u ad=3.6400e-13 pd=1.8600e-06 as=3.6400e-13 ps=1.8600e-06 nf=1 m=2 par=2
XMpar11 a_6054_1249.t0 ib.t0 vss.t3 vss.t2 nfet_03v3 w=1.3u l=2.25u ad=7.8000e-13 pd=3.8000e-06 as=3.6400e-13 ps=1.8600e-06 nf=1 m=2 par=2
XMpar12 a_6054_1249.t2 inp.t0 a_906_5717.t0 vss.t33 nfet_03v3 w=1.13u l=1.95u ad=6.7800e-13 pd=3.4600e-06 as=3.1640e-13 ps=1.6900e-06 nf=1 m=2 par=2
XMpar13 a_5552_2896.t6 a_9038_10873.t2 vdd.t1 vdd.t0 pfet_03v3 w=5.43u l=2.25u ad=3.2580e-12 pd=1.2060e-05 as=1.5204e-12 ps=5.9900e-06 nf=1 m=2 par=2
XMpar14 a_6800_13539.t5 a_6800_13539.t4 vdd.t5 vdd.t4 pfet_03v3 w=4.2u l=1.13u ad=1.1760e-12 pd=4.7600e-06 as=1.1760e-12 ps=4.7600e-06 nf=1 m=2 par=2
XMpar15 a_6062_2896.t1 a_6062_2896.t0 vss.t1 vss.t0 nfet_03v3 w=0.44u l=1.8u ad=2.6400e-13 pd=2.0800e-06 as=1.2320e-13 ps=1.0000e-06 nf=1 m=2 par=2
XMpar16 ib.t1 ib.t0 vss.t3 vss.t2 nfet_03v3 w=1.3u l=2.25u ad=7.8000e-13 pd=3.8000e-06 as=3.6400e-13 ps=1.8600e-06 nf=1 m=2 par=2
X15 a_906_6237.t1 out.t9 cap_mim_2f0fF c_width=12.99u c_length=12.99u
X33 a_906_6237.t0 a_3272_5717.t0 vss.t39 ppolyf_u_1k r_width=1u r_length=11.17u
X42 a_906_5717.t6 a_3272_5717.t0 vss.t39 ppolyf_u_1k r_width=1u r_length=11.17u
Rpar0 a_5552_2896.t0 a_5552_2896.t6 65.4208
Rpar1 a_6054_1249.t0 a_6054_1249.t2 102.8829
Rpar2 a_6062_2896.t0 a_6062_2896.t1 21.9193
Rpar3 a_6062_2896.t0 a_6062_2896.t4 123.3852
Rpar4 a_6062_2896.t1 a_6062_2896.t4 83.2042
Rpar5 a_6532_5422.t0 a_6532_5422.t6 102.5857
Rpar6 a_6532_5422.t0 a_6532_5422.t7 103.9526
Rpar7 a_6532_5422.t6 a_6532_5422.t7 30.3284
Rpar8 a_6800_13539.t0 a_6800_13539.t2 112.8241
Rpar9 a_6800_13539.t0 a_6800_13539.t4 481.7261
Rpar10 a_6800_13539.t0 a_6800_13539.t5 208.6070
Rpar11 a_6800_13539.t2 a_6800_13539.t4 525.2992
Rpar12 a_6800_13539.t2 a_6800_13539.t5 227.4759
Rpar13 a_6800_13539.t4 a_6800_13539.t5 25.6697
Rpar14 a_9038_10873.t0 a_9038_10873.t2 226.4864
Rpar15 a_9038_10873.t0 a_9038_10873.t3 88.0401
Rpar16 a_9038_10873.t2 a_9038_10873.t3 23.8437
Rpar17 a_906_5717.t0 a_906_5717.t7 159.1448
Rpar18 a_906_5717.t0 a_906_5717.t2 707.6672
Rpar19 a_906_5717.t0 a_906_5717.t4 204.3937
Rpar20 a_906_5717.t0 a_906_5717.t6 177.9957
Rpar21 a_906_5717.t7 a_906_5717.t2 93.4481
Rpar22 a_906_5717.t7 a_906_5717.t4 134.1560
Rpar23 a_906_5717.t7 a_906_5717.t6 116.8293
Rpar24 a_906_5717.t2 a_906_5717.t4 596.5495
Rpar25 a_906_5717.t2 a_906_5717.t6 519.5034
Rpar26 a_906_5717.t4 a_906_5717.t6 150.0468
Rpar27 a_906_6237.t0 a_906_6237.t1 50.6980
Rpar28 ib ib.t0 28.4301
Rpar29 ib ib.t1 10.4722
Rpar30 ib.t0 ib.t1 44.3183
Rpar31 inn inn.t0 4.9275
Rpar32 inn inn.t2 54.3687
Rpar33 inp inp.t0 4.9761
Rpar34 inp inp.t2 43.9899
Rpar35 out out.t0 49.7624
Rpar36 out out.t8 110.3422
Rpar37 out out.t9 20.1315
Rpar38 out.t0 out.t8 69.7223
Rpar39 out.t0 out.t9 695.5384
Rpar40 out.t8 out.t9 1542.2749
Rpar41 vdd vdd.t0 416.8590
Rpar42 vdd vdd.t1 620.6379
Rpar43 vdd vdd.t8 245.7533
Rpar44 vdd vdd.t4 49.2546
Rpar45 vdd vdd.t5 67.2053
Rpar46 vdd.t0 vdd.t1 9.9542
Rpar47 vdd.t0 vdd.t8 1485.2420
Rpar48 vdd.t0 vdd.t4 141.4674
Rpar49 vdd.t0 vdd.t5 201.1427
Rpar50 vdd.t1 vdd.t8 2211.2934
Rpar51 vdd.t1 vdd.t4 210.6229
Rpar52 vdd.t1 vdd.t5 299.4701
Rpar53 vdd.t8 vdd.t4 175.4911
Rpar54 vdd.t8 vdd.t5 239.4481
Rpar55 vdd.t4 vdd.t5 3.6484
Rpar56 vss vss.t0 299.3813
Rpar57 vss vss.t1 454.1756
Rpar58 vss vss.t2 173.0580
Rpar59 vss vss.t3 632.7648
Rpar60 vss vss.t33 70.5087
Rpar61 vss vss.t39 216.0461
Rpar62 vss.t0 vss.t1 12.8438
Rpar63 vss.t0 vss.t2 5.4515
Rpar64 vss.t0 vss.t3 24.9597
Rpar65 vss.t0 vss.t33 559.1516
Rpar66 vss.t0 vss.t39 1318.6772
Rpar67 vss.t1 vss.t2 10.5153
Rpar68 vss.t1 vss.t3 54.6127
Rpar69 vss.t1 vss.t33 858.3448
Rpar70 vss.t1 vss.t39 2183.3948
Rpar71 vss.t2 vss.t3 7.2305
Rpar72 vss.t2 vss.t33 310.7106
Rpar73 vss.t2 vss.t39 609.1514
Rpar74 vss.t3 vss.t33 1126.8037
Rpar75 vss.t3 vss.t39 2095.2168
Rpar76 vss.t33 vss.t39 117.2879
Cpar0 a_3272_5717.t0 vss 2.99000e-17
Cpar1 a_5552_2896.t0 vss 1.26677e-14
Cpar2 a_5552_2896.t6 vss 1.08520e-14
Cpar3 a_6054_1249.t0 vss 8.85944e-15
Cpar4 a_6054_1249.t2 vss 6.36871e-15
Cpar5 a_6062_2896.t0 vss 3.99288e-15
Cpar6 a_6062_2896.t1 vss 1.87132e-15
Cpar7 a_6062_2896.t4 vss 4.46564e-15
Cpar8 a_6532_5422.t0 vss 4.65278e-15
Cpar9 a_6532_5422.t6 vss 4.26887e-15
Cpar10 a_6532_5422.t7 vss 1.29943e-15
Cpar11 a_6800_13539.t0 vss 4.12448e-15
Cpar12 a_6800_13539.t2 vss 4.20279e-15
Cpar13 a_6800_13539.t4 vss 5.48546e-15
Cpar14 a_6800_13539.t5 vss 5.30641e-15
Cpar15 a_9038_10873.t0 vss 3.92910e-15
Cpar16 a_9038_10873.t2 vss 9.80921e-15
Cpar17 a_9038_10873.t3 vss 3.96451e-15
Cpar18 a_906_5717.t0 vss 1.92659e-15
Cpar19 a_906_5717.t2 vss 4.45440e-15
Cpar20 a_906_5717.t4 vss 2.60235e-15
Cpar21 a_906_5717.t6 vss 2.46659e-15
Cpar22 a_906_5717.t7 vss 9.91031e-15
Cpar23 a_906_6237.t0 vss 1.22920e-16
Cpar24 a_906_6237.t1 vss 2.30380e-15
Cpar25 ib out 1.22231e-15
Cpar26 ib vdd 9.39400e-17
Cpar27 ib vss 2.29168e-14
Cpar28 ib.t0 vss 8.06351e-15
Cpar29 ib.t1 vss 6.42079e-16
Cpar30 inn inp 1.56060e-16
Cpar31 inn vdd 6.55976e-15
Cpar32 inn vss 7.52798e-15
Cpar33 inn.t0 vss 1.08013e-15
Cpar34 inn.t2 vss 9.23583e-15
Cpar35 inp vdd 6.57363e-15
Cpar36 inp vss 6.16030e-15
Cpar37 inp.t0 vss 1.04886e-15
Cpar38 inp.t2 vss 8.53335e-15
Cpar39 out vdd 6.45864e-15
Cpar40 out vss 1.16706e-14
Cpar41 out.t0 vss 3.73824e-15
Cpar42 out.t8 vss 5.05767e-15
Cpar43 out.t9 vss 6.68178e-15
Cpar44 vdd vss 1.25509e-13
Cpar45 vdd.t0 vss 7.98401e-15
Cpar46 vdd.t1 vss 5.17086e-15
Cpar47 vdd.t4 vss 1.43524e-14
Cpar48 vdd.t5 vss 8.90701e-15
Cpar49 vdd.t8 vss 2.10761e-14
.ends opamp_dut

Vdd vdd 0 3.300000
Vss vss 0 0
Ibias vdd ib 1.250000e-06
Vinp inp 0 DC 1.645000 AC 1 PWL(0 1.645000 1.142358e-08 1.645000 1.256593e-08 1.655000)
Rfb out inn 1m
Cload out 0 2.000000e-13
Xdut vdd vss inp inn out ib opamp_dut
.end
