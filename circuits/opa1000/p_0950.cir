* opa1000[0950]: 200f/telescopic_pmos_3v3_i10u_subth (telescopic_pmos, VDD=3.3V, CL=0.2pF, Iref=2.0uA)
.include "pdk_opa.inc"
.temp 27
.option gmin=1e-12 rshunt=1e12 reltol=1e-3 abstol=1e-12 vntol=1e-5 method=gear
* Post-PEX R+C extracted netlist for telescopic_pmos_3v3_i10u_subth
.subckt opamp_dut vdd vss inp inn out ib
XMpar0 a_6180_20675.t0 a_6300_20467.t28 a_6300_20467.t29 vdd.t2 pfet_03v3 w=2.23u l=0.75u ad=8.4740e-13 pd=3.6869e-06 as=7.8050e-13 ps=3.4178e-06 nf=1 m=64 par=64
XMpar1 a_6980_20675.t0 a_6300_20467.t28 out.t0 vdd.t2 pfet_03v3 w=2.23u l=0.75u ad=8.4740e-13 pd=3.6869e-06 as=8.0280e-13 ps=3.5075e-06 nf=1 m=64 par=64
XMpar2 a_6418_13553.t0 inn.t0 a_6980_20675.t12 vdd.t2 pfet_03v3 w=8u l=0.54u ad=2.4000e-12 pd=9.1000e-06 as=2.2400e-12 ps=8.5600e-06 nf=1 m=64 par=64
XMpar3 a_6180_20675.t4 inp.t0 a_6418_13553.t0 vdd.t2 pfet_03v3 w=8u l=0.54u ad=2.2400e-12 pd=8.5600e-06 as=2.4000e-12 ps=9.1000e-06 nf=1 m=64 par=64
XMpar4 a_11624_7740.t0 a_6300_20467.t0 out.t2 vss.t0 nfet_03v3 w=1.8u l=0.75u ad=7.5086e-13 pd=3.4057e-06 as=5.8629e-13 ps=2.7086e-06 nf=1 m=14 par=14
XMpar5 a_10824_7740.t2 a_6300_20467.t0 a_6300_20467.t1 vss.t0 nfet_03v3 w=1.8u l=0.75u ad=7.5086e-13 pd=3.4057e-06 as=5.8629e-13 ps=2.7086e-06 nf=1 m=14 par=14
XMpar6 a_10824_7740.t0 a_6300_20467.t156 vss.t5 vss.t4 nfet_03v3 w=1.89u l=1.44u ad=5.2920e-13 pd=2.4500e-06 as=6.0480e-13 ps=2.7663e-06 nf=1 m=8 par=8
XMpar7 a_11624_7740.t12 a_6300_20467.t156 vss.t5 vss.t4 nfet_03v3 w=1.89u l=1.44u ad=5.2920e-13 pd=2.4500e-06 as=6.0480e-13 ps=2.7663e-06 nf=1 m=8 par=8
XMpar8 a_10776_1086.t3 a_10776_1086.t2 vdd.t1 vdd.t0 pfet_03v3 w=10u l=2.25u ad=2.8000e-12 pd=1.0560e-05 as=2.8000e-12 ps=1.0560e-05 nf=1 m=2 par=2
XMpar9 a_6418_13553.t128 a_10776_1086.t2 vdd.t1 vdd.t0 pfet_03v3 w=10u l=2.25u ad=2.8000e-12 pd=1.0560e-05 as=3.6000e-12 ps=1.3220e-05 nf=1 m=8 par=8
XMpar10 a_10776_1086.t0 ib.t0 vss.t45 vss.t44 nfet_03v3 w=6.21u l=2.25u ad=1.7388e-12 pd=6.7700e-06 as=1.7388e-12 ps=6.7700e-06 nf=1 m=2 par=2
XMpar11 ib.t1 ib.t0 vss.t45 vss.t44 nfet_03v3 w=6.21u l=2.25u ad=3.7260e-12 pd=1.3620e-05 as=1.7388e-12 ps=6.7700e-06 nf=1 m=2 par=2
X37 out.t78 vss.t30 cap_mim_2f0fF c_width=19.63u c_length=19.62u
X100 out.t78 vss.t30 cap_mim_2f0fF c_width=19.63u c_length=19.62u
X147 out.t78 vss.t30 cap_mim_2f0fF c_width=19.63u c_length=19.62u
X298 out.t78 vss.t30 cap_mim_2f0fF c_width=19.63u c_length=19.62u
Rpar0 a_10776_1086.t0 a_10776_1086.t2 111.6628
Rpar1 a_10776_1086.t0 a_10776_1086.t3 70.5906
Rpar2 a_10776_1086.t2 a_10776_1086.t3 26.1332
Rpar3 a_10824_7740.t0 a_10824_7740.t2 56.4733
Rpar4 a_11624_7740.t0 a_11624_7740.t12 36.4949
Rpar5 a_6180_20675.t0 a_6180_20675.t4 45.6046
Rpar6 a_6300_20467.t0 a_6300_20467.t1 8.6837
Rpar7 a_6300_20467.t0 a_6300_20467.t29 475.0796
Rpar8 a_6300_20467.t0 a_6300_20467.t156 293.1501
Rpar9 a_6300_20467.t1 a_6300_20467.t28 579.2985
Rpar10 a_6300_20467.t1 a_6300_20467.t29 143.5456
Rpar11 a_6300_20467.t1 a_6300_20467.t156 88.5755
Rpar12 a_6300_20467.t28 a_6300_20467.t29 5.3707
Rpar13 a_6300_20467.t28 a_6300_20467.t156 977.0980
Rpar14 a_6300_20467.t29 a_6300_20467.t156 242.1172
Rpar15 a_6418_13553.t0 a_6418_13553.t128 77.3289
Rpar16 a_6980_20675.t0 a_6980_20675.t12 34.0700
Rpar17 ib ib.t0 22.2617
Rpar18 ib ib.t1 3.6808
Rpar19 ib.t0 ib.t1 68.2457
Rpar20 inn inn.t0 2.6319
Rpar21 inp inp.t0 2.6319
Rpar22 out out.t0 131.2186
Rpar23 out out.t2 75.0886
Rpar24 out out.t78 18.7337
Rpar25 out.t0 out.t2 140.8900
Rpar26 out.t0 out.t78 506.8215
Rpar27 out.t2 out.t78 290.0240
Rpar28 vdd vdd.t0 329.4538
Rpar29 vdd vdd.t1 1597.3405
Rpar30 vdd vdd.t2 69.0631
Rpar31 vdd.t0 vdd.t1 5.8172
Rpar32 vdd.t0 vdd.t2 135.2844
Rpar33 vdd.t1 vdd.t2 655.9196
Rpar34 vss vss.t0 261.4660
Rpar35 vss vss.t4 124.1356
Rpar36 vss vss.t5 1538.7497
Rpar37 vss vss.t30 69.3496
Rpar38 vss vss.t44 338.5979
Rpar39 vss vss.t45 934.9822
Rpar40 vss.t0 vss.t4 1.6173
Rpar41 vss.t0 vss.t5 10.2469
Rpar42 vss.t0 vss.t30 599.5529
Rpar43 vss.t0 vss.t44 2.9167
Rpar44 vss.t0 vss.t45 27.8519
Rpar45 vss.t4 vss.t5 8.3415
Rpar46 vss.t4 vss.t30 284.6484
Rpar47 vss.t4 vss.t44 3.1095
Rpar48 vss.t4 vss.t45 12.1453
Rpar49 vss.t5 vss.t30 3528.4191
Rpar50 vss.t5 vss.t44 21.9517
Rpar51 vss.t5 vss.t45 172.4784
Rpar52 vss.t30 vss.t44 776.4195
Rpar53 vss.t30 vss.t45 2143.9544
Rpar54 vss.t44 vss.t45 33.3823
Cpar0 a_10776_1086.t0 vss 2.52049e-15
Cpar1 a_10776_1086.t2 vss 2.67184e-14
Cpar2 a_10776_1086.t3 vss 3.86589e-15
Cpar3 a_10824_7740.t0 vss 8.40250e-15
Cpar4 a_10824_7740.t2 vss 1.11294e-14
Cpar5 a_11624_7740.t0 vss 1.41818e-14
Cpar6 a_11624_7740.t12 vss 1.02287e-14
Cpar7 a_6180_20675.t0 vss 7.08179e-14
Cpar8 a_6180_20675.t4 vss 1.13027e-13
Cpar9 a_6300_20467.t0 vss 1.96375e-14
Cpar10 a_6300_20467.t1 vss 1.29311e-14
Cpar11 a_6300_20467.t156 vss 2.09599e-14
Cpar12 a_6300_20467.t28 vss 9.15310e-14
Cpar13 a_6300_20467.t29 vss 6.19221e-14
Cpar14 a_6418_13553.t0 vss 1.99894e-13
Cpar15 a_6418_13553.t128 vss 2.21525e-14
Cpar16 a_6980_20675.t0 vss 7.38752e-14
Cpar17 a_6980_20675.t12 vss 1.15822e-13
Cpar18 ib out 2.76400e-17
Cpar19 ib vdd 3.65900e-17
Cpar20 ib vss 1.13529e-14
Cpar21 ib.t0 vss 1.47422e-15
Cpar22 ib.t1 vss 4.49752e-16
Cpar23 inn inp 1.02250e-16
Cpar24 inn vdd 2.59443e-14
Cpar25 inn vss 1.15795e-14
Cpar26 inn.t0 vss 4.47901e-14
Cpar27 inp vdd 2.55408e-14
Cpar28 inp vss 1.15269e-14
Cpar29 inp.t0 vss 4.45122e-14
Cpar30 out vdd 2.69845e-14
Cpar31 out vss 4.28342e-14
Cpar32 out.t0 vss 1.01042e-14
Cpar33 out.t2 vss 1.93247e-15
Cpar34 out.t78 vss 9.93514e-14
Cpar35 vdd vss 6.25801e-13
Cpar36 vdd.t0 vss 2.20410e-14
Cpar37 vdd.t1 vss 8.41450e-15
Cpar38 vdd.t2 vss 2.02847e-13
.ends opamp_dut

Vdd vdd 0 3.300000
Vss vss 0 0
Ibias vdd ib 2.000000e-06
Vinp inp 0 DC 1.480000 AC 1 PWL(0 1.480000 2.255804e-08 1.480000 2.481384e-08 1.490000)
Rfb out inn 1m
Cload out 0 2.000000e-13
Xdut vdd vss inp inn out ib opamp_dut
.end
