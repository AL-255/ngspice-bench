* opa1000[0659]: 2p/pmos_miller_3v3_i10u_subth (pmos_miller, VDD=3.3V, CL=2.0pF, Iref=1.25uA)
.include "pdk_opa.inc"
.temp 27
.option gmin=1e-12 rshunt=1e12 reltol=1e-3 abstol=1e-12 vntol=1e-5 method=gear
* Post-PEX R+C extracted netlist for pmos_miller_3v3_i10u_subth
.subckt opamp_dut vdd vss inp inn out ib
XMpar0 a_2308_10226.t0 inp.t0 a_999_6258.t3 vdd.t8 pfet_03v3 w=1.96u l=1.13u ad=6.1368e-13 pd=2.7890e-06 as=5.7043e-13 ps=2.6097e-06 nf=1 m=58 par=58
XMpar1 a_2308_10226.t0 inn.t0 a_7196_7960.t0 vdd.t8 pfet_03v3 w=1.96u l=1.13u ad=6.1368e-13 pd=2.7890e-06 as=5.7043e-13 ps=2.6097e-06 nf=1 m=58 par=58
XMpar2 out.t0 a_6638_6218.t2 vdd.t1 vdd.t0 pfet_03v3 w=9.07u l=1.2u ad=4.2810e-12 pd=1.5456e-05 as=3.7006e-12 ps=1.3514e-05 nf=1 m=10 par=10
XMpar3 a_2308_10226.t116 a_6638_6218.t2 vdd.t1 vdd.t0 pfet_03v3 w=9.07u l=1.2u ad=5.4420e-12 pd=1.9340e-05 as=2.5396e-12 ps=9.6300e-06 nf=1 m=4 par=4
XMpar4 out.t1 a_999_6258.t61 vss.t1 vss.t0 nfet_03v3 w=2.39u l=0.94u ad=6.6920e-13 pd=2.9500e-06 as=8.2216e-13 ps=3.5560e-06 nf=1 m=10 par=10
XMpar5 a_6638_6218.t0 ib.t0 vss.t30 vss.t29 nfet_03v3 w=1.85u l=1.2u ad=5.1800e-13 pd=2.4100e-06 as=5.1800e-13 ps=2.4100e-06 nf=1 m=2 par=2
XMpar6 a_999_6258.t0 a_7196_7960.t58 vss.t1 vss.t0 nfet_03v3 w=2.39u l=0.94u ad=1.4340e-12 pd=5.9800e-06 as=6.6920e-13 ps=2.9500e-06 nf=1 m=2 par=2
XMpar7 ib.t1 ib.t0 vss.t30 vss.t29 nfet_03v3 w=1.85u l=1.2u ad=1.1100e-12 pd=4.9000e-06 as=5.1800e-13 ps=2.4100e-06 nf=1 m=2 par=2
XMpar8 a_7196_7960.t59 a_7196_7960.t58 vss.t1 vss.t0 nfet_03v3 w=2.39u l=0.94u ad=6.6920e-13 pd=2.9500e-06 as=6.6920e-13 ps=2.9500e-06 nf=1 m=2 par=2
XMpar9 a_6638_6218.t3 a_6638_6218.t2 vdd.t1 vdd.t0 pfet_03v3 w=9.07u l=1.2u ad=5.4420e-12 pd=1.9340e-05 as=2.5396e-12 ps=9.6300e-06 nf=1 m=2 par=2
X1 a_4289_6258.t1 out.t5 cap_mim_2f0fF c_width=16.58u c_length=16.59u
X128 a_4289_6258.t1 out.t5 cap_mim_2f0fF c_width=16.58u c_length=16.59u
X136 a_999_6258.t2 a_4289_6258.t0 vss.t26 ppolyf_u_1k r_width=1u r_length=15.79u
Rpar0 a_2308_10226.t0 a_2308_10226.t116 53.3952
Rpar1 a_4289_6258.t0 a_4289_6258.t1 60.5857
Rpar2 a_6638_6218.t0 a_6638_6218.t2 199.2275
Rpar3 a_6638_6218.t0 a_6638_6218.t3 65.0397
Rpar4 a_6638_6218.t2 a_6638_6218.t3 13.5741
Rpar5 a_7196_7960.t0 a_7196_7960.t58 171.6470
Rpar6 a_7196_7960.t0 a_7196_7960.t59 79.1695
Rpar7 a_7196_7960.t58 a_7196_7960.t59 26.8652
Rpar8 a_999_6258.t0 a_999_6258.t3 205.0804
Rpar9 a_999_6258.t0 a_999_6258.t2 105.8585
Rpar10 a_999_6258.t0 a_999_6258.t61 190.0442
Rpar11 a_999_6258.t3 a_999_6258.t2 221.3734
Rpar12 a_999_6258.t3 a_999_6258.t61 60.0548
Rpar13 a_999_6258.t2 a_999_6258.t61 205.1427
Rpar14 ib ib.t0 14.3521
Rpar15 ib ib.t1 4.8383
Rpar16 inn inn.t0 1.5769
Rpar17 inp inp.t0 1.5769
Rpar18 out out.t0 3.1993
Rpar19 out out.t1 90.5983
Rpar20 out out.t5 91.8013
Rpar21 out.t1 out.t5 261.1711
Rpar22 vdd vdd.t0 3547.6570
Rpar23 vdd vdd.t1 395.7559
Rpar24 vdd vdd.t8 20.0411
Rpar25 vdd.t0 vdd.t1 12.6393
Rpar26 vdd.t0 vdd.t8 1290.2576
Rpar27 vdd.t1 vdd.t8 143.9336
Rpar28 vss vss.t0 111.2164
Rpar29 vss vss.t1 366.9566
Rpar30 vss vss.t26 3137.7526
Rpar31 vss vss.t29 247.7322
Rpar32 vss vss.t30 672.8004
Rpar33 vss.t0 vss.t1 3.6705
Rpar34 vss.t0 vss.t26 15.2621
Rpar35 vss.t0 vss.t29 5.6614
Rpar36 vss.t0 vss.t30 27.8363
Rpar37 vss.t1 vss.t26 99.4406
Rpar38 vss.t1 vss.t29 14.8050
Rpar39 vss.t1 vss.t30 75.0539
Rpar40 vss.t26 vss.t29 1470.9966
Rpar41 vss.t29 vss.t30 12.6839
Cpar0 a_2308_10226.t0 vss 7.72774e-14
Cpar1 a_2308_10226.t116 vss 2.33932e-14
Cpar2 a_4289_6258.t0 vss 7.73430e-17
Cpar3 a_4289_6258.t1 vss 4.70954e-15
Cpar4 a_6638_6218.t0 vss 2.69596e-15
Cpar5 a_6638_6218.t2 vss 2.94291e-14
Cpar6 a_6638_6218.t3 vss 1.08834e-14
Cpar7 a_7196_7960.t0 vss 4.14055e-14
Cpar8 a_7196_7960.t58 vss 5.46863e-15
Cpar9 a_7196_7960.t59 vss 4.53597e-15
Cpar10 a_999_6258.t0 vss 4.31975e-15
Cpar11 a_999_6258.t2 vss 3.39581e-15
Cpar12 a_999_6258.t3 vss 3.20760e-14
Cpar13 a_999_6258.t61 vss 1.03109e-14
Cpar14 ib out 8.89200e-17
Cpar15 ib vss 6.75900e-15
Cpar16 ib.t0 vss 6.30032e-16
Cpar17 ib.t1 vss 1.73820e-16
Cpar18 inn inp 1.43640e-16
Cpar19 inn vdd 3.21929e-14
Cpar20 inn vss 5.42408e-15
Cpar21 inn.t0 vss 5.01335e-14
Cpar22 inp out 1.53300e-17
Cpar23 inp vdd 3.21201e-14
Cpar24 inp vss 5.40829e-15
Cpar25 inp.t0 vss 4.99834e-14
Cpar26 out vdd 1.84948e-14
Cpar27 out vss 2.24826e-14
Cpar28 out.t0 vss 1.39017e-14
Cpar29 out.t1 vss 4.11412e-15
Cpar30 out.t5 vss 1.67276e-14
Cpar31 vdd vss 2.97845e-13
Cpar32 vdd.t0 vss 4.41647e-14
Cpar33 vdd.t1 vss 1.27700e-14
Cpar34 vdd.t8 vss 8.51839e-14
.ends opamp_dut

Vdd vdd 0 3.300000
Vss vss 0 0
Ibias vdd ib 1.250000e-06
Vinp inp 0 DC 1.480000 AC 1 PWL(0 1.480000 2.509022e-08 1.480000 2.759924e-08 1.490000)
Rfb out inn 1m
Cload out 0 2.000000e-12
Xdut vdd vss inp inn out ib opamp_dut
.end
