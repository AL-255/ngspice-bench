* opa1000[0870]: 200f/telescopic_nmos_3v3_10u_100u_subth (telescopic_nmos, VDD=3.3V, CL=0.2pF, Iref=16.25uA)
.include "pdk_opa.inc"
.temp 27
.option gmin=1e-12 rshunt=1e12 reltol=1e-3 abstol=1e-12 vntol=1e-5 method=gear
* Post-PEX R+C extracted netlist for telescopic_nmos_3v3_10u_100u_subth
.subckt opamp_dut vdd vss inp inn out ib
XMpar0 a_4362_10583.t1 a_4362_10583.t0 a_5777_1204.t0 vss.t0 nfet_03v3 w=2.02u l=0.28u ad=1.0841e-12 pd=3.7667e-06 as=1.1456e-12 ps=4.0200e-06 nf=1 m=42 par=42
XMpar1 a_4234_10791.t0 a_4362_10583.t84 a_4362_10583.t85 vdd.t0 pfet_03v3 w=4.89u l=0.28u ad=2.3961e-12 pd=6.7869e-06 as=2.2983e-12 ps=6.4412e-06 nf=1 m=64 par=64
XMpar2 a_4738_10791.t0 a_4362_10583.t84 out.t2 vdd.t0 pfet_03v3 w=4.89u l=0.28u ad=2.4939e-12 pd=7.1325e-06 as=2.1027e-12 ps=5.7500e-06 nf=1 m=64 par=64
XMpar3 a_1446_5101.t0 inn.t0 a_6510_1204.t1 vss.t0 nfet_03v3 w=4.91u l=0.6u ad=1.4730e-12 pd=5.8169e-06 as=1.4239e-12 ps=5.6434e-06 nf=1 m=64 par=64
XMpar4 a_1446_5101.t0 inp.t0 a_5777_1204.t4 vss.t0 nfet_03v3 w=4.91u l=0.6u ad=1.4730e-12 pd=5.8169e-06 as=1.4239e-12 ps=5.6434e-06 nf=1 m=64 par=64
XMpar5 a_4234_10791.t12 a_4362_10583.t318 vdd.t33 vdd.t32 pfet_03v3 w=4.38u l=0.8u ad=1.4016e-12 pd=5.5675e-06 as=1.3140e-12 ps=5.2538e-06 nf=1 m=64 par=64
XMpar6 a_4738_10791.t24 a_4362_10583.t318 vdd.t33 vdd.t32 pfet_03v3 w=4.38u l=0.8u ad=1.4454e-12 pd=5.7244e-06 as=1.3140e-12 ps=5.2538e-06 nf=1 m=64 par=64
XMpar7 a_1446_5101.t128 ib.t0 vss.t104 vss.t103 nfet_03v3 w=10u l=1.5u ad=2.8000e-12 pd=1.0560e-05 as=3.6000e-12 ps=1.3220e-05 nf=1 m=8 par=8
XMpar8 a_6510_1204.t0 a_4362_10583.t0 out.t0 vss.t0 nfet_03v3 w=2.02u l=0.28u ad=1.1456e-12 pd=4.0200e-06 as=1.0841e-12 ps=3.7667e-06 nf=1 m=42 par=42
XMpar9 ib.t1 ib.t0 vss.t104 vss.t103 nfet_03v3 w=10u l=1.5u ad=2.8000e-12 pd=1.0560e-05 as=2.8000e-12 ps=1.0560e-05 nf=1 m=2 par=2
X47 out.t106 vss.t100 cap_mim_2f0fF c_width=18.88u c_length=18.88u
Rpar0 a_1446_5101.t0 a_1446_5101.t128 33.5794
Rpar1 a_4234_10791.t0 a_4234_10791.t12 47.6957
Rpar2 a_4362_10583.t0 a_4362_10583.t1 8.3978
Rpar3 a_4362_10583.t1 a_4362_10583.t85 108.4801
Rpar4 a_4362_10583.t1 a_4362_10583.t318 159.0197
Rpar5 a_4362_10583.t84 a_4362_10583.t85 8.5695
Rpar6 a_4362_10583.t85 a_4362_10583.t318 67.7185
Rpar7 a_4738_10791.t0 a_4738_10791.t24 55.6531
Rpar8 a_5777_1204.t0 a_5777_1204.t4 64.5466
Rpar9 a_6510_1204.t0 a_6510_1204.t1 47.1967
Rpar10 ib ib.t0 15.2292
Rpar11 ib ib.t1 8.0365
Rpar12 inn inn.t0 2.4128
Rpar13 inp inp.t0 2.4128
Rpar14 out out.t2 3.2179
Rpar15 out.t0 out.t2 87.6221
Rpar16 out.t0 out.t106 176.9779
Rpar17 out.t2 out.t106 127.6898
Rpar18 vdd vdd.t0 173.0441
Rpar19 vdd vdd.t32 20.8280
Rpar20 vdd.t0 vdd.t32 63.5087
Rpar21 vdd.t33 vdd.t32 10.0414
Rpar22 vss vss.t0 54.7149
Rpar23 vss vss.t100 449.5247
Rpar24 vss vss.t103 98.6642
Rpar25 vss vss.t104 411.3476
Rpar26 vss.t0 vss.t100 863.9239
Rpar27 vss.t0 vss.t103 23.1277
Rpar28 vss.t0 vss.t104 104.2189
Rpar29 vss.t100 vss.t103 264.2184
Rpar30 vss.t100 vss.t104 1101.2464
Rpar31 vss.t103 vss.t104 5.7972
Cpar0 a_1446_5101.t0 vss 1.18741e-13
Cpar1 a_1446_5101.t128 vss 1.50213e-14
Cpar2 a_4234_10791.t0 vss 9.71069e-14
Cpar3 a_4234_10791.t12 vss 8.82153e-14
Cpar4 a_4362_10583.t0 vss 3.19164e-14
Cpar5 a_4362_10583.t1 vss 4.24960e-14
Cpar6 a_4362_10583.t318 vss 1.32398e-13
Cpar7 a_4362_10583.t84 vss 6.63560e-14
Cpar8 a_4362_10583.t85 vss 8.56416e-14
Cpar9 a_4738_10791.t0 vss 1.10628e-13
Cpar10 a_4738_10791.t24 vss 9.41902e-14
Cpar11 a_5777_1204.t0 vss 4.39762e-14
Cpar12 a_5777_1204.t4 vss 6.84731e-14
Cpar13 a_6510_1204.t0 vss 4.83533e-14
Cpar14 a_6510_1204.t1 vss 7.42566e-14
Cpar15 ib out 3.07750e-16
Cpar16 ib vss 1.97025e-14
Cpar17 ib.t0 vss 4.67034e-15
Cpar18 ib.t1 vss 4.79490e-16
Cpar19 inn inp 1.01060e-16
Cpar20 inn out 1.06400e-17
Cpar21 inn vdd 1.28000e-17
Cpar22 inn vss 3.07343e-14
Cpar23 inn.t0 vss 2.14423e-14
Cpar24 inp out 1.11900e-17
Cpar25 inp vdd 1.27500e-17
Cpar26 inp vss 3.04501e-14
Cpar27 inp.t0 vss 2.14066e-14
Cpar28 out vdd 2.39103e-14
Cpar29 out vss 4.77830e-14
Cpar30 out.t0 vss 2.49178e-14
Cpar31 out.t106 vss 7.45766e-14
Cpar32 out.t2 vss 4.38050e-14
Cpar33 vdd vss 5.42399e-13
Cpar34 vdd.t0 vss 1.40850e-13
Cpar35 vdd.t32 vss 1.46543e-13
Cpar36 vdd.t33 vss 3.15957e-14
.ends opamp_dut

Vdd vdd 0 3.300000
Vss vss 0 0
Ibias vdd ib 1.625000e-05
Vinp inp 0 DC 1.711000 AC 1 PWL(0 1.711000 3.000000e-09 1.711000 3.300000e-09 1.721000)
Rfb out inn 1m
Cload out 0 2.000000e-13
Xdut vdd vss inp inn out ib opamp_dut
.end
