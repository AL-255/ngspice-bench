* opa1000[0423]: 200f/nmos_miller_1v8_0p1u_1u_weak (nmos_miller, VDD=1.8V, CL=0.2pF, Iref=0.0929uA)
.include "pdk_opa.inc"
.temp 27
.option gmin=1e-12 rshunt=1e12 reltol=1e-3 abstol=1e-12 vntol=1e-5 method=gear
* Post-PEX R+C extracted netlist for nmos_miller_1v8_0p1u_1u_weak
.subckt opamp_dut vdd vss inp inn out ib
XMpar0 a_4225_1205.t4 ib.t0 vss.t6 vss.t5 nfet_03v3 w=0.4u l=6.25u ad=2.4000e-13 pd=2.0000e-06 as=1.1200e-13 ps=9.6000e-07 nf=1 m=4 par=4
XMpar1 out.t9 ib.t0 vss.t6 vss.t5 nfet_03v3 w=0.4u l=6.25u ad=1.8880e-13 pd=1.5840e-06 as=1.6320e-13 ps=1.3760e-06 nf=1 m=10 par=10
XMpar2 out.t0 a_1452_8587.t5 vdd.t1 vdd.t0 pfet_03v3 w=0.75u l=2u ad=2.5800e-13 pd=1.5880e-06 as=2.5800e-13 ps=1.5880e-06 nf=1 m=10 par=10
XMpar3 a_4225_1205.t0 inn.t0 a_6452_4291.t0 vss.t0 nfet_03v3 w=0.63u l=5u ad=3.7800e-13 pd=2.4600e-06 as=1.7640e-13 ps=1.1900e-06 nf=1 m=2 par=2
XMpar4 ib.t1 ib.t0 vss.t6 vss.t5 nfet_03v3 w=0.4u l=6.25u ad=2.4000e-13 pd=2.0000e-06 as=1.1200e-13 ps=9.6000e-07 nf=1 m=2 par=2
XMpar5 a_6452_4291.t3 a_6452_4291.t2 vdd.t1 vdd.t0 pfet_03v3 w=0.75u l=2u ad=2.1000e-13 pd=1.3100e-06 as=2.1000e-13 ps=1.3100e-06 nf=1 m=2 par=2
XMpar6 a_1452_8587.t3 a_6452_4291.t2 vdd.t1 vdd.t0 pfet_03v3 w=0.75u l=2u ad=4.5000e-13 pd=2.7000e-06 as=2.1000e-13 ps=1.3100e-06 nf=1 m=2 par=2
XMpar7 a_1452_8587.t0 inp.t0 a_4225_1205.t0 vss.t0 nfet_03v3 w=0.63u l=5u ad=1.7640e-13 pd=1.1900e-06 as=3.7800e-13 ps=2.4600e-06 nf=1 m=2 par=2
X2 a_9475_10936.t1 out.t6 cap_mim_2f0fF c_width=13.23u c_length=13.23u
X3 a_1452_8587.t2 a_9475_7816.t0 vss.t4 ppolyf_u_1k r_width=1u r_length=19.85u
X5 a_5373_10416.t0 a_9475_10936.t0 vss.t4 ppolyf_u_1k r_width=1u r_length=19.85u
X11 a_5373_10416.t0 a_9475_9896.t0 vss.t4 ppolyf_u_1k r_width=1u r_length=19.85u
X19 a_5373_9376.t0 a_9475_9896.t0 vss.t4 ppolyf_u_1k r_width=1u r_length=19.85u
X27 a_5373_9376.t0 a_9475_8856.t0 vss.t4 ppolyf_u_1k r_width=1u r_length=19.85u
X32 a_5373_8336.t0 a_9475_8856.t0 vss.t4 ppolyf_u_1k r_width=1u r_length=19.85u
X37 a_5373_8336.t0 a_9475_7816.t0 vss.t4 ppolyf_u_1k r_width=1u r_length=19.85u
Rpar0 a_1452_8587.t0 a_1452_8587.t5 75.3073
Rpar1 a_1452_8587.t0 a_1452_8587.t2 122.2945
Rpar2 a_1452_8587.t0 a_1452_8587.t3 139.6682
Rpar3 a_1452_8587.t5 a_1452_8587.t2 63.0446
Rpar4 a_1452_8587.t5 a_1452_8587.t3 150.9593
Rpar5 a_1452_8587.t2 a_1452_8587.t3 245.1486
Rpar6 a_4225_1205.t0 a_4225_1205.t4 68.8867
Rpar7 a_6452_4291.t0 a_6452_4291.t2 110.3717
Rpar8 a_6452_4291.t0 a_6452_4291.t3 95.0675
Rpar9 a_6452_4291.t2 a_6452_4291.t3 28.3929
Rpar10 a_9475_10936.t0 a_9475_10936.t1 71.2226
Rpar11 ib ib.t0 18.1486
Rpar12 ib ib.t1 15.7665
Rpar13 ib.t0 ib.t1 34.3541
Rpar14 inn inn.t0 3.1889
Rpar15 inp inp.t0 3.2374
Rpar16 out out.t0 3.9647
Rpar17 out out.t9 66.7875
Rpar18 out out.t6 53.3517
Rpar19 out.t9 out.t6 137.8600
Rpar20 vdd vdd.t0 128.9128
Rpar21 vdd vdd.t1 48.5543
Rpar22 vdd.t0 vdd.t1 6.5738
Rpar23 vss vss.t0 284.4353
Rpar24 vss vss.t6 1137.0853
Rpar25 vss vss.t5 96.2666
Rpar26 vss vss.t4 357.9380
Rpar27 vss.t0 vss.t6 1053.3168
Rpar28 vss.t0 vss.t5 85.1043
Rpar29 vss.t0 vss.t4 6.6920
Rpar30 vss.t6 vss.t5 12.9562
Rpar31 vss.t6 vss.t4 1330.3209
Rpar32 vss.t5 vss.t4 107.5712
Cpar0 a_1452_8587.t0 vss 2.16723e-15
Cpar1 a_1452_8587.t2 vss 2.80259e-15
Cpar2 a_1452_8587.t3 vss 3.11792e-15
Cpar3 a_1452_8587.t5 vss 1.32691e-14
Cpar4 a_4225_1205.t0 vss 9.07280e-15
Cpar5 a_4225_1205.t4 vss 2.13105e-14
Cpar6 a_5373_10416.t0 vss 4.20800e-17
Cpar7 a_5373_8336.t0 vss 4.43600e-17
Cpar8 a_5373_9376.t0 vss 4.24200e-17
Cpar9 a_6452_4291.t0 vss 2.40823e-15
Cpar10 a_6452_4291.t2 vss 6.18629e-15
Cpar11 a_6452_4291.t3 vss 2.00845e-15
Cpar12 a_9475_10936.t0 vss 2.46430e-16
Cpar13 a_9475_10936.t1 vss 4.05131e-15
Cpar14 a_9475_7816.t0 vss 3.47000e-17
Cpar15 a_9475_8856.t0 vss 3.71000e-17
Cpar16 a_9475_9896.t0 vss 4.00800e-17
Cpar17 ib out 2.32898e-15
Cpar18 ib vss 6.91813e-14
Cpar19 ib.t0 vss 1.08078e-14
Cpar20 ib.t1 vss 8.02190e-16
Cpar21 inn inp 5.12600e-17
Cpar22 inn vdd 9.76600e-17
Cpar23 inn vss 5.44730e-15
Cpar24 inn.t0 vss 5.18249e-16
Cpar25 inp vdd 2.20800e-17
Cpar26 inp vss 5.40548e-15
Cpar27 inp.t0 vss 4.82045e-16
Cpar28 out vdd 9.53275e-15
Cpar29 out vss 2.53228e-14
Cpar30 out.t0 vss 2.21633e-15
Cpar31 out.t6 vss 9.33775e-15
Cpar32 out.t9 vss 1.16193e-14
Cpar33 vdd vss 6.41869e-14
Cpar34 vdd.t0 vss 1.93975e-14
Cpar35 vdd.t1 vss 6.66296e-15
.ends opamp_dut

Vdd vdd 0 1.800000
Vss vss 0 0
Ibias vdd ib 9.290000e-08
Vinp inp 0 DC 0.895000 AC 1 PWL(0 0.895000 1.526012e-07 0.895000 1.678613e-07 0.905000)
Rfb out inn 1m
Cload out 0 2.000000e-13
Xdut vdd vss inp inn out ib opamp_dut
.end
