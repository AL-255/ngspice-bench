* opa1000[0282]: 200f/folded_cascode_pmos_3v3_i10u_weak (folded_cascode_pmos, VDD=3.3V, CL=0.2pF, Iref=2.2222uA)
.include "pdk_opa.inc"
.temp 27
.option gmin=1e-12 rshunt=1e12 reltol=1e-3 abstol=1e-12 vntol=1e-5 method=gear
* Post-PEX R+C extracted netlist for folded_cascode_pmos_3v3_i10u_weak
.subckt opamp_dut vdd vss inp inn out ib
XMpar0 a_1412_6884.t12 a_1124_6676.t2 vdd.t1 vdd.t0 pfet_03v3 w=4.21u l=1.44u ad=1.1788e-12 pd=4.7700e-06 as=1.8524e-12 ps=7.1950e-06 nf=1 m=4 par=4
XMpar1 a_1412_6884.t0 inn.t0 a_5614_6930.t0 vdd.t2 pfet_03v3 w=1.84u l=0.78u ad=8.0960e-13 pd=3.6400e-06 as=5.1520e-13 ps=2.4000e-06 nf=1 m=12 par=12
XMpar2 a_1412_6884.t0 inp.t0 a_4430_5053.t0 vdd.t2 pfet_03v3 w=1.84u l=0.78u ad=8.0960e-13 pd=3.6400e-06 as=5.1520e-13 ps=2.4000e-06 nf=1 m=12 par=12
XMpar3 ib.t1 ib.t0 vss.t4 vss.t0 nfet_03v3 w=0.81u l=0.9u ad=4.8600e-13 pd=2.8200e-06 as=2.2680e-13 ps=1.3700e-06 nf=1 m=2 par=2
XMpar4 a_4430_5053.t14 ib.t0 vss.t4 vss.t0 nfet_03v3 w=0.81u l=0.9u ad=2.2680e-13 pd=1.3700e-06 as=3.5640e-13 ps=2.0950e-06 nf=1 m=4 par=4
XMpar5 a_4796_9261.t1 a_4796_9261.t0 vdd.t1 vdd.t0 pfet_03v3 w=4.21u l=1.44u ad=2.5260e-12 pd=9.6200e-06 as=1.1788e-12 ps=4.7700e-06 nf=1 m=2 par=2
XMpar6 a_5614_6930.t12 a_1124_6676.t6 out.t1 vss.t0 nfet_03v3 w=1.68u l=0.94u ad=1.0080e-12 pd=4.5600e-06 as=4.7040e-13 ps=2.2400e-06 nf=1 m=2 par=2
XMpar7 a_1124_6676.t0 ib.t0 vss.t4 vss.t0 nfet_03v3 w=0.81u l=0.9u ad=2.2680e-13 pd=1.3700e-06 as=2.2680e-13 ps=1.3700e-06 nf=1 m=2 par=2
XMpar8 a_5614_6930.t13 ib.t0 vss.t4 vss.t0 nfet_03v3 w=0.81u l=0.9u ad=2.2680e-13 pd=1.3700e-06 as=3.5640e-13 ps=2.0950e-06 nf=1 m=4 par=4
XMpar9 a_4430_5053.t12 a_1124_6676.t6 a_4796_9261.t4 vss.t0 nfet_03v3 w=1.68u l=0.94u ad=1.0080e-12 pd=4.5600e-06 as=4.7040e-13 ps=2.2400e-06 nf=1 m=2 par=2
XMpar10 a_1124_6676.t3 a_1124_6676.t2 vdd.t1 vdd.t0 pfet_03v3 w=4.21u l=1.44u ad=1.1788e-12 pd=4.7700e-06 as=1.1788e-12 ps=4.7700e-06 nf=1 m=2 par=2
XMpar11 out.t0 a_4796_9261.t0 vdd.t1 vdd.t0 pfet_03v3 w=4.21u l=1.44u ad=1.1788e-12 pd=4.7700e-06 as=1.1788e-12 ps=4.7700e-06 nf=1 m=2 par=2
Rpar0 a_1124_6676.t0 a_1124_6676.t2 457.1390
Rpar1 a_1124_6676.t0 a_1124_6676.t3 188.0340
Rpar2 a_1124_6676.t0 a_1124_6676.t6 62.9357
Rpar3 a_1124_6676.t2 a_1124_6676.t3 23.5584
Rpar4 a_1124_6676.t2 a_1124_6676.t6 341.4914
Rpar5 a_1124_6676.t3 a_1124_6676.t6 140.4649
Rpar6 a_1412_6884.t0 a_1412_6884.t12 119.8273
Rpar7 a_4430_5053.t0 a_4430_5053.t12 138.6224
Rpar8 a_4430_5053.t0 a_4430_5053.t14 66.3948
Rpar9 a_4430_5053.t12 a_4430_5053.t14 66.9160
Rpar10 a_4796_9261.t0 a_4796_9261.t1 19.5088
Rpar11 a_4796_9261.t0 a_4796_9261.t4 325.0950
Rpar12 a_4796_9261.t1 a_4796_9261.t4 75.9854
Rpar13 a_5614_6930.t0 a_5614_6930.t12 138.6224
Rpar14 a_5614_6930.t0 a_5614_6930.t13 66.3948
Rpar15 a_5614_6930.t12 a_5614_6930.t13 66.9160
Rpar16 ib ib.t0 10.6907
Rpar17 ib ib.t1 7.0116
Rpar18 ib.t0 ib.t1 583.5793
Rpar19 inn inn.t0 4.4673
Rpar20 inp inp.t0 4.4673
Rpar21 out out.t0 37.5910
Rpar22 out out.t1 9.1331
Rpar23 vdd vdd.t0 36.8421
Rpar24 vdd vdd.t1 57.3292
Rpar25 vdd vdd.t2 146.7926
Rpar26 vdd.t0 vdd.t1 4.0691
Rpar27 vdd.t0 vdd.t2 215.6129
Rpar28 vdd.t1 vdd.t2 309.9618
Rpar29 vss vss.t0 64.1335
Rpar30 vss vss.t4 88.1383
Rpar31 vss.t0 vss.t4 4.9482
Cpar0 a_1124_6676.t0 vss 2.04406e-15
Cpar1 a_1124_6676.t2 vss 8.90922e-15
Cpar2 a_1124_6676.t3 vss 3.67987e-15
Cpar3 a_1124_6676.t6 vss 4.04672e-15
Cpar4 a_1412_6884.t0 vss 2.02708e-14
Cpar5 a_1412_6884.t12 vss 7.31477e-15
Cpar6 a_4430_5053.t0 vss 1.13458e-14
Cpar7 a_4430_5053.t12 vss 2.51733e-15
Cpar8 a_4430_5053.t14 vss 2.99448e-15
Cpar9 a_4796_9261.t0 vss 5.76880e-15
Cpar10 a_4796_9261.t1 vss 4.55097e-15
Cpar11 a_4796_9261.t4 vss 1.63342e-15
Cpar12 a_5614_6930.t0 vss 1.06603e-14
Cpar13 a_5614_6930.t12 vss 2.36520e-15
Cpar14 a_5614_6930.t13 vss 2.81349e-15
Cpar15 ib vdd 1.71670e-16
Cpar16 ib vss 1.32776e-14
Cpar17 ib.t0 vss 2.39726e-15
Cpar18 ib.t1 vss 1.17677e-16
Cpar19 inn inp 1.54680e-16
Cpar20 inn vdd 7.32468e-15
Cpar21 inn vss 4.07611e-15
Cpar22 inn.t0 vss 8.29406e-15
Cpar23 inp vdd 7.25349e-15
Cpar24 inp vss 4.12843e-15
Cpar25 inp.t0 vss 8.25040e-15
Cpar26 out vdd 2.40681e-15
Cpar27 out vss 3.43904e-15
Cpar28 out.t0 vss 3.27101e-15
Cpar29 out.t1 vss 2.39204e-16
Cpar30 vdd vss 1.10450e-13
Cpar31 vdd.t0 vss 1.25855e-14
Cpar32 vdd.t1 vss 8.86346e-15
Cpar33 vdd.t2 vss 2.32651e-14
.ends opamp_dut

Vdd vdd 0 3.300000
Vss vss 0 0
Ibias vdd ib 2.222200e-06
Vinp inp 0 DC 1.381000 AC 1 PWL(0 1.381000 3.634716e-09 1.381000 3.998188e-09 1.391000)
Rfb out inn 1m
Cload out 0 2.000000e-13
Xdut vdd vss inp inn out ib opamp_dut
.end
