* opa1000[0990]: 2p/telescopic_pmos_3v3_1u_10u_subth (telescopic_pmos, VDD=3.3V, CL=2.0pF, Iref=1.3uA)
.include "pdk_opa.inc"
.temp 27
.option gmin=1e-12 rshunt=1e12 reltol=1e-3 abstol=1e-12 vntol=1e-5 method=gear
* Post-PEX R+C extracted netlist for telescopic_pmos_3v3_1u_10u_subth
.subckt opamp_dut vdd vss inp inn out ib
XMpar0 a_2192_1204.t0 inp.t0 a_5288_14480.t7 vdd.t10 pfet_03v3 w=2.25u l=0.8u ad=6.7500e-13 pd=2.9906e-06 as=6.5250e-13 ps=2.9003e-06 nf=1 m=64 par=64
XMpar1 a_5288_14480.t0 a_5408_14272.t32 a_5408_14272.t33 vdd.t0 pfet_03v3 w=3.17u l=1.3u ad=1.1412e-12 pd=4.6825e-06 as=8.8760e-13 ps=3.7300e-06 nf=1 m=64 par=64
XMpar2 a_8540_14480.t0 a_5408_14272.t32 out.t0 vdd.t0 pfet_03v3 w=3.17u l=1.3u ad=1.0144e-12 pd=4.2062e-06 as=8.8760e-13 ps=3.7300e-06 nf=1 m=64 par=64
XMpar3 a_2192_1204.t0 inn.t0 a_8540_14480.t2 vdd.t10 pfet_03v3 w=2.25u l=0.8u ad=6.7500e-13 pd=2.9906e-06 as=6.5250e-13 ps=2.9003e-06 nf=1 m=64 par=64
XMpar4 a_9614_3013.t0 a_5408_14272.t176 vss.t2 vss.t0 nfet_03v3 w=2.14u l=2u ad=5.9920e-13 pd=2.7000e-06 as=5.9920e-13 ps=2.7000e-06 nf=1 m=4 par=4
XMpar5 a_9614_3013.t2 a_5408_14272.t0 out.t2 vss.t0 nfet_03v3 w=1.85u l=1.3u ad=8.1400e-13 pd=3.6550e-06 as=7.4000e-13 ps=3.3438e-06 nf=1 m=16 par=16
XMpar6 a_2192_1204.t128 a_1692_996.t2 vdd.t5 vdd.t4 pfet_03v3 w=10u l=2.5u ad=2.8000e-12 pd=1.0560e-05 as=5.2000e-12 ps=1.8540e-05 nf=1 m=8 par=8
XMpar7 a_5408_14272.t1 a_5408_14272.t0 a_8965_3013.t0 vss.t0 nfet_03v3 w=1.85u l=1.3u ad=8.1400e-13 pd=3.6550e-06 as=8.1400e-13 ps=3.6550e-06 nf=1 m=16 par=16
XMpar8 a_1692_996.t0 ib.t0 vss.t21 vss.t20 nfet_03v3 w=4.61u l=2.5u ad=1.2908e-12 pd=5.1700e-06 as=1.2908e-12 ps=5.1700e-06 nf=1 m=2 par=2
XMpar9 ib.t1 ib.t0 vss.t21 vss.t20 nfet_03v3 w=4.61u l=2.5u ad=2.7660e-12 pd=1.0420e-05 as=1.2908e-12 ps=5.1700e-06 nf=1 m=2 par=2
XMpar10 a_8965_3013.t3 a_5408_14272.t176 vss.t2 vss.t0 nfet_03v3 w=2.14u l=2u ad=5.9920e-13 pd=2.7000e-06 as=9.4160e-13 ps=4.0900e-06 nf=1 m=4 par=4
XMpar11 a_1692_996.t3 a_1692_996.t2 vdd.t5 vdd.t4 pfet_03v3 w=10u l=2.5u ad=6.0000e-12 pd=2.1200e-05 as=2.8000e-12 ps=1.0560e-05 nf=1 m=2 par=2
Rpar0 a_1692_996.t0 a_1692_996.t2 100.3742
Rpar1 a_1692_996.t0 a_1692_996.t3 51.0894
Rpar2 a_1692_996.t2 a_1692_996.t3 13.1674
Rpar3 a_2192_1204.t0 a_2192_1204.t128 39.9427
Rpar4 a_5288_14480.t0 a_5288_14480.t7 48.5396
Rpar5 a_5408_14272.t0 a_5408_14272.t1 5.7754
Rpar6 a_5408_14272.t0 a_5408_14272.t33 703.3110
Rpar7 a_5408_14272.t0 a_5408_14272.t176 168.8302
Rpar8 a_5408_14272.t1 a_5408_14272.t32 887.5311
Rpar9 a_5408_14272.t1 a_5408_14272.t33 205.1377
Rpar10 a_5408_14272.t1 a_5408_14272.t176 49.2434
Rpar11 a_5408_14272.t32 a_5408_14272.t33 3.5489
Rpar12 a_5408_14272.t32 a_5408_14272.t176 1123.9804
Rpar13 a_5408_14272.t33 a_5408_14272.t176 259.7889
Rpar14 a_8540_14480.t0 a_8540_14480.t2 27.1567
Rpar15 a_8965_3013.t0 a_8965_3013.t3 48.6308
Rpar16 a_9614_3013.t0 a_9614_3013.t2 48.5374
Rpar17 ib ib.t0 14.0043
Rpar18 ib ib.t1 3.6652
Rpar19 inn inn.t0 1.5488
Rpar20 inp inp.t0 1.5488
Rpar21 out out.t0 453.1908
Rpar22 out out.t2 3.4855
Rpar23 out.t0 out.t2 145.7610
Rpar24 vdd vdd.t0 28.2041
Rpar25 vdd vdd.t10 294.5450
Rpar26 vdd vdd.t5 2636.3311
Rpar27 vdd.t0 vdd.t10 71.1759
Rpar28 vdd.t0 vdd.t5 637.0615
Rpar29 vdd.t10 vdd.t4 1623.2204
Rpar30 vdd.t10 vdd.t5 53.7048
Rpar31 vdd.t4 vdd.t5 13.1938
Rpar32 vss vss.t0 31.1118
Rpar33 vss vss.t2 358.9044
Rpar34 vss vss.t20 288.5112
Rpar35 vss vss.t21 366.2248
Rpar36 vss.t0 vss.t2 4.2650
Rpar37 vss.t0 vss.t20 119.5716
Rpar38 vss.t0 vss.t21 151.8781
Rpar39 vss.t2 vss.t20 1347.3224
Rpar40 vss.t2 vss.t21 1711.3064
Rpar41 vss.t20 vss.t21 10.5066
Cpar0 a_1692_996.t0 vss 2.32565e-15
Cpar1 a_1692_996.t2 vss 3.07895e-14
Cpar2 a_1692_996.t3 vss 8.01523e-15
Cpar3 a_2192_1204.t0 vss 8.06056e-14
Cpar4 a_2192_1204.t128 vss 2.33829e-14
Cpar5 a_5288_14480.t0 vss 8.26266e-14
Cpar6 a_5288_14480.t7 vss 4.49247e-14
Cpar7 a_5408_14272.t0 vss 2.82387e-14
Cpar8 a_5408_14272.t1 vss 1.84871e-14
Cpar9 a_5408_14272.t176 vss 1.24717e-14
Cpar10 a_5408_14272.t32 vss 1.40676e-13
Cpar11 a_5408_14272.t33 vss 5.64688e-14
Cpar12 a_8540_14480.t0 vss 9.17015e-14
Cpar13 a_8540_14480.t2 vss 5.07628e-14
Cpar14 a_8965_3013.t0 vss 1.85839e-14
Cpar15 a_8965_3013.t3 vss 4.86355e-15
Cpar16 a_9614_3013.t0 vss 5.56102e-15
Cpar17 a_9614_3013.t2 vss 2.41501e-14
Cpar18 ib out 5.77900e-17
Cpar19 ib vdd 4.77500e-17
Cpar20 ib vss 1.10550e-14
Cpar21 ib.t0 vss 1.46399e-15
Cpar22 ib.t1 vss 3.39580e-16
Cpar23 inn inp 9.76600e-17
Cpar24 inn vdd 2.95577e-14
Cpar25 inn vss 6.21323e-15
Cpar26 inn.t0 vss 4.42284e-14
Cpar27 inp vdd 2.92534e-14
Cpar28 inp vss 6.19460e-15
Cpar29 inp.t0 vss 4.40797e-14
Cpar30 out vdd 3.40231e-14
Cpar31 out vss 3.29627e-14
Cpar32 out.t0 vss 8.30967e-14
Cpar33 out.t2 vss 2.49496e-14
Cpar34 vdd vss 6.21044e-13
Cpar35 vdd.t0 vss 1.61484e-13
Cpar36 vdd.t10 vss 7.34441e-14
Cpar37 vdd.t4 vss 3.66370e-14
Cpar38 vdd.t5 vss 1.03388e-14
.ends opamp_dut

Vdd vdd 0 3.300000
Vss vss 0 0
Ibias vdd ib 1.300000e-06
Vinp inp 0 DC 1.480000 AC 1 PWL(0 1.480000 2.798841e-08 1.480000 3.078725e-08 1.490000)
Rfb out inn 1m
Cload out 0 2.000000e-12
Xdut vdd vss inp inn out ib opamp_dut
.end
