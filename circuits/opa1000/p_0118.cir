* opa1000[0118]: 200f/current_reuse_3v3_i20u_subth (current_reuse, VDD=3.3V, CL=0.2pF, Iref=2.8571uA)
.include "pdk_opa.inc"
.temp 27
.option gmin=1e-12 rshunt=1e12 reltol=1e-3 abstol=1e-12 vntol=1e-5 method=gear
* Post-PEX R+C extracted netlist for current_reuse_3v3_i20u_subth
.subckt opamp_dut vdd vss inp inn out ib
XMpar0 a_1018_6661.t2 inp.t10 a_1033_10245.t0 vdd.t0 pfet_03v3 w=1.95u l=0.65u ad=5.9057e-13 pd=2.6950e-06 as=6.3514e-13 ps=2.8800e-06 nf=1 m=28 par=28
XMpar1 a_1033_10245.t0 inn.t10 a_883_10037.t2 vdd.t0 pfet_03v3 w=1.95u l=0.65u ad=6.3514e-13 pd=2.8800e-06 as=5.9057e-13 ps=2.6950e-06 nf=1 m=28 par=28
XMpar2 a_1018_6661.t20 inp.t0 a_5688_7031.t0 vss.t1 nfet_03v3 w=1.86u l=0.65u ad=6.3984e-13 pd=2.9200e-06 as=6.3984e-13 ps=2.9200e-06 nf=1 m=10 par=10
XMpar3 ib.t1 ib.t0 vss.t12 vss.t11 nfet_03v3 w=2.31u l=0.72u ad=6.4680e-13 pd=2.8700e-06 as=6.4680e-13 ps=2.8700e-06 nf=1 m=2 par=2
XMpar4 a_5688_7031.t0 inn.t0 a_883_10037.t30 vss.t1 nfet_03v3 w=1.86u l=0.65u ad=6.3984e-13 pd=2.9200e-06 as=6.3984e-13 ps=2.9200e-06 nf=1 m=10 par=10
XMpar5 out.t9 ib.t0 vss.t12 vss.t11 nfet_03v3 w=2.31u l=0.72u ad=7.9464e-13 pd=3.4600e-06 as=6.4680e-13 ps=2.8700e-06 nf=1 m=10 par=10
XMpar6 a_5688_7031.t20 ib.t0 vss.t12 vss.t11 nfet_03v3 w=2.31u l=0.72u ad=6.4680e-13 pd=2.8700e-06 as=6.4680e-13 ps=2.8700e-06 nf=1 m=4 par=4
XMpar7 out.t1 a_1018_6661.t40 vdd.t20 vdd.t19 pfet_03v3 w=10u l=0.75u ad=2.8000e-12 pd=1.0560e-05 as=3.4400e-12 ps=1.2688e-05 nf=1 m=10 par=10
XMpar8 a_1033_10245.t28 a_883_10037.t0 vdd.t20 vdd.t19 pfet_03v3 w=10u l=0.75u ad=2.8000e-12 pd=1.0560e-05 as=6.0000e-12 ps=2.1200e-05 nf=1 m=2 par=2
XMpar9 a_883_10037.t1 a_883_10037.t0 vdd.t20 vdd.t19 pfet_03v3 w=10u l=0.75u ad=6.0000e-12 pd=2.1200e-05 as=2.8000e-12 ps=1.0560e-05 nf=1 m=1
XMpar10 a_1018_6661.t1 a_883_10037.t0 vdd.t20 vdd.t19 pfet_03v3 w=10u l=0.75u ad=6.0000e-12 pd=2.1200e-05 as=2.8000e-12 ps=1.0560e-05 nf=1 m=1
X70 a_7360_1290.t1 out.t0 cap_mim_2f0fF c_width=19.84u c_length=19.85u
X79 a_1018_6661.t0 a_7360_1290.t0 vss.t0 ppolyf_u_1k r_width=1u r_length=6.75u
Rpar0 a_1018_6661.t0 a_1018_6661.t1 95.7578
Rpar1 a_1018_6661.t0 a_1018_6661.t2 230.8490
Rpar2 a_1018_6661.t0 a_1018_6661.t20 422.3519
Rpar3 a_1018_6661.t0 a_1018_6661.t40 124.6010
Rpar4 a_1018_6661.t1 a_1018_6661.t2 466.2308
Rpar5 a_1018_6661.t1 a_1018_6661.t20 147.4043
Rpar6 a_1018_6661.t1 a_1018_6661.t40 251.6485
Rpar7 a_1018_6661.t2 a_1018_6661.t20 2056.3704
Rpar8 a_1018_6661.t2 a_1018_6661.t40 110.6410
Rpar9 a_1018_6661.t20 a_1018_6661.t40 1109.9280
Rpar10 a_1033_10245.t0 a_1033_10245.t28 47.2636
Rpar11 a_5688_7031.t0 a_5688_7031.t20 53.5017
Rpar12 a_7360_1290.t0 a_7360_1290.t1 60.4022
Rpar13 a_883_10037.t0 a_883_10037.t1 46.4103
Rpar14 a_883_10037.t0 a_883_10037.t2 478.0264
Rpar15 a_883_10037.t0 a_883_10037.t30 138.6863
Rpar16 a_883_10037.t1 a_883_10037.t2 398.3695
Rpar17 a_883_10037.t1 a_883_10037.t30 115.5761
Rpar18 a_883_10037.t2 a_883_10037.t30 71.5410
Rpar19 ib ib.t0 12.6100
Rpar20 ib ib.t1 9.7740
Rpar21 inn inn.t0 4.9479
Rpar22 inn inn.t10 43.7994
Rpar23 inp inp.t0 4.9479
Rpar24 inp inp.t10 43.7508
Rpar25 out out.t0 274.6434
Rpar26 out out.t1 340.8333
Rpar27 out out.t9 2.1062
Rpar28 out.t0 out.t1 354.2088
Rpar29 out.t0 out.t9 154.1083
Rpar30 out.t1 out.t9 191.2488
Rpar31 vdd vdd.t0 36.4039
Rpar32 vdd vdd.t19 68.8817
Rpar33 vdd vdd.t20 113.9727
Rpar34 vdd.t0 vdd.t19 52.9680
Rpar35 vdd.t0 vdd.t20 85.6559
Rpar36 vdd.t19 vdd.t20 3.3549
Rpar37 vss vss.t0 73.7905
Rpar38 vss vss.t1 32.1076
Rpar39 vss vss.t11 84.9689
Rpar40 vss vss.t12 412.2975
Rpar41 vss.t0 vss.t1 7.1887
Rpar42 vss.t0 vss.t11 64.1611
Rpar43 vss.t0 vss.t12 354.6436
Rpar44 vss.t1 vss.t11 7.9315
Rpar45 vss.t1 vss.t12 45.2540
Rpar46 vss.t11 vss.t12 4.2489
Cpar0 a_1018_6661.t0 vss 5.13055e-15
Cpar1 a_1018_6661.t1 vss 8.34474e-15
Cpar2 a_1018_6661.t2 vss 1.72931e-14
Cpar3 a_1018_6661.t20 vss 1.05273e-14
Cpar4 a_1018_6661.t40 vss 1.88429e-14
Cpar5 a_1033_10245.t0 vss 3.93510e-14
Cpar6 a_1033_10245.t28 vss 5.41880e-15
Cpar7 a_5688_7031.t0 vss 1.41323e-14
Cpar8 a_5688_7031.t20 vss 6.07686e-15
Cpar9 a_7360_1290.t0 vss 1.10130e-16
Cpar10 a_7360_1290.t1 vss 5.16833e-15
Cpar11 a_883_10037.t0 vss 9.76128e-15
Cpar12 a_883_10037.t1 vss 8.83446e-15
Cpar13 a_883_10037.t2 vss 1.97113e-14
Cpar14 a_883_10037.t30 vss 1.23080e-14
Cpar15 ib out 1.31541e-15
Cpar16 ib vss 1.52620e-14
Cpar17 ib.t0 vss 2.67764e-15
Cpar18 ib.t1 vss 2.60884e-16
Cpar19 inn inp 2.04440e-16
Cpar20 inn vdd 1.38984e-14
Cpar21 inn vss 1.09775e-14
Cpar22 inn.t0 vss 4.01997e-15
Cpar23 inn.t10 vss 1.90150e-14
Cpar24 inp out 2.84470e-16
Cpar25 inp vdd 1.33801e-14
Cpar26 inp vss 1.09579e-14
Cpar27 inp.t0 vss 3.92616e-15
Cpar28 inp.t10 vss 1.85696e-14
Cpar29 out vdd 1.45336e-14
Cpar30 out vss 1.84816e-14
Cpar31 out.t0 vss 1.14214e-14
Cpar32 out.t1 vss 1.20800e-14
Cpar33 out.t9 vss 4.48269e-15
Cpar34 vdd vss 1.61620e-13
Cpar35 vdd.t0 vss 3.95461e-14
Cpar36 vdd.t19 vss 2.25813e-14
Cpar37 vdd.t20 vss 1.61323e-14
.ends opamp_dut

Vdd vdd 0 3.300000
Vss vss 0 0
Ibias vdd ib 2.857100e-06
Vinp inp 0 DC 1.645000 AC 1 PWL(0 1.645000 5.460726e-09 1.645000 6.006799e-09 1.655000)
Rfb out inn 1m
Cload out 0 2.000000e-13
Xdut vdd vss inp inn out ib opamp_dut
.end
