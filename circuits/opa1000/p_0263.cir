* opa1000[0263]: 200f/folded_cascode_pmos_1v8_i10u_weak (folded_cascode_pmos, VDD=1.8V, CL=0.2pF, Iref=1.5556uA)
.include "pdk_opa.inc"
.temp 27
.option gmin=1e-12 rshunt=1e12 reltol=1e-3 abstol=1e-12 vntol=1e-5 method=gear
* Post-PEX R+C extracted netlist for folded_cascode_pmos_1v8_i10u_weak
.subckt opamp_dut vdd vss inp inn out ib
XMpar0 a_1714_2890.t8 a_2172_4656.t2 vdd.t1 vdd.t0 pfet_03v3 w=2.98u l=1.44u ad=8.3440e-13 pd=3.5400e-06 as=1.3112e-12 ps=5.3500e-06 nf=1 m=4 par=4
XMpar1 a_1714_2890.t0 inp.t0 a_1990_2890.t0 vdd.t2 pfet_03v3 w=1.95u l=0.78u ad=7.0200e-13 pd=3.1575e-06 as=5.4600e-13 ps=2.5100e-06 nf=1 m=8 par=8
XMpar2 a_4174_6832.t0 a_2172_4656.t10 out.t0 vss.t0 nfet_03v3 w=1.43u l=1.13u ad=8.5800e-13 pd=4.0600e-06 as=4.0040e-13 ps=1.9900e-06 nf=1 m=2 par=2
XMpar3 a_1714_2890.t0 inn.t0 a_4174_6832.t6 vdd.t2 pfet_03v3 w=1.95u l=0.78u ad=7.0200e-13 pd=3.1575e-06 as=5.4600e-13 ps=2.5100e-06 nf=1 m=8 par=8
XMpar4 a_1990_2890.t9 ib.t0 vss.t4 vss.t3 nfet_03v3 w=1.32u l=1.88u ad=3.6960e-13 pd=1.8800e-06 as=5.8080e-13 ps=2.8600e-06 nf=1 m=4 par=4
XMpar5 ib.t1 ib.t0 vss.t4 vss.t3 nfet_03v3 w=1.32u l=1.88u ad=7.9200e-13 pd=3.8400e-06 as=3.6960e-13 ps=1.8800e-06 nf=1 m=2 par=2
XMpar6 a_3356_8538.t3 a_3356_8538.t2 vdd.t1 vdd.t0 pfet_03v3 w=2.98u l=1.44u ad=1.7880e-12 pd=7.1600e-06 as=8.3440e-13 ps=3.5400e-06 nf=1 m=2 par=2
XMpar7 out.t2 a_3356_8538.t2 vdd.t1 vdd.t0 pfet_03v3 w=2.98u l=1.44u ad=8.3440e-13 pd=3.5400e-06 as=8.3440e-13 ps=3.5400e-06 nf=1 m=2 par=2
XMpar8 a_1990_2890.t8 a_2172_4656.t10 a_3356_8538.t0 vss.t0 nfet_03v3 w=1.43u l=1.13u ad=8.5800e-13 pd=4.0600e-06 as=4.0040e-13 ps=1.9900e-06 nf=1 m=2 par=2
XMpar9 a_2172_4656.t3 a_2172_4656.t2 vdd.t1 vdd.t0 pfet_03v3 w=2.98u l=1.44u ad=8.3440e-13 pd=3.5400e-06 as=8.3440e-13 ps=3.5400e-06 nf=1 m=2 par=2
XMpar10 a_4174_6832.t2 ib.t0 vss.t4 vss.t3 nfet_03v3 w=1.32u l=1.88u ad=3.6960e-13 pd=1.8800e-06 as=5.8080e-13 ps=2.8600e-06 nf=1 m=4 par=4
XMpar11 a_2172_4656.t0 ib.t0 vss.t4 vss.t3 nfet_03v3 w=1.32u l=1.88u ad=3.6960e-13 pd=1.8800e-06 as=3.6960e-13 ps=1.8800e-06 nf=1 m=2 par=2
Rpar0 a_1714_2890.t0 a_1714_2890.t8 46.0419
Rpar1 a_1990_2890.t0 a_1990_2890.t9 63.2190
Rpar2 a_1990_2890.t0 a_1990_2890.t8 93.6598
Rpar3 a_1990_2890.t9 a_1990_2890.t8 117.1776
Rpar4 a_2172_4656.t0 a_2172_4656.t10 98.9087
Rpar5 a_2172_4656.t0 a_2172_4656.t2 169.2068
Rpar6 a_2172_4656.t0 a_2172_4656.t3 105.4854
Rpar7 a_2172_4656.t10 a_2172_4656.t2 182.2831
Rpar8 a_2172_4656.t10 a_2172_4656.t3 113.6373
Rpar9 a_2172_4656.t2 a_2172_4656.t3 25.3185
Rpar10 a_3356_8538.t0 a_3356_8538.t2 209.3972
Rpar11 a_3356_8538.t0 a_3356_8538.t3 57.2273
Rpar12 a_3356_8538.t2 a_3356_8538.t3 19.2170
Rpar13 a_4174_6832.t0 a_4174_6832.t6 93.6598
Rpar14 a_4174_6832.t0 a_4174_6832.t2 117.1776
Rpar15 a_4174_6832.t6 a_4174_6832.t2 63.2190
Rpar16 ib ib.t0 9.6181
Rpar17 ib ib.t1 6.6961
Rpar18 inn inn.t0 3.5188
Rpar19 inp inp.t0 3.5674
Rpar20 out out.t0 12.3855
Rpar21 out out.t2 37.3264
Rpar22 vdd vdd.t0 39.7827
Rpar23 vdd vdd.t1 56.6458
Rpar24 vdd vdd.t2 201.1912
Rpar25 vdd.t0 vdd.t1 4.3799
Rpar26 vdd.t0 vdd.t2 44.8695
Rpar27 vdd.t1 vdd.t2 56.7151
Rpar28 vss vss.t0 209.9142
Rpar29 vss vss.t4 89.8943
Rpar30 vss vss.t3 98.5982
Rpar31 vss.t0 vss.t4 25.7847
Rpar32 vss.t0 vss.t3 19.7150
Rpar33 vss.t4 vss.t3 8.3758
Cpar0 a_1714_2890.t0 vss 1.19160e-14
Cpar1 a_1714_2890.t8 vss 5.39840e-15
Cpar2 a_1990_2890.t0 vss 4.50887e-15
Cpar3 a_1990_2890.t8 vss 2.38381e-15
Cpar4 a_1990_2890.t9 vss 2.31875e-15
Cpar5 a_2172_4656.t0 vss 1.38708e-15
Cpar6 a_2172_4656.t10 vss 3.16031e-15
Cpar7 a_2172_4656.t2 vss 6.71582e-15
Cpar8 a_2172_4656.t3 vss 2.24603e-15
Cpar9 a_3356_8538.t0 vss 1.09643e-15
Cpar10 a_3356_8538.t2 vss 5.06664e-15
Cpar11 a_3356_8538.t3 vss 3.64609e-15
Cpar12 a_4174_6832.t0 vss 3.02421e-15
Cpar13 a_4174_6832.t2 vss 2.94165e-15
Cpar14 a_4174_6832.t6 vss 5.72017e-15
Cpar15 ib inn 1.75200e-17
Cpar16 ib inp 2.23900e-17
Cpar17 ib vdd 5.71600e-17
Cpar18 ib vss 2.13112e-14
Cpar19 ib.t0 vss 2.65294e-15
Cpar20 ib.t1 vss 6.96000e-17
Cpar21 inn inp 5.19700e-17
Cpar22 inn vdd 4.57277e-15
Cpar23 inn vss 3.16673e-15
Cpar24 inn.t0 vss 3.34157e-15
Cpar25 inp vdd 4.52363e-15
Cpar26 inp vss 3.24954e-15
Cpar27 inp.t0 vss 3.35017e-15
Cpar28 out vdd 2.81126e-15
Cpar29 out vss 3.29430e-15
Cpar30 out.t0 vss 2.37165e-16
Cpar31 out.t2 vss 3.03368e-15
Cpar32 vdd vss 7.37596e-14
Cpar33 vdd.t0 vss 1.16022e-14
Cpar34 vdd.t1 vss 8.58654e-15
Cpar35 vdd.t2 vss 1.44776e-14
.ends opamp_dut

Vdd vdd 0 1.800000
Vss vss 0 0
Ibias vdd ib 1.555600e-06
Vinp inp 0 DC 0.751000 AC 1 PWL(0 0.751000 6.294665e-09 0.751000 6.924131e-09 0.761000)
Rfb out inn 1m
Cload out 0 2.000000e-13
Xdut vdd vss inp inn out ib opamp_dut
.end
