* opa1000[0838]: 200f/telescopic_nmos_1v8_i200n_weak (telescopic_nmos, VDD=1.8V, CL=0.2pF, Iref=0.065uA)
.include "pdk_opa.inc"
.temp 27
.option gmin=1e-12 rshunt=1e12 reltol=1e-3 abstol=1e-12 vntol=1e-5 method=gear
* Post-PEX R+C extracted netlist for telescopic_nmos_1v8_i200n_weak
.subckt opamp_dut vdd vss inp inn out ib
XMpar0 a_2772_11421.t2 a_2892_11212.t8 vdd.t1 vdd.t0 pfet_03v3 w=1.65u l=9.75u ad=9.9000e-13 pd=4.5000e-06 as=4.6200e-13 ps=2.2100e-06 nf=1 m=2 par=2
XMpar1 a_2772_11421.t0 a_2892_11212.t2 a_2892_11212.t3 vdd.t2 pfet_03v3 w=1.86u l=3.5u ad=1.1160e-12 pd=4.9200e-06 as=1.1160e-12 ps=4.9200e-06 nf=1 m=2 par=2
XMpar2 a_2614_1249.t0 ib.t0 vss.t1 vss.t0 nfet_03v3 w=0.4u l=6.25u ad=1.1200e-13 pd=9.6000e-07 as=2.0800e-13 ps=1.7400e-06 nf=1 m=8 par=8
XMpar3 a_6224_9398.t1 a_2892_11212.t2 out.t0 vdd.t2 pfet_03v3 w=1.86u l=3.5u ad=1.1160e-12 pd=4.9200e-06 as=5.2080e-13 ps=2.4200e-06 nf=1 m=2 par=2
XMpar4 ib.t1 ib.t0 vss.t1 vss.t0 nfet_03v3 w=0.4u l=6.25u ad=2.4000e-13 pd=2.0000e-06 as=1.1200e-13 ps=9.6000e-07 nf=1 m=2 par=2
XMpar5 a_2614_1249.t8 inp.t0 a_4684_1249.t0 vss.t15 nfet_03v3 w=1.6u l=9.75u ad=9.6000e-13 pd=4.4000e-06 as=4.4800e-13 ps=2.1600e-06 nf=1 m=4 par=4
XMpar6 a_6224_9398.t0 a_2892_11212.t8 vdd.t1 vdd.t0 pfet_03v3 w=1.65u l=9.75u ad=4.6200e-13 pd=2.2100e-06 as=4.6200e-13 ps=2.2100e-06 nf=1 m=2 par=2
XMpar7 a_2892_11212.t0 vdd.t12 a_4684_1249.t4 vss.t17 nfet_03v3 w=0.48u l=3.5u ad=2.8800e-13 pd=2.1600e-06 as=2.8800e-13 ps=2.1600e-06 nf=1 m=2 par=2
XMpar8 a_2614_1249.t8 inn.t0 a_7874_7080.t2 vss.t15 nfet_03v3 w=1.6u l=9.75u ad=9.6000e-13 pd=4.4000e-06 as=4.4800e-13 ps=2.1600e-06 nf=1 m=4 par=4
XMpar9 a_7874_7080.t0 vdd.t12 out.t1 vss.t17 nfet_03v3 w=0.48u l=3.5u ad=2.8800e-13 pd=2.1600e-06 as=2.8800e-13 ps=2.1600e-06 nf=1 m=2 par=2
X2 out.t4 vss.t19 cap_mim_2f0fF c_width=14.79u c_length=14.79u
Rpar0 a_2614_1249.t0 a_2614_1249.t8 52.3728
Rpar1 a_2772_11421.t0 a_2772_11421.t2 62.5652
Rpar2 a_2892_11212.t0 a_2892_11212.t8 134.6593
Rpar3 a_2892_11212.t0 a_2892_11212.t2 178.0149
Rpar4 a_2892_11212.t0 a_2892_11212.t3 83.7336
Rpar5 a_2892_11212.t8 a_2892_11212.t2 190.3335
Rpar6 a_2892_11212.t8 a_2892_11212.t3 89.5280
Rpar7 a_2892_11212.t2 a_2892_11212.t3 21.8471
Rpar8 a_4684_1249.t0 a_4684_1249.t4 73.1168
Rpar9 a_6224_9398.t0 a_6224_9398.t1 68.5628
Rpar10 a_7874_7080.t0 a_7874_7080.t2 73.1168
Rpar11 ib ib.t0 14.2472
Rpar12 ib ib.t1 14.6153
Rpar13 ib.t0 ib.t1 33.5448
Rpar14 inn inn.t0 3.2520
Rpar15 inp inp.t0 3.2519
Rpar16 out out.t0 149.0435
Rpar17 out out.t1 80.2940
Rpar18 out out.t4 15.4613
Rpar19 out.t0 out.t1 105.1611
Rpar20 out.t0 out.t4 1409.1991
Rpar21 out.t1 out.t4 759.1763
Rpar22 vdd vdd.t0 39.0131
Rpar23 vdd vdd.t1 97.5102
Rpar24 vdd vdd.t2 51.5051
Rpar25 vdd vdd.t12 320.9281
Rpar26 vdd.t0 vdd.t1 12.1086
Rpar27 vdd.t0 vdd.t2 171.3980
Rpar28 vdd.t0 vdd.t12 1067.9806
Rpar29 vdd.t1 vdd.t2 428.3965
Rpar30 vdd.t1 vdd.t12 2669.3376
Rpar31 vdd.t2 vdd.t12 75.3294
Rpar32 vss vss.t0 120.9968
Rpar33 vss vss.t1 613.3554
Rpar34 vss vss.t15 461.0556
Rpar35 vss vss.t17 1045.2418
Rpar36 vss vss.t19 711.8644
Rpar37 vss.t0 vss.t1 14.1545
Rpar38 vss.t0 vss.t15 5.1745
Rpar39 vss.t0 vss.t17 10.0084
Rpar40 vss.t0 vss.t19 70.6512
Rpar41 vss.t1 vss.t15 59.1747
Rpar42 vss.t1 vss.t17 126.3615
Rpar43 vss.t1 vss.t19 152.5053
Rpar44 vss.t15 vss.t17 45.2974
Rpar45 vss.t15 vss.t19 271.8547
Rpar46 vss.t17 vss.t19 607.2049
Cpar0 a_2614_1249.t0 vss 1.05513e-14
Cpar1 a_2614_1249.t8 vss 1.33180e-14
Cpar2 a_2772_11421.t0 vss 6.99253e-15
Cpar3 a_2772_11421.t2 vss 8.59802e-15
Cpar4 a_2892_11212.t0 vss 2.83521e-15
Cpar5 a_2892_11212.t2 vss 9.80709e-15
Cpar6 a_2892_11212.t3 vss 4.16559e-15
Cpar7 a_2892_11212.t8 vss 2.33312e-14
Cpar8 a_4684_1249.t0 vss 7.38461e-15
Cpar9 a_4684_1249.t4 vss 4.25000e-15
Cpar10 a_6224_9398.t0 vss 8.72960e-15
Cpar11 a_6224_9398.t1 vss 9.21742e-15
Cpar12 a_7874_7080.t0 vss 4.43050e-15
Cpar13 a_7874_7080.t2 vss 7.69820e-15
Cpar14 ib inn 3.42100e-17
Cpar15 ib inp 1.08000e-17
Cpar16 ib vdd 1.52600e-17
Cpar17 ib vss 4.50773e-14
Cpar18 ib.t0 vss 6.29903e-15
Cpar19 ib.t1 vss 4.91669e-16
Cpar20 inn inp 1.02860e-16
Cpar21 inn vss 1.69326e-14
Cpar22 inn.t0 vss 3.60606e-15
Cpar23 inp vss 1.68480e-14
Cpar24 inp.t0 vss 3.58403e-15
Cpar25 out vdd 4.16413e-15
Cpar26 out vss 1.13957e-14
Cpar27 out.t0 vss 5.13321e-16
Cpar28 out.t1 vss 5.15738e-16
Cpar29 out.t4 vss 9.94358e-15
Cpar30 vdd vss 9.85216e-14
Cpar31 vdd.t0 vss 1.64910e-14
Cpar32 vdd.t1 vss 7.08494e-15
Cpar33 vdd.t12 vss 3.30995e-15
Cpar34 vdd.t2 vss 1.42544e-14
.ends opamp_dut

Vdd vdd 0 1.800000
Vss vss 0 0
Ibias vdd ib 6.500000e-08
Vinp inp 0 DC 0.931000 AC 1 PWL(0 0.931000 2.038177e-07 0.931000 2.241995e-07 0.941000)
Rfb out inn 1m
Cload out 0 2.000000e-13
Xdut vdd vss inp inn out ib opamp_dut
.end
