* opa1000[0085]: 200f/current_reuse_1v8_i50n_subth (current_reuse, VDD=1.8V, CL=0.2pF, Iref=0.0071uA)
.include "pdk_opa.inc"
.temp 27
.option gmin=1e-12 rshunt=1e12 reltol=1e-3 abstol=1e-12 vntol=1e-5 method=gear
* Post-PEX R+C extracted netlist for current_reuse_1v8_i50n_subth
.subckt opamp_dut vdd vss inp inn out ib
XMpar0 out.t1 ib.t0 vss.t2 vss.t1 nfet_03v3 w=0.4u l=6.25u ad=1.8880e-13 pd=1.5840e-06 as=1.6320e-13 ps=1.3760e-06 nf=1 m=10 par=10
XMpar1 a_4705_12531.t4 inn.t4 a_7364_15707.t2 vss.t28 nfet_03v3 w=0.92u l=5.5u ad=5.5200e-13 pd=3.0400e-06 as=2.5760e-13 ps=1.4800e-06 nf=1 m=2 par=2
XMpar2 a_2690_9030.t2 inn.t0 a_7364_15707.t4 vdd.t14 pfet_03v3 w=1.71u l=5.5u ad=7.5240e-13 pd=3.4450e-06 as=4.7880e-13 ps=2.2700e-06 nf=1 m=4 par=4
XMpar3 out.t0 a_1161_1290.t8 vdd.t1 vdd.t0 pfet_03v3 w=0.4u l=2.4u ad=1.3760e-13 pd=1.1680e-06 as=1.3760e-13 ps=1.1680e-06 nf=1 m=10 par=10
XMpar4 a_1161_1290.t3 inp.t0 a_2690_9030.t2 vdd.t14 pfet_03v3 w=1.71u l=5.5u ad=4.7880e-13 pd=2.2700e-06 as=7.5240e-13 ps=3.4450e-06 nf=1 m=4 par=4
XMpar5 a_2690_9030.t0 a_7364_15707.t0 vdd.t1 vdd.t0 pfet_03v3 w=0.4u l=2.4u ad=1.1200e-13 pd=9.6000e-07 as=2.4000e-13 ps=2.0000e-06 nf=1 m=2 par=2
XMpar6 a_4705_12531.t0 ib.t0 vss.t2 vss.t1 nfet_03v3 w=0.4u l=6.25u ad=2.4000e-13 pd=2.0000e-06 as=1.1200e-13 ps=9.6000e-07 nf=1 m=4 par=4
XMpar7 a_1161_1290.t0 a_7364_15707.t0 vdd.t1 vdd.t0 pfet_03v3 w=0.4u l=2.4u ad=2.4000e-13 pd=2.0000e-06 as=1.1200e-13 ps=9.6000e-07 nf=1 m=1
XMpar8 ib.t1 ib.t0 vss.t2 vss.t1 nfet_03v3 w=0.4u l=6.25u ad=2.4000e-13 pd=2.0000e-06 as=1.1200e-13 ps=9.6000e-07 nf=1 m=2 par=2
XMpar9 a_7364_15707.t1 a_7364_15707.t0 vdd.t1 vdd.t0 pfet_03v3 w=0.4u l=2.4u ad=2.4000e-13 pd=2.0000e-06 as=1.1200e-13 ps=9.6000e-07 nf=1 m=1
XMpar10 a_1161_1290.t1 inp.t4 a_4705_12531.t4 vss.t28 nfet_03v3 w=0.92u l=5.5u ad=2.5760e-13 pd=1.4800e-06 as=5.5200e-13 ps=3.0400e-06 nf=1 m=2 par=2
X1 a_1161_4930.t0 a_5139_5450.t0 vss.t0 ppolyf_u_1k r_width=1u r_length=19.23u
X4 a_1161_1810.t0 a_5139_2330.t0 vss.t0 ppolyf_u_1k r_width=1u r_length=19.23u
X10 a_1161_4930.t0 a_5139_4410.t0 vss.t0 ppolyf_u_1k r_width=1u r_length=19.23u
X13 a_1161_1810.t0 a_5139_1290.t0 vss.t0 ppolyf_u_1k r_width=1u r_length=19.23u
X17 a_1161_7010.t0 a_5139_7530.t0 vss.t0 ppolyf_u_1k r_width=1u r_length=19.23u
X18 a_1161_3890.t0 a_5139_4410.t0 vss.t0 ppolyf_u_1k r_width=1u r_length=19.23u
X24 a_1161_7010.t0 a_5139_6490.t0 vss.t0 ppolyf_u_1k r_width=1u r_length=19.23u
X27 a_5139_7530.t1 out.t19 cap_mim_2f0fF c_width=15u c_length=15u
X32 a_1161_1290.t7 a_5139_1290.t0 vss.t0 ppolyf_u_1k r_width=1u r_length=19.23u
X40 a_1161_3890.t0 a_5139_3370.t0 vss.t0 ppolyf_u_1k r_width=1u r_length=19.23u
X46 a_1161_5970.t0 a_5139_6490.t0 vss.t0 ppolyf_u_1k r_width=1u r_length=19.23u
X48 a_1161_2850.t0 a_5139_3370.t0 vss.t0 ppolyf_u_1k r_width=1u r_length=19.23u
X51 a_1161_5970.t0 a_5139_5450.t0 vss.t0 ppolyf_u_1k r_width=1u r_length=19.23u
X53 a_1161_2850.t0 a_5139_2330.t0 vss.t0 ppolyf_u_1k r_width=1u r_length=19.23u
Rpar0 a_1161_1290.t0 a_1161_1290.t1 313.0476
Rpar1 a_1161_1290.t0 a_1161_1290.t8 102.5300
Rpar2 a_1161_1290.t0 a_1161_1290.t3 354.5983
Rpar3 a_1161_1290.t0 a_1161_1290.t7 780.9365
Rpar4 a_1161_1290.t1 a_1161_1290.t8 360.7638
Rpar5 a_1161_1290.t1 a_1161_1290.t3 96.1189
Rpar6 a_1161_1290.t1 a_1161_1290.t7 211.6838
Rpar7 a_1161_1290.t8 a_1161_1290.t3 408.6480
Rpar8 a_1161_1290.t8 a_1161_1290.t7 899.9708
Rpar9 a_1161_1290.t3 a_1161_1290.t7 129.6192
Rpar10 a_2690_9030.t0 a_2690_9030.t2 73.0831
Rpar11 a_4705_12531.t0 a_4705_12531.t4 65.3833
Rpar12 a_5139_7530.t0 a_5139_7530.t1 68.9207
Rpar13 a_7364_15707.t0 a_7364_15707.t1 28.3020
Rpar14 a_7364_15707.t0 a_7364_15707.t2 223.7738
Rpar15 a_7364_15707.t0 a_7364_15707.t4 120.8338
Rpar16 a_7364_15707.t1 a_7364_15707.t2 762.0651
Rpar17 a_7364_15707.t1 a_7364_15707.t4 411.5014
Rpar18 a_7364_15707.t2 a_7364_15707.t4 77.7796
Rpar19 ib ib.t0 18.1489
Rpar20 ib ib.t1 15.7667
Rpar21 ib.t0 ib.t1 34.3536
Rpar22 inn inn.t0 42.7603
Rpar23 inn inn.t4 3.4275
Rpar24 inp inp.t0 51.9997
Rpar25 inp inp.t4 3.4761
Rpar26 out out.t0 46.0450
Rpar27 out out.t1 127.0838
Rpar28 out out.t19 20.4125
Rpar29 out.t0 out.t1 190.3680
Rpar30 out.t0 out.t19 572.1382
Rpar31 out.t1 out.t19 1579.0965
Rpar32 vdd vdd.t0 109.3931
Rpar33 vdd vdd.t1 42.4931
Rpar34 vdd vdd.t14 328.3952
Rpar35 vdd.t0 vdd.t1 7.0560
Rpar36 vdd.t0 vdd.t14 152.2588
Rpar37 vdd.t1 vdd.t14 85.2489
Rpar38 vss vss.t0 26.3602
Rpar39 vss vss.t1 137.6307
Rpar40 vss vss.t2 1804.8173
Rpar41 vss vss.t28 378.3988
Rpar42 vss.t0 vss.t1 162.3478
Rpar43 vss.t0 vss.t2 2114.9671
Rpar44 vss.t0 vss.t28 455.6681
Rpar45 vss.t1 vss.t2 16.0457
Rpar46 vss.t1 vss.t28 3.2404
Rpar47 vss.t2 vss.t28 54.3312
Cpar0 a_1161_1290.t0 vss 3.49527e-15
Cpar1 a_1161_1290.t1 vss 4.76686e-15
Cpar2 a_1161_1290.t3 vss 6.89714e-15
Cpar3 a_1161_1290.t7 vss 5.32260e-15
Cpar4 a_1161_1290.t8 vss 1.31506e-14
Cpar5 a_1161_1810.t0 vss 3.20200e-17
Cpar6 a_1161_2850.t0 vss 2.93600e-17
Cpar7 a_1161_3890.t0 vss 2.93600e-17
Cpar8 a_1161_4930.t0 vss 2.93600e-17
Cpar9 a_1161_5970.t0 vss 3.00800e-17
Cpar10 a_1161_7010.t0 vss 2.64400e-17
Cpar11 a_2690_9030.t0 vss 5.16306e-15
Cpar12 a_2690_9030.t2 vss 1.20749e-14
Cpar13 a_4705_12531.t0 vss 1.98004e-14
Cpar14 a_4705_12531.t4 vss 8.37091e-15
Cpar15 a_5139_1290.t0 vss 3.38800e-17
Cpar16 a_5139_2330.t0 vss 3.59200e-17
Cpar17 a_5139_3370.t0 vss 3.52000e-17
Cpar18 a_5139_4410.t0 vss 3.52000e-17
Cpar19 a_5139_5450.t0 vss 3.52000e-17
Cpar20 a_5139_6490.t0 vss 3.92800e-17
Cpar21 a_5139_7530.t0 vss 4.51200e-16
Cpar22 a_5139_7530.t1 vss 7.23727e-15
Cpar23 a_7364_15707.t0 vss 1.02875e-14
Cpar24 a_7364_15707.t1 vss 2.26208e-15
Cpar25 a_7364_15707.t2 vss 4.08013e-15
Cpar26 a_7364_15707.t4 vss 7.76375e-15
Cpar27 ib inn 1.73800e-17
Cpar28 ib inp 2.04200e-17
Cpar29 ib out 2.32470e-15
Cpar30 ib vdd 1.80380e-16
Cpar31 ib vss 6.88367e-14
Cpar32 ib.t0 vss 1.12504e-14
Cpar33 ib.t1 vss 8.35040e-16
Cpar34 inn inp 1.04470e-16
Cpar35 inn vdd 1.18417e-14
Cpar36 inn vss 9.71012e-15
Cpar37 inn.t0 vss 1.07775e-14
Cpar38 inn.t4 vss 2.16787e-15
Cpar39 inp vdd 1.04741e-14
Cpar40 inp vss 9.82585e-15
Cpar41 inp.t0 vss 1.01008e-14
Cpar42 inp.t4 vss 2.03682e-15
Cpar43 out vdd 1.07618e-14
Cpar44 out vss 2.68719e-14
Cpar45 out.t0 vss 5.52527e-15
Cpar46 out.t1 vss 1.30968e-14
Cpar47 out.t19 vss 8.77298e-15
Cpar48 vdd vss 1.18111e-13
Cpar49 vdd.t0 vss 2.22958e-14
Cpar50 vdd.t1 vss 1.10989e-14
Cpar51 vdd.t14 vss 3.06013e-14
.ends opamp_dut

Vdd vdd 0 1.800000
Vss vss 0 0
Ibias vdd ib 7.100000e-09
Vinp inp 0 DC 0.895000 AC 1 PWL(0 0.895000 1.131015e-06 0.895000 1.244117e-06 0.905000)
Rfb out inn 1m
Cload out 0 2.000000e-13
Xdut vdd vss inp inn out ib opamp_dut
.end
