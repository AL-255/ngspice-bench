* opa1000[0417]: 200f/nmos_miller_1v8_ulp_lt0p1uw_subth (nmos_miller, VDD=1.8V, CL=0.2pF, Iref=0.0002uA)
.include "pdk_opa.inc"
.temp 27
.option gmin=1e-12 rshunt=1e12 reltol=1e-3 abstol=1e-12 vntol=1e-5 method=gear
* Post-PEX R+C extracted netlist for nmos_miller_1v8_ulp_lt0p1uw_subth
.subckt opamp_dut vdd vss inp inn out ib
XMpar0 out.t0 a_1552_15426.t7 vdd.t1 vdd.t0 pfet_03v3 w=0.4u l=9.5u ad=1.3760e-13 pd=1.1680e-06 as=1.3760e-13 ps=1.1680e-06 nf=1 m=10 par=10
XMpar1 out.t8 ib.t0 vss.t6 vss.t1 nfet_03v3 w=0.4u l=9.5u ad=1.8880e-13 pd=1.5840e-06 as=1.6320e-13 ps=1.3760e-06 nf=1 m=10 par=10
XMpar2 a_1552_15426.t0 inp.t0 a_3090_1294.t0 vss.t1 nfet_03v3 w=0.47u l=8u ad=1.3160e-13 pd=1.0300e-06 as=2.0680e-13 ps=1.5850e-06 nf=1 m=4 par=4
XMpar3 a_3090_1294.t4 ib.t0 vss.t6 vss.t1 nfet_03v3 w=0.4u l=9.5u ad=2.4000e-13 pd=2.0000e-06 as=1.1200e-13 ps=9.6000e-07 nf=1 m=4 par=4
XMpar4 ib.t1 ib.t0 vss.t6 vss.t1 nfet_03v3 w=0.4u l=9.5u ad=2.4000e-13 pd=2.0000e-06 as=1.1200e-13 ps=9.6000e-07 nf=1 m=2 par=2
XMpar5 a_3090_1294.t0 inn.t0 a_6332_13765.t4 vss.t1 nfet_03v3 w=0.47u l=8u ad=2.0680e-13 pd=1.5850e-06 as=1.3160e-13 ps=1.0300e-06 nf=1 m=4 par=4
XMpar6 a_1552_15426.t4 a_6332_13765.t0 vdd.t1 vdd.t0 pfet_03v3 w=0.4u l=9.5u ad=2.4000e-13 pd=2.0000e-06 as=1.1200e-13 ps=9.6000e-07 nf=1 m=2 par=2
XMpar7 a_6332_13765.t1 a_6332_13765.t0 vdd.t1 vdd.t0 pfet_03v3 w=0.4u l=9.5u ad=1.1200e-13 pd=9.6000e-07 as=1.1200e-13 ps=9.6000e-07 nf=1 m=2 par=2
X12 a_9917_12474.t1 out.t1 cap_mim_2f0fF c_width=19.62u c_length=19.63u
X18 a_5939_7794.t0 a_9917_7274.t0 vss.t0 ppolyf_u_1k r_width=1u r_length=19.23u
X23 a_5939_9874.t0 a_9917_10394.t0 vss.t0 ppolyf_u_1k r_width=1u r_length=19.23u
X27 a_5939_6754.t0 a_9917_7274.t0 vss.t0 ppolyf_u_1k r_width=1u r_length=19.23u
X31 a_5939_9874.t0 a_9917_9354.t0 vss.t0 ppolyf_u_1k r_width=1u r_length=19.23u
X32 a_5939_6754.t0 a_9917_6234.t0 vss.t0 ppolyf_u_1k r_width=1u r_length=19.23u
X36 a_5939_11954.t0 a_9917_12474.t0 vss.t0 ppolyf_u_1k r_width=1u r_length=19.23u
X38 a_5939_8834.t0 a_9917_9354.t0 vss.t0 ppolyf_u_1k r_width=1u r_length=19.23u
X39 a_1552_15426.t6 a_9917_6234.t0 vss.t0 ppolyf_u_1k r_width=1u r_length=19.23u
X41 a_5939_11954.t0 a_9917_11434.t0 vss.t0 ppolyf_u_1k r_width=1u r_length=19.23u
X44 a_5939_8834.t0 a_9917_8314.t0 vss.t0 ppolyf_u_1k r_width=1u r_length=19.23u
X47 a_5939_10914.t0 a_9917_11434.t0 vss.t0 ppolyf_u_1k r_width=1u r_length=19.23u
X49 a_5939_7794.t0 a_9917_8314.t0 vss.t0 ppolyf_u_1k r_width=1u r_length=19.23u
X50 a_5939_10914.t0 a_9917_10394.t0 vss.t0 ppolyf_u_1k r_width=1u r_length=19.23u
Rpar0 a_1552_15426.t0 a_1552_15426.t7 201.3413
Rpar1 a_1552_15426.t0 a_1552_15426.t4 262.8287
Rpar2 a_1552_15426.t0 a_1552_15426.t6 148.7065
Rpar3 a_1552_15426.t7 a_1552_15426.t4 113.5551
Rpar4 a_1552_15426.t7 a_1552_15426.t6 172.8298
Rpar5 a_1552_15426.t4 a_1552_15426.t6 225.6102
Rpar6 a_3090_1294.t0 a_3090_1294.t4 54.7784
Rpar7 a_6332_13765.t0 a_6332_13765.t1 30.9770
Rpar8 a_6332_13765.t0 a_6332_13765.t4 189.8303
Rpar9 a_6332_13765.t1 a_6332_13765.t4 152.4432
Rpar10 a_9917_12474.t0 a_9917_12474.t1 51.2831
Rpar11 ib ib.t0 22.9621
Rpar12 ib ib.t1 16.8749
Rpar13 ib.t0 ib.t1 35.3501
Rpar14 inn inn.t0 1.8022
Rpar15 inp inp.t0 1.8508
Rpar16 out out.t0 5.6460
Rpar17 out out.t1 85.8669
Rpar18 out out.t8 80.5380
Rpar19 out.t1 out.t8 85.3579
Rpar20 vdd vdd.t0 68.0837
Rpar21 vdd vdd.t1 51.0884
Rpar22 vdd.t0 vdd.t1 6.6010
Rpar23 vss vss.t0 198.9671
Rpar24 vss vss.t1 50.4987
Rpar25 vss vss.t6 1324.9090
Rpar26 vss.t0 vss.t1 2.1436
Rpar27 vss.t0 vss.t6 64.5233
Rpar28 vss.t1 vss.t6 15.3885
Cpar0 a_1552_15426.t0 vss 7.92634e-15
Cpar1 a_1552_15426.t4 vss 8.37901e-15
Cpar2 a_1552_15426.t6 vss 6.95148e-15
Cpar3 a_1552_15426.t7 vss 4.45227e-14
Cpar4 a_3090_1294.t0 vss 1.47087e-14
Cpar5 a_3090_1294.t4 vss 2.73734e-14
Cpar6 a_5939_10914.t0 vss 3.85400e-17
Cpar7 a_5939_11954.t0 vss 3.53400e-17
Cpar8 a_5939_6754.t0 vss 4.21600e-17
Cpar9 a_5939_7794.t0 vss 3.95000e-17
Cpar10 a_5939_8834.t0 vss 3.95000e-17
Cpar11 a_5939_9874.t0 vss 3.81600e-17
Cpar12 a_6332_13765.t0 vss 1.73058e-14
Cpar13 a_6332_13765.t1 vss 4.97395e-15
Cpar14 a_6332_13765.t4 vss 9.02579e-15
Cpar15 a_9917_10394.t0 vss 2.93600e-17
Cpar16 a_9917_11434.t0 vss 3.20200e-17
Cpar17 a_9917_12474.t0 vss 5.21000e-17
Cpar18 a_9917_12474.t1 vss 2.24184e-15
Cpar19 a_9917_6234.t0 vss 2.67400e-17
Cpar20 a_9917_7274.t0 vss 3.00800e-17
Cpar21 a_9917_8314.t0 vss 2.93600e-17
Cpar22 a_9917_9354.t0 vss 2.93600e-17
Cpar23 ib inn 5.55500e-17
Cpar24 ib inp 4.81600e-17
Cpar25 ib out 2.44193e-15
Cpar26 ib vss 9.84588e-14
Cpar27 ib.t0 vss 1.51306e-14
Cpar28 ib.t1 vss 1.10826e-15
Cpar29 inn inp 5.13900e-17
Cpar30 inn vss 1.62563e-14
Cpar31 inn.t0 vss 1.14208e-15
Cpar32 inp vss 1.59247e-14
Cpar33 inp.t0 vss 1.16830e-15
Cpar34 out vdd 2.24754e-14
Cpar35 out vss 3.58058e-14
Cpar36 out.t0 vss 5.92718e-15
Cpar37 out.t1 vss 1.54987e-14
Cpar38 out.t8 vss 1.79634e-14
Cpar39 vdd vss 1.43796e-13
Cpar40 vdd.t0 vss 6.66300e-14
Cpar41 vdd.t1 vss 1.96846e-14
.ends opamp_dut

Vdd vdd 0 1.800000
Vss vss 0 0
Ibias vdd ib 2.000000e-10
Vinp inp 0 DC 0.895000 AC 1 PWL(0 0.895000 9.549297e-05 0.895000 1.050423e-04 0.905000)
Rfb out inn 1m
Cload out 0 2.000000e-13
Xdut vdd vss inp inn out ib opamp_dut
.end
