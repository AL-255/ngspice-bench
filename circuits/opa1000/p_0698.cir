* opa1000[0698]: 200f/rail_to_rail_3v3_1u_10u_weak (rail_to_rail, VDD=3.3V, CL=0.2pF, Iref=0.7188uA)
.include "pdk_opa.inc"
.temp 27
.option gmin=1e-12 rshunt=1e12 reltol=1e-3 abstol=1e-12 vntol=1e-5 method=gear
* Post-PEX R+C extracted netlist for rail_to_rail_3v3_1u_10u_weak
.subckt opamp_dut vdd vss inp inn out ib
XMpar0 a_5554_8372.t4 a_4138_1249.t2 vdd.t3 vdd.t2 pfet_03v3 w=1.76u l=1.2u ad=1.0560e-12 pd=4.7200e-06 as=4.9280e-13 ps=2.3200e-06 nf=1 m=2 par=2
XMpar1 a_4138_1249.t3 a_4138_1249.t2 vdd.t3 vdd.t2 pfet_03v3 w=1.76u l=1.2u ad=4.9280e-13 pd=2.3200e-06 as=4.9280e-13 ps=2.3200e-06 nf=1 m=2 par=2
XMpar2 a_6172_10734.t3 a_6172_10734.t2 vdd.t1 vdd.t0 pfet_03v3 w=3.65u l=1.5u ad=1.0220e-12 pd=4.2100e-06 as=1.0220e-12 ps=4.2100e-06 nf=1 m=2 par=2
XMpar3 a_6172_10734.t6 a_5152_6694.t0 vss.t1 vss.t0 nfet_03v3 w=0.49u l=3.75u ad=1.3720e-13 pd=1.0500e-06 as=1.3720e-13 ps=1.0500e-06 nf=1 m=2 par=2
XMpar4 a_5272_3236.t3 a_5272_3236.t2 vss.t1 vss.t0 nfet_03v3 w=0.49u l=3.75u ad=1.3720e-13 pd=1.0500e-06 as=1.3720e-13 ps=1.0500e-06 nf=1 m=2 par=2
XMpar5 out.t1 ib.t0 vss.t7 vss.t6 nfet_03v3 w=0.4u l=1.2u ad=1.1200e-13 pd=9.6000e-07 as=1.4400e-13 ps=1.2200e-06 nf=1 m=8 par=8
XMpar6 a_4138_1249.t0 ib.t0 vss.t7 vss.t6 nfet_03v3 w=0.4u l=1.2u ad=1.1200e-13 pd=9.6000e-07 as=1.1200e-13 ps=9.6000e-07 nf=1 m=2 par=2
XMpar7 out.t0 a_1036_10984.t7 vdd.t1 vdd.t0 pfet_03v3 w=3.65u l=1.5u ad=1.0220e-12 pd=4.2100e-06 as=1.3140e-12 ps=5.2825e-06 nf=1 m=8 par=8
XMpar8 a_1036_10984.t3 inp.t0 a_2454_1249.t0 vss.t2 nfet_03v3 w=0.53u l=2u ad=1.4840e-13 pd=1.0900e-06 as=3.1800e-13 ps=2.2600e-06 nf=1 m=2 par=2
XMpar9 a_2454_1249.t0 inn.t0 a_6172_10734.t0 vss.t2 nfet_03v3 w=0.53u l=2u ad=3.1800e-13 pd=2.2600e-06 as=1.4840e-13 ps=1.0900e-06 nf=1 m=2 par=2
XMpar10 a_5152_6694.t1 a_5152_6694.t0 vss.t1 vss.t0 nfet_03v3 w=0.49u l=3.75u ad=2.9400e-13 pd=2.1800e-06 as=1.3720e-13 ps=1.0500e-06 nf=1 m=2 par=2
XMpar11 a_1036_10984.t0 a_6172_10734.t2 vdd.t1 vdd.t0 pfet_03v3 w=3.65u l=1.5u ad=2.1900e-12 pd=8.5000e-06 as=1.0220e-12 ps=4.2100e-06 nf=1 m=2 par=2
XMpar12 a_2454_1249.t2 ib.t0 vss.t7 vss.t6 nfet_03v3 w=0.4u l=1.2u ad=2.4000e-13 pd=2.0000e-06 as=1.1200e-13 ps=9.6000e-07 nf=1 m=2 par=2
XMpar13 a_1036_10984.t5 a_5272_3236.t2 vss.t1 vss.t0 nfet_03v3 w=0.49u l=3.75u ad=2.9400e-13 pd=2.1800e-06 as=1.3720e-13 ps=1.0500e-06 nf=1 m=2 par=2
XMpar14 a_5152_6694.t4 inp.t2 a_5554_8372.t0 vdd.t4 pfet_03v3 w=2.32u l=2u ad=6.4960e-13 pd=2.8800e-06 as=1.3920e-12 ps=5.8400e-06 nf=1 m=2 par=2
XMpar15 a_5272_3236.t0 inn.t2 a_5554_8372.t0 vdd.t4 pfet_03v3 w=2.32u l=2u ad=6.4960e-13 pd=2.8800e-06 as=1.3920e-12 ps=5.8400e-06 nf=1 m=2 par=2
XMpar16 ib.t1 ib.t0 vss.t7 vss.t6 nfet_03v3 w=0.4u l=1.2u ad=2.4000e-13 pd=2.0000e-06 as=1.1200e-13 ps=9.6000e-07 nf=1 m=2 par=2
X0 a_1036_10984.t2 a_4406_10984.t0 vss.t35 ppolyf_u_1k r_width=1u r_length=16.19u
X3 a_1036_11504.t1 out.t15 cap_mim_2f0fF c_width=12.99u c_length=12.99u
X34 a_1036_11504.t0 a_4406_10984.t0 vss.t35 ppolyf_u_1k r_width=1u r_length=16.19u
Rpar0 a_1036_10984.t0 a_1036_10984.t7 436.7086
Rpar1 a_1036_10984.t0 a_1036_10984.t2 76.2823
Rpar2 a_1036_10984.t0 a_1036_10984.t3 216.4791
Rpar3 a_1036_10984.t0 a_1036_10984.t5 256.9411
Rpar4 a_1036_10984.t7 a_1036_10984.t2 629.6740
Rpar5 a_1036_10984.t7 a_1036_10984.t3 175.5413
Rpar6 a_1036_10984.t7 a_1036_10984.t5 208.3517
Rpar7 a_1036_10984.t2 a_1036_10984.t3 312.1332
Rpar8 a_1036_10984.t2 a_1036_10984.t5 370.4740
Rpar9 a_1036_10984.t3 a_1036_10984.t5 97.1881
Rpar10 a_1036_11504.t0 a_1036_11504.t1 56.4382
Rpar11 a_2454_1249.t0 a_2454_1249.t2 65.2700
Rpar12 a_4138_1249.t0 a_4138_1249.t2 198.3165
Rpar13 a_4138_1249.t0 a_4138_1249.t3 108.5608
Rpar14 a_4138_1249.t2 a_4138_1249.t3 25.3796
Rpar15 a_5152_6694.t0 a_5152_6694.t1 21.4808
Rpar16 a_5152_6694.t0 a_5152_6694.t4 124.9895
Rpar17 a_5152_6694.t1 a_5152_6694.t4 88.2933
Rpar18 a_5272_3236.t0 a_5272_3236.t2 140.3510
Rpar19 a_5272_3236.t0 a_5272_3236.t3 136.9288
Rpar20 a_5272_3236.t2 a_5272_3236.t3 29.3596
Rpar21 a_5554_8372.t0 a_5554_8372.t4 49.9380
Rpar22 a_6172_10734.t0 a_6172_10734.t2 509.1392
Rpar23 a_6172_10734.t0 a_6172_10734.t3 207.9568
Rpar24 a_6172_10734.t0 a_6172_10734.t6 75.4043
Rpar25 a_6172_10734.t2 a_6172_10734.t3 23.9564
Rpar26 a_6172_10734.t2 a_6172_10734.t6 362.3100
Rpar27 a_6172_10734.t3 a_6172_10734.t6 147.9847
Rpar28 ib ib.t0 11.5792
Rpar29 ib ib.t1 9.8298
Rpar30 inn inn.t0 4.3699
Rpar31 inn inn.t2 56.7827
Rpar32 inp inp.t0 4.4185
Rpar33 inp inp.t2 66.0221
Rpar34 out out.t0 2.6032
Rpar35 out out.t1 110.1356
Rpar36 out out.t15 206.1088
Rpar37 out.t0 out.t1 96.2335
Rpar38 out.t0 out.t15 180.0921
Rpar39 out.t1 out.t15 283.4534
Rpar40 vdd vdd.t0 49.9355
Rpar41 vdd vdd.t1 108.3307
Rpar42 vdd vdd.t2 3245.4162
Rpar43 vdd vdd.t4 254.1125
Rpar44 vdd vdd.t3 4948.3054
Rpar45 vdd.t0 vdd.t1 3.3474
Rpar46 vdd.t0 vdd.t2 106.4626
Rpar47 vdd.t0 vdd.t4 60.7638
Rpar48 vdd.t0 vdd.t3 162.3242
Rpar49 vdd.t1 vdd.t2 301.1128
Rpar50 vdd.t1 vdd.t4 149.4640
Rpar51 vdd.t1 vdd.t3 459.1084
Rpar52 vdd.t2 vdd.t4 336.2752
Rpar53 vdd.t2 vdd.t3 10.3268
Rpar54 vdd.t4 vdd.t3 512.7208
Rpar55 vss vss.t0 276.3262
Rpar56 vss vss.t1 514.4123
Rpar57 vss vss.t6 77.3365
Rpar58 vss vss.t7 536.8654
Rpar59 vss vss.t2 338.4484
Rpar60 vss vss.t35 766.0970
Rpar61 vss.t0 vss.t1 23.3800
Rpar62 vss.t0 vss.t6 3.8517
Rpar63 vss.t0 vss.t7 29.1449
Rpar64 vss.t0 vss.t2 11.8423
Rpar65 vss.t0 vss.t35 654.6899
Rpar66 vss.t1 vss.t6 9.2198
Rpar67 vss.t1 vss.t7 112.8927
Rpar68 vss.t1 vss.t2 23.4507
Rpar69 vss.t1 vss.t35 967.4056
Rpar70 vss.t6 vss.t7 6.3950
Rpar71 vss.t6 vss.t2 3.8236
Rpar72 vss.t6 vss.t35 212.4022
Rpar73 vss.t7 vss.t2 45.2544
Rpar74 vss.t7 vss.t35 1756.4233
Rpar75 vss.t2 vss.t35 724.9113
Cpar0 a_1036_10984.t0 vss 3.82082e-15
Cpar1 a_1036_10984.t2 vss 2.18544e-15
Cpar2 a_1036_10984.t3 vss 2.52114e-15
Cpar3 a_1036_10984.t5 vss 3.20535e-15
Cpar4 a_1036_10984.t7 vss 1.08391e-14
Cpar5 a_1036_11504.t0 vss 8.29800e-17
Cpar6 a_1036_11504.t1 vss 1.72964e-15
Cpar7 a_2454_1249.t0 vss 4.80849e-15
Cpar8 a_2454_1249.t2 vss 5.92489e-15
Cpar9 a_4138_1249.t0 vss 4.24979e-15
Cpar10 a_4138_1249.t2 vss 4.39016e-15
Cpar11 a_4138_1249.t3 vss 3.21288e-15
Cpar12 a_4406_10984.t0 vss 4.03000e-17
Cpar13 a_5152_6694.t0 vss 3.16016e-15
Cpar14 a_5152_6694.t1 vss 1.00200e-15
Cpar15 a_5152_6694.t4 vss 1.00152e-15
Cpar16 a_5272_3236.t0 vss 2.36842e-15
Cpar17 a_5272_3236.t2 vss 5.50857e-15
Cpar18 a_5272_3236.t3 vss 1.60253e-15
Cpar19 a_5554_8372.t0 vss 6.31657e-15
Cpar20 a_5554_8372.t4 vss 3.69729e-15
Cpar21 a_6172_10734.t0 vss 1.90166e-15
Cpar22 a_6172_10734.t2 vss 5.95888e-15
Cpar23 a_6172_10734.t3 vss 3.45216e-15
Cpar24 a_6172_10734.t6 vss 2.56839e-15
Cpar25 ib out 7.05820e-16
Cpar26 ib vss 1.58768e-14
Cpar27 ib.t0 vss 4.33520e-15
Cpar28 ib.t1 vss 4.27092e-16
Cpar29 inn inp 1.03940e-16
Cpar30 inn vdd 2.47984e-15
Cpar31 inn vss 5.99453e-15
Cpar32 inn.t0 vss 7.01236e-16
Cpar33 inn.t2 vss 3.52848e-15
Cpar34 inp out 3.24130e-16
Cpar35 inp vdd 2.32788e-15
Cpar36 inp vss 6.82502e-15
Cpar37 inp.t0 vss 6.70104e-16
Cpar38 inp.t2 vss 3.39076e-15
Cpar39 out vdd 6.21825e-15
Cpar40 out vss 1.32411e-14
Cpar41 out.t0 vss 3.54620e-15
Cpar42 out.t1 vss 2.51865e-15
Cpar43 out.t15 vss 7.08226e-15
Cpar44 vdd vss 8.61596e-14
Cpar45 vdd.t0 vss 1.62969e-14
Cpar46 vdd.t1 vss 8.25723e-15
Cpar47 vdd.t2 vss 4.72853e-15
Cpar48 vdd.t3 vss 2.49945e-15
Cpar49 vdd.t4 vss 8.12978e-15
.ends opamp_dut

Vdd vdd 0 3.300000
Vss vss 0 0
Ibias vdd ib 7.188000e-07
Vinp inp 0 DC 1.645000 AC 1 PWL(0 1.645000 2.120346e-08 1.645000 2.332381e-08 1.655000)
Rfb out inn 1m
Cload out 0 2.000000e-13
Xdut vdd vss inp inn out ib opamp_dut
.end
