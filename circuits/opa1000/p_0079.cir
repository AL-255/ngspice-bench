* opa1000[0079]: 2p/cherry_hooper_3v3_i150u_subth (cherry_hooper, VDD=3.3V, CL=2.0pF, Iref=6.5625uA)
.include "pdk_opa.inc"
.temp 27
.option gmin=1e-12 rshunt=1e12 reltol=1e-3 abstol=1e-12 vntol=1e-5 method=gear
* Post-PEX R+C extracted netlist for cherry_hooper_3v3_i150u_subth
.subckt opamp_dut vdd vss inp inn out ib
XMpar0 a_1378_18029.t1 a_1378_18029.t0 vdd.t0 vdd.t0 pfet_03v3 w=9.77u l=0.6u ad=3.0198e-12 pd=1.1276e-05 as=3.0198e-12 ps=1.1276e-05 nf=1 m=11 par=11
XMpar1 a_10702_4893.t4 a_15174_4194.t109 out.t6 vss.t95 nfet_03v3 w=9.03u l=0.44u ad=3.1063e-12 pd=1.1524e-05 as=3.1063e-12 ps=1.1524e-05 nf=1 m=5 par=5
XMpar2 a_10138_18074.t0 inp.t0 a_10346_18074.t11 vss.t0 nfet_03v3 w=1.96u l=0.44u ad=5.7731e-13 pd=2.6382e-06 as=5.7731e-13 ps=2.6382e-06 nf=1 m=44 par=44
XMpar3 a_5572_18029.t0 ib.t0 vss.t24 vss.t0 nfet_03v3 w=6.19u l=0.81u ad=3.7140e-12 pd=1.3580e-05 as=1.7332e-12 ps=6.7500e-06 nf=1 m=2 par=2
XMpar4 a_1557_1176.t4 a_1557_1176.t3 vdd.t0 vdd.t0 pfet_03v3 w=9.77u l=0.6u ad=2.7356e-12 pd=1.0330e-05 as=2.8777e-12 ps=1.0803e-05 nf=1 m=44 par=44
XMpar5 a_10138_18074.t46 ib.t0 vss.t24 vss.t0 nfet_03v3 w=6.19u l=0.81u ad=1.7332e-12 pd=6.7500e-06 as=1.7332e-12 ps=6.7500e-06 nf=1 m=8 par=8
XMpar6 a_11120_15031.t1 ib.t0 vss.t24 vss.t0 nfet_03v3 w=6.19u l=0.81u ad=1.7332e-12 pd=6.7500e-06 as=1.9808e-12 ps=7.6037e-06 nf=1 m=16 par=16
XMpar7 out.t0 a_12466_11155.t0 vdd.t0 vdd.t0 pfet_03v3 w=9.77u l=0.6u ad=3.0198e-12 pd=1.1276e-05 as=3.0198e-12 ps=1.1276e-05 nf=1 m=11 par=11
XMpar8 a_10702_4893.t4 a_1557_1176.t109 a_12466_11155.t22 vss.t95 nfet_03v3 w=9.03u l=0.44u ad=3.1063e-12 pd=1.1524e-05 as=3.1063e-12 ps=1.1524e-05 nf=1 m=5 par=5
XMpar9 a_15174_4194.t22 a_15174_4194.t21 vdd.t0 vdd.t0 pfet_03v3 w=9.77u l=0.6u ad=2.7356e-12 pd=1.0330e-05 as=2.8777e-12 ps=1.0803e-05 nf=1 m=44 par=44
XMpar10 a_5572_18029.t3 a_5572_18029.t2 vdd.t5 vdd.t4 pfet_03v3 w=9.59u l=0.81u ad=2.6852e-12 pd=1.0150e-05 as=3.7081e-12 ps=1.3560e-05 nf=1 m=6 par=6
XMpar11 a_11120_15031.t0 a_10346_18074.t63 a_1557_1176.t91 vss.t15 nfet_03v3 w=10u l=0.44u ad=6.0000e-12 pd=2.1200e-05 as=2.8000e-12 ps=1.0560e-05 nf=1 m=1
XMpar12 a_11120_15031.t0 a_15054_1339.t63 a_15174_4194.t1 vss.t15 nfet_03v3 w=10u l=0.44u ad=6.0000e-12 pd=2.1200e-05 as=2.8000e-12 ps=1.0560e-05 nf=1 m=1
XMpar13 a_10138_18074.t0 inn.t0 a_15054_1339.t1 vss.t0 nfet_03v3 w=1.96u l=0.44u ad=5.7731e-13 pd=2.6382e-06 as=5.7731e-13 ps=2.6382e-06 nf=1 m=44 par=44
XMpar14 a_12466_11155.t1 a_12466_11155.t0 vdd.t0 vdd.t0 pfet_03v3 w=9.77u l=0.6u ad=3.0198e-12 pd=1.1276e-05 as=3.0198e-12 ps=1.1276e-05 nf=1 m=11 par=11
XMpar15 a_10346_18074.t0 a_5572_18029.t2 vdd.t5 vdd.t4 pfet_03v3 w=9.59u l=0.81u ad=2.6852e-12 pd=1.0150e-05 as=3.1967e-12 ps=1.1855e-05 nf=1 m=12 par=12
XMpar16 a_1378_18029.t22 a_1618_14495.t2 a_1618_14495.t3 vdd.t19 pfet_03v3 w=9.9u l=0.45u ad=3.1240e-12 pd=1.1631e-05 as=3.1240e-12 ps=1.1631e-05 nf=1 m=9 par=9
XMpar17 a_11120_15031.t0 a_15054_1339.t63 a_15174_4194.t1 vss.t91 nfet_03v3 w=10u l=0.44u ad=2.8000e-12 pd=1.0560e-05 as=2.8000e-12 ps=1.0560e-05 nf=1 m=10 par=10
XMpar18 a_1618_14495.t0 ib.t0 vss.t24 vss.t0 nfet_03v3 w=6.19u l=0.81u ad=1.7332e-12 pd=6.7500e-06 as=2.7236e-12 ps=1.0165e-05 nf=1 m=2 par=2
XMpar19 a_15054_1339.t0 a_5572_18029.t2 vdd.t5 vdd.t4 pfet_03v3 w=9.59u l=0.81u ad=2.6852e-12 pd=1.0150e-05 as=3.1967e-12 ps=1.1855e-05 nf=1 m=12 par=12
XMpar20 a_11120_15031.t0 a_10346_18074.t63 a_1557_1176.t91 vss.t95 nfet_03v3 w=10u l=0.44u ad=3.4400e-12 pd=1.2688e-05 as=2.8000e-12 ps=1.0560e-05 nf=1 m=5 par=5
XMpar21 a_10702_4893.t0 ib.t0 vss.t24 vss.t0 nfet_03v3 w=6.19u l=0.81u ad=1.7332e-12 pd=6.7500e-06 as=2.7236e-12 ps=1.0165e-05 nf=1 m=4 par=4
XMpar22 a_11120_15031.t0 a_10346_18074.t63 a_1557_1176.t91 vss.t91 nfet_03v3 w=10u l=0.44u ad=2.8000e-12 pd=1.0560e-05 as=2.8000e-12 ps=1.0560e-05 nf=1 m=10 par=10
XMpar23 a_11120_15031.t0 a_15054_1339.t63 a_15174_4194.t1 vss.t95 nfet_03v3 w=10u l=0.44u ad=3.4400e-12 pd=1.2688e-05 as=2.8000e-12 ps=1.0560e-05 nf=1 m=5 par=5
XMpar24 ib.t1 ib.t0 vss.t24 vss.t0 nfet_03v3 w=6.19u l=0.81u ad=3.7140e-12 pd=1.3580e-05 as=2.7236e-12 ps=1.0165e-05 nf=1 m=2 par=2
XMpar25 a_10346_18074.t57 a_1618_14495.t20 a_1557_1176.t0 vdd.t16 pfet_03v3 w=7.32u l=0.45u ad=2.5181e-12 pd=9.4720e-06 as=2.5181e-12 ps=9.4720e-06 nf=1 m=5 par=5
XMpar26 a_15054_1339.t55 a_1618_14495.t20 a_15174_4194.t0 vdd.t16 pfet_03v3 w=7.32u l=0.45u ad=2.5181e-12 pd=9.4720e-06 as=2.5181e-12 ps=9.4720e-06 nf=1 m=5 par=5
XMpar27 a_10138_18074.t0 inp.t0 a_10346_18074.t11 vss.t15 nfet_03v3 w=1.96u l=0.44u ad=5.4880e-13 pd=2.5200e-06 as=5.4880e-13 ps=2.5200e-06 nf=1 m=2 par=2
XMpar28 a_10138_18074.t0 inn.t0 a_15054_1339.t1 vss.t15 nfet_03v3 w=1.96u l=0.44u ad=5.4880e-13 pd=2.5200e-06 as=5.4880e-13 ps=2.5200e-06 nf=1 m=2 par=2
X5 out.t16 vss.t129 cap_mim_2f0fF c_width=19.37u c_length=19.37u
X257 out.t16 vss.t129 cap_mim_2f0fF c_width=19.37u c_length=19.37u
X294 out.t16 vss.t129 cap_mim_2f0fF c_width=19.37u c_length=19.37u
X313 out.t16 vss.t129 cap_mim_2f0fF c_width=19.37u c_length=19.37u
Rpar0 a_10138_18074.t0 a_10138_18074.t46 36.7299
Rpar1 a_10346_18074.t0 a_10346_18074.t11 42.9843
Rpar2 a_10346_18074.t0 a_10346_18074.t57 492.1164
Rpar3 a_10346_18074.t0 a_10346_18074.t63 299.1545
Rpar4 a_10346_18074.t11 a_10346_18074.t57 225.6204
Rpar5 a_10346_18074.t11 a_10346_18074.t63 137.1532
Rpar6 a_10346_18074.t57 a_10346_18074.t63 52.1740
Rpar7 a_10702_4893.t0 a_10702_4893.t4 43.5930
Rpar8 a_11120_15031.t0 a_11120_15031.t1 57.1034
Rpar9 a_12466_11155.t0 a_12466_11155.t1 18.2189
Rpar10 a_12466_11155.t0 a_12466_11155.t22 1190.9471
Rpar11 a_12466_11155.t1 a_12466_11155.t22 189.8853
Rpar12 a_1378_18029.t0 a_1378_18029.t1 21.9132
Rpar13 a_1378_18029.t0 a_1378_18029.t22 464.1619
Rpar14 a_1378_18029.t1 a_1378_18029.t22 49.5260
Rpar15 a_15054_1339.t0 a_15054_1339.t1 42.9843
Rpar16 a_15054_1339.t0 a_15054_1339.t55 492.1164
Rpar17 a_15054_1339.t0 a_15054_1339.t63 299.1545
Rpar18 a_15054_1339.t1 a_15054_1339.t55 225.6204
Rpar19 a_15054_1339.t1 a_15054_1339.t63 137.1532
Rpar20 a_15054_1339.t55 a_15054_1339.t63 52.1740
Rpar21 a_15174_4194.t0 a_15174_4194.t1 108.3602
Rpar22 a_15174_4194.t0 a_15174_4194.t22 99.9624
Rpar23 a_15174_4194.t0 a_15174_4194.t21 713.8078
Rpar24 a_15174_4194.t0 a_15174_4194.t109 92.3958
Rpar25 a_15174_4194.t1 a_15174_4194.t22 151.2057
Rpar26 a_15174_4194.t1 a_15174_4194.t21 1079.7236
Rpar27 a_15174_4194.t1 a_15174_4194.t109 293.9508
Rpar28 a_15174_4194.t22 a_15174_4194.t21 15.9826
Rpar29 a_15174_4194.t22 a_15174_4194.t109 271.1700
Rpar30 a_15174_4194.t21 a_15174_4194.t109 1936.3605
Rpar31 a_1557_1176.t0 a_1557_1176.t4 99.9624
Rpar32 a_1557_1176.t0 a_1557_1176.t91 108.3602
Rpar33 a_1557_1176.t0 a_1557_1176.t109 92.3958
Rpar34 a_1557_1176.t0 a_1557_1176.t3 713.8078
Rpar35 a_1557_1176.t4 a_1557_1176.t91 151.2057
Rpar36 a_1557_1176.t4 a_1557_1176.t109 271.1700
Rpar37 a_1557_1176.t4 a_1557_1176.t3 15.9826
Rpar38 a_1557_1176.t91 a_1557_1176.t109 293.9508
Rpar39 a_1557_1176.t91 a_1557_1176.t3 1079.7236
Rpar40 a_1557_1176.t109 a_1557_1176.t3 1936.3605
Rpar41 a_1618_14495.t0 a_1618_14495.t2 1446.4311
Rpar42 a_1618_14495.t0 a_1618_14495.t3 55.7318
Rpar43 a_1618_14495.t0 a_1618_14495.t20 361.6759
Rpar44 a_1618_14495.t2 a_1618_14495.t3 25.8605
Rpar45 a_1618_14495.t2 a_1618_14495.t20 2952.9764
Rpar46 a_1618_14495.t3 a_1618_14495.t20 113.7799
Rpar47 a_5572_18029.t0 a_5572_18029.t2 113.9233
Rpar48 a_5572_18029.t0 a_5572_18029.t3 51.4941
Rpar49 a_5572_18029.t2 a_5572_18029.t3 18.1267
Rpar50 ib ib.t0 8.5864
Rpar51 ib ib.t1 165.9606
Rpar52 ib.t0 ib.t1 17.6538
Rpar53 inn inn.t0 2.1024
Rpar54 inp inp.t0 2.1024
Rpar55 out out.t0 70.8965
Rpar56 out out.t6 322.1769
Rpar57 out out.t16 18.4065
Rpar58 out.t0 out.t6 89.0069
Rpar59 out.t0 out.t16 277.0190
Rpar60 out.t6 out.t16 1258.8640
Rpar61 vdd vdd.t0 284.3578
Rpar62 vdd vdd.t4 162.9966
Rpar63 vdd vdd.t5 59.5021
Rpar64 vdd vdd.t19 867.0744
Rpar65 vdd vdd.t16 3815.3629
Rpar66 vdd.t0 vdd.t4 98.0914
Rpar67 vdd.t0 vdd.t5 93.6605
Rpar68 vdd.t0 vdd.t19 97.3085
Rpar69 vdd.t0 vdd.t16 30.2462
Rpar70 vdd.t4 vdd.t5 2.9254
Rpar71 vdd.t4 vdd.t19 261.2681
Rpar72 vdd.t4 vdd.t16 1498.5458
Rpar73 vdd.t5 vdd.t19 263.2276
Rpar74 vdd.t5 vdd.t16 1353.3378
Rpar75 vdd.t19 vdd.t16 5012.0317
Rpar76 vss vss.t0 88.7810
Rpar77 vss vss.t91 334.7995
Rpar78 vss vss.t95 648.8015
Rpar79 vss vss.t15 2647.5206
Rpar80 vss vss.t129 753.0922
Rpar81 vss vss.t24 889.9699
Rpar82 vss.t0 vss.t91 2.8713
Rpar83 vss.t0 vss.t95 6.7680
Rpar84 vss.t0 vss.t15 3.5896
Rpar85 vss.t0 vss.t129 79.4590
Rpar86 vss.t0 vss.t24 1.6846
Rpar87 vss.t91 vss.t95 3.1341
Rpar88 vss.t91 vss.t15 18.7840
Rpar89 vss.t91 vss.t129 404.9030
Rpar90 vss.t91 vss.t24 73.4360
Rpar91 vss.t95 vss.t15 45.0918
Rpar92 vss.t95 vss.t129 805.2143
Rpar93 vss.t95 vss.t24 217.6007
Rpar94 vss.t15 vss.t129 2539.1903
Rpar95 vss.t15 vss.t24 63.9171
Rpar96 vss.t129 vss.t24 736.1074
Cpar0 a_10138_18074.t0 vss 4.98492e-14
Cpar1 a_10138_18074.t46 vss 1.45973e-14
Cpar2 a_10346_18074.t0 vss 2.14464e-14
Cpar3 a_10346_18074.t11 vss 2.59586e-14
Cpar4 a_10346_18074.t57 vss 1.14796e-14
Cpar5 a_10346_18074.t63 vss 1.96172e-14
Cpar6 a_10702_4893.t0 vss 4.46763e-15
Cpar7 a_10702_4893.t4 vss 1.54362e-14
Cpar8 a_11120_15031.t0 vss 5.48454e-14
Cpar9 a_11120_15031.t1 vss 1.90609e-14
Cpar10 a_12466_11155.t0 vss 2.65274e-14
Cpar11 a_12466_11155.t1 vss 2.68778e-14
Cpar12 a_12466_11155.t22 vss 1.49044e-14
Cpar13 a_1378_18029.t0 vss 1.26278e-14
Cpar14 a_1378_18029.t1 vss 2.02162e-14
Cpar15 a_1378_18029.t22 vss 1.50959e-14
Cpar16 a_15054_1339.t0 vss 1.97210e-14
Cpar17 a_15054_1339.t1 vss 2.38703e-14
Cpar18 a_15054_1339.t55 vss 1.05561e-14
Cpar19 a_15054_1339.t63 vss 1.80390e-14
Cpar20 a_15174_4194.t0 vss 9.13713e-15
Cpar21 a_15174_4194.t1 vss 2.42760e-14
Cpar22 a_15174_4194.t109 vss 4.86656e-15
Cpar23 a_15174_4194.t21 vss 4.93273e-14
Cpar24 a_15174_4194.t22 vss 6.15989e-14
Cpar25 a_1557_1176.t0 vss 9.19193e-15
Cpar26 a_1557_1176.t109 vss 4.89575e-15
Cpar27 a_1557_1176.t3 vss 4.96233e-14
Cpar28 a_1557_1176.t4 vss 6.19679e-14
Cpar29 a_1557_1176.t91 vss 2.44214e-14
Cpar30 a_1618_14495.t0 vss 4.08540e-15
Cpar31 a_1618_14495.t2 vss 6.10816e-15
Cpar32 a_1618_14495.t20 vss 1.15934e-14
Cpar33 a_1618_14495.t3 vss 1.76754e-14
Cpar34 a_5572_18029.t0 vss 4.27557e-15
Cpar35 a_5572_18029.t2 vss 3.44501e-14
Cpar36 a_5572_18029.t3 vss 8.82918e-15
Cpar37 ib out 3.68950e-16
Cpar38 ib vdd 3.22760e-16
Cpar39 ib vss 3.96070e-14
Cpar40 ib.t0 vss 9.62779e-15
Cpar41 ib.t1 vss 1.71683e-15
Cpar42 inn inp 1.02930e-16
Cpar43 inn vss 1.94338e-14
Cpar44 inn.t0 vss 7.11131e-15
Cpar45 inp vss 1.95876e-14
Cpar46 inp.t0 vss 7.15781e-15
Cpar47 out vdd 2.23701e-14
Cpar48 out vss 3.65221e-14
Cpar49 out.t0 vss 1.81242e-15
Cpar50 out.t16 vss 4.03448e-14
Cpar51 out.t6 vss 9.80416e-16
Cpar52 vdd vss 4.88748e-13
Cpar53 vdd.t0 vss 2.60893e-13
Cpar54 vdd.t16 vss 1.74366e-14
Cpar55 vdd.t19 vss 1.75273e-14
Cpar56 vdd.t4 vss 5.38888e-14
Cpar57 vdd.t5 vss 2.76461e-14
.ends opamp_dut

Vdd vdd 0 3.300000
Vss vss 0 0
Ibias vdd ib 6.562500e-06
Vinp inp 0 DC 2.058500 AC 1 PWL(0 2.058500 1.184960e-08 2.058500 1.303456e-08 2.068500)
Rfb out inn 1m
Cload out 0 2.000000e-12
Xdut vdd vss inp inn out ib opamp_dut
.end
