* opa1000[0599]: 200f/pmos_miller_1v8_i20u_subth (pmos_miller, VDD=1.8V, CL=0.2pF, Iref=1.75uA)
.include "pdk_opa.inc"
.temp 27
.option gmin=1e-12 rshunt=1e12 reltol=1e-3 abstol=1e-12 vntol=1e-5 method=gear
* Post-PEX R+C extracted netlist for pmos_miller_1v8_i20u_subth
.subckt opamp_dut vdd vss inp inn out ib
XMpar0 a_2304_10396.t0 inn.t0 a_6312_7727.t0 vdd.t14 pfet_03v3 w=1.98u l=0.65u ad=5.9167e-13 pd=2.6941e-06 as=5.9167e-13 ps=2.6941e-06 nf=1 m=34 par=34
XMpar1 ib.t1 ib.t0 vss.t22 vss.t21 nfet_03v3 w=3.47u l=1.5u ad=2.0820e-12 pd=8.1400e-06 as=9.7160e-13 ps=4.0300e-06 nf=1 m=2 par=2
XMpar2 out.t4 a_1098_7976.t37 vss.t1 vss.t0 nfet_03v3 w=4.4u l=0.75u ad=1.2320e-12 pd=4.9600e-06 as=1.5136e-12 ps=5.9680e-06 nf=1 m=10 par=10
XMpar3 a_2304_10396.t68 a_5524_3476.t2 vdd.t1 vdd.t0 pfet_03v3 w=10u l=1.5u ad=2.8000e-12 pd=1.0560e-05 as=2.8000e-12 ps=1.0560e-05 nf=1 m=4 par=4
XMpar4 a_1098_7976.t3 inp.t0 a_2304_10396.t0 vdd.t14 pfet_03v3 w=1.98u l=0.65u ad=5.9167e-13 pd=2.6941e-06 as=5.9167e-13 ps=2.6941e-06 nf=1 m=34 par=34
XMpar5 out.t0 a_5524_3476.t2 vdd.t1 vdd.t0 pfet_03v3 w=10u l=1.5u ad=3.4400e-12 pd=1.2688e-05 as=2.8000e-12 ps=1.0560e-05 nf=1 m=10 par=10
XMpar6 a_1098_7976.t1 a_6312_7727.t34 vss.t1 vss.t0 nfet_03v3 w=4.4u l=0.75u ad=2.6400e-12 pd=1.0000e-05 as=1.2320e-12 ps=4.9600e-06 nf=1 m=2 par=2
XMpar7 a_6312_7727.t35 a_6312_7727.t34 vss.t1 vss.t0 nfet_03v3 w=4.4u l=0.75u ad=1.2320e-12 pd=4.9600e-06 as=1.2320e-12 ps=4.9600e-06 nf=1 m=2 par=2
XMpar8 a_5524_3476.t3 a_5524_3476.t2 vdd.t1 vdd.t0 pfet_03v3 w=10u l=1.5u ad=2.8000e-12 pd=1.0560e-05 as=2.8000e-12 ps=1.0560e-05 nf=1 m=2 par=2
XMpar9 a_5524_3476.t0 ib.t0 vss.t22 vss.t21 nfet_03v3 w=3.47u l=1.5u ad=9.7160e-13 pd=4.0300e-06 as=9.7160e-13 ps=4.0300e-06 nf=1 m=2 par=2
X9 a_2624_7976.t1 out.t15 cap_mim_2f0fF c_width=13.23u c_length=13.23u
X38 a_1098_7976.t0 a_2624_7976.t0 vss.t12 ppolyf_u_1k r_width=1u r_length=6.97u
Rpar0 a_1098_7976.t0 a_1098_7976.t1 106.0841
Rpar1 a_1098_7976.t0 a_1098_7976.t3 161.2410
Rpar2 a_1098_7976.t0 a_1098_7976.t37 282.5070
Rpar3 a_1098_7976.t1 a_1098_7976.t3 124.1639
Rpar4 a_1098_7976.t1 a_1098_7976.t37 217.5451
Rpar5 a_1098_7976.t3 a_1098_7976.t37 175.2138
Rpar6 a_2304_10396.t0 a_2304_10396.t68 49.5083
Rpar7 a_2624_7976.t0 a_2624_7976.t1 48.1170
Rpar8 a_5524_3476.t0 a_5524_3476.t2 135.0671
Rpar9 a_5524_3476.t0 a_5524_3476.t3 91.7484
Rpar10 a_5524_3476.t2 a_5524_3476.t3 26.0336
Rpar11 a_6312_7727.t0 a_6312_7727.t34 310.0711
Rpar12 a_6312_7727.t0 a_6312_7727.t35 92.9211
Rpar13 a_6312_7727.t34 a_6312_7727.t35 30.0963
Rpar14 ib ib.t0 14.6059
Rpar15 ib ib.t1 3.7795
Rpar16 inn inn.t0 2.1512
Rpar17 inp inp.t0 2.1512
Rpar18 out out.t0 2.0412
Rpar19 out out.t4 40.4483
Rpar20 out out.t15 129.3001
Rpar21 out.t4 out.t15 70.4129
Rpar22 vdd vdd.t0 165.4752
Rpar23 vdd vdd.t1 1530.2175
Rpar24 vdd vdd.t14 21.1758
Rpar25 vdd.t0 vdd.t1 5.4068
Rpar26 vdd.t0 vdd.t14 63.5063
Rpar27 vdd.t1 vdd.t14 587.2691
Rpar28 vss vss.t0 68.6613
Rpar29 vss vss.t1 170.4021
Rpar30 vss vss.t12 294.7400
Rpar31 vss vss.t21 185.8233
Rpar32 vss vss.t22 250.7623
Rpar33 vss.t0 vss.t1 3.7697
Rpar34 vss.t0 vss.t12 3.9978
Rpar35 vss.t0 vss.t21 131.1116
Rpar36 vss.t0 vss.t22 176.9300
Rpar37 vss.t1 vss.t12 23.4973
Rpar38 vss.t1 vss.t21 312.5201
Rpar39 vss.t1 vss.t22 421.7313
Rpar40 vss.t12 vss.t21 561.2501
Rpar41 vss.t12 vss.t22 757.3877
Rpar42 vss.t21 vss.t22 10.1280
Cpar0 a_1098_7976.t0 vss 2.34344e-15
Cpar1 a_1098_7976.t1 vss 4.54645e-15
Cpar2 a_1098_7976.t3 vss 1.40248e-14
Cpar3 a_1098_7976.t37 vss 9.52666e-15
Cpar4 a_2304_10396.t0 vss 4.32963e-14
Cpar5 a_2304_10396.t68 vss 1.42176e-14
Cpar6 a_2624_7976.t0 vss 7.25900e-17
Cpar7 a_2624_7976.t1 vss 2.27137e-15
Cpar8 a_5524_3476.t0 vss 2.42996e-15
Cpar9 a_5524_3476.t2 vss 3.24088e-14
Cpar10 a_5524_3476.t3 vss 4.71686e-15
Cpar11 a_6312_7727.t0 vss 2.08588e-14
Cpar12 a_6312_7727.t34 vss 4.72586e-15
Cpar13 a_6312_7727.t35 vss 5.22917e-15
Cpar14 ib vss 8.23602e-15
Cpar15 ib.t0 vss 7.99136e-16
Cpar16 ib.t1 vss 2.64660e-16
Cpar17 inn inp 1.03030e-16
Cpar18 inn vdd 1.53407e-14
Cpar19 inn vss 6.12957e-15
Cpar20 inn.t0 vss 1.82190e-14
Cpar21 inp vdd 1.51268e-14
Cpar22 inp vss 6.09410e-15
Cpar23 inp.t0 vss 1.80974e-14
Cpar24 out vdd 1.25258e-14
Cpar25 out vss 1.61385e-14
Cpar26 out.t0 vss 1.09786e-14
Cpar27 out.t15 vss 6.75868e-15
Cpar28 out.t4 vss 5.53264e-15
Cpar29 vdd vss 1.79543e-13
Cpar30 vdd.t0 vss 3.44211e-14
Cpar31 vdd.t1 vss 1.02509e-14
Cpar32 vdd.t14 vss 4.03954e-14
.ends opamp_dut

Vdd vdd 0 1.800000
Vss vss 0 0
Ibias vdd ib 1.750000e-06
Vinp inp 0 DC 0.805000 AC 1 PWL(0 0.805000 6.584000e-09 0.805000 7.242400e-09 0.815000)
Rfb out inn 1m
Cload out 0 2.000000e-13
Xdut vdd vss inp inn out ib opamp_dut
.end
