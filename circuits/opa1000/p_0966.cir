* opa1000[0966]: 2p/telescopic_pmos_1v8_i1u_subth (telescopic_pmos, VDD=1.8V, CL=2.0pF, Iref=0.2uA)
.include "pdk_opa.inc"
.temp 27
.option gmin=1e-12 rshunt=1e12 reltol=1e-3 abstol=1e-12 vntol=1e-5 method=gear
* Post-PEX R+C extracted netlist for telescopic_pmos_1v8_i1u_subth
.subckt opamp_dut vdd vss inp inn out ib
XMpar0 a_13774_6869.t64 vss.t23 out.t2 vdd.t4 pfet_03v3 w=1.92u l=2.55u ad=6.6048e-13 pd=2.9920e-06 as=5.7856e-13 ps=2.6507e-06 nf=1 m=30 par=30
XMpar1 a_1648_11900.t0 inp.t0 a_4322_13926.t0 vdd.t7 pfet_03v3 w=8u l=3.25u ad=2.4800e-12 pd=9.3700e-06 as=2.4000e-12 ps=9.1000e-06 nf=1 m=64 par=64
XMpar2 a_13774_6869.t0 inn.t0 a_1648_11900.t0 vdd.t7 pfet_03v3 w=8u l=3.25u ad=2.4000e-12 pd=9.1000e-06 as=2.4800e-12 ps=9.3700e-06 nf=1 m=64 par=64
XMpar3 a_1228_11691.t0 ib.t0 vss.t12 vss.t11 nfet_03v3 w=0.58u l=2.1u ad=1.6240e-13 pd=1.1400e-06 as=1.6240e-13 ps=1.1400e-06 nf=1 m=2 par=2
XMpar4 a_4322_13926.t64 vss.t23 a_9112_6869.t12 vdd.t4 pfet_03v3 w=1.92u l=2.55u ad=6.6048e-13 pd=2.9920e-06 as=5.7856e-13 ps=2.6507e-06 nf=1 m=30 par=30
XMpar5 a_11476_1249.t0 a_9112_6869.t0 a_9112_6869.t1 vss.t0 nfet_03v3 w=1.77u l=2.55u ad=1.0620e-12 pd=4.7400e-06 as=6.8440e-13 ps=3.1333e-06 nf=1 m=6 par=6
XMpar6 a_1648_11900.t128 a_1228_11691.t2 vdd.t1 vdd.t0 pfet_03v3 w=2.68u l=2.1u ad=7.5040e-13 pd=3.2400e-06 as=9.6480e-13 ps=4.0700e-06 nf=1 m=8 par=8
XMpar7 a_12374_1249.t0 a_9112_6869.t0 out.t0 vss.t0 nfet_03v3 w=1.77u l=2.55u ad=1.0620e-12 pd=4.7400e-06 as=6.8440e-13 ps=3.1333e-06 nf=1 m=6 par=6
XMpar8 a_1228_11691.t3 a_1228_11691.t2 vdd.t1 vdd.t0 pfet_03v3 w=2.68u l=2.1u ad=7.5040e-13 pd=3.2400e-06 as=7.5040e-13 ps=3.2400e-06 nf=1 m=2 par=2
XMpar9 a_11476_1249.t1 a_9112_6869.t48 vss.t4 vss.t3 nfet_03v3 w=1.08u l=2.7u ad=6.4800e-13 pd=3.3600e-06 as=3.0240e-13 ps=1.6400e-06 nf=1 m=2 par=2
XMpar10 ib.t1 ib.t0 vss.t12 vss.t11 nfet_03v3 w=0.58u l=2.1u ad=3.4800e-13 pd=2.3600e-06 as=1.6240e-13 ps=1.1400e-06 nf=1 m=2 par=2
XMpar11 a_12374_1249.t2 a_9112_6869.t48 vss.t4 vss.t3 nfet_03v3 w=1.08u l=2.7u ad=3.0240e-13 pd=1.6400e-06 as=3.0240e-13 ps=1.6400e-06 nf=1 m=2 par=2
X33 out.t36 vss.t10 cap_mim_2f0fF c_width=19.84u c_length=19.85u
Rpar0 a_11476_1249.t0 a_11476_1249.t1 177.2274
Rpar1 a_1228_11691.t0 a_1228_11691.t2 168.3069
Rpar2 a_1228_11691.t0 a_1228_11691.t3 139.5370
Rpar3 a_1228_11691.t2 a_1228_11691.t3 22.6853
Rpar4 a_12374_1249.t0 a_12374_1249.t2 99.0396
Rpar5 a_13774_6869.t0 a_13774_6869.t64 66.4080
Rpar6 a_1648_11900.t0 a_1648_11900.t128 60.4276
Rpar7 a_4322_13926.t0 a_4322_13926.t64 66.4080
Rpar8 a_9112_6869.t0 a_9112_6869.t1 9.6146
Rpar9 a_9112_6869.t0 a_9112_6869.t12 255.9533
Rpar10 a_9112_6869.t0 a_9112_6869.t48 516.9840
Rpar11 a_9112_6869.t1 a_9112_6869.t12 119.4333
Rpar12 a_9112_6869.t1 a_9112_6869.t48 241.2358
Rpar13 a_9112_6869.t12 a_9112_6869.t48 92.1715
Rpar14 ib ib.t0 11.9389
Rpar15 ib ib.t1 7.5505
Rpar16 inn inn.t0 1.5300
Rpar17 inp inp.t0 1.5300
Rpar18 out out.t0 163.1813
Rpar19 out out.t2 2.7362
Rpar20 out out.t36 109.5404
Rpar21 out.t0 out.t36 79.9088
Rpar22 vdd vdd.t7 24.8567
Rpar23 vdd vdd.t4 441.2983
Rpar24 vdd.t0 vdd.t1 5.0045
Rpar25 vdd.t0 vdd.t7 1641.2575
Rpar26 vdd.t0 vdd.t4 80.3010
Rpar27 vdd.t1 vdd.t7 3809.5520
Rpar28 vdd.t1 vdd.t4 186.3882
Rpar29 vdd.t7 vdd.t4 123.1761
Rpar30 vss vss.t0 112.8573
Rpar31 vss vss.t10 97.3526
Rpar32 vss vss.t11 137.7318
Rpar33 vss vss.t12 452.1373
Rpar34 vss vss.t3 1282.9843
Rpar35 vss vss.t4 2766.0026
Rpar36 vss vss.t23 425.8667
Rpar37 vss.t0 vss.t10 317.2962
Rpar38 vss.t0 vss.t11 439.8303
Rpar39 vss.t0 vss.t12 1443.9460
Rpar40 vss.t0 vss.t3 3447.1588
Rpar41 vss.t0 vss.t4 7261.9045
Rpar42 vss.t0 vss.t23 1382.1219
Rpar43 vss.t10 vss.t11 153.3660
Rpar44 vss.t10 vss.t12 503.4602
Rpar45 vss.t10 vss.t3 1429.7077
Rpar46 vss.t10 vss.t4 3082.6720
Rpar47 vss.t10 vss.t23 474.1769
Rpar48 vss.t11 vss.t12 11.0682
Rpar49 vss.t11 vss.t3 625.6493
Rpar50 vss.t11 vss.t4 1347.3664
Rpar51 vss.t11 vss.t23 209.4053
Rpar52 vss.t12 vss.t3 2053.9151
Rpar53 vss.t12 vss.t23 687.4226
Rpar54 vss.t3 vss.t4 12.5034
Rpar55 vss.t3 vss.t23 172.5296
Rpar56 vss.t4 vss.t23 372.0698
Cpar0 a_11476_1249.t0 vss 1.27683e-14
Cpar1 a_11476_1249.t1 vss 8.61341e-15
Cpar2 a_1228_11691.t0 vss 3.67695e-15
Cpar3 a_1228_11691.t2 vss 1.63460e-14
Cpar4 a_1228_11691.t3 vss 3.97620e-15
Cpar5 a_12374_1249.t0 vss 2.11982e-14
Cpar6 a_12374_1249.t2 vss 1.01343e-14
Cpar7 a_13774_6869.t0 vss 1.10851e-13
Cpar8 a_13774_6869.t64 vss 2.57883e-14
Cpar9 a_1648_11900.t0 vss 1.89740e-13
Cpar10 a_1648_11900.t128 vss 7.47669e-15
Cpar11 a_4322_13926.t0 vss 1.08923e-13
Cpar12 a_4322_13926.t64 vss 2.53398e-14
Cpar13 a_9112_6869.t0 vss 1.50941e-14
Cpar14 a_9112_6869.t1 vss 5.92650e-15
Cpar15 a_9112_6869.t12 vss 1.64771e-14
Cpar16 a_9112_6869.t48 vss 5.92659e-15
Cpar17 ib vss 8.24441e-15
Cpar18 ib.t0 vss 8.58801e-16
Cpar19 ib.t1 vss 6.32300e-17
Cpar20 inn inp 2.16700e-16
Cpar21 inn vdd 7.70843e-14
Cpar22 inn vss 1.22054e-14
Cpar23 inn.t0 vss 1.57474e-13
Cpar24 inp vdd 7.68057e-14
Cpar25 inp vss 1.21607e-14
Cpar26 inp.t0 vss 1.57242e-13
Cpar27 out vdd 7.67793e-15
Cpar28 out vss 3.36518e-14
Cpar29 out.t0 vss 2.24551e-15
Cpar30 out.t2 vss 4.00584e-15
Cpar31 out.t36 vss 3.21066e-14
Cpar32 vdd vss 1.10990e-12
Cpar33 vdd.t0 vss 7.65329e-15
Cpar34 vdd.t1 vss 3.48711e-15
Cpar35 vdd.t4 vss 4.60308e-14
Cpar36 vdd.t7 vss 1.93047e-13
.ends opamp_dut

Vdd vdd 0 1.800000
Vss vss 0 0
Ibias vdd ib 2.000000e-07
Vinp inp 0 DC 0.805000 AC 1 PWL(0 0.805000 1.849315e-07 0.805000 2.034246e-07 0.815000)
Rfb out inn 1m
Cload out 0 2.000000e-12
Xdut vdd vss inp inn out ib opamp_dut
.end
