* opa1000[0636]: 2p/pmos_miller_1v8_1u_10u_subth (pmos_miller, VDD=1.8V, CL=2.0pF, Iref=0.7188uA)
.include "pdk_opa.inc"
.temp 27
.option gmin=1e-12 rshunt=1e12 reltol=1e-3 abstol=1e-12 vntol=1e-5 method=gear
* Post-PEX R+C extracted netlist for pmos_miller_1v8_1u_10u_subth
.subckt opamp_dut vdd vss inp inn out ib
XMpar0 a_1954_1249.t3 inp.t0 a_999_8436.t0 vdd.t20 pfet_03v3 w=3.97u l=1u ad=1.1910e-12 pd=4.8181e-06 as=1.1513e-12 ps=4.6741e-06 nf=1 m=64 par=64
XMpar1 a_1954_1249.t3 inn.t0 a_8512_10266.t4 vdd.t20 pfet_03v3 w=3.97u l=1u ad=1.1910e-12 pd=4.8181e-06 as=1.1513e-12 ps=4.6741e-06 nf=1 m=64 par=64
XMpar2 out.t0 a_2525_6509.t2 vdd.t1 vdd.t0 pfet_03v3 w=10u l=2.5u ad=3.4400e-12 pd=1.2688e-05 as=2.8000e-12 ps=1.0560e-05 nf=1 m=10 par=10
XMpar3 out.t2 a_999_8436.t67 vss.t1 vss.t0 nfet_03v3 w=1.99u l=1.25u ad=5.5720e-13 pd=2.5500e-06 as=6.8456e-13 ps=3.0760e-06 nf=1 m=10 par=10
XMpar4 a_8512_10266.t1 a_8512_10266.t0 vss.t1 vss.t0 nfet_03v3 w=1.99u l=1.25u ad=5.5720e-13 pd=2.5500e-06 as=5.5720e-13 ps=2.5500e-06 nf=1 m=2 par=2
XMpar5 a_1954_1249.t0 a_2525_6509.t2 vdd.t1 vdd.t0 pfet_03v3 w=10u l=2.5u ad=2.8000e-12 pd=1.0560e-05 as=2.8000e-12 ps=1.0560e-05 nf=1 m=4 par=4
XMpar6 a_2525_6509.t0 ib.t0 vss.t9 vss.t8 nfet_03v3 w=2.55u l=2.5u ad=7.1400e-13 pd=3.1100e-06 as=7.1400e-13 ps=3.1100e-06 nf=1 m=2 par=2
XMpar7 ib.t1 ib.t0 vss.t9 vss.t8 nfet_03v3 w=2.55u l=2.5u ad=1.5300e-12 pd=6.3000e-06 as=7.1400e-13 ps=3.1100e-06 nf=1 m=2 par=2
XMpar8 a_2525_6509.t3 a_2525_6509.t2 vdd.t1 vdd.t0 pfet_03v3 w=10u l=2.5u ad=2.8000e-12 pd=1.0560e-05 as=2.8000e-12 ps=1.0560e-05 nf=1 m=2 par=2
XMpar9 a_999_8436.t65 a_8512_10266.t0 vss.t1 vss.t0 nfet_03v3 w=1.99u l=1.25u ad=1.1940e-12 pd=5.1800e-06 as=5.5720e-13 ps=2.5500e-06 nf=1 m=2 par=2
X25 a_1061_13014.t1 out.t5 cap_mim_2f0fF c_width=16.59u c_length=16.58u
X55 a_1061_13014.t1 out.t5 cap_mim_2f0fF c_width=16.59u c_length=16.58u
X100 a_1061_13014.t0 a_3939_12494.t0 vss.t20 ppolyf_u_1k r_width=1u r_length=13.73u
X156 a_999_8436.t64 a_3939_12494.t0 vss.t20 ppolyf_u_1k r_width=1u r_length=13.73u
Rpar0 a_1061_13014.t0 a_1061_13014.t1 62.0518
Rpar1 a_1954_1249.t0 a_1954_1249.t3 50.5951
Rpar2 a_2525_6509.t0 a_2525_6509.t2 142.9985
Rpar3 a_2525_6509.t0 a_2525_6509.t3 117.7742
Rpar4 a_2525_6509.t2 a_2525_6509.t3 26.5597
Rpar5 a_8512_10266.t0 a_8512_10266.t1 26.3586
Rpar6 a_8512_10266.t0 a_8512_10266.t4 158.1293
Rpar7 a_8512_10266.t1 a_8512_10266.t4 91.5896
Rpar8 a_999_8436.t0 a_999_8436.t64 335.0237
Rpar9 a_999_8436.t0 a_999_8436.t65 275.6206
Rpar10 a_999_8436.t0 a_999_8436.t67 71.2275
Rpar11 a_999_8436.t64 a_999_8436.t65 83.3592
Rpar12 a_999_8436.t64 a_999_8436.t67 199.8701
Rpar13 a_999_8436.t65 a_999_8436.t67 164.4311
Rpar14 ib ib.t0 12.8797
Rpar15 ib ib.t1 4.1368
Rpar16 inn inn.t0 1.6816
Rpar17 inp inp.t0 1.6816
Rpar18 out out.t0 48.4067
Rpar19 out out.t2 2.7776
Rpar20 out out.t5 63.6001
Rpar21 out.t0 out.t5 216.6091
Rpar22 vdd vdd.t0 51.9201
Rpar23 vdd vdd.t1 489.2272
Rpar24 vdd vdd.t20 216.5154
Rpar25 vdd.t0 vdd.t1 5.8910
Rpar26 vdd.t0 vdd.t20 38.6158
Rpar27 vdd.t1 vdd.t20 363.8651
Rpar28 vss vss.t0 240.4780
Rpar29 vss vss.t1 518.4894
Rpar30 vss vss.t8 646.1046
Rpar31 vss vss.t9 863.0247
Rpar32 vss vss.t20 1019.1065
Rpar33 vss.t0 vss.t1 4.4199
Rpar34 vss.t0 vss.t8 6.7209
Rpar35 vss.t0 vss.t9 11.8110
Rpar36 vss.t0 vss.t20 38.0602
Rpar37 vss.t1 vss.t8 17.0812
Rpar38 vss.t1 vss.t9 59.7992
Rpar39 vss.t1 vss.t20 52.6118
Rpar40 vss.t8 vss.t9 31.2273
Rpar41 vss.t8 vss.t20 90.9873
Rpar42 vss.t9 vss.t20 245.7272
Cpar0 a_1061_13014.t0 vss 1.07978e-16
Cpar1 a_1061_13014.t1 vss 6.23146e-15
Cpar2 a_1954_1249.t0 vss 1.35036e-14
Cpar3 a_1954_1249.t3 vss 1.11521e-13
Cpar4 a_2525_6509.t0 vss 2.05529e-15
Cpar5 a_2525_6509.t2 vss 4.60756e-14
Cpar6 a_2525_6509.t3 vss 4.56518e-15
Cpar7 a_3939_12494.t0 vss 3.85000e-17
Cpar8 a_8512_10266.t0 vss 5.88495e-15
Cpar9 a_8512_10266.t1 vss 3.96054e-15
Cpar10 a_8512_10266.t4 vss 5.77454e-14
Cpar11 a_999_8436.t0 vss 4.60467e-14
Cpar12 a_999_8436.t64 vss 3.48381e-15
Cpar13 a_999_8436.t65 vss 4.94791e-15
Cpar14 a_999_8436.t67 vss 1.15513e-14
Cpar15 ib vdd 3.35300e-17
Cpar16 ib vss 1.00928e-14
Cpar17 ib.t0 vss 1.09278e-15
Cpar18 ib.t1 vss 1.93420e-16
Cpar19 inn inp 9.34500e-17
Cpar20 inn vdd 3.35852e-14
Cpar21 inn vss 7.27969e-15
Cpar22 inn.t0 vss 5.69626e-14
Cpar23 inp vdd 3.36589e-14
Cpar24 inp vss 7.46758e-15
Cpar25 inp.t0 vss 5.70088e-14
Cpar26 out vdd 1.35806e-14
Cpar27 out vss 1.76083e-14
Cpar28 out.t0 vss 1.19566e-14
Cpar29 out.t2 vss 1.67645e-15
Cpar30 out.t5 vss 1.50946e-14
Cpar31 vdd vss 3.74065e-13
Cpar32 vdd.t0 vss 4.16770e-14
Cpar33 vdd.t1 vss 1.03856e-14
Cpar34 vdd.t20 vss 9.26781e-14
.ends opamp_dut

Vdd vdd 0 1.800000
Vss vss 0 0
Ibias vdd ib 7.188000e-07
Vinp inp 0 DC 0.805000 AC 1 PWL(0 0.805000 4.494838e-08 0.805000 4.944322e-08 0.815000)
Rfb out inn 1m
Cload out 0 2.000000e-12
Xdut vdd vss inp inn out ib opamp_dut
.end
