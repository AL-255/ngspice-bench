* opa1000[0779]: 200f/symmetrical_ota_3v3_i1u_weak (symmetrical_ota, VDD=3.3V, CL=0.2pF, Iref=0.1917uA)
.include "pdk_opa.inc"
.temp 27
.option gmin=1e-12 rshunt=1e12 reltol=1e-3 abstol=1e-12 vntol=1e-5 method=gear
* Post-PEX R+C extracted netlist for symmetrical_ota_3v3_i1u_weak
.subckt opamp_dut vdd vss inp inn out ib
XMpar0 out.t0 a_1644_8766.t2 vdd.t1 vdd.t0 pfet_03v3 w=1.08u l=4.5u ad=6.4800e-13 pd=3.3600e-06 as=4.7520e-13 ps=2.5000e-06 nf=1 m=4 par=4
XMpar1 a_3234_5812.t4 ib.t0 vss.t20 vss.t19 nfet_03v3 w=0.4u l=3.5u ad=2.4000e-13 pd=2.0000e-06 as=1.7600e-13 ps=1.4800e-06 nf=1 m=4 par=4
XMpar2 out.t1 a_1828_7195.t0 vss.t1 vss.t0 nfet_03v3 w=0.4u l=4.5u ad=1.1200e-13 pd=9.6000e-07 as=1.7600e-13 ps=1.4800e-06 nf=1 m=4 par=4
XMpar3 a_1828_7195.t8 a_6516_8766.t0 vdd.t1 vdd.t0 pfet_03v3 w=1.08u l=4.5u ad=6.4800e-13 pd=3.3600e-06 as=4.7520e-13 ps=2.5000e-06 nf=1 m=4 par=4
XMpar4 a_1644_8766.t3 a_1644_8766.t2 vdd.t1 vdd.t0 pfet_03v3 w=1.08u l=4.5u ad=6.4800e-13 pd=3.3600e-06 as=3.0240e-13 ps=1.6400e-06 nf=1 m=2 par=2
XMpar5 a_1644_8766.t0 inp.t0 a_3234_5812.t0 vss.t2 nfet_03v3 w=1.3u l=5u ad=3.6400e-13 pd=1.8600e-06 as=7.8000e-13 ps=3.8000e-06 nf=1 m=2 par=2
XMpar6 ib.t1 ib.t0 vss.t20 vss.t19 nfet_03v3 w=0.4u l=3.5u ad=2.4000e-13 pd=2.0000e-06 as=1.1200e-13 ps=9.6000e-07 nf=1 m=2 par=2
XMpar7 a_1828_7195.t1 a_1828_7195.t0 vss.t1 vss.t0 nfet_03v3 w=0.4u l=4.5u ad=1.1200e-13 pd=9.6000e-07 as=1.1200e-13 ps=9.6000e-07 nf=1 m=4 par=4
XMpar8 a_6516_8766.t1 a_6516_8766.t0 vdd.t1 vdd.t0 pfet_03v3 w=1.08u l=4.5u ad=6.4800e-13 pd=3.3600e-06 as=3.0240e-13 ps=1.6400e-06 nf=1 m=2 par=2
XMpar9 a_3234_5812.t0 inn.t0 a_6516_8766.t4 vss.t2 nfet_03v3 w=1.3u l=5u ad=7.8000e-13 pd=3.8000e-06 as=3.6400e-13 ps=1.8600e-06 nf=1 m=2 par=2
X26 out.t8 vss.t14 cap_mim_2f0fF c_width=14.79u c_length=14.79u
Rpar0 a_1644_8766.t0 a_1644_8766.t2 114.7192
Rpar1 a_1644_8766.t0 a_1644_8766.t3 133.5472
Rpar2 a_1644_8766.t2 a_1644_8766.t3 13.9513
Rpar3 a_1828_7195.t0 a_1828_7195.t1 23.4214
Rpar4 a_1828_7195.t0 a_1828_7195.t8 143.2626
Rpar5 a_1828_7195.t1 a_1828_7195.t8 61.6937
Rpar6 a_3234_5812.t0 a_3234_5812.t4 42.2727
Rpar7 a_6516_8766.t0 a_6516_8766.t1 13.9513
Rpar8 a_6516_8766.t0 a_6516_8766.t4 114.7188
Rpar9 a_6516_8766.t1 a_6516_8766.t4 133.5476
Rpar10 ib ib.t0 10.6542
Rpar11 ib ib.t1 15.4299
Rpar12 ib.t0 ib.t1 34.0770
Rpar13 inn inn.t0 3.4354
Rpar14 inp inp.t0 3.4839
Rpar15 out out.t0 5.3136
Rpar16 out out.t1 49.1767
Rpar17 out out.t8 97.6659
Rpar18 out.t1 out.t8 87.6322
Rpar19 vdd vdd.t0 64.5991
Rpar20 vdd vdd.t1 23.2978
Rpar21 vdd.t0 vdd.t1 7.5024
Rpar22 vss vss.t0 135.1018
Rpar23 vss vss.t1 806.0750
Rpar24 vss vss.t14 101.8907
Rpar25 vss vss.t19 234.9398
Rpar26 vss vss.t2 344.2654
Rpar27 vss vss.t20 86.2640
Rpar28 vss.t0 vss.t1 10.2165
Rpar29 vss.t0 vss.t14 200.6019
Rpar30 vss.t0 vss.t19 3.9936
Rpar31 vss.t0 vss.t2 4.5760
Rpar32 vss.t0 vss.t20 37.6432
Rpar33 vss.t1 vss.t14 1196.8768
Rpar34 vss.t1 vss.t19 27.9435
Rpar35 vss.t1 vss.t2 37.5427
Rpar36 vss.t1 vss.t20 270.0253
Rpar37 vss.t14 vss.t19 348.8435
Rpar38 vss.t14 vss.t2 511.1723
Rpar39 vss.t14 vss.t20 128.0865
Rpar40 vss.t19 vss.t2 6.5925
Rpar41 vss.t19 vss.t20 36.6189
Rpar42 vss.t2 vss.t20 58.6268
Cpar0 a_1644_8766.t0 vss 3.63739e-15
Cpar1 a_1644_8766.t2 vss 2.00967e-14
Cpar2 a_1644_8766.t3 vss 5.30322e-15
Cpar3 a_1828_7195.t0 vss 1.01870e-14
Cpar4 a_1828_7195.t1 vss 2.34856e-15
Cpar5 a_1828_7195.t8 vss 4.41948e-15
Cpar6 a_3234_5812.t0 vss 3.49260e-15
Cpar7 a_3234_5812.t4 vss 4.48440e-15
Cpar8 a_6516_8766.t0 vss 2.00553e-14
Cpar9 a_6516_8766.t1 vss 5.29228e-15
Cpar10 a_6516_8766.t4 vss 3.62990e-15
Cpar11 ib out 1.41600e-17
Cpar12 ib vss 1.96392e-14
Cpar13 ib.t0 vss 2.62989e-15
Cpar14 ib.t1 vss 4.09302e-16
Cpar15 inn inp 5.12600e-17
Cpar16 inn vss 5.32179e-15
Cpar17 inn.t0 vss 5.88432e-16
Cpar18 inp out 1.36800e-17
Cpar19 inp vss 5.51047e-15
Cpar20 inp.t0 vss 5.82421e-16
Cpar21 out vdd 6.21406e-15
Cpar22 out vss 1.54364e-14
Cpar23 out.t0 vss 4.93740e-16
Cpar24 out.t1 vss 8.69041e-16
Cpar25 out.t8 vss 1.47289e-14
Cpar26 vdd vss 9.19655e-14
Cpar27 vdd.t0 vss 4.07945e-14
Cpar28 vdd.t1 vss 7.14921e-15
.ends opamp_dut

Vdd vdd 0 3.300000
Vss vss 0 0
Ibias vdd ib 1.917000e-07
Vinp inp 0 DC 1.645000 AC 1 PWL(0 1.645000 7.396030e-08 1.645000 8.135633e-08 1.655000)
Rfb out inn 1m
Cload out 0 2.000000e-13
Xdut vdd vss inp inn out ib opamp_dut
.end
