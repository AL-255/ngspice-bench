* opa1000[0518]: 200f/pmos_5t_1v8_i150u_subth (pmos_5t, VDD=1.8V, CL=0.2pF, Iref=28.5uA)
.include "pdk_opa.inc"
.temp 27
.option gmin=1e-12 rshunt=1e12 reltol=1e-3 abstol=1e-12 vntol=1e-5 method=gear
* Post-PEX R+C extracted netlist for pmos_5t_1v8_i150u_subth
.subckt opamp_dut vdd vss inp inn out ib
XMpar0 a_1374_14226.t8 inp.t0 a_1740_1204.t0 vdd.t18 pfet_03v3 w=14u l=0.35u ad=4.0320e-12 pd=1.4926e-05 as=3.9760e-12 ps=1.4743e-05 nf=1 m=160 par=160
XMpar1 a_1374_14226.t8 inn.t0 out.t4 vdd.t18 pfet_03v3 w=14u l=0.35u ad=4.0320e-12 pd=1.4926e-05 as=3.9760e-12 ps=1.4743e-05 nf=1 m=160 par=160
XMpar2 out.t0 a_1740_1204.t160 vss.t1 vss.t0 nfet_03v3 w=1.94u l=0.7u ad=5.4320e-13 pd=2.5000e-06 as=5.7769e-13 ps=2.6433e-06 nf=1 m=36 par=36
XMpar3 ib.t1 ib.t0 vss.t15 vss.t14 nfet_03v3 w=6.91u l=0.65u ad=2.6719e-12 pd=9.9867e-06 as=1.9348e-12 ps=7.4700e-06 nf=1 m=6 par=6
XMpar4 a_1740_1204.t161 a_1740_1204.t160 vss.t1 vss.t0 nfet_03v3 w=1.94u l=0.7u ad=5.4320e-13 pd=2.5000e-06 as=5.4320e-13 ps=2.5000e-06 nf=1 m=36 par=36
XMpar5 a_1244_14018.t1 a_1244_14018.t0 vdd.t1 vdd.t0 pfet_03v3 w=10u l=0.65u ad=2.8000e-12 pd=1.0560e-05 as=2.8000e-12 ps=1.0560e-05 nf=1 m=6 par=6
XMpar6 a_1374_14226.t0 a_1244_14018.t0 vdd.t1 vdd.t0 pfet_03v3 w=10u l=0.65u ad=2.8000e-12 pd=1.0560e-05 as=3.0667e-12 ps=1.1447e-05 nf=1 m=24 par=24
XMpar7 a_1244_14018.t12 ib.t0 vss.t15 vss.t14 nfet_03v3 w=6.91u l=0.65u ad=1.9348e-12 pd=7.4700e-06 as=1.9348e-12 ps=7.4700e-06 nf=1 m=6 par=6
X86 out.t196 vss.t40 cap_mim_2f0fF c_width=19.56u c_length=19.56u
X359 out.t196 vss.t40 cap_mim_2f0fF c_width=19.56u c_length=19.56u
Rpar0 a_1244_14018.t0 a_1244_14018.t1 21.1372
Rpar1 a_1244_14018.t0 a_1244_14018.t12 120.6046
Rpar2 a_1244_14018.t1 a_1244_14018.t12 36.2947
Rpar3 a_1374_14226.t0 a_1374_14226.t8 48.7726
Rpar4 a_1740_1204.t0 a_1740_1204.t160 184.9927
Rpar5 a_1740_1204.t0 a_1740_1204.t161 82.2093
Rpar6 a_1740_1204.t160 a_1740_1204.t161 16.5253
Rpar7 ib ib.t0 16.0807
Rpar8 ib ib.t1 2.1468
Rpar9 inn inn.t0 2.9519
Rpar10 inp inp.t0 2.9519
Rpar11 out out.t0 1.9062
Rpar12 out out.t4 61.9271
Rpar13 out out.t196 73.3908
Rpar14 out.t4 out.t196 344.4539
Rpar15 vdd vdd.t0 69.0871
Rpar16 vdd vdd.t1 1079.4610
Rpar17 vdd vdd.t18 126.4440
Rpar18 vdd.t0 vdd.t1 4.3607
Rpar19 vdd.t0 vdd.t18 305.5774
Rpar20 vdd.t1 vdd.t18 4774.5372
Rpar21 vss vss.t0 83.5525
Rpar22 vss vss.t1 1043.7069
Rpar23 vss vss.t14 393.5850
Rpar24 vss vss.t15 696.3861
Rpar25 vss vss.t40 836.9732
Rpar26 vss.t0 vss.t1 2.9820
Rpar27 vss.t0 vss.t14 235.4765
Rpar28 vss.t0 vss.t15 416.6403
Rpar29 vss.t0 vss.t40 519.6000
Rpar30 vss.t1 vss.t40 6497.0155
Rpar31 vss.t14 vss.t15 6.1401
Rpar32 vss.t14 vss.t40 277.4677
Rpar33 vss.t15 vss.t40 490.9348
Cpar0 a_1244_14018.t0 vss 3.17393e-14
Cpar1 a_1244_14018.t1 vss 1.08481e-14
Cpar2 a_1244_14018.t12 vss 6.71767e-15
Cpar3 a_1374_14226.t0 vss 5.92649e-14
Cpar4 a_1374_14226.t8 vss 9.86398e-13
Cpar5 a_1740_1204.t0 vss 4.46614e-13
Cpar6 a_1740_1204.t160 vss 5.51779e-14
Cpar7 a_1740_1204.t161 vss 2.88020e-14
Cpar8 ib vdd 1.36270e-16
Cpar9 ib vss 1.90827e-14
Cpar10 ib.t0 vss 1.61379e-15
Cpar11 ib.t1 vss 1.06460e-15
Cpar12 inn inp 1.07900e-16
Cpar13 inn out 4.47486e-14
Cpar14 inn vdd 5.01663e-14
Cpar15 inn vss 2.17280e-14
Cpar16 inn.t0 vss 1.13838e-13
Cpar17 inp vdd 5.03344e-14
Cpar18 inp vss 2.18900e-14
Cpar19 inp.t0 vss 1.13992e-13
Cpar20 out vdd 1.72980e-14
Cpar21 out vss 5.38041e-14
Cpar22 out.t0 vss 1.39249e-14
Cpar23 out.t196 vss 2.29470e-13
Cpar24 out.t4 vss 2.78524e-13
Cpar25 vdd vss 8.50621e-13
Cpar26 vdd.t0 vss 2.17621e-14
Cpar27 vdd.t1 vss 9.00825e-15
Cpar28 vdd.t18 vss 1.83942e-13
.ends opamp_dut

Vdd vdd 0 1.800000
Vss vss 0 0
Ibias vdd ib 2.850000e-05
Vinp inp 0 DC 0.805000 AC 1 PWL(0 0.805000 3.000000e-09 0.805000 3.300000e-09 0.815000)
Rfb out inn 1m
Cload out 0 2.000000e-13
Xdut vdd vss inp inn out ib opamp_dut
.end
