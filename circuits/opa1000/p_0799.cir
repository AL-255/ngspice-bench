* opa1000[0799]: 2p/symmetrical_ota_1v8_i1u_weak (symmetrical_ota, VDD=1.8V, CL=2.0pF, Iref=0.1667uA)
.include "pdk_opa.inc"
.temp 27
.option gmin=1e-12 rshunt=1e12 reltol=1e-3 abstol=1e-12 vntol=1e-5 method=gear
* Post-PEX R+C extracted netlist for symmetrical_ota_1v8_i1u_weak
.subckt opamp_dut vdd vss inp inn out ib
XMpar0 out.t2 a_1828_7587.t0 vss.t1 vss.t0 nfet_03v3 w=0.4u l=4.5u ad=1.1200e-13 pd=9.6000e-07 as=1.7600e-13 ps=1.4800e-06 nf=1 m=4 par=4
XMpar1 a_2045_6225.t0 ib.t0 vss.t5 vss.t4 nfet_03v3 w=0.4u l=4.38u ad=1.1200e-13 pd=9.6000e-07 as=1.7600e-13 ps=1.4800e-06 nf=1 m=4 par=4
XMpar2 a_1644_2819.t0 inp.t0 a_2045_6225.t4 vss.t18 nfet_03v3 w=2.46u l=6u ad=6.8880e-13 pd=3.0200e-06 as=1.4760e-12 ps=6.1200e-06 nf=1 m=2 par=2
XMpar3 out.t0 a_1644_2819.t2 vdd.t1 vdd.t0 pfet_03v3 w=1.07u l=4.5u ad=6.4200e-13 pd=3.3400e-06 as=4.7080e-13 ps=2.4850e-06 nf=1 m=4 par=4
XMpar4 ib.t1 ib.t0 vss.t5 vss.t4 nfet_03v3 w=0.4u l=4.38u ad=1.1200e-13 pd=9.6000e-07 as=1.1200e-13 ps=9.6000e-07 nf=1 m=2 par=2
XMpar5 a_1644_2819.t3 a_1644_2819.t2 vdd.t1 vdd.t0 pfet_03v3 w=1.07u l=4.5u ad=6.4200e-13 pd=3.3400e-06 as=2.9960e-13 ps=1.6300e-06 nf=1 m=2 par=2
XMpar6 a_2045_6225.t4 inn.t0 a_6516_2819.t0 vss.t18 nfet_03v3 w=2.46u l=6u ad=1.4760e-12 pd=6.1200e-06 as=6.8880e-13 ps=3.0200e-06 nf=1 m=2 par=2
XMpar7 a_6516_2819.t3 a_6516_2819.t2 vdd.t1 vdd.t0 pfet_03v3 w=1.07u l=4.5u ad=6.4200e-13 pd=3.3400e-06 as=2.9960e-13 ps=1.6300e-06 nf=1 m=2 par=2
XMpar8 a_1828_7587.t8 a_6516_2819.t2 vdd.t1 vdd.t0 pfet_03v3 w=1.07u l=4.5u ad=6.4200e-13 pd=3.3400e-06 as=4.7080e-13 ps=2.4850e-06 nf=1 m=4 par=4
XMpar9 a_1828_7587.t1 a_1828_7587.t0 vss.t1 vss.t0 nfet_03v3 w=0.4u l=4.5u ad=1.1200e-13 pd=9.6000e-07 as=1.1200e-13 ps=9.6000e-07 nf=1 m=4 par=4
Rpar0 a_1644_2819.t0 a_1644_2819.t2 100.9806
Rpar1 a_1644_2819.t0 a_1644_2819.t3 117.7347
Rpar2 a_1644_2819.t2 a_1644_2819.t3 14.0641
Rpar3 a_1828_7587.t0 a_1828_7587.t1 22.9040
Rpar4 a_1828_7587.t0 a_1828_7587.t8 178.4250
Rpar5 a_1828_7587.t1 a_1828_7587.t8 76.8350
Rpar6 a_2045_6225.t0 a_2045_6225.t4 67.9707
Rpar7 a_6516_2819.t0 a_6516_2819.t2 83.7260
Rpar8 a_6516_2819.t0 a_6516_2819.t3 97.6180
Rpar9 a_6516_2819.t2 a_6516_2819.t3 14.2529
Rpar10 ib ib.t0 11.2605
Rpar11 ib ib.t1 16.2841
Rpar12 inn inn.t0 3.8189
Rpar13 inp inp.t0 3.8674
Rpar14 out out.t0 6.2285
Rpar15 out out.t2 69.7532
Rpar16 out.t0 out.t2 113.5857
Rpar17 vdd vdd.t0 175.6571
Rpar18 vdd vdd.t1 63.4082
Rpar19 vdd.t0 vdd.t1 7.1193
Rpar20 vss vss.t0 170.3721
Rpar21 vss vss.t1 694.8735
Rpar22 vss vss.t4 237.8819
Rpar23 vss vss.t5 441.1665
Rpar24 vss vss.t18 73.3270
Rpar25 vss.t0 vss.t1 11.4354
Rpar26 vss.t0 vss.t4 5.2366
Rpar27 vss.t0 vss.t5 14.4968
Rpar28 vss.t0 vss.t18 116.9695
Rpar29 vss.t1 vss.t4 19.4553
Rpar30 vss.t1 vss.t5 65.6460
Rpar31 vss.t1 vss.t18 476.5635
Rpar32 vss.t4 vss.t5 18.2826
Rpar33 vss.t4 vss.t18 163.3834
Rpar34 vss.t5 vss.t18 303.4468
Cpar0 a_1644_2819.t0 vss 3.81745e-15
Cpar1 a_1644_2819.t2 vss 1.97208e-14
Cpar2 a_1644_2819.t3 vss 4.85725e-15
Cpar3 a_1828_7587.t0 vss 1.07107e-14
Cpar4 a_1828_7587.t1 vss 2.69995e-15
Cpar5 a_1828_7587.t8 vss 4.81877e-15
Cpar6 a_2045_6225.t0 vss 3.93576e-15
Cpar7 a_2045_6225.t4 vss 6.30614e-15
Cpar8 a_6516_2819.t0 vss 3.95204e-15
Cpar9 a_6516_2819.t2 vss 2.07347e-14
Cpar10 a_6516_2819.t3 vss 5.04068e-15
Cpar11 ib out 5.89300e-17
Cpar12 ib vdd 1.67160e-16
Cpar13 ib vss 1.90252e-14
Cpar14 ib.t0 vss 2.44314e-15
Cpar15 ib.t1 vss 1.13830e-16
Cpar16 inn inp 5.19700e-17
Cpar17 inn vdd 1.47800e-17
Cpar18 inn vss 6.33849e-15
Cpar19 inn.t0 vss 9.20803e-16
Cpar20 inp vdd 1.73400e-17
Cpar21 inp vss 6.49745e-15
Cpar22 inp.t0 vss 9.17257e-16
Cpar23 out vdd 6.16578e-15
Cpar24 out vss 1.31729e-14
Cpar25 out.t0 vss 5.09547e-15
Cpar26 out.t2 vss 6.13228e-15
Cpar27 vdd vss 9.76218e-14
Cpar28 vdd.t0 vss 4.15487e-14
Cpar29 vdd.t1 vss 8.15718e-15
.ends opamp_dut

Vdd vdd 0 1.800000
Vss vss 0 0
Ibias vdd ib 1.667000e-07
Vinp inp 0 DC 0.895000 AC 1 PWL(0 0.895000 2.048983e-07 0.895000 2.253882e-07 0.905000)
Rfb out inn 1m
Cload out 0 2.000000e-12
Xdut vdd vss inp inn out ib opamp_dut
.end
