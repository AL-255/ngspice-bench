* opa1000[0500]: 200f/pmos_5t_1v8_ulp_lt0p1uw_weak (pmos_5t, VDD=1.8V, CL=0.2pF, Iref=0.0013uA)
.include "pdk_opa.inc"
.temp 27
.option gmin=1e-12 rshunt=1e12 reltol=1e-3 abstol=1e-12 vntol=1e-5 method=gear
* Post-PEX R+C extracted netlist for pmos_5t_1v8_ulp_lt0p1uw_weak
.subckt opamp_dut vdd vss inp inn out ib
XMpar0 a_3703_9300.t0 ib.t0 vss.t5 vss.t4 nfet_03v3 w=0.4u l=5u ad=2.4000e-13 pd=2.0000e-06 as=1.1200e-13 ps=9.6000e-07 nf=1 m=2 par=2
XMpar1 a_3703_9300.t3 a_3703_9300.t2 vdd.t1 vdd.t0 pfet_03v3 w=0.4u l=5u ad=2.4000e-13 pd=2.0000e-06 as=1.1200e-13 ps=9.6000e-07 nf=1 m=2 par=2
XMpar2 a_2234_7844.t0 a_3703_9300.t2 vdd.t1 vdd.t0 pfet_03v3 w=0.4u l=5u ad=1.1200e-13 pd=9.6000e-07 as=2.0800e-13 ps=1.7400e-06 nf=1 m=8 par=8
XMpar3 a_2234_7844.t1 inp.t0 a_2532_6228.t0 vdd.t2 pfet_03v3 w=0.4u l=9.5u ad=2.4000e-13 pd=2.0000e-06 as=1.1200e-13 ps=9.6000e-07 nf=1 m=2 par=2
XMpar4 a_2234_7844.t1 inn.t0 out.t0 vdd.t2 pfet_03v3 w=0.4u l=9.5u ad=2.4000e-13 pd=2.0000e-06 as=1.1200e-13 ps=9.6000e-07 nf=1 m=2 par=2
XMpar5 ib.t1 ib.t0 vss.t5 vss.t4 nfet_03v3 w=0.4u l=5u ad=2.4000e-13 pd=2.0000e-06 as=1.1200e-13 ps=9.6000e-07 nf=1 m=2 par=2
XMpar6 a_2532_6228.t3 a_2532_6228.t2 vss.t1 vss.t0 nfet_03v3 w=0.4u l=9.5u ad=2.4000e-13 pd=2.0000e-06 as=1.1200e-13 ps=9.6000e-07 nf=1 m=2 par=2
XMpar7 out.t1 a_2532_6228.t2 vss.t1 vss.t0 nfet_03v3 w=0.4u l=9.5u ad=1.1200e-13 pd=9.6000e-07 as=1.1200e-13 ps=9.6000e-07 nf=1 m=2 par=2
X13 out.t4 vss.t14 cap_mim_2f0fF c_width=16.86u c_length=16.87u
X18 out.t4 vss.t14 cap_mim_2f0fF c_width=16.86u c_length=16.87u
Rpar0 a_2234_7844.t0 a_2234_7844.t1 53.8375
Rpar1 a_2532_6228.t0 a_2532_6228.t2 89.8808
Rpar2 a_2532_6228.t0 a_2532_6228.t3 71.1345
Rpar3 a_2532_6228.t2 a_2532_6228.t3 24.0560
Rpar4 a_3703_9300.t0 a_3703_9300.t2 73.4942
Rpar5 a_3703_9300.t0 a_3703_9300.t3 119.2559
Rpar6 a_3703_9300.t2 a_3703_9300.t3 16.1227
Rpar7 ib ib.t0 9.4990
Rpar8 ib ib.t1 11.8304
Rpar9 ib.t0 ib.t1 43.3716
Rpar10 inn inn.t0 3.5826
Rpar11 inp inp.t0 3.6311
Rpar12 out out.t0 96.5611
Rpar13 out out.t1 99.2115
Rpar14 out out.t4 16.7924
Rpar15 out.t0 out.t1 111.3968
Rpar16 vdd vdd.t0 596.4172
Rpar17 vdd vdd.t1 167.5906
Rpar18 vdd vdd.t2 71.8397
Rpar19 vdd.t0 vdd.t1 13.4272
Rpar20 vdd.t0 vdd.t2 175.7851
Rpar21 vdd.t1 vdd.t2 49.3948
Rpar22 vss vss.t0 101.4609
Rpar23 vss vss.t1 405.2094
Rpar24 vss vss.t14 56.0709
Rpar25 vss vss.t4 186.2268
Rpar26 vss vss.t5 328.1906
Rpar27 vss.t0 vss.t1 13.3494
Rpar28 vss.t0 vss.t14 259.3937
Rpar29 vss.t0 vss.t4 126.6412
Rpar30 vss.t0 vss.t5 223.6937
Rpar31 vss.t1 vss.t14 1035.9536
Rpar32 vss.t1 vss.t4 505.7780
Rpar33 vss.t1 vss.t5 893.3843
Rpar34 vss.t14 vss.t4 476.1053
Rpar35 vss.t14 vss.t5 839.0482
Rpar36 vss.t4 vss.t5 27.9793
Cpar0 a_2234_7844.t0 vss 1.58916e-14
Cpar1 a_2234_7844.t1 vss 1.00935e-14
Cpar2 a_2532_6228.t0 vss 9.84804e-16
Cpar3 a_2532_6228.t2 vss 6.22983e-15
Cpar4 a_2532_6228.t3 vss 1.51656e-15
Cpar5 a_3703_9300.t0 vss 6.50900e-15
Cpar6 a_3703_9300.t2 vss 3.36468e-14
Cpar7 a_3703_9300.t3 vss 6.10678e-15
Cpar8 ib vdd 8.78300e-17
Cpar9 ib vss 1.76017e-14
Cpar10 ib.t0 vss 2.60185e-15
Cpar11 ib.t1 vss 3.10346e-16
Cpar12 inn inp 5.23500e-17
Cpar13 inn out 2.01030e-16
Cpar14 inn vdd 8.64634e-15
Cpar15 inn vss 5.29609e-15
Cpar16 inn.t0 vss 4.91163e-15
Cpar17 inp vdd 8.59716e-15
Cpar18 inp vss 5.25020e-15
Cpar19 inp.t0 vss 4.93736e-15
Cpar20 out vdd 2.56922e-15
Cpar21 out vss 2.22612e-14
Cpar22 out.t0 vss 1.38410e-16
Cpar23 out.t1 vss 1.79074e-16
Cpar24 out.t4 vss 8.77646e-15
Cpar25 vdd vss 1.10909e-13
Cpar26 vdd.t0 vss 3.43739e-14
Cpar27 vdd.t1 vss 8.57071e-15
Cpar28 vdd.t2 vss 1.73711e-14
.ends opamp_dut

Vdd vdd 0 1.800000
Vss vss 0 0
Ibias vdd ib 1.300000e-09
Vinp inp 0 DC 0.805000 AC 1 PWL(0 0.805000 1.642579e-05 0.805000 1.806837e-05 0.815000)
Rfb out inn 1m
Cload out 0 2.000000e-13
Xdut vdd vss inp inn out ib opamp_dut
.end
