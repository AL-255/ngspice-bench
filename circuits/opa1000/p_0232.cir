* opa1000[0232]: 2p/folded_cascode_nmos_3v3_i200n_subth (folded_cascode_nmos, VDD=3.3V, CL=2.0pF, Iref=0.0444uA)
.include "pdk_opa.inc"
.temp 27
.option gmin=1e-12 rshunt=1e12 reltol=1e-3 abstol=1e-12 vntol=1e-5 method=gear
* Post-PEX R+C extracted netlist for folded_cascode_nmos_3v3_i200n_subth
.subckt opamp_dut vdd vss inp inn out ib
XMpar0 out.t0 a_5430_6576.t4 vss.t1 vss.t0 nfet_03v3 w=0.43u l=6.25u ad=2.5800e-13 pd=2.0600e-06 as=1.2040e-13 ps=9.9000e-07 nf=1 m=2 par=2
XMpar1 a_1650_1249.t0 inp.t0 a_3210_1249.t1 vss.t2 nfet_03v3 w=8u l=7.2u ad=3.5200e-12 pd=1.2880e-05 as=2.2400e-12 ps=8.5600e-06 nf=1 m=8 par=8
XMpar2 a_3210_1249.t10 ib.t4 a_5430_6576.t0 vdd.t14 pfet_03v3 w=2.14u l=3.5u ad=9.4160e-13 pd=4.0900e-06 as=5.9920e-13 ps=2.7000e-06 nf=1 m=4 par=4
XMpar3 a_8174_6576.t11 ib.t4 out.t1 vdd.t14 pfet_03v3 w=2.14u l=3.5u ad=9.4160e-13 pd=4.0900e-06 as=5.9920e-13 ps=2.7000e-06 nf=1 m=4 par=4
XMpar4 a_1650_1249.t16 ib.t0 vss.t1 vss.t0 nfet_03v3 w=0.43u l=6.25u ad=2.5800e-13 pd=2.0600e-06 as=1.2040e-13 ps=9.9000e-07 nf=1 m=4 par=4
XMpar5 ib.t1 ib.t0 vss.t1 vss.t0 nfet_03v3 w=0.43u l=6.25u ad=2.5800e-13 pd=2.0600e-06 as=1.2040e-13 ps=9.9000e-07 nf=1 m=2 par=2
XMpar6 a_1650_1249.t0 inn.t0 a_8174_6576.t3 vss.t2 nfet_03v3 w=8u l=7.2u ad=3.5200e-12 pd=1.2880e-05 as=2.2400e-12 ps=8.5600e-06 nf=1 m=8 par=8
XMpar7 a_8174_6576.t0 a_1194_11247.t2 vdd.t1 vdd.t0 pfet_03v3 w=0.95u l=5.2u ad=2.6600e-13 pd=1.5100e-06 as=4.1800e-13 ps=2.3050e-06 nf=1 m=4 par=4
XMpar8 a_5430_6576.t5 a_5430_6576.t4 vss.t1 vss.t0 nfet_03v3 w=0.43u l=6.25u ad=2.5800e-13 pd=2.0600e-06 as=1.2040e-13 ps=9.9000e-07 nf=1 m=2 par=2
XMpar9 a_3210_1249.t0 a_1194_11247.t2 vdd.t1 vdd.t0 pfet_03v3 w=0.95u l=5.2u ad=2.6600e-13 pd=1.5100e-06 as=4.1800e-13 ps=2.3050e-06 nf=1 m=4 par=4
XMpar10 a_1194_11247.t3 a_1194_11247.t2 vdd.t1 vdd.t0 pfet_03v3 w=0.95u l=5.2u ad=2.6600e-13 pd=1.5100e-06 as=5.7000e-13 ps=3.1000e-06 nf=1 m=2 par=2
XMpar11 a_1194_11247.t0 ib.t0 vss.t1 vss.t0 nfet_03v3 w=0.43u l=6.25u ad=2.5800e-13 pd=2.0600e-06 as=1.2040e-13 ps=9.9000e-07 nf=1 m=2 par=2
Rpar0 a_1194_11247.t0 a_1194_11247.t2 58.2858
Rpar1 a_1194_11247.t0 a_1194_11247.t3 134.7972
Rpar2 a_1194_11247.t2 a_1194_11247.t3 24.8436
Rpar3 a_1650_1249.t0 a_1650_1249.t16 74.7717
Rpar4 a_3210_1249.t0 a_3210_1249.t1 174.9253
Rpar5 a_3210_1249.t0 a_3210_1249.t10 82.9275
Rpar6 a_3210_1249.t1 a_3210_1249.t10 47.3290
Rpar7 a_5430_6576.t0 a_5430_6576.t4 108.1246
Rpar8 a_5430_6576.t0 a_5430_6576.t5 130.1235
Rpar9 a_5430_6576.t4 a_5430_6576.t5 15.1465
Rpar10 a_8174_6576.t0 a_8174_6576.t3 174.9253
Rpar11 a_8174_6576.t0 a_8174_6576.t11 82.9275
Rpar12 a_8174_6576.t3 a_8174_6576.t11 47.3290
Rpar13 ib ib.t0 13.7675
Rpar14 ib ib.t1 14.5803
Rpar15 ib ib.t4 34.7194
Rpar16 ib.t0 ib.t1 31.7581
Rpar17 inn inn.t0 2.6968
Rpar18 inp inp.t0 2.6968
Rpar19 out out.t0 12.0429
Rpar20 out out.t1 100.9377
Rpar21 out.t0 out.t1 114.2596
Rpar22 vdd vdd.t0 39.1564
Rpar23 vdd vdd.t1 55.8887
Rpar24 vdd vdd.t14 174.5629
Rpar25 vdd.t0 vdd.t1 7.1506
Rpar26 vdd.t0 vdd.t14 259.3929
Rpar27 vdd.t1 vdd.t14 157.8364
Rpar28 vss vss.t0 265.9284
Rpar29 vss vss.t1 1011.8233
Rpar30 vss vss.t2 87.6837
Rpar31 vss.t0 vss.t1 8.2890
Rpar32 vss.t0 vss.t2 69.9388
Rpar33 vss.t1 vss.t2 277.4691
Cpar0 a_1194_11247.t0 vss 7.67576e-15
Cpar1 a_1194_11247.t2 vss 3.06287e-14
Cpar2 a_1194_11247.t3 vss 2.40945e-15
Cpar3 a_1650_1249.t0 vss 3.25798e-14
Cpar4 a_1650_1249.t16 vss 8.03393e-15
Cpar5 a_3210_1249.t0 vss 5.15570e-15
Cpar6 a_3210_1249.t1 vss 1.66363e-14
Cpar7 a_3210_1249.t10 vss 6.71337e-15
Cpar8 a_5430_6576.t0 vss 2.46109e-15
Cpar9 a_5430_6576.t4 vss 6.94347e-15
Cpar10 a_5430_6576.t5 vss 1.87108e-15
Cpar11 a_8174_6576.t0 vss 4.74750e-15
Cpar12 a_8174_6576.t11 vss 6.18185e-15
Cpar13 a_8174_6576.t3 vss 1.53192e-14
Cpar14 ib inn 3.45800e-17
Cpar15 ib inp 2.81800e-17
Cpar16 ib out 2.06180e-15
Cpar17 ib vdd 1.39946e-14
Cpar18 ib vss 3.76421e-14
Cpar19 ib.t0 vss 1.38616e-14
Cpar20 ib.t1 vss 1.27542e-15
Cpar21 ib.t4 vss 1.38663e-14
Cpar22 inn inp 1.02790e-16
Cpar23 inn vdd 1.45200e-17
Cpar24 inn vss 2.66529e-14
Cpar25 inn.t0 vss 1.22740e-14
Cpar26 inp vdd 1.44200e-17
Cpar27 inp vss 2.61478e-14
Cpar28 inp.t0 vss 1.23353e-14
Cpar29 out vdd 2.13789e-15
Cpar30 out vss 1.12176e-14
Cpar31 out.t0 vss 1.88813e-15
Cpar32 out.t1 vss 4.98145e-15
Cpar33 vdd vss 1.17922e-13
Cpar34 vdd.t0 vss 1.89969e-14
Cpar35 vdd.t1 vss 1.47247e-14
Cpar36 vdd.t14 vss 2.06074e-14
.ends opamp_dut

Vdd vdd 0 3.300000
Vss vss 0 0
Ibias vdd ib 4.440000e-08
Vinp inp 0 DC 1.810000 AC 1 PWL(0 1.810000 1.007336e-06 1.810000 1.108070e-06 1.820000)
Rfb out inn 1m
Cload out 0 2.000000e-12
Xdut vdd vss inp inn out ib opamp_dut
.end
