* opa1000[0811]: 2p/symmetrical_ota_1v8_i150u_weak (symmetrical_ota, VDD=1.8V, CL=2.0pF, Iref=32.5uA)
.include "pdk_opa.inc"
.temp 27
.option gmin=1e-12 rshunt=1e12 reltol=1e-3 abstol=1e-12 vntol=1e-5 method=gear
* Post-PEX R+C extracted netlist for symmetrical_ota_1v8_i150u_weak
.subckt opamp_dut vdd vss inp inn out ib
XMpar0 a_4234_1249.t0 inn.t0 a_6574_1249.t0 vss.t13 nfet_03v3 w=1.94u l=0.36u ad=5.9964e-13 pd=2.7345e-06 as=5.9964e-13 ps=2.7345e-06 nf=1 m=22 par=22
XMpar1 a_3652_7478.t24 a_6574_1249.t22 vdd.t1 vdd.t0 pfet_03v3 w=10u l=0.7u ad=2.8000e-12 pd=1.0560e-05 as=3.3333e-12 ps=1.2333e-05 nf=1 m=12 par=12
XMpar2 a_1348_3942.t12 inp.t0 a_4234_1249.t0 vss.t13 nfet_03v3 w=1.94u l=0.36u ad=5.9964e-13 pd=2.7345e-06 as=5.9964e-13 ps=2.7345e-06 nf=1 m=22 par=22
XMpar3 out.t0 a_1348_3942.t0 vdd.t1 vdd.t0 pfet_03v3 w=10u l=0.7u ad=2.8000e-12 pd=1.0560e-05 as=3.3333e-12 ps=1.2333e-05 nf=1 m=12 par=12
XMpar4 a_3652_7478.t1 a_3652_7478.t0 vss.t1 vss.t0 nfet_03v3 w=2.77u l=0.7u ad=7.7560e-13 pd=3.3300e-06 as=7.7560e-13 ps=3.3300e-06 nf=1 m=12 par=12
XMpar5 out.t3 a_3652_7478.t0 vss.t1 vss.t0 nfet_03v3 w=2.77u l=0.7u ad=7.7560e-13 pd=3.3300e-06 as=9.2333e-13 ps=3.8983e-06 nf=1 m=12 par=12
XMpar6 a_6574_1249.t23 a_6574_1249.t22 vdd.t1 vdd.t0 pfet_03v3 w=10u l=0.7u ad=2.8000e-12 pd=1.0560e-05 as=2.8000e-12 ps=1.0560e-05 nf=1 m=6 par=6
XMpar7 a_1348_3942.t1 a_1348_3942.t0 vdd.t1 vdd.t0 pfet_03v3 w=10u l=0.7u ad=2.8000e-12 pd=1.0560e-05 as=2.8000e-12 ps=1.0560e-05 nf=1 m=6 par=6
XMpar8 ib.t1 ib.t0 vss.t35 vss.t0 nfet_03v3 w=1.78u l=0.39u ad=4.9840e-13 pd=2.3400e-06 as=4.9840e-13 ps=2.3400e-06 nf=1 m=6 par=6
XMpar9 a_4234_1249.t22 ib.t0 vss.t35 vss.t0 nfet_03v3 w=1.78u l=0.39u ad=4.9840e-13 pd=2.3400e-06 as=7.8320e-13 ps=3.5500e-06 nf=1 m=12 par=12
X11 out.t24 vss.t4 cap_mim_2f0fF c_width=17.43u c_length=17.43u
Rpar0 a_1348_3942.t0 a_1348_3942.t1 20.2165
Rpar1 a_1348_3942.t0 a_1348_3942.t12 351.0915
Rpar2 a_1348_3942.t1 a_1348_3942.t12 80.9491
Rpar3 a_3652_7478.t0 a_3652_7478.t1 15.0602
Rpar4 a_3652_7478.t0 a_3652_7478.t24 1327.8663
Rpar5 a_3652_7478.t1 a_3652_7478.t24 59.1190
Rpar6 a_4234_1249.t0 a_4234_1249.t22 66.4290
Rpar7 a_6574_1249.t0 a_6574_1249.t22 306.1228
Rpar8 a_6574_1249.t0 a_6574_1249.t23 70.5834
Rpar9 a_6574_1249.t22 a_6574_1249.t23 20.3566
Rpar10 ib ib.t0 13.0382
Rpar11 ib ib.t1 6.2886
Rpar12 ib.t0 ib.t1 16.8334
Rpar13 inn inn.t0 3.8007
Rpar14 inp inp.t0 3.8007
Rpar15 out out.t0 302.8073
Rpar16 out out.t3 2.3585
Rpar17 out out.t24 496.4859
Rpar18 out.t0 out.t3 102.3581
Rpar19 out.t0 out.t24 90.0100
Rpar20 out.t3 out.t24 167.8274
Rpar21 vdd vdd.t0 109.7955
Rpar22 vdd vdd.t1 622.0904
Rpar23 vdd.t0 vdd.t1 2.3824
Rpar24 vss vss.t0 189.1767
Rpar25 vss vss.t1 748.2418
Rpar26 vss vss.t13 48.7092
Rpar27 vss vss.t35 3586.6001
Rpar28 vss vss.t4 5025.8348
Rpar29 vss.t0 vss.t1 3.4193
Rpar30 vss.t0 vss.t13 35.1420
Rpar31 vss.t0 vss.t35 10.3780
Rpar32 vss.t0 vss.t4 184.6365
Rpar33 vss.t1 vss.t13 139.3417
Rpar34 vss.t1 vss.t35 365.4910
Rpar35 vss.t1 vss.t4 1128.2240
Rpar36 vss.t13 vss.t35 668.5760
Rpar37 vss.t13 vss.t4 937.4817
Rpar38 vss.t35 vss.t4 69.2863
Cpar0 a_1348_3942.t0 vss 2.46189e-14
Cpar1 a_1348_3942.t1 vss 1.30921e-14
Cpar2 a_1348_3942.t12 vss 1.14687e-14
Cpar3 a_3652_7478.t0 vss 9.88245e-15
Cpar4 a_3652_7478.t1 vss 6.50061e-15
Cpar5 a_3652_7478.t24 vss 1.29367e-14
Cpar6 a_4234_1249.t0 vss 2.77953e-14
Cpar7 a_4234_1249.t22 vss 1.11212e-14
Cpar8 a_6574_1249.t0 vss 1.18588e-14
Cpar9 a_6574_1249.t22 vss 2.56367e-14
Cpar10 a_6574_1249.t23 vss 1.37942e-14
Cpar11 ib out 1.91600e-17
Cpar12 ib vdd 1.73000e-17
Cpar13 ib vss 2.02662e-14
Cpar14 ib.t0 vss 2.04310e-15
Cpar15 ib.t1 vss 9.27220e-16
Cpar16 inn inp 1.03210e-16
Cpar17 inn vss 1.01285e-14
Cpar18 inn.t0 vss 2.83011e-15
Cpar19 inp vss 1.02186e-14
Cpar20 inp.t0 vss 2.82724e-15
Cpar21 out vdd 2.04672e-14
Cpar22 out vss 1.98263e-14
Cpar23 out.t0 vss 4.91616e-15
Cpar24 out.t24 vss 2.47203e-14
Cpar25 out.t3 vss 1.74571e-15
Cpar26 vdd vss 1.32166e-13
Cpar27 vdd.t0 vss 5.60604e-14
Cpar28 vdd.t1 vss 2.43978e-14
.ends opamp_dut

Vdd vdd 0 1.800000
Vss vss 0 0
Ibias vdd ib 3.250000e-05
Vinp inp 0 DC 0.895000 AC 1 PWL(0 0.895000 3.000000e-09 0.895000 3.300000e-09 0.905000)
Rfb out inn 1m
Cload out 0 2.000000e-12
Xdut vdd vss inp inn out ib opamp_dut
.end
