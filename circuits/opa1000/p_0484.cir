* opa1000[0484]: 2p/nmos_miller_3v3_0p1u_1u_subth (nmos_miller, VDD=3.3V, CL=2.0pF, Iref=0.0929uA)
.include "pdk_opa.inc"
.temp 27
.option gmin=1e-12 rshunt=1e12 reltol=1e-3 abstol=1e-12 vntol=1e-5 method=gear
* Post-PEX R+C extracted netlist for nmos_miller_3v3_0p1u_1u_subth
.subckt opamp_dut vdd vss inp inn out ib
XMpar0 out.t0 a_1092_11819.t9 vdd.t1 vdd.t0 pfet_03v3 w=2.17u l=2u ad=6.0760e-13 pd=2.7300e-06 as=7.4648e-13 ps=3.2920e-06 nf=1 m=10 par=10
XMpar1 a_1092_11819.t1 inp.t0 a_2982_1204.t4 vss.t0 nfet_03v3 w=1.54u l=6.5u ad=5.9547e-13 pd=2.8267e-06 as=5.9547e-13 ps=2.8267e-06 nf=1 m=6 par=6
XMpar2 out.t1 ib.t0 vss.t1 vss.t0 nfet_03v3 w=0.95u l=6.25u ad=4.4840e-13 pd=2.4640e-06 as=3.8760e-13 ps=2.1460e-06 nf=1 m=10 par=10
XMpar3 a_6612_13762.t7 a_6612_13762.t6 vdd.t1 vdd.t0 pfet_03v3 w=2.17u l=2u ad=6.0760e-13 pd=2.7300e-06 as=6.0760e-13 ps=2.7300e-06 nf=1 m=2 par=2
XMpar4 a_2982_1204.t0 ib.t0 vss.t1 vss.t0 nfet_03v3 w=0.95u l=6.25u ad=5.7000e-13 pd=3.1000e-06 as=2.6600e-13 ps=1.5100e-06 nf=1 m=4 par=4
XMpar5 a_2982_1204.t4 inn.t0 a_6612_13762.t0 vss.t0 nfet_03v3 w=1.54u l=6.5u ad=5.9547e-13 pd=2.8267e-06 as=5.9547e-13 ps=2.8267e-06 nf=1 m=6 par=6
XMpar6 a_1092_11819.t0 a_6612_13762.t6 vdd.t1 vdd.t0 pfet_03v3 w=2.17u l=2u ad=1.3020e-12 pd=5.5400e-06 as=6.0760e-13 ps=2.7300e-06 nf=1 m=2 par=2
XMpar7 ib.t1 ib.t0 vss.t1 vss.t0 nfet_03v3 w=0.95u l=6.25u ad=5.7000e-13 pd=3.1000e-06 as=2.6600e-13 ps=1.5100e-06 nf=1 m=2 par=2
X2 a_8356_9061.t0 a_12268_8541.t0 vss.t30 ppolyf_u_1k r_width=1u r_length=18.9u
X7 a_8356_10101.t1 out.t11 cap_mim_2f0fF c_width=14.37u c_length=14.36u
X10 a_8356_8021.t0 a_12268_8541.t0 vss.t30 ppolyf_u_1k r_width=1u r_length=18.9u
X16 a_8356_8021.t0 a_12268_7501.t0 vss.t30 ppolyf_u_1k r_width=1u r_length=18.9u
X24 a_1092_11819.t7 a_12268_7501.t0 vss.t30 ppolyf_u_1k r_width=1u r_length=18.9u
X36 a_8356_10101.t1 out.t11 cap_mim_2f0fF c_width=14.37u c_length=14.36u
X42 a_8356_9061.t0 a_12268_9581.t0 vss.t30 ppolyf_u_1k r_width=1u r_length=18.9u
X49 a_8356_10101.t0 a_12268_9581.t0 vss.t30 ppolyf_u_1k r_width=1u r_length=18.9u
Rpar0 a_1092_11819.t0 a_1092_11819.t1 170.8717
Rpar1 a_1092_11819.t0 a_1092_11819.t9 97.3030
Rpar2 a_1092_11819.t0 a_1092_11819.t7 283.1984
Rpar3 a_1092_11819.t1 a_1092_11819.t9 85.6708
Rpar4 a_1092_11819.t1 a_1092_11819.t7 151.8998
Rpar5 a_1092_11819.t9 a_1092_11819.t7 141.9886
Rpar6 a_2982_1204.t0 a_2982_1204.t4 50.9302
Rpar7 a_6612_13762.t0 a_6612_13762.t6 220.8670
Rpar8 a_6612_13762.t0 a_6612_13762.t7 113.5213
Rpar9 a_6612_13762.t6 a_6612_13762.t7 23.1654
Rpar10 a_8356_10101.t0 a_8356_10101.t1 57.0108
Rpar11 ib ib.t0 19.1592
Rpar12 ib ib.t1 13.8800
Rpar13 ib.t0 ib.t1 30.6906
Rpar14 inn inn.t0 2.3679
Rpar15 inp inp.t0 2.3679
Rpar16 out out.t0 93.0483
Rpar17 out out.t1 42.7515
Rpar18 out out.t11 22.8627
Rpar19 out.t0 out.t1 93.5241
Rpar20 out.t0 out.t11 626.0894
Rpar21 out.t1 out.t11 287.6600
Rpar22 vdd vdd.t0 34.4964
Rpar23 vdd vdd.t1 50.9552
Rpar24 vdd.t0 vdd.t1 3.4276
Rpar25 vss vss.t0 40.9620
Rpar26 vss vss.t1 1096.9828
Rpar27 vss vss.t30 635.6636
Rpar28 vss.t0 vss.t1 12.6107
Rpar29 vss.t0 vss.t30 6.4517
Rpar30 vss.t1 vss.t30 202.9729
Cpar0 a_1092_11819.t0 vss 4.91285e-15
Cpar1 a_1092_11819.t1 vss 7.86805e-15
Cpar2 a_1092_11819.t7 vss 4.15343e-15
Cpar3 a_1092_11819.t9 vss 1.59991e-14
Cpar4 a_12268_7501.t0 vss 2.67400e-17
Cpar5 a_12268_8541.t0 vss 3.08200e-17
Cpar6 a_12268_9581.t0 vss 2.64400e-17
Cpar7 a_2982_1204.t0 vss 1.99490e-14
Cpar8 a_2982_1204.t4 vss 1.87725e-14
Cpar9 a_6612_13762.t0 vss 8.20388e-15
Cpar10 a_6612_13762.t6 vss 5.97364e-15
Cpar11 a_6612_13762.t7 vss 3.70983e-15
Cpar12 a_8356_10101.t0 vss 1.04703e-16
Cpar13 a_8356_10101.t1 vss 4.71827e-15
Cpar14 a_8356_8021.t0 vss 3.96400e-17
Cpar15 a_8356_9061.t0 vss 3.96400e-17
Cpar16 ib inn 3.71700e-17
Cpar17 ib inp 3.10300e-17
Cpar18 ib out 2.75425e-15
Cpar19 ib vss 6.91151e-14
Cpar20 ib.t0 vss 1.19059e-14
Cpar21 ib.t1 vss 8.40982e-16
Cpar22 inn inp 1.03710e-16
Cpar23 inn vss 1.73887e-14
Cpar24 inn.t0 vss 4.10885e-15
Cpar25 inp vss 1.71410e-14
Cpar26 inp.t0 vss 4.10642e-15
Cpar27 out vdd 7.51871e-15
Cpar28 out vss 2.62444e-14
Cpar29 out.t0 vss 4.58750e-15
Cpar30 out.t1 vss 8.85825e-15
Cpar31 out.t11 vss 1.39706e-14
Cpar32 vdd vss 6.17485e-14
Cpar33 vdd.t0 vss 1.62663e-14
Cpar34 vdd.t1 vss 8.54381e-15
.ends opamp_dut

Vdd vdd 0 3.300000
Vss vss 0 0
Ibias vdd ib 9.290000e-08
Vinp inp 0 DC 1.645000 AC 1 PWL(0 1.645000 2.940539e-07 1.645000 3.234593e-07 1.655000)
Rfb out inn 1m
Cload out 0 2.000000e-12
Xdut vdd vss inp inn out ib opamp_dut
.end
