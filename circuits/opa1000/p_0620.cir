* opa1000[0620]: 200f/pmos_miller_3v3_10u_100u_weak (pmos_miller, VDD=3.3V, CL=0.2pF, Iref=6.25uA)
.include "pdk_opa.inc"
.temp 27
.option gmin=1e-12 rshunt=1e12 reltol=1e-3 abstol=1e-12 vntol=1e-5 method=gear
* Post-PEX R+C extracted netlist for pmos_miller_3v3_10u_100u_weak
.subckt opamp_dut vdd vss inp inn out ib
XMpar0 out.t4 a_1091_3866.t21 vss.t1 vss.t0 nfet_03v3 w=1.85u l=0.63u ad=5.1800e-13 pd=2.4100e-06 as=6.3640e-13 ps=2.9080e-06 nf=1 m=10 par=10
XMpar1 a_5649_5817.t4 ib.t0 vss.t15 vss.t14 nfet_03v3 w=2.05u l=0.8u ad=5.7400e-13 pd=2.6100e-06 as=5.7400e-13 ps=2.6100e-06 nf=1 m=2 par=2
XMpar2 a_5649_5817.t1 a_5649_5817.t0 vdd.t1 vdd.t0 pfet_03v3 w=8.55u l=0.8u ad=2.3940e-12 pd=9.1100e-06 as=2.3940e-12 ps=9.1100e-06 nf=1 m=2 par=2
XMpar3 out.t0 a_5649_5817.t0 vdd.t1 vdd.t0 pfet_03v3 w=8.55u l=0.8u ad=2.9412e-12 pd=1.0948e-05 as=2.3940e-12 ps=9.1100e-06 nf=1 m=10 par=10
XMpar4 a_1091_3866.t0 inp.t0 a_2850_1204.t0 vdd.t6 pfet_03v3 w=1.97u l=0.8u ad=6.2164e-13 pd=2.8200e-06 as=6.2164e-13 ps=2.8200e-06 nf=1 m=18 par=18
XMpar5 ib.t1 ib.t0 vss.t15 vss.t14 nfet_03v3 w=2.05u l=0.8u ad=1.2300e-12 pd=5.3000e-06 as=5.7400e-13 ps=2.6100e-06 nf=1 m=2 par=2
XMpar6 a_2850_1204.t18 a_5649_5817.t0 vdd.t1 vdd.t0 pfet_03v3 w=8.55u l=0.8u ad=2.3940e-12 pd=9.1100e-06 as=2.3940e-12 ps=9.1100e-06 nf=1 m=4 par=4
XMpar7 a_1091_3866.t19 a_5240_3866.t18 vss.t1 vss.t0 nfet_03v3 w=1.85u l=0.63u ad=1.1100e-12 pd=4.9000e-06 as=5.1800e-13 ps=2.4100e-06 nf=1 m=2 par=2
XMpar8 a_2850_1204.t0 inn.t0 a_5240_3866.t0 vdd.t6 pfet_03v3 w=1.97u l=0.8u ad=6.2164e-13 pd=2.8200e-06 as=6.2164e-13 ps=2.8200e-06 nf=1 m=18 par=18
XMpar9 a_5240_3866.t19 a_5240_3866.t18 vss.t1 vss.t0 nfet_03v3 w=1.85u l=0.63u ad=5.1800e-13 pd=2.4100e-06 as=5.1800e-13 ps=2.4100e-06 nf=1 m=2 par=2
X30 a_1091_3866.t18 a_1759_5905.t0 vss.t30 ppolyf_u_1k r_width=1u r_length=2.37u
X40 a_1759_5905.t1 out.t1 cap_mim_2f0fF c_width=15.37u c_length=15.37u
Rpar0 a_1091_3866.t0 a_1091_3866.t18 196.7704
Rpar1 a_1091_3866.t0 a_1091_3866.t19 310.4540
Rpar2 a_1091_3866.t0 a_1091_3866.t21 41.6134
Rpar3 a_1091_3866.t18 a_1091_3866.t19 75.7946
Rpar4 a_1091_3866.t18 a_1091_3866.t21 197.1737
Rpar5 a_1091_3866.t19 a_1091_3866.t21 311.0904
Rpar6 a_1759_5905.t0 a_1759_5905.t1 60.4083
Rpar7 a_2850_1204.t0 a_2850_1204.t18 49.5010
Rpar8 a_5240_3866.t0 a_5240_3866.t18 163.9262
Rpar9 a_5240_3866.t0 a_5240_3866.t19 72.7495
Rpar10 a_5240_3866.t18 a_5240_3866.t19 32.4230
Rpar11 a_5649_5817.t0 a_5649_5817.t1 25.7944
Rpar12 a_5649_5817.t0 a_5649_5817.t4 145.4959
Rpar13 a_5649_5817.t1 a_5649_5817.t4 82.9402
Rpar14 ib ib.t0 19.3770
Rpar15 ib ib.t1 4.3139
Rpar16 ib.t0 ib.t1 157.4554
Rpar17 inn inn.t0 2.4101
Rpar18 inp inp.t0 2.4101
Rpar19 out out.t0 36.9981
Rpar20 out out.t1 19.5293
Rpar21 out out.t4 55.4329
Rpar22 out.t0 out.t4 130.4871
Rpar23 vdd vdd.t0 274.6572
Rpar24 vdd vdd.t1 1435.0868
Rpar25 vdd vdd.t6 97.4596
Rpar26 vdd.t0 vdd.t1 4.9367
Rpar27 vdd.t0 vdd.t6 58.5238
Rpar28 vdd.t1 vdd.t6 305.7874
Rpar29 vss vss.t0 96.8136
Rpar30 vss vss.t1 134.3866
Rpar31 vss vss.t14 236.3145
Rpar32 vss vss.t15 264.9948
Rpar33 vss vss.t30 285.5294
Rpar34 vss.t0 vss.t1 4.4234
Rpar35 vss.t0 vss.t14 234.2593
Rpar36 vss.t0 vss.t15 262.9869
Rpar37 vss.t0 vss.t30 4.8475
Rpar38 vss.t1 vss.t14 172.6278
Rpar39 vss.t1 vss.t15 193.8054
Rpar40 vss.t1 vss.t30 20.1760
Rpar41 vss.t14 vss.t15 11.2480
Cpar0 a_1091_3866.t0 vss 8.89876e-15
Cpar1 a_1091_3866.t18 vss 1.98000e-15
Cpar2 a_1091_3866.t19 vss 2.95614e-15
Cpar3 a_1091_3866.t21 vss 5.16067e-15
Cpar4 a_1759_5905.t0 vss 1.02290e-16
Cpar5 a_1759_5905.t1 vss 3.47354e-15
Cpar6 a_2850_1204.t0 vss 2.43634e-14
Cpar7 a_2850_1204.t18 vss 1.12753e-14
Cpar8 a_5240_3866.t0 vss 1.27811e-14
Cpar9 a_5240_3866.t18 vss 2.87510e-15
Cpar10 a_5240_3866.t19 vss 2.58350e-15
Cpar11 a_5649_5817.t0 vss 1.97907e-14
Cpar12 a_5649_5817.t1 vss 4.78169e-15
Cpar13 a_5649_5817.t4 vss 1.99480e-15
Cpar14 ib vdd 3.12600e-17
Cpar15 ib vss 5.98361e-15
Cpar16 ib.t0 vss 4.96214e-16
Cpar17 ib.t1 vss 2.24971e-16
Cpar18 inn inp 1.04260e-16
Cpar19 inn vdd 9.66076e-15
Cpar20 inn vss 4.31145e-15
Cpar21 inn.t0 vss 1.10596e-14
Cpar22 inp vdd 9.63517e-15
Cpar23 inp vss 4.33021e-15
Cpar24 inp.t0 vss 1.10393e-14
Cpar25 out vdd 1.43564e-14
Cpar26 out vss 1.34509e-14
Cpar27 out.t0 vss 1.13377e-14
Cpar28 out.t1 vss 7.22468e-15
Cpar29 out.t4 vss 3.32053e-15
Cpar30 vdd vss 1.33045e-13
Cpar31 vdd.t0 vss 2.42271e-14
Cpar32 vdd.t1 vss 8.80728e-15
Cpar33 vdd.t6 vss 3.09483e-14
.ends opamp_dut

Vdd vdd 0 3.300000
Vss vss 0 0
Ibias vdd ib 6.250000e-06
Vinp inp 0 DC 1.480000 AC 1 PWL(0 1.480000 3.040268e-09 1.480000 3.344295e-09 1.490000)
Rfb out inn 1m
Cload out 0 2.000000e-13
Xdut vdd vss inp inn out ib opamp_dut
.end
