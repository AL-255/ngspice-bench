* opa1000[0000]: 200f/cherry_hooper_1v8_i50n_subth (cherry_hooper, VDD=1.8V, CL=0.2pF, Iref=0.0027uA)
.include "pdk_opa.inc"
.temp 27
.option gmin=1e-12 rshunt=1e12 reltol=1e-3 abstol=1e-12 vntol=1e-5 method=gear
* Post-PEX R+C extracted netlist for cherry_hooper_1v8_i50n_subth
.subckt opamp_dut vdd vss inp inn out ib
XMpar0 a_7099_10252.t2 a_7099_10252.t1 vdd.t6 vdd.t5 pfet_03v3 w=0.4u l=6.25u ad=2.4000e-13 pd=2.0000e-06 as=2.4000e-13 ps=2.0000e-06 nf=1 m=1
XMpar1 a_11336_13906.t0 a_4590_6573.t3 a_11336_4696.t0 vdd.t11 pfet_03v3 w=0.4u l=2.67u ad=2.4000e-13 pd=2.0000e-06 as=2.4000e-13 ps=2.0000e-06 nf=1 m=1
XMpar2 a_8130_6736.t0 a_13294_14114.t8 out.t0 vss.t1 nfet_03v3 w=1.39u l=8.25u ad=8.3400e-13 pd=3.9800e-06 as=8.3400e-13 ps=3.9800e-06 nf=1 m=1
XMpar3 a_12160_3063.t2 a_12160_3063.t1 vdd.t1 vdd.t0 pfet_03v3 w=0.4u l=1.3u ad=1.5467e-13 pd=1.3067e-06 as=1.1200e-13 ps=9.6000e-07 nf=1 m=3 par=3
XMpar4 a_8130_6736.t1 ib.t0 vss.t3 vss.t2 nfet_03v3 w=0.4u l=6.25u ad=1.1200e-13 pd=9.6000e-07 as=1.5467e-13 ps=1.3067e-06 nf=1 m=6 par=6
XMpar5 a_11336_4696.t2 a_11336_4696.t1 vdd.t1 vdd.t0 pfet_03v3 w=0.4u l=1.3u ad=1.5467e-13 pd=1.3067e-06 as=1.5467e-13 ps=1.3067e-06 nf=1 m=3 par=3
XMpar6 a_13294_10505.t3 a_7099_10252.t1 vdd.t6 vdd.t5 pfet_03v3 w=0.4u l=6.25u ad=2.4000e-13 pd=2.0000e-06 as=2.4000e-13 ps=2.0000e-06 nf=1 m=1
XMpar7 a_4206_12274.t0 ib.t0 vss.t3 vss.t2 nfet_03v3 w=0.4u l=6.25u ad=1.5467e-13 pd=1.3067e-06 as=1.1200e-13 ps=9.6000e-07 nf=1 m=6 par=6
XMpar8 a_9662_12274.t2 ib.t0 vss.t3 vss.t2 nfet_03v3 w=0.4u l=6.25u ad=1.1200e-13 pd=9.6000e-07 as=1.1200e-13 ps=9.6000e-07 nf=1 m=2 par=2
XMpar9 a_13294_14114.t3 a_13294_14114.t2 vdd.t1 vdd.t0 pfet_03v3 w=0.4u l=1.3u ad=1.5467e-13 pd=1.3067e-06 as=1.5467e-13 ps=1.3067e-06 nf=1 m=3 par=3
XMpar10 a_7099_10252.t0 ib.t0 vss.t3 vss.t2 nfet_03v3 w=0.4u l=6.25u ad=2.4000e-13 pd=2.0000e-06 as=1.1200e-13 ps=9.6000e-07 nf=1 m=1
XMpar11 a_12160_3063.t0 a_11336_4696.t8 a_8130_6736.t0 vss.t1 nfet_03v3 w=1.39u l=8.25u ad=8.3400e-13 pd=3.9800e-06 as=8.3400e-13 ps=3.9800e-06 nf=1 m=1
XMpar12 out.t1 a_12160_3063.t1 vdd.t1 vdd.t0 pfet_03v3 w=0.4u l=1.3u ad=1.5467e-13 pd=1.3067e-06 as=1.1200e-13 ps=9.6000e-07 nf=1 m=3 par=3
XMpar13 a_13294_10505.t0 a_4590_6573.t3 a_13294_14114.t0 vdd.t11 pfet_03v3 w=0.4u l=2.67u ad=2.4000e-13 pd=2.0000e-06 as=2.4000e-13 ps=2.0000e-06 nf=1 m=1
XMpar14 ib.t1 ib.t0 vss.t3 vss.t2 nfet_03v3 w=0.4u l=6.25u ad=2.4000e-13 pd=2.0000e-06 as=1.1200e-13 ps=9.6000e-07 nf=1 m=1
XMpar15 a_4395_4785.t0 a_4590_6573.t0 a_4590_6573.t1 vdd.t2 pfet_03v3 w=2.86u l=1u ad=1.7160e-12 pd=6.9200e-06 as=1.7160e-12 ps=6.9200e-06 nf=1 m=1
XMpar16 a_4395_4785.t2 a_4395_4785.t1 vdd.t1 vdd.t0 pfet_03v3 w=0.4u l=1.3u ad=2.4000e-13 pd=2.0000e-06 as=2.4000e-13 ps=2.0000e-06 nf=1 m=1
XMpar17 a_13294_10505.t1 inn.t0 a_9662_12274.t0 vss.t0 nfet_03v3 w=0.4u l=8.25u ad=2.4000e-13 pd=2.0000e-06 as=2.4000e-13 ps=2.0000e-06 nf=1 m=2 par=2
XMpar18 a_11336_13906.t1 inp.t0 a_9662_12274.t0 vss.t0 nfet_03v3 w=0.4u l=8.25u ad=2.4000e-13 pd=2.0000e-06 as=2.4000e-13 ps=2.0000e-06 nf=1 m=2 par=2
XMpar19 a_4590_6573.t2 ib.t0 vss.t3 vss.t2 nfet_03v3 w=0.4u l=6.25u ad=2.4000e-13 pd=2.0000e-06 as=2.4000e-13 ps=2.0000e-06 nf=1 m=1
XMpar20 a_13294_14114.t1 a_13294_10505.t4 a_4206_12274.t6 vss.t1 nfet_03v3 w=1.39u l=8.25u ad=8.3400e-13 pd=3.9800e-06 as=8.3400e-13 ps=3.9800e-06 nf=1 m=1
XMpar21 a_11336_4696.t7 a_11336_13906.t4 a_4206_12274.t6 vss.t1 nfet_03v3 w=1.39u l=8.25u ad=8.3400e-13 pd=3.9800e-06 as=8.3400e-13 ps=3.9800e-06 nf=1 m=1
XMpar22 a_11336_13906.t3 a_7099_10252.t1 vdd.t6 vdd.t5 pfet_03v3 w=0.4u l=6.25u ad=2.4000e-13 pd=2.0000e-06 as=2.4000e-13 ps=2.0000e-06 nf=1 m=1
X17 out.t4 vss.t39 cap_mim_2f0fF c_width=20u c_length=20u
X27 out.t4 vss.t39 cap_mim_2f0fF c_width=20u c_length=20u
X35 out.t4 vss.t39 cap_mim_2f0fF c_width=20u c_length=20u
Rpar0 a_11336_13906.t0 a_11336_13906.t1 603.9509
Rpar1 a_11336_13906.t0 a_11336_13906.t3 483.2831
Rpar2 a_11336_13906.t0 a_11336_13906.t4 110.8824
Rpar3 a_11336_13906.t1 a_11336_13906.t3 74.8135
Rpar4 a_11336_13906.t1 a_11336_13906.t4 189.5753
Rpar5 a_11336_13906.t3 a_11336_13906.t4 151.6986
Rpar6 a_11336_4696.t0 a_11336_4696.t1 623.1009
Rpar7 a_11336_4696.t0 a_11336_4696.t2 340.8802
Rpar8 a_11336_4696.t0 a_11336_4696.t7 175.8982
Rpar9 a_11336_4696.t0 a_11336_4696.t8 143.8423
Rpar10 a_11336_4696.t1 a_11336_4696.t2 24.0393
Rpar11 a_11336_4696.t1 a_11336_4696.t7 2555.1775
Rpar12 a_11336_4696.t1 a_11336_4696.t8 172.4005
Rpar13 a_11336_4696.t2 a_11336_4696.t7 1397.8625
Rpar14 a_11336_4696.t2 a_11336_4696.t8 94.3152
Rpar15 a_11336_4696.t7 a_11336_4696.t8 589.8606
Rpar16 a_12160_3063.t0 a_12160_3063.t1 177.2841
Rpar17 a_12160_3063.t0 a_12160_3063.t2 110.1090
Rpar18 a_12160_3063.t1 a_12160_3063.t2 20.0597
Rpar19 a_13294_10505.t0 a_13294_10505.t1 336.2041
Rpar20 a_13294_10505.t0 a_13294_10505.t3 289.1734
Rpar21 a_13294_10505.t0 a_13294_10505.t4 105.2554
Rpar22 a_13294_10505.t1 a_13294_10505.t3 147.6828
Rpar23 a_13294_10505.t1 a_13294_10505.t4 177.1672
Rpar24 a_13294_10505.t3 a_13294_10505.t4 152.3837
Rpar25 a_13294_14114.t0 a_13294_14114.t1 137.7574
Rpar26 a_13294_14114.t0 a_13294_14114.t2 521.7492
Rpar27 a_13294_14114.t0 a_13294_14114.t3 285.4337
Rpar28 a_13294_14114.t0 a_13294_14114.t8 175.1579
Rpar29 a_13294_14114.t1 a_13294_14114.t2 1124.1279
Rpar30 a_13294_14114.t1 a_13294_14114.t3 614.9773
Rpar31 a_13294_14114.t1 a_13294_14114.t8 377.3841
Rpar32 a_13294_14114.t2 a_13294_14114.t3 24.2572
Rpar33 a_13294_14114.t2 a_13294_14114.t8 179.5764
Rpar34 a_13294_14114.t3 a_13294_14114.t8 98.2409
Rpar35 a_4206_12274.t0 a_4206_12274.t6 61.1891
Rpar36 a_4395_4785.t0 a_4395_4785.t1 131.6145
Rpar37 a_4395_4785.t0 a_4395_4785.t2 73.1682
Rpar38 a_4395_4785.t1 a_4395_4785.t2 55.4276
Rpar39 a_4590_6573.t0 a_4590_6573.t1 52.5752
Rpar40 a_4590_6573.t0 a_4590_6573.t2 589.2648
Rpar41 a_4590_6573.t0 a_4590_6573.t3 910.1539
Rpar42 a_4590_6573.t1 a_4590_6573.t2 104.7925
Rpar43 a_4590_6573.t1 a_4590_6573.t3 161.8582
Rpar44 a_4590_6573.t2 a_4590_6573.t3 113.4066
Rpar45 a_7099_10252.t0 a_7099_10252.t1 114.5150
Rpar46 a_7099_10252.t0 a_7099_10252.t2 186.8505
Rpar47 a_7099_10252.t1 a_7099_10252.t2 31.1518
Rpar48 a_8130_6736.t0 a_8130_6736.t1 53.4853
Rpar49 a_9662_12274.t0 a_9662_12274.t2 67.8841
Rpar50 ib ib.t0 7.7852
Rpar51 ib ib.t1 15.6646
Rpar52 inn inn.t0 4.2867
Rpar53 inp inp.t0 4.2867
Rpar54 out out.t0 114.5786
Rpar55 out out.t1 131.9816
Rpar56 out out.t4 18.1624
Rpar57 out.t0 out.t1 112.4004
Rpar58 out.t0 out.t4 431.0257
Rpar59 out.t1 out.t4 496.4928
Rpar60 vdd vdd.t0 1409.2447
Rpar61 vdd vdd.t1 1319.7654
Rpar62 vdd vdd.t11 449.7917
Rpar63 vdd vdd.t5 178.8705
Rpar64 vdd vdd.t6 77.4923
Rpar65 vdd vdd.t2 514.8622
Rpar66 vdd.t0 vdd.t1 4.1902
Rpar67 vdd.t0 vdd.t11 634.2671
Rpar68 vdd.t0 vdd.t5 1007.3233
Rpar69 vdd.t0 vdd.t6 659.6175
Rpar70 vdd.t0 vdd.t2 273.4380
Rpar71 vdd.t1 vdd.t11 593.9946
Rpar72 vdd.t1 vdd.t5 943.3638
Rpar73 vdd.t1 vdd.t6 617.7354
Rpar74 vdd.t1 vdd.t2 256.0762
Rpar75 vdd.t11 vdd.t5 146.5745
Rpar76 vdd.t11 vdd.t6 110.1724
Rpar77 vdd.t11 vdd.t2 231.7271
Rpar78 vdd.t5 vdd.t6 18.3716
Rpar79 vdd.t5 vdd.t2 368.0217
Rpar80 vdd.t6 vdd.t2 240.9887
Rpar81 vss vss.t0 2647.6811
Rpar82 vss vss.t1 1086.0415
Rpar83 vss vss.t2 95.1195
Rpar84 vss vss.t3 443.3500
Rpar85 vss vss.t39 102.0561
Rpar86 vss.t0 vss.t1 333.9675
Rpar87 vss.t0 vss.t2 29.6599
Rpar88 vss.t0 vss.t3 181.0480
Rpar89 vss.t0 vss.t39 3600.0094
Rpar90 vss.t1 vss.t2 4.5506
Rpar91 vss.t1 vss.t3 37.2884
Rpar92 vss.t1 vss.t39 1476.6731
Rpar93 vss.t2 vss.t3 3.2708
Rpar94 vss.t2 vss.t39 129.3325
Rpar95 vss.t3 vss.t39 602.8158
Cpar0 a_11336_13906.t0 vss 4.20688e-15
Cpar1 a_11336_13906.t1 vss 4.35134e-15
Cpar2 a_11336_13906.t3 vss 2.80797e-15
Cpar3 a_11336_13906.t4 vss 8.11246e-15
Cpar4 a_11336_4696.t0 vss 5.45884e-15
Cpar5 a_11336_4696.t1 vss 2.71757e-15
Cpar6 a_11336_4696.t2 vss 2.70893e-15
Cpar7 a_11336_4696.t7 vss 4.65140e-15
Cpar8 a_11336_4696.t8 vss 6.97640e-15
Cpar9 a_12160_3063.t0 vss 2.89271e-15
Cpar10 a_12160_3063.t1 vss 6.28761e-15
Cpar11 a_12160_3063.t2 vss 2.99621e-15
Cpar12 a_13294_10505.t0 vss 2.05491e-15
Cpar13 a_13294_10505.t1 vss 3.88176e-15
Cpar14 a_13294_10505.t3 vss 2.24617e-15
Cpar15 a_13294_10505.t4 vss 5.72743e-15
Cpar16 a_13294_14114.t0 vss 2.66844e-15
Cpar17 a_13294_14114.t1 vss 3.11505e-15
Cpar18 a_13294_14114.t2 vss 2.37919e-15
Cpar19 a_13294_14114.t3 vss 2.15599e-15
Cpar20 a_13294_14114.t8 vss 5.33140e-15
Cpar21 a_4206_12274.t0 vss 6.78920e-15
Cpar22 a_4206_12274.t6 vss 3.38689e-15
Cpar23 a_4395_4785.t0 vss 2.71455e-15
Cpar24 a_4395_4785.t1 vss 1.23703e-15
Cpar25 a_4395_4785.t2 vss 1.35407e-15
Cpar26 a_4590_6573.t0 vss 1.43035e-15
Cpar27 a_4590_6573.t1 vss 4.19000e-15
Cpar28 a_4590_6573.t2 vss 3.49297e-15
Cpar29 a_4590_6573.t3 vss 5.48138e-15
Cpar30 a_7099_10252.t0 vss 4.97178e-15
Cpar31 a_7099_10252.t1 vss 1.65190e-14
Cpar32 a_7099_10252.t2 vss 3.64004e-15
Cpar33 a_8130_6736.t0 vss 2.38257e-15
Cpar34 a_8130_6736.t1 vss 3.64165e-15
Cpar35 a_9662_12274.t0 vss 9.65631e-15
Cpar36 a_9662_12274.t2 vss 6.56369e-15
Cpar37 ib vdd 2.48930e-16
Cpar38 ib vss 6.21123e-14
Cpar39 ib.t0 vss 7.41824e-15
Cpar40 ib.t1 vss 1.62200e-17
Cpar41 inn inp 1.05140e-16
Cpar42 inn vdd 3.12400e-17
Cpar43 inn vss 8.52521e-15
Cpar44 inn.t0 vss 1.28140e-15
Cpar45 inp vdd 3.55600e-17
Cpar46 inp vss 8.48547e-15
Cpar47 inp.t0 vss 1.28550e-15
Cpar48 out vdd 2.30708e-15
Cpar49 out vss 3.17119e-14
Cpar50 out.t0 vss 5.42543e-17
Cpar51 out.t1 vss 6.17077e-17
Cpar52 out.t4 vss 8.30073e-15
Cpar53 vdd vss 1.19188e-13
Cpar54 vdd.t0 vss 1.31099e-14
Cpar55 vdd.t1 vss 1.03781e-14
Cpar56 vdd.t11 vss 6.87708e-15
Cpar57 vdd.t2 vss 3.12609e-15
Cpar58 vdd.t5 vss 6.42313e-15
Cpar59 vdd.t6 vss 8.33335e-15
.ends opamp_dut

Vdd vdd 0 1.800000
Vss vss 0 0
Ibias vdd ib 2.700000e-09
Vinp inp 0 DC 1.186500 AC 1 PWL(0 1.186500 2.685245e-06 1.186500 2.953770e-06 1.196500)
Rfb out inn 1m
Cload out 0 2.000000e-13
Xdut vdd vss inp inn out ib opamp_dut
.end
