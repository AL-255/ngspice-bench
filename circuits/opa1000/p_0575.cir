* opa1000[0575]: 2p/pmos_5t_3v3_i10u_subth (pmos_5t, VDD=3.3V, CL=2.0pF, Iref=2.0uA)
.include "pdk_opa.inc"
.temp 27
.option gmin=1e-12 rshunt=1e12 reltol=1e-3 abstol=1e-12 vntol=1e-5 method=gear
* Post-PEX R+C extracted netlist for pmos_5t_3v3_i10u_subth
.subckt opamp_dut vdd vss inp inn out ib
XMpar0 a_1316_9328.t65 a_1316_9328.t64 vss.t1 vss.t0 nfet_03v3 w=1.86u l=2.7u ad=6.3984e-13 pd=2.9200e-06 as=5.2080e-13 ps=2.4200e-06 nf=1 m=10 par=10
XMpar1 a_1168_11072.t1 a_1168_11072.t0 vdd.t1 vdd.t0 pfet_03v3 w=10u l=1.2u ad=2.8000e-12 pd=1.0560e-05 as=2.8000e-12 ps=1.0560e-05 nf=1 m=2 par=2
XMpar2 out.t0 a_1316_9328.t64 vss.t1 vss.t0 nfet_03v3 w=1.86u l=2.7u ad=5.2080e-13 pd=2.4200e-06 as=5.2080e-13 ps=2.4200e-06 nf=1 m=10 par=10
XMpar3 a_1316_9328.t0 inp.t0 a_1408_11280.t5 vdd.t14 pfet_03v3 w=5.73u l=1.13u ad=1.6044e-12 pd=6.2900e-06 as=1.8336e-12 ps=7.0863e-06 nf=1 m=64 par=64
XMpar4 a_1408_11280.t0 a_1168_11072.t0 vdd.t1 vdd.t0 pfet_03v3 w=10u l=1.2u ad=2.8000e-12 pd=1.0560e-05 as=3.6000e-12 ps=1.3220e-05 nf=1 m=8 par=8
XMpar5 a_1408_11280.t5 inn.t0 out.t5 vdd.t14 pfet_03v3 w=5.73u l=1.13u ad=1.8336e-12 pd=7.0863e-06 as=1.6044e-12 ps=6.2900e-06 nf=1 m=64 par=64
XMpar6 a_1168_11072.t4 ib.t0 vss.t30 vss.t29 nfet_03v3 w=2.96u l=1.2u ad=8.2880e-13 pd=3.5200e-06 as=8.2880e-13 ps=3.5200e-06 nf=1 m=2 par=2
XMpar7 ib.t1 ib.t0 vss.t30 vss.t29 nfet_03v3 w=2.96u l=1.2u ad=1.7760e-12 pd=7.1200e-06 as=8.2880e-13 ps=3.5200e-06 nf=1 m=2 par=2
X51 out.t74 vss.t16 cap_mim_2f0fF c_width=11.18u c_length=11.18u
Rpar0 a_1168_11072.t0 a_1168_11072.t1 26.2983
Rpar1 a_1168_11072.t0 a_1168_11072.t4 169.8081
Rpar2 a_1168_11072.t1 a_1168_11072.t4 58.1996
Rpar3 a_1316_9328.t0 a_1316_9328.t64 144.0993
Rpar4 a_1316_9328.t0 a_1316_9328.t65 48.3847
Rpar5 a_1316_9328.t64 a_1316_9328.t65 15.3218
Rpar6 a_1408_11280.t0 a_1408_11280.t5 48.9750
Rpar7 ib ib.t0 15.4298
Rpar8 ib ib.t1 3.9177
Rpar9 inn inn.t0 1.9085
Rpar10 inp inp.t0 1.9085
Rpar11 out out.t0 4.8032
Rpar12 out out.t5 49.1086
Rpar13 out out.t74 72.1100
Rpar14 out.t5 out.t74 254.4954
Rpar15 vdd vdd.t0 55.7876
Rpar16 vdd vdd.t1 203.0173
Rpar17 vdd vdd.t14 73.1709
Rpar18 vdd.t0 vdd.t1 5.7104
Rpar19 vdd.t0 vdd.t14 666.7253
Rpar20 vdd.t1 vdd.t14 2426.2895
Rpar21 vss vss.t0 114.0121
Rpar22 vss vss.t1 721.2122
Rpar23 vss vss.t16 617.5119
Rpar24 vss vss.t29 458.0413
Rpar25 vss vss.t30 1231.0816
Rpar26 vss.t0 vss.t1 6.1940
Rpar27 vss.t0 vss.t16 61.8743
Rpar28 vss.t0 vss.t29 2.3363
Rpar29 vss.t0 vss.t30 15.7175
Rpar30 vss.t1 vss.t16 394.1380
Rpar31 vss.t1 vss.t29 30.1145
Rpar32 vss.t1 vss.t30 108.0811
Rpar33 vss.t16 vss.t29 194.3794
Rpar34 vss.t16 vss.t30 414.4610
Rpar35 vss.t29 vss.t30 15.7679
Cpar0 a_1168_11072.t0 vss 1.69830e-14
Cpar1 a_1168_11072.t1 vss 4.19179e-15
Cpar2 a_1168_11072.t4 vss 1.80707e-15
Cpar3 a_1316_9328.t0 vss 4.96682e-14
Cpar4 a_1316_9328.t64 vss 2.72993e-14
Cpar5 a_1316_9328.t65 vss 7.67205e-15
Cpar6 a_1408_11280.t0 vss 1.49464e-14
Cpar7 a_1408_11280.t5 vss 1.35087e-13
Cpar8 ib vdd 9.07700e-17
Cpar9 ib vss 7.26726e-15
Cpar10 ib.t0 vss 7.02886e-16
Cpar11 ib.t1 vss 2.58560e-16
Cpar12 inn inp 2.05630e-16
Cpar13 inn out 2.30248e-14
Cpar14 inn vdd 3.64941e-14
Cpar15 inn vss 8.53681e-15
Cpar16 inn.t0 vss 7.09255e-14
Cpar17 inp vdd 3.63489e-14
Cpar18 inp vss 8.79688e-15
Cpar19 inp.t0 vss 7.08034e-14
Cpar20 out vdd 1.44850e-14
Cpar21 out vss 2.08252e-14
Cpar22 out.t0 vss 4.59873e-15
Cpar23 out.t5 vss 4.63900e-14
Cpar24 out.t74 vss 3.29604e-14
Cpar25 vdd vss 3.83478e-13
Cpar26 vdd.t0 vss 1.43750e-14
Cpar27 vdd.t1 vss 6.49061e-15
Cpar28 vdd.t14 vss 1.06693e-13
.ends opamp_dut

Vdd vdd 0 3.300000
Vss vss 0 0
Ibias vdd ib 2.000000e-06
Vinp inp 0 DC 1.480000 AC 1 PWL(0 1.480000 1.684383e-08 1.480000 1.852821e-08 1.490000)
Rfb out inn 1m
Cload out 0 2.000000e-12
Xdut vdd vss inp inn out ib opamp_dut
.end
