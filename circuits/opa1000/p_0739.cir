* opa1000[0739]: 2p/rail_to_rail_3v3_1u_10u_subth (rail_to_rail, VDD=3.3V, CL=2.0pF, Iref=0.625uA)
.include "pdk_opa.inc"
.temp 27
.option gmin=1e-12 rshunt=1e12 reltol=1e-3 abstol=1e-12 vntol=1e-5 method=gear
* Post-PEX R+C extracted netlist for rail_to_rail_3v3_1u_10u_subth
.subckt opamp_dut vdd vss inp inn out ib
XMpar0 a_4350_5917.t0 inp.t8 a_6122_13121.t4 vdd.t4 pfet_03v3 w=2.32u l=1.3u ad=7.1920e-13 pd=3.1575e-06 as=6.9600e-13 ps=3.0650e-06 nf=1 m=64 par=64
XMpar1 a_2354_1249.t0 inp.t0 a_949_5709.t2 vss.t2 nfet_03v3 w=1.67u l=1.3u ad=7.3480e-13 pd=3.3850e-06 as=4.6760e-13 ps=2.2300e-06 nf=1 m=8 par=8
XMpar2 a_4350_5917.t0 inn.t8 a_9772_8316.t0 vdd.t4 pfet_03v3 w=2.32u l=1.3u ad=7.1920e-13 pd=3.1575e-06 as=6.9600e-13 ps=3.0650e-06 nf=1 m=64 par=64
XMpar3 out.t0 a_949_5709.t13 vdd.t1 vdd.t0 pfet_03v3 w=5.13u l=0.65u ad=1.4364e-12 pd=5.6900e-06 as=1.8468e-12 ps=7.1325e-06 nf=1 m=8 par=8
XMpar4 a_949_5709.t0 a_9772_8316.t64 vss.t1 vss.t0 nfet_03v3 w=1.11u l=2.5u ad=6.6600e-13 pd=3.4200e-06 as=3.1080e-13 ps=1.6700e-06 nf=1 m=2 par=2
XMpar5 a_2354_1249.t16 ib.t0 vss.t21 vss.t20 nfet_03v3 w=1.05u l=1.3u ad=6.3000e-13 pd=3.3000e-06 as=2.9400e-13 ps=1.6100e-06 nf=1 m=2 par=2
XMpar6 a_6122_13121.t1 a_6122_13121.t0 vss.t1 vss.t0 nfet_03v3 w=1.11u l=2.5u ad=6.6600e-13 pd=3.4200e-06 as=3.1080e-13 ps=1.6700e-06 nf=1 m=2 par=2
XMpar7 out.t7 ib.t0 vss.t21 vss.t20 nfet_03v3 w=1.05u l=1.3u ad=2.9400e-13 pd=1.6100e-06 as=3.7800e-13 ps=2.0325e-06 nf=1 m=8 par=8
XMpar8 a_10512_3103.t0 inn.t0 a_2354_1249.t0 vss.t2 nfet_03v3 w=1.67u l=1.3u ad=4.6760e-13 pd=2.2300e-06 as=7.3480e-13 ps=3.3850e-06 nf=1 m=8 par=8
XMpar9 a_4118_1249.t3 a_4118_1249.t2 vdd.t36 vdd.t35 pfet_03v3 w=5.13u l=1.3u ad=1.4364e-12 pd=5.6900e-06 as=1.4364e-12 ps=5.6900e-06 nf=1 m=2 par=2
XMpar10 a_949_5709.t10 a_10512_3103.t10 vdd.t1 vdd.t0 pfet_03v3 w=5.13u l=0.65u ad=3.0780e-12 pd=1.1460e-05 as=1.4364e-12 ps=5.6900e-06 nf=1 m=2 par=2
XMpar11 ib.t1 ib.t0 vss.t21 vss.t20 nfet_03v3 w=1.05u l=1.3u ad=6.3000e-13 pd=3.3000e-06 as=2.9400e-13 ps=1.6100e-06 nf=1 m=2 par=2
XMpar12 a_9772_8316.t65 a_9772_8316.t64 vss.t1 vss.t0 nfet_03v3 w=1.11u l=2.5u ad=3.1080e-13 pd=1.6700e-06 as=3.1080e-13 ps=1.6700e-06 nf=1 m=2 par=2
XMpar13 a_4118_1249.t0 ib.t0 vss.t21 vss.t20 nfet_03v3 w=1.05u l=1.3u ad=2.9400e-13 pd=1.6100e-06 as=2.9400e-13 ps=1.6100e-06 nf=1 m=2 par=2
XMpar14 a_10512_3103.t8 a_6122_13121.t0 vss.t1 vss.t0 nfet_03v3 w=1.11u l=2.5u ad=3.1080e-13 pd=1.6700e-06 as=3.1080e-13 ps=1.6700e-06 nf=1 m=2 par=2
XMpar15 a_10512_3103.t11 a_10512_3103.t10 vdd.t1 vdd.t0 pfet_03v3 w=5.13u l=0.65u ad=1.4364e-12 pd=5.6900e-06 as=1.4364e-12 ps=5.6900e-06 nf=1 m=2 par=2
XMpar16 a_4350_5917.t128 a_4118_1249.t2 vdd.t36 vdd.t35 pfet_03v3 w=5.13u l=1.3u ad=3.0780e-12 pd=1.1460e-05 as=1.4364e-12 ps=5.6900e-06 nf=1 m=2 par=2
X1 a_8464_1811.t1 out.t2 cap_mim_2f0fF c_width=18.03u c_length=18.03u
X65 a_8464_1811.t0 a_11836_1291.t0 vss.t14 ppolyf_u_1k r_width=1u r_length=16.2u
X136 a_949_5709.t12 a_11836_1291.t0 vss.t14 ppolyf_u_1k r_width=1u r_length=16.2u
X159 a_8464_1811.t1 out.t2 cap_mim_2f0fF c_width=18.03u c_length=18.03u
Rpar0 a_10512_3103.t0 a_10512_3103.t10 863.6649
Rpar1 a_10512_3103.t0 a_10512_3103.t11 224.9927
Rpar2 a_10512_3103.t0 a_10512_3103.t8 114.3057
Rpar3 a_10512_3103.t10 a_10512_3103.t11 33.0285
Rpar4 a_10512_3103.t10 a_10512_3103.t8 356.6850
Rpar5 a_10512_3103.t11 a_10512_3103.t8 92.9198
Rpar6 a_2354_1249.t0 a_2354_1249.t16 56.8958
Rpar7 a_4118_1249.t0 a_4118_1249.t2 246.3704
Rpar8 a_4118_1249.t0 a_4118_1249.t3 85.2406
Rpar9 a_4118_1249.t2 a_4118_1249.t3 25.9398
Rpar10 a_4350_5917.t0 a_4350_5917.t128 42.2657
Rpar11 a_6122_13121.t0 a_6122_13121.t1 19.8383
Rpar12 a_6122_13121.t0 a_6122_13121.t4 228.7619
Rpar13 a_6122_13121.t1 a_6122_13121.t4 132.8418
Rpar14 a_8464_1811.t0 a_8464_1811.t1 81.1224
Rpar15 a_949_5709.t0 a_949_5709.t10 96.1599
Rpar16 a_949_5709.t0 a_949_5709.t12 717.6014
Rpar17 a_949_5709.t0 a_949_5709.t13 225.6446
Rpar18 a_949_5709.t0 a_949_5709.t2 97.8746
Rpar19 a_949_5709.t10 a_949_5709.t12 164.6909
Rpar20 a_949_5709.t10 a_949_5709.t13 106.8016
Rpar21 a_949_5709.t10 a_949_5709.t2 175.2165
Rpar22 a_949_5709.t12 a_949_5709.t13 797.0160
Rpar23 a_949_5709.t12 a_949_5709.t2 1307.5679
Rpar24 a_949_5709.t13 a_949_5709.t2 411.1552
Rpar25 a_9772_8316.t0 a_9772_8316.t64 141.0104
Rpar26 a_9772_8316.t0 a_9772_8316.t65 127.5529
Rpar27 a_9772_8316.t64 a_9772_8316.t65 28.3155
Rpar28 ib ib.t0 11.8620
Rpar29 ib ib.t1 8.5718
Rpar30 inn inn.t0 3.2909
Rpar31 inn inn.t8 35.9718
Rpar32 inp inp.t0 3.2909
Rpar33 inp inp.t8 35.9232
Rpar34 out out.t0 1.8646
Rpar35 out out.t7 100.9017
Rpar36 out out.t2 454.3878
Rpar37 out.t0 out.t7 219.0387
Rpar38 out.t0 out.t2 986.3908
Rpar39 out.t7 out.t2 214.9321
Rpar40 vdd vdd.t0 603.5117
Rpar41 vdd vdd.t1 903.4600
Rpar42 vdd vdd.t4 28.4123
Rpar43 vdd vdd.t35 130.7280
Rpar44 vdd vdd.t36 235.6659
Rpar45 vdd.t0 vdd.t1 3.7980
Rpar46 vdd.t0 vdd.t4 1725.9071
Rpar47 vdd.t0 vdd.t35 127.1426
Rpar48 vdd.t0 vdd.t36 229.2024
Rpar49 vdd.t1 vdd.t4 2583.6915
Rpar50 vdd.t1 vdd.t35 190.3331
Rpar51 vdd.t1 vdd.t36 343.1171
Rpar52 vdd.t4 vdd.t35 373.8527
Rpar53 vdd.t4 vdd.t36 673.9513
Rpar54 vdd.t35 vdd.t36 9.8829
Rpar55 vss vss.t0 314.1344
Rpar56 vss vss.t1 280.5906
Rpar57 vss vss.t14 712.1942
Rpar58 vss vss.t2 60.7882
Rpar59 vss vss.t20 75.9916
Rpar60 vss vss.t21 239.7004
Rpar61 vss.t0 vss.t1 26.1793
Rpar62 vss.t0 vss.t14 27.0606
Rpar63 vss.t0 vss.t2 5.7477
Rpar64 vss.t0 vss.t20 669.3278
Rpar65 vss.t1 vss.t14 131.9089
Rpar66 vss.t1 vss.t2 6.3676
Rpar67 vss.t1 vss.t20 616.4859
Rpar68 vss.t14 vss.t2 26.3535
Rpar69 vss.t14 vss.t20 1519.0851
Rpar70 vss.t2 vss.t20 128.9621
Rpar71 vss.t2 vss.t21 407.4435
Rpar72 vss.t20 vss.t21 5.0499
Cpar0 a_10512_3103.t0 vss 5.35950e-15
Cpar1 a_10512_3103.t10 vss 3.72734e-15
Cpar2 a_10512_3103.t11 vss 4.39833e-15
Cpar3 a_10512_3103.t8 vss 3.08794e-15
Cpar4 a_11836_1291.t0 vss 4.14200e-17
Cpar5 a_2354_1249.t0 vss 1.31443e-14
Cpar6 a_2354_1249.t16 vss 6.98070e-15
Cpar7 a_4118_1249.t0 vss 3.44469e-15
Cpar8 a_4118_1249.t2 vss 6.10863e-15
Cpar9 a_4118_1249.t3 vss 4.14031e-15
Cpar10 a_4350_5917.t0 vss 8.93764e-14
Cpar11 a_4350_5917.t128 vss 8.04564e-15
Cpar12 a_6122_13121.t0 vss 8.18879e-15
Cpar13 a_6122_13121.t1 vss 4.21865e-15
Cpar14 a_6122_13121.t4 vss 4.95993e-14
Cpar15 a_8464_1811.t0 vss 1.19856e-16
Cpar16 a_8464_1811.t1 vss 7.19566e-15
Cpar17 a_949_5709.t0 vss 4.02118e-15
Cpar18 a_949_5709.t10 vss 7.89614e-15
Cpar19 a_949_5709.t12 vss 4.98526e-15
Cpar20 a_949_5709.t13 vss 8.60885e-15
Cpar21 a_949_5709.t2 vss 4.94103e-15
Cpar22 a_9772_8316.t0 vss 4.75561e-14
Cpar23 a_9772_8316.t64 vss 8.58362e-15
Cpar24 a_9772_8316.t65 vss 2.99931e-15
Cpar25 ib out 1.02438e-15
Cpar26 ib vss 1.65765e-14
Cpar27 ib.t0 vss 5.09665e-15
Cpar28 ib.t1 vss 4.95277e-16
Cpar29 inn inp 3.32260e-16
Cpar30 inn vdd 3.85280e-14
Cpar31 inn vss 1.30106e-14
Cpar32 inn.t0 vss 5.08382e-15
Cpar33 inn.t8 vss 6.40992e-14
Cpar34 inp vdd 4.05106e-14
Cpar35 inp vss 1.29209e-14
Cpar36 inp.t0 vss 5.14303e-15
Cpar37 inp.t8 vss 6.48433e-14
Cpar38 out vdd 9.91151e-15
Cpar39 out vss 2.23655e-14
Cpar40 out.t0 vss 3.14656e-15
Cpar41 out.t2 vss 1.51716e-14
Cpar42 out.t7 vss 4.11808e-15
Cpar43 vdd vss 3.10264e-13
Cpar44 vdd.t0 vss 1.27198e-14
Cpar45 vdd.t1 vss 9.19545e-15
Cpar46 vdd.t35 vss 7.17983e-15
Cpar47 vdd.t36 vss 4.56076e-15
Cpar48 vdd.t4 vss 1.06461e-13
.ends opamp_dut

Vdd vdd 0 3.300000
Vss vss 0 0
Ibias vdd ib 6.250000e-07
Vinp inp 0 DC 1.645000 AC 1 PWL(0 1.645000 5.687500e-08 1.645000 6.256250e-08 1.655000)
Rfb out inn 1m
Cload out 0 2.000000e-12
Xdut vdd vss inp inn out ib opamp_dut
.end
