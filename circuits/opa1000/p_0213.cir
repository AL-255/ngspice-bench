* opa1000[0213]: 2p/folded_cascode_nmos_1v8_0p1u_1u_subth (folded_cascode_nmos, VDD=1.8V, CL=2.0pF, Iref=0.1111uA)
.include "pdk_opa.inc"
.temp 27
.option gmin=1e-12 rshunt=1e12 reltol=1e-3 abstol=1e-12 vntol=1e-5 method=gear
* Post-PEX R+C extracted netlist for folded_cascode_nmos_1v8_0p1u_1u_subth
.subckt opamp_dut vdd vss inp inn out ib
XMpar0 out.t0 a_7690_17346.t12 vss.t1 vss.t0 nfet_03v3 w=1.13u l=6.25u ad=6.7800e-13 pd=3.4600e-06 as=3.1640e-13 ps=1.6900e-06 nf=1 m=2 par=2
XMpar1 a_1522_1205.t4 inp.t0 a_2642_1205.t16 vss.t0 nfet_03v3 w=2.18u l=5u ad=7.1940e-13 pd=3.1806e-06 as=6.9760e-13 ps=3.0925e-06 nf=1 m=64 par=64
XMpar2 a_10734_17346.t14 inn.t0 a_1522_1205.t4 vss.t0 nfet_03v3 w=2.18u l=5u ad=6.9760e-13 pd=3.0925e-06 as=7.1940e-13 ps=3.1806e-06 nf=1 m=64 par=64
XMpar3 a_2642_1205.t0 a_1200_17093.t2 vdd.t1 vdd.t0 pfet_03v3 w=5.81u l=8.13u ad=1.6268e-12 pd=6.3700e-06 as=2.5564e-12 ps=9.5950e-06 nf=1 m=4 par=4
XMpar4 a_10734_17346.t1 ib.t10 out.t1 vdd.t6 pfet_03v3 w=2.05u l=4u ad=9.0200e-13 pd=3.9550e-06 as=5.7400e-13 ps=2.6100e-06 nf=1 m=12 par=12
XMpar5 a_10734_17346.t0 a_1200_17093.t2 vdd.t1 vdd.t0 pfet_03v3 w=5.81u l=8.13u ad=1.6268e-12 pd=6.3700e-06 as=2.5564e-12 ps=9.5950e-06 nf=1 m=4 par=4
XMpar6 a_1200_17093.t3 a_1200_17093.t2 vdd.t1 vdd.t0 pfet_03v3 w=5.81u l=8.13u ad=1.6268e-12 pd=6.3700e-06 as=3.4860e-12 ps=1.2820e-05 nf=1 m=2 par=2
XMpar7 a_1522_1205.t0 ib.t0 vss.t1 vss.t0 nfet_03v3 w=1.13u l=6.25u ad=3.1640e-13 pd=1.6900e-06 as=3.1640e-13 ps=1.6900e-06 nf=1 m=4 par=4
XMpar8 a_2642_1205.t1 ib.t10 a_7690_17346.t0 vdd.t6 pfet_03v3 w=2.05u l=4u ad=9.0200e-13 pd=3.9550e-06 as=5.7400e-13 ps=2.6100e-06 nf=1 m=12 par=12
XMpar9 ib.t1 ib.t0 vss.t1 vss.t0 nfet_03v3 w=1.13u l=6.25u ad=6.7800e-13 pd=3.4600e-06 as=3.1640e-13 ps=1.6900e-06 nf=1 m=2 par=2
XMpar10 a_1200_17093.t0 ib.t0 vss.t1 vss.t0 nfet_03v3 w=1.13u l=6.25u ad=3.1640e-13 pd=1.6900e-06 as=3.1640e-13 ps=1.6900e-06 nf=1 m=2 par=2
XMpar11 a_7690_17346.t13 a_7690_17346.t12 vss.t1 vss.t0 nfet_03v3 w=1.13u l=6.25u ad=6.7800e-13 pd=3.4600e-06 as=3.1640e-13 ps=1.6900e-06 nf=1 m=2 par=2
Rpar0 a_10734_17346.t0 a_10734_17346.t1 73.1746
Rpar1 a_10734_17346.t0 a_10734_17346.t14 274.5068
Rpar2 a_10734_17346.t1 a_10734_17346.t14 70.4906
Rpar3 a_1200_17093.t0 a_1200_17093.t2 112.9024
Rpar4 a_1200_17093.t0 a_1200_17093.t3 271.7580
Rpar5 a_1200_17093.t2 a_1200_17093.t3 19.1330
Rpar6 a_1522_1205.t0 a_1522_1205.t4 59.0064
Rpar7 a_2642_1205.t0 a_2642_1205.t1 73.1746
Rpar8 a_2642_1205.t0 a_2642_1205.t16 274.5068
Rpar9 a_2642_1205.t1 a_2642_1205.t16 70.4906
Rpar10 a_7690_17346.t0 a_7690_17346.t12 182.4853
Rpar11 a_7690_17346.t0 a_7690_17346.t13 180.1092
Rpar12 a_7690_17346.t12 a_7690_17346.t13 13.6665
Rpar13 ib ib.t0 166.5484
Rpar14 ib ib.t1 51.6697
Rpar15 ib ib.t10 1.5422
Rpar16 ib.t0 ib.t1 21.4118
Rpar17 inn inn.t0 1.7184
Rpar18 inp inp.t0 1.7184
Rpar19 out out.t0 10.4072
Rpar20 out out.t1 76.9237
Rpar21 out.t0 out.t1 294.1190
Rpar22 vdd vdd.t0 35.0376
Rpar23 vdd vdd.t1 74.5932
Rpar24 vdd vdd.t6 82.2421
Rpar25 vdd.t0 vdd.t1 4.5602
Rpar26 vdd.t0 vdd.t6 97.1072
Rpar27 vdd.t1 vdd.t6 123.4392
Rpar28 vss vss.t0 18.8502
Rpar29 vss vss.t1 842.4158
Rpar30 vss.t0 vss.t1 4.9137
Cpar0 a_10734_17346.t0 vss 1.04392e-14
Cpar1 a_10734_17346.t1 vss 1.87244e-14
Cpar2 a_10734_17346.t14 vss 7.95565e-14
Cpar3 a_1200_17093.t0 vss 4.10840e-15
Cpar4 a_1200_17093.t2 vss 5.90026e-14
Cpar5 a_1200_17093.t3 vss 3.25503e-15
Cpar6 a_1522_1205.t0 vss 8.47953e-15
Cpar7 a_1522_1205.t4 vss 1.45472e-13
Cpar8 a_2642_1205.t0 vss 1.13909e-14
Cpar9 a_2642_1205.t1 vss 2.04314e-14
Cpar10 a_2642_1205.t16 vss 8.68091e-14
Cpar11 a_7690_17346.t0 vss 1.09856e-14
Cpar12 a_7690_17346.t12 vss 1.21466e-14
Cpar13 a_7690_17346.t13 vss 4.22133e-15
Cpar14 ib out 5.47165e-15
Cpar15 ib vdd 3.87995e-14
Cpar16 ib vss 4.06092e-14
Cpar17 ib.t0 vss 1.71741e-14
Cpar18 ib.t1 vss 2.97606e-15
Cpar19 ib.t10 vss 4.00815e-14
Cpar20 inn inp 9.92900e-17
Cpar21 inn vss 1.09437e-13
Cpar22 inn.t0 vss 5.97176e-14
Cpar23 inp vss 1.08940e-13
Cpar24 inp.t0 vss 5.97205e-14
Cpar25 out vdd 4.30285e-15
Cpar26 out vss 1.47113e-14
Cpar27 out.t0 vss 2.38311e-15
Cpar28 out.t1 vss 1.53418e-14
Cpar29 vdd vss 2.69813e-13
Cpar30 vdd.t0 vss 4.14481e-14
Cpar31 vdd.t1 vss 2.27571e-14
Cpar32 vdd.t6 vss 4.64281e-14
.ends opamp_dut

Vdd vdd 0 1.800000
Vss vss 0 0
Ibias vdd ib 1.111000e-07
Vinp inp 0 DC 0.985000 AC 1 PWL(0 0.985000 4.309341e-07 0.985000 4.740275e-07 0.995000)
Rfb out inn 1m
Cload out 0 2.000000e-12
Xdut vdd vss inp inn out ib opamp_dut
.end
