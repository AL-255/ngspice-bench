* opa1000[0481]: 2p/nmos_miller_3v3_i50n_subth (nmos_miller, VDD=3.3V, CL=2.0pF, Iref=0.0093uA)
.include "pdk_opa.inc"
.temp 27
.option gmin=1e-12 rshunt=1e12 reltol=1e-3 abstol=1e-12 vntol=1e-5 method=gear
* Post-PEX R+C extracted netlist for nmos_miller_3v3_i50n_subth
.subckt opamp_dut vdd vss inp inn out ib
XMpar0 out.t1 a_1158_2978.t5 vdd.t1 vdd.t0 pfet_03v3 w=0.54u l=4u ad=1.5120e-13 pd=1.1000e-06 as=1.8576e-13 ps=1.3360e-06 nf=1 m=10 par=10
XMpar1 a_1158_2978.t0 inp.t0 a_7566_13353.t0 vss.t0 nfet_03v3 w=1.44u l=3.3u ad=8.6400e-13 pd=4.0800e-06 as=8.6400e-13 ps=4.0800e-06 nf=1 m=2 par=2
XMpar2 a_7566_13353.t2 ib.t0 vss.t4 vss.t3 nfet_03v3 w=0.4u l=4u ad=2.4000e-13 pd=2.0000e-06 as=1.1200e-13 ps=9.6000e-07 nf=1 m=4 par=4
XMpar3 out.t0 ib.t0 vss.t4 vss.t3 nfet_03v3 w=0.4u l=4u ad=1.8880e-13 pd=1.5840e-06 as=1.6320e-13 ps=1.3760e-06 nf=1 m=10 par=10
XMpar4 a_1158_2978.t2 a_6932_1041.t2 vdd.t1 vdd.t0 pfet_03v3 w=0.54u l=4u ad=3.2400e-13 pd=2.2800e-06 as=1.5120e-13 ps=1.1000e-06 nf=1 m=2 par=2
XMpar5 ib.t1 ib.t0 vss.t4 vss.t3 nfet_03v3 w=0.4u l=4u ad=2.4000e-13 pd=2.0000e-06 as=1.1200e-13 ps=9.6000e-07 nf=1 m=2 par=2
XMpar6 a_6932_1041.t0 inn.t0 a_7566_13353.t0 vss.t0 nfet_03v3 w=1.44u l=3.3u ad=8.6400e-13 pd=4.0800e-06 as=8.6400e-13 ps=4.0800e-06 nf=1 m=2 par=2
XMpar7 a_6932_1041.t3 a_6932_1041.t2 vdd.t1 vdd.t0 pfet_03v3 w=0.54u l=4u ad=1.5120e-13 pd=1.1000e-06 as=1.5120e-13 ps=1.1000e-06 nf=1 m=2 par=2
X0 a_1158_3498.t0 a_5136_4018.t0 vss.t2 ppolyf_u_1k r_width=1u r_length=19.23u
X2 a_1158_6618.t0 a_5136_6098.t0 vss.t2 ppolyf_u_1k r_width=1u r_length=19.23u
X6 a_1158_8698.t0 a_5136_9218.t0 vss.t2 ppolyf_u_1k r_width=1u r_length=19.23u
X12 a_1158_3498.t0 a_5136_2978.t0 vss.t2 ppolyf_u_1k r_width=1u r_length=19.23u
X17 a_5136_9218.t1 out.t8 cap_mim_2f0fF c_width=19.27u c_length=19.27u
X21 a_1158_2978.t4 a_5136_2978.t0 vss.t2 ppolyf_u_1k r_width=1u r_length=19.23u
X23 a_1158_5578.t0 a_5136_6098.t0 vss.t2 ppolyf_u_1k r_width=1u r_length=19.23u
X25 a_1158_8698.t0 a_5136_8178.t0 vss.t2 ppolyf_u_1k r_width=1u r_length=19.23u
X27 a_1158_5578.t0 a_5136_5058.t0 vss.t2 ppolyf_u_1k r_width=1u r_length=19.23u
X30 a_1158_7658.t0 a_5136_8178.t0 vss.t2 ppolyf_u_1k r_width=1u r_length=19.23u
X33 a_1158_4538.t0 a_5136_5058.t0 vss.t2 ppolyf_u_1k r_width=1u r_length=19.23u
X36 a_1158_7658.t0 a_5136_7138.t0 vss.t2 ppolyf_u_1k r_width=1u r_length=19.23u
X38 a_1158_4538.t0 a_5136_4018.t0 vss.t2 ppolyf_u_1k r_width=1u r_length=19.23u
X44 a_5136_9218.t1 out.t8 cap_mim_2f0fF c_width=19.27u c_length=19.27u
X45 a_1158_6618.t0 a_5136_7138.t0 vss.t2 ppolyf_u_1k r_width=1u r_length=19.23u
Rpar0 a_1158_2978.t0 a_1158_2978.t5 202.2093
Rpar1 a_1158_2978.t0 a_1158_2978.t2 181.1885
Rpar2 a_1158_2978.t0 a_1158_2978.t4 352.8771
Rpar3 a_1158_2978.t5 a_1158_2978.t2 53.0816
Rpar4 a_1158_2978.t5 a_1158_2978.t4 103.3800
Rpar5 a_1158_2978.t2 a_1158_2978.t4 92.6331
Rpar6 a_5136_9218.t0 a_5136_9218.t1 58.0229
Rpar7 a_6932_1041.t0 a_6932_1041.t2 181.5433
Rpar8 a_6932_1041.t0 a_6932_1041.t3 161.0984
Rpar9 a_6932_1041.t2 a_6932_1041.t3 27.6520
Rpar10 a_7566_13353.t0 a_7566_13353.t2 51.8122
Rpar11 ib ib.t0 15.0825
Rpar12 ib ib.t1 14.9091
Rpar13 ib.t0 ib.t1 34.1144
Rpar14 inn inn.t0 5.4105
Rpar15 inp inp.t0 5.4102
Rpar16 out out.t0 85.8549
Rpar17 out out.t1 65.1657
Rpar18 out out.t8 21.5519
Rpar19 out.t0 out.t1 44.1117
Rpar20 vdd vdd.t0 122.2379
Rpar21 vdd vdd.t1 238.4440
Rpar22 vdd.t0 vdd.t1 4.5316
Rpar23 vss vss.t0 864.6868
Rpar24 vss vss.t4 308.2952
Rpar25 vss vss.t3 2872.1106
Rpar26 vss vss.t2 50.8814
Rpar27 vss.t0 vss.t4 97.3344
Rpar28 vss.t0 vss.t3 382.6771
Rpar29 vss.t0 vss.t2 274.7265
Rpar30 vss.t4 vss.t3 41.5293
Rpar31 vss.t4 vss.t2 41.6950
Rpar32 vss.t3 vss.t2 29.1793
Cpar0 a_1158_2978.t0 vss 7.24808e-15
Cpar1 a_1158_2978.t2 vss 6.13143e-15
Cpar2 a_1158_2978.t4 vss 4.17351e-15
Cpar3 a_1158_2978.t5 vss 2.13401e-14
Cpar4 a_1158_3498.t0 vss 3.47200e-17
Cpar5 a_1158_4538.t0 vss 3.05800e-17
Cpar6 a_1158_5578.t0 vss 3.05800e-17
Cpar7 a_1158_6618.t0 vss 3.05800e-17
Cpar8 a_1158_7658.t0 vss 3.13200e-17
Cpar9 a_1158_8698.t0 vss 3.57200e-17
Cpar10 a_5136_2978.t0 vss 3.75800e-17
Cpar11 a_5136_4018.t0 vss 3.32400e-17
Cpar12 a_5136_5058.t0 vss 3.74400e-17
Cpar13 a_5136_6098.t0 vss 3.74400e-17
Cpar14 a_5136_7138.t0 vss 3.74400e-17
Cpar15 a_5136_8178.t0 vss 3.87800e-17
Cpar16 a_5136_9218.t0 vss 7.05692e-17
Cpar17 a_5136_9218.t1 vss 5.14202e-15
Cpar18 a_6932_1041.t0 vss 7.12933e-15
Cpar19 a_6932_1041.t2 vss 9.74229e-15
Cpar20 a_6932_1041.t3 vss 4.39053e-15
Cpar21 a_7566_13353.t0 vss 7.94625e-15
Cpar22 a_7566_13353.t2 vss 1.38431e-14
Cpar23 ib out 2.28575e-15
Cpar24 ib vss 4.84195e-14
Cpar25 ib.t0 vss 8.22992e-15
Cpar26 ib.t1 vss 6.59297e-16
Cpar27 inn inp 1.02720e-16
Cpar28 inn vss 4.76161e-15
Cpar29 inn.t0 vss 1.04915e-15
Cpar30 inp vss 4.82328e-15
Cpar31 inp.t0 vss 1.06416e-15
Cpar32 out vdd 1.14438e-14
Cpar33 out vss 2.48278e-14
Cpar34 out.t0 vss 6.57848e-15
Cpar35 out.t1 vss 3.69820e-15
Cpar36 out.t8 vss 1.67719e-14
Cpar37 vdd vss 9.11740e-14
Cpar38 vdd.t0 vss 2.94411e-14
Cpar39 vdd.t1 vss 1.42712e-14
.ends opamp_dut

Vdd vdd 0 3.300000
Vss vss 0 0
Ibias vdd ib 9.300000e-09
Vinp inp 0 DC 1.645000 AC 1 PWL(0 1.645000 3.989479e-06 1.645000 4.388427e-06 1.655000)
Rfb out inn 1m
Cload out 0 2.000000e-12
Xdut vdd vss inp inn out ib opamp_dut
.end
