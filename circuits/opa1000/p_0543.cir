* opa1000[0543]: 2p/pmos_5t_1v8_ulp_lt0p1uw_weak (pmos_5t, VDD=1.8V, CL=2.0pF, Iref=0.0041uA)
.include "pdk_opa.inc"
.temp 27
.option gmin=1e-12 rshunt=1e12 reltol=1e-3 abstol=1e-12 vntol=1e-5 method=gear
* Post-PEX R+C extracted netlist for pmos_5t_1v8_ulp_lt0p1uw_weak
.subckt opamp_dut vdd vss inp inn out ib
XMpar0 a_1714_9092.t0 a_1658_11263.t0 vdd.t1 vdd.t0 pfet_03v3 w=0.4u l=8u ad=1.1200e-13 pd=9.6000e-07 as=2.0800e-13 ps=1.7400e-06 nf=1 m=8 par=8
XMpar1 ib.t1 ib.t0 vss.t7 vss.t6 nfet_03v3 w=0.4u l=8u ad=2.4000e-13 pd=2.0000e-06 as=1.1200e-13 ps=9.6000e-07 nf=1 m=2 par=2
XMpar2 a_1714_9092.t1 inp.t0 a_2212_7477.t0 vdd.t4 pfet_03v3 w=0.74u l=10u ad=4.4400e-13 pd=2.6800e-06 as=2.0720e-13 ps=1.3000e-06 nf=1 m=4 par=4
XMpar3 a_1714_9092.t1 inn.t0 out.t0 vdd.t4 pfet_03v3 w=0.74u l=10u ad=4.4400e-13 pd=2.6800e-06 as=2.0720e-13 ps=1.3000e-06 nf=1 m=4 par=4
XMpar4 a_1658_11263.t4 ib.t0 vss.t7 vss.t6 nfet_03v3 w=0.4u l=8u ad=1.1200e-13 pd=9.6000e-07 as=1.1200e-13 ps=9.6000e-07 nf=1 m=2 par=2
XMpar5 a_1658_11263.t1 a_1658_11263.t0 vdd.t1 vdd.t0 pfet_03v3 w=0.4u l=8u ad=2.4000e-13 pd=2.0000e-06 as=1.1200e-13 ps=9.6000e-07 nf=1 m=2 par=2
XMpar6 a_2212_7477.t5 a_2212_7477.t4 vss.t3 vss.t2 nfet_03v3 w=0.4u l=9.5u ad=2.4000e-13 pd=2.0000e-06 as=1.1200e-13 ps=9.6000e-07 nf=1 m=2 par=2
XMpar7 out.t3 a_2212_7477.t4 vss.t3 vss.t2 nfet_03v3 w=0.4u l=9.5u ad=1.1200e-13 pd=9.6000e-07 as=1.1200e-13 ps=9.6000e-07 nf=1 m=2 par=2
X1 out.t6 vss.t0 cap_mim_2f0fF c_width=14.82u c_length=14.81u
X6 out.t6 vss.t0 cap_mim_2f0fF c_width=14.82u c_length=14.81u
Rpar0 a_1658_11263.t0 a_1658_11263.t1 16.4407
Rpar1 a_1658_11263.t0 a_1658_11263.t4 149.9133
Rpar2 a_1658_11263.t1 a_1658_11263.t4 259.2924
Rpar3 a_1714_9092.t0 a_1714_9092.t1 59.3068
Rpar4 a_2212_7477.t0 a_2212_7477.t4 144.8203
Rpar5 a_2212_7477.t0 a_2212_7477.t5 114.6154
Rpar6 a_2212_7477.t4 a_2212_7477.t5 22.7657
Rpar7 ib ib.t0 11.6280
Rpar8 ib ib.t1 9.0634
Rpar9 inn inn.t0 3.2615
Rpar10 inp inp.t0 3.2615
Rpar11 out out.t0 101.0692
Rpar12 out out.t3 88.5273
Rpar13 out out.t6 16.4805
Rpar14 out.t0 out.t3 81.2489
Rpar15 vdd vdd.t0 27.9676
Rpar16 vdd vdd.t1 169.4922
Rpar17 vdd vdd.t4 102.0086
Rpar18 vdd.t0 vdd.t1 14.8536
Rpar19 vdd.t0 vdd.t4 58.5803
Rpar20 vdd.t1 vdd.t4 355.0152
Rpar21 vss vss.t0 51.3830
Rpar22 vss vss.t6 102.9091
Rpar23 vss vss.t7 382.1861
Rpar24 vss vss.t2 83.7483
Rpar25 vss vss.t3 434.5997
Rpar26 vss.t0 vss.t6 520.5855
Rpar27 vss.t0 vss.t7 1933.3613
Rpar28 vss.t0 vss.t2 423.6567
Rpar29 vss.t0 vss.t3 2198.5056
Rpar30 vss.t6 vss.t7 26.7838
Rpar31 vss.t6 vss.t2 5.0983
Rpar32 vss.t6 vss.t3 28.9366
Rpar33 vss.t7 vss.t2 22.4545
Rpar34 vss.t7 vss.t3 125.0358
Rpar35 vss.t2 vss.t3 22.1374
Cpar0 a_1658_11263.t0 vss 5.06760e-14
Cpar1 a_1658_11263.t1 vss 9.22540e-15
Cpar2 a_1658_11263.t4 vss 7.55361e-15
Cpar3 a_1714_9092.t0 vss 1.95030e-14
Cpar4 a_1714_9092.t1 vss 2.16659e-14
Cpar5 a_2212_7477.t0 vss 4.07817e-15
Cpar6 a_2212_7477.t4 vss 1.01647e-14
Cpar7 a_2212_7477.t5 vss 2.73022e-15
Cpar8 ib out 2.00830e-16
Cpar9 ib vss 2.21579e-14
Cpar10 ib.t0 vss 2.58804e-15
Cpar11 ib.t1 vss 1.44980e-16
Cpar12 inn inp 1.03940e-16
Cpar13 inn out 2.13528e-15
Cpar14 inn vdd 1.56581e-14
Cpar15 inn vss 5.91035e-15
Cpar16 inn.t0 vss 1.45392e-14
Cpar17 inp vdd 1.55354e-14
Cpar18 inp vss 5.87729e-15
Cpar19 inp.t0 vss 1.44608e-14
Cpar20 out vdd 3.84682e-15
Cpar21 out vss 2.13251e-14
Cpar22 out.t0 vss 5.93086e-16
Cpar23 out.t3 vss 3.76290e-16
Cpar24 out.t6 vss 1.35125e-14
Cpar25 vdd vss 1.71351e-13
Cpar26 vdd.t0 vss 4.48968e-14
Cpar27 vdd.t1 vss 9.98327e-15
Cpar28 vdd.t4 vss 3.97872e-14
.ends opamp_dut

Vdd vdd 0 1.800000
Vss vss 0 0
Ibias vdd ib 4.100000e-09
Vinp inp 0 DC 0.805000 AC 1 PWL(0 0.805000 1.059538e-05 0.805000 1.165492e-05 0.815000)
Rfb out inn 1m
Cload out 0 2.000000e-12
Xdut vdd vss inp inn out ib opamp_dut
.end
