* opa1000[0881]: 2p/telescopic_nmos_1v8_0p1u_1u_weak (telescopic_nmos, VDD=1.8V, CL=2.0pF, Iref=0.1437uA)
.include "pdk_opa.inc"
.temp 27
.option gmin=1e-12 rshunt=1e12 reltol=1e-3 abstol=1e-12 vntol=1e-5 method=gear
* Post-PEX R+C extracted netlist for telescopic_nmos_1v8_0p1u_1u_weak
.subckt opamp_dut vdd vss inp inn out ib
XMpar0 a_5294_8042.t6 vdd.t14 out.t5 vss.t19 nfet_03v3 w=1.23u l=4u ad=7.3800e-13 pd=3.6600e-06 as=3.4440e-13 ps=1.7900e-06 nf=1 m=2 par=2
XMpar1 a_3314_11531.t1 a_2245_11323.t0 out.t0 vdd.t0 pfet_03v3 w=1.59u l=4u ad=9.5400e-13 pd=4.3800e-06 as=6.1480e-13 ps=2.8933e-06 nf=1 m=6 par=6
XMpar2 a_1554_4134.t6 ib.t0 vss.t3 vss.t2 nfet_03v3 w=0.4u l=5u ad=1.1200e-13 pd=9.6000e-07 as=2.0800e-13 ps=1.7400e-06 nf=1 m=8 par=8
XMpar3 a_1554_4134.t0 inn.t0 a_5294_8042.t0 vss.t0 nfet_03v3 w=1.94u l=8u ad=1.1640e-12 pd=5.0800e-06 as=5.4320e-13 ps=2.5000e-06 nf=1 m=6 par=6
XMpar4 a_2125_11531.t0 a_2245_11323.t0 a_2245_11323.t1 vdd.t0 pfet_03v3 w=1.59u l=4u ad=9.5400e-13 pd=4.3800e-06 as=6.1480e-13 ps=2.8933e-06 nf=1 m=6 par=6
XMpar5 a_1554_4134.t0 inp.t0 a_3154_8042.t0 vss.t0 nfet_03v3 w=1.94u l=8u ad=1.1640e-12 pd=5.0800e-06 as=5.4320e-13 ps=2.5000e-06 nf=1 m=6 par=6
XMpar6 a_2125_11531.t1 a_2245_11323.t14 vdd.t2 vdd.t1 pfet_03v3 w=2.11u l=5u ad=1.2660e-12 pd=5.4200e-06 as=5.9080e-13 ps=2.6700e-06 nf=1 m=2 par=2
XMpar7 a_3314_11531.t0 a_2245_11323.t14 vdd.t2 vdd.t1 pfet_03v3 w=2.11u l=5u ad=5.9080e-13 pd=2.6700e-06 as=5.9080e-13 ps=2.6700e-06 nf=1 m=2 par=2
XMpar8 a_2245_11323.t12 vdd.t14 a_3154_8042.t6 vss.t19 nfet_03v3 w=1.23u l=4u ad=3.4440e-13 pd=1.7900e-06 as=7.3800e-13 ps=3.6600e-06 nf=1 m=2 par=2
XMpar9 ib.t1 ib.t0 vss.t3 vss.t2 nfet_03v3 w=0.4u l=5u ad=2.4000e-13 pd=2.0000e-06 as=1.1200e-13 ps=9.6000e-07 nf=1 m=2 par=2
Rpar0 a_1554_4134.t0 a_1554_4134.t6 30.5405
Rpar1 a_2125_11531.t0 a_2125_11531.t1 48.7691
Rpar2 a_2245_11323.t0 a_2245_11323.t1 9.7167
Rpar3 a_2245_11323.t0 a_2245_11323.t12 332.4574
Rpar4 a_2245_11323.t0 a_2245_11323.t14 196.7730
Rpar5 a_2245_11323.t1 a_2245_11323.t12 164.8732
Rpar6 a_2245_11323.t1 a_2245_11323.t14 97.5842
Rpar7 a_2245_11323.t12 a_2245_11323.t14 57.8151
Rpar8 a_3154_8042.t0 a_3154_8042.t6 44.8057
Rpar9 a_3314_11531.t0 a_3314_11531.t1 72.8536
Rpar10 a_5294_8042.t0 a_5294_8042.t6 44.8057
Rpar11 ib ib.t0 13.2776
Rpar12 ib ib.t1 14.2358
Rpar13 ib.t0 ib.t1 33.8788
Rpar14 inn inn.t0 2.9152
Rpar15 inp inp.t0 2.9152
Rpar16 out out.t0 58.3685
Rpar17 out out.t5 12.9423
Rpar18 vdd vdd.t0 27.0301
Rpar19 vdd vdd.t1 283.0301
Rpar20 vdd vdd.t2 271.5365
Rpar21 vdd vdd.t14 479.7826
Rpar22 vdd.t0 vdd.t1 158.3148
Rpar23 vdd.t0 vdd.t2 151.8858
Rpar24 vdd.t0 vdd.t14 268.3696
Rpar25 vdd.t1 vdd.t2 14.8221
Rpar26 vdd.t1 vdd.t14 127.0307
Rpar27 vdd.t2 vdd.t14 121.8721
Rpar28 vss vss.t0 196.9403
Rpar29 vss vss.t2 105.2828
Rpar30 vss vss.t3 52.3994
Rpar31 vss vss.t19 129.5335
Rpar32 vss.t0 vss.t2 4.4248
Rpar33 vss.t0 vss.t3 55.0678
Rpar34 vss.t0 vss.t19 5.9516
Rpar35 vss.t2 vss.t3 26.1373
Rpar36 vss.t2 vss.t19 2.1186
Rpar37 vss.t3 vss.t19 40.4623
Cpar0 a_1554_4134.t0 vss 1.93411e-14
Cpar1 a_1554_4134.t6 vss 7.19183e-15
Cpar2 a_2125_11531.t0 vss 1.57811e-14
Cpar3 a_2125_11531.t1 vss 7.29793e-15
Cpar4 a_2245_11323.t0 vss 3.37673e-14
Cpar5 a_2245_11323.t1 vss 9.73035e-15
Cpar6 a_2245_11323.t12 vss 1.99610e-15
Cpar7 a_2245_11323.t14 vss 1.62961e-14
Cpar8 a_3154_8042.t0 vss 1.05769e-14
Cpar9 a_3154_8042.t6 vss 3.17230e-15
Cpar10 a_3314_11531.t0 vss 7.53434e-15
Cpar11 a_3314_11531.t1 vss 1.94110e-14
Cpar12 a_5294_8042.t0 vss 1.01273e-14
Cpar13 a_5294_8042.t6 vss 3.03745e-15
Cpar14 ib inn 2.30700e-17
Cpar15 ib inp 3.48900e-17
Cpar16 ib vss 3.76098e-14
Cpar17 ib.t0 vss 5.28222e-15
Cpar18 ib.t1 vss 4.38025e-16
Cpar19 inn inp 1.55910e-16
Cpar20 inn vdd 1.68900e-17
Cpar21 inn vss 1.99177e-14
Cpar22 inn.t0 vss 6.41407e-15
Cpar23 inp vdd 3.53500e-17
Cpar24 inp vss 1.97244e-14
Cpar25 inp.t0 vss 6.48755e-15
Cpar26 out vdd 9.10947e-15
Cpar27 out vss 9.69024e-15
Cpar28 out.t0 vss 1.64488e-14
Cpar29 out.t5 vss 3.19724e-16
Cpar30 vdd vss 1.27146e-13
Cpar31 vdd.t0 vss 3.74695e-14
Cpar32 vdd.t1 vss 6.80263e-15
Cpar33 vdd.t14 vss 3.51324e-15
Cpar34 vdd.t2 vss 7.10101e-15
.ends opamp_dut

Vdd vdd 0 1.800000
Vss vss 0 0
Ibias vdd ib 1.437000e-07
Vinp inp 0 DC 0.931000 AC 1 PWL(0 0.931000 2.440966e-07 0.931000 2.685062e-07 0.941000)
Rfb out inn 1m
Cload out 0 2.000000e-12
Xdut vdd vss inp inn out ib opamp_dut
.end
