* opa1000[0294]: 2p/folded_cascode_pmos_1v8_i50n_weak (folded_cascode_pmos, VDD=1.8V, CL=2.0pF, Iref=0.0128uA)
.include "pdk_opa.inc"
.temp 27
.option gmin=1e-12 rshunt=1e12 reltol=1e-3 abstol=1e-12 vntol=1e-5 method=gear
* Post-PEX R+C extracted netlist for folded_cascode_pmos_1v8_i50n_weak
.subckt opamp_dut vdd vss inp inn out ib
XMpar0 a_1472_5598.t3 a_1472_5598.t2 vdd.t1 vdd.t0 pfet_03v3 w=0.4u l=9.75u ad=2.4000e-13 pd=2.0000e-06 as=1.1200e-13 ps=9.6000e-07 nf=1 m=2 par=2
XMpar1 a_5614_4187.t1 ib vss.t2 vss.t1 nfet_03v3 w=0.4u l=5u ad=1.1200e-13 pd=9.6000e-07 as=1.7600e-13 ps=1.4800e-06 nf=1 m=4 par=4
XMpar2 a_1587_8661.t2 inp.t0 a_1970_2776.t4 vdd.t10 pfet_03v3 w=0.81u l=6.5u ad=4.8600e-13 pd=2.8200e-06 as=2.2680e-13 ps=1.3700e-06 nf=1 m=2 par=2
XMpar3 a_1587_8661.t0 a_1707_8453.t2 vdd.t1 vdd.t0 pfet_03v3 w=0.4u l=9.75u ad=2.4000e-13 pd=2.0000e-06 as=1.7600e-13 ps=1.4800e-06 nf=1 m=4 par=4
XMpar4 a_1472_5598.t0 a_1707_8453.t6 a_1970_2776.t6 vss.t0 nfet_03v3 w=0.4u l=2.8u ad=1.1200e-13 pd=9.6000e-07 as=2.4000e-13 ps=2.0000e-06 nf=1 m=2 par=2
XMpar5 out.t1 a_1472_5598.t2 vdd.t1 vdd.t0 pfet_03v3 w=0.4u l=9.75u ad=1.1200e-13 pd=9.6000e-07 as=1.1200e-13 ps=9.6000e-07 nf=1 m=2 par=2
XMpar6 a_1970_2776.t0 ib vss.t2 vss.t1 nfet_03v3 w=0.4u l=5u ad=1.1200e-13 pd=9.6000e-07 as=1.7600e-13 ps=1.4800e-06 nf=1 m=4 par=4
XMpar7 ib.t1 ib vss.t2 vss.t1 nfet_03v3 w=0.4u l=5u ad=2.4000e-13 pd=2.0000e-06 as=1.1200e-13 ps=9.6000e-07 nf=1 m=2 par=2
XMpar8 a_1587_8661.t2 inn.t0 a_5614_4187.t5 vdd.t10 pfet_03v3 w=0.81u l=6.5u ad=4.8600e-13 pd=2.8200e-06 as=2.2680e-13 ps=1.3700e-06 nf=1 m=2 par=2
XMpar9 a_1707_8453.t0 ib vss.t2 vss.t1 nfet_03v3 w=0.4u l=5u ad=1.1200e-13 pd=9.6000e-07 as=1.1200e-13 ps=9.6000e-07 nf=1 m=2 par=2
XMpar10 a_1707_8453.t3 a_1707_8453.t2 vdd.t1 vdd.t0 pfet_03v3 w=0.4u l=9.75u ad=2.4000e-13 pd=2.0000e-06 as=1.1200e-13 ps=9.6000e-07 nf=1 m=2 par=2
XMpar11 a_5614_4187.t0 a_1707_8453.t6 out.t0 vss.t0 nfet_03v3 w=0.4u l=2.8u ad=2.4000e-13 pd=2.0000e-06 as=1.1200e-13 ps=9.6000e-07 nf=1 m=2 par=2
Rpar0 a_1472_5598.t0 a_1472_5598.t2 116.6534
Rpar1 a_1472_5598.t0 a_1472_5598.t3 89.6354
Rpar2 a_1472_5598.t2 a_1472_5598.t3 22.9081
Rpar3 a_1587_8661.t0 a_1587_8661.t2 52.3963
Rpar4 a_1707_8453.t0 a_1707_8453.t2 365.6024
Rpar5 a_1707_8453.t0 a_1707_8453.t3 339.8984
Rpar6 a_1707_8453.t0 a_1707_8453.t6 100.7717
Rpar7 a_1707_8453.t2 a_1707_8453.t3 16.8248
Rpar8 a_1707_8453.t2 a_1707_8453.t6 175.4935
Rpar9 a_1707_8453.t3 a_1707_8453.t6 163.1553
Rpar10 a_1970_2776.t0 a_1970_2776.t4 77.3515
Rpar11 a_1970_2776.t0 a_1970_2776.t6 63.1253
Rpar12 a_1970_2776.t4 a_1970_2776.t6 122.5784
Rpar13 a_5614_4187.t0 a_5614_4187.t1 63.1253
Rpar14 a_5614_4187.t0 a_5614_4187.t5 122.5784
Rpar15 a_5614_4187.t1 a_5614_4187.t5 77.3515
Rpar16 ib ib.t1 15.8101
Rpar17 inn inn.t0 3.3294
Rpar18 inp inp.t0 3.3779
Rpar19 out out.t0 14.1321
Rpar20 out out.t1 67.4941
Rpar21 vdd vdd.t0 27.5462
Rpar22 vdd vdd.t1 175.7418
Rpar23 vdd vdd.t10 110.6274
Rpar24 vdd.t0 vdd.t1 7.6349
Rpar25 vdd.t0 vdd.t10 44.3736
Rpar26 vdd.t1 vdd.t10 189.3717
Rpar27 vss vss.t0 188.8738
Rpar28 vss vss.t1 27.9599
Rpar29 vss vss.t2 110.7889
Rpar30 vss.t0 vss.t1 6.2691
Rpar31 vss.t0 vss.t2 37.3490
Rpar32 vss.t1 vss.t2 5.3979
Cpar0 a_1472_5598.t0 vss 2.94604e-15
Cpar1 a_1472_5598.t2 vss 2.21442e-14
Cpar2 a_1472_5598.t3 vss 5.68965e-15
Cpar3 a_1587_8661.t0 vss 1.65729e-14
Cpar4 a_1587_8661.t2 vss 9.12380e-15
Cpar5 a_1707_8453.t0 vss 5.22210e-15
Cpar6 a_1707_8453.t2 vss 3.03401e-14
Cpar7 a_1707_8453.t3 vss 6.89279e-15
Cpar8 a_1707_8453.t6 vss 1.05585e-14
Cpar9 a_1970_2776.t0 vss 2.67133e-15
Cpar10 a_1970_2776.t4 vss 1.79667e-15
Cpar11 a_1970_2776.t6 vss 1.78820e-15
Cpar12 a_5614_4187.t0 vss 2.93877e-15
Cpar13 a_5614_4187.t1 vss 4.39015e-15
Cpar14 a_5614_4187.t5 vss 2.95270e-15
Cpar15 ib vss 4.02571e-14
Cpar16 ib.t1 vss 2.08176e-16
Cpar17 inn inp 5.16300e-17
Cpar18 inn vdd 6.16990e-15
Cpar19 inn vss 3.35477e-15
Cpar20 inn.t0 vss 3.99062e-15
Cpar21 inp vdd 6.08662e-15
Cpar22 inp vss 3.25270e-15
Cpar23 inp.t0 vss 3.98304e-15
Cpar24 out vdd 5.45139e-15
Cpar25 out vss 7.88043e-15
Cpar26 out.t0 vss 1.75776e-16
Cpar27 out.t1 vss 6.23434e-15
Cpar28 vdd vss 1.44202e-13
Cpar29 vdd.t0 vss 5.64544e-14
Cpar30 vdd.t1 vss 1.50335e-14
Cpar31 vdd.t10 vss 1.74013e-14
.ends opamp_dut

Vdd vdd 0 1.800000
Vss vss 0 0
Ibias vdd ib 1.280000e-08
Vinp inp 0 DC 0.751000 AC 1 PWL(0 0.751000 5.195115e-06 0.751000 5.714626e-06 0.761000)
Rfb out inn 1m
Cload out 0 2.000000e-12
Xdut vdd vss inp inn out ib opamp_dut
.end
