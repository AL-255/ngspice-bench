* opa1000[0798]: 2p/symmetrical_ota_1v8_0p1u_1u_weak (symmetrical_ota, VDD=1.8V, CL=2.0pF, Iref=0.0958uA)
.include "pdk_opa.inc"
.temp 27
.option gmin=1e-12 rshunt=1e12 reltol=1e-3 abstol=1e-12 vntol=1e-5 method=gear
* Post-PEX R+C extracted netlist for symmetrical_ota_1v8_0p1u_1u_weak
.subckt opamp_dut vdd vss inp inn out ib
XMpar0 a_5218_6132.t0 a_10011_10465.t2 vdd.t1 vdd.t0 pfet_03v3 w=1.62u l=9.75u ad=9.7200e-13 pd=4.4400e-06 as=7.1280e-13 ps=3.3100e-06 nf=1 m=4 par=4
XMpar1 a_10011_10465.t3 a_10011_10465.t2 vdd.t1 vdd.t0 pfet_03v3 w=1.62u l=9.75u ad=9.7200e-13 pd=4.4400e-06 as=4.5360e-13 ps=2.1800e-06 nf=1 m=2 par=2
XMpar2 out.t0 a_1719_10465.t2 vdd.t1 vdd.t0 pfet_03v3 w=1.62u l=9.75u ad=9.7200e-13 pd=4.4400e-06 as=7.1280e-13 ps=3.3100e-06 nf=1 m=4 par=4
XMpar3 a_5394_4224.t4 ib.t0 vss.t16 vss.t15 nfet_03v3 w=0.4u l=3.25u ad=2.4000e-13 pd=2.0000e-06 as=1.7600e-13 ps=1.4800e-06 nf=1 m=4 par=4
XMpar4 a_1719_10465.t3 a_1719_10465.t2 vdd.t1 vdd.t0 pfet_03v3 w=1.62u l=9.75u ad=9.7200e-13 pd=4.4400e-06 as=4.5360e-13 ps=2.1800e-06 nf=1 m=2 par=2
XMpar5 a_5218_6132.t2 a_5218_6132.t1 vss.t3 vss.t2 nfet_03v3 w=0.4u l=9.75u ad=1.7600e-13 pd=1.4800e-06 as=1.1200e-13 ps=9.6000e-07 nf=1 m=4 par=4
XMpar6 a_1719_10465.t0 inp.t0 a_5394_4224.t0 vss.t0 nfet_03v3 w=1.94u l=8u ad=5.4320e-13 pd=2.5000e-06 as=1.1640e-12 ps=5.0800e-06 nf=1 m=2 par=2
XMpar7 ib.t1 ib.t0 vss.t16 vss.t15 nfet_03v3 w=0.4u l=3.25u ad=2.4000e-13 pd=2.0000e-06 as=1.1200e-13 ps=9.6000e-07 nf=1 m=2 par=2
XMpar8 a_10011_10465.t0 inn.t0 a_5394_4224.t0 vss.t0 nfet_03v3 w=1.94u l=8u ad=5.4320e-13 pd=2.5000e-06 as=1.1640e-12 ps=5.0800e-06 nf=1 m=2 par=2
XMpar9 out.t1 a_5218_6132.t1 vss.t3 vss.t2 nfet_03v3 w=0.4u l=9.75u ad=2.4000e-13 pd=2.0000e-06 as=1.1200e-13 ps=9.6000e-07 nf=1 m=4 par=4
X22 out.t8 vss.t8 cap_mim_2f0fF c_width=17.43u c_length=17.43u
Rpar0 a_10011_10465.t0 a_10011_10465.t2 143.5325
Rpar1 a_10011_10465.t0 a_10011_10465.t3 147.0068
Rpar2 a_10011_10465.t2 a_10011_10465.t3 13.3852
Rpar3 a_1719_10465.t0 a_1719_10465.t2 268.4316
Rpar4 a_1719_10465.t0 a_1719_10465.t3 143.8878
Rpar5 a_1719_10465.t2 a_1719_10465.t3 13.2057
Rpar6 a_5218_6132.t0 a_5218_6132.t1 109.9875
Rpar7 a_5218_6132.t0 a_5218_6132.t2 98.6423
Rpar8 a_5218_6132.t1 a_5218_6132.t2 11.1239
Rpar9 a_5394_4224.t0 a_5394_4224.t4 30.3354
Rpar10 ib ib.t0 11.2357
Rpar11 ib ib.t1 12.8068
Rpar12 ib.t0 ib.t1 38.1471
Rpar13 inn inn.t0 3.7506
Rpar14 inp inp.t0 3.7992
Rpar15 out out.t0 137.2535
Rpar16 out out.t1 8.6859
Rpar17 out out.t8 172.9782
Rpar18 out.t0 out.t1 134.9427
Rpar19 out.t0 out.t8 79.9832
Rpar20 out.t1 out.t8 170.0659
Rpar21 vdd vdd.t0 78.0439
Rpar22 vdd vdd.t1 24.6599
Rpar23 vdd.t0 vdd.t1 7.3472
Rpar24 vss vss.t0 410.1247
Rpar25 vss vss.t2 325.0966
Rpar26 vss vss.t3 2846.2315
Rpar27 vss vss.t15 244.0486
Rpar28 vss vss.t16 125.3048
Rpar29 vss vss.t8 81.6621
Rpar30 vss.t0 vss.t2 5.6535
Rpar31 vss.t0 vss.t3 51.6523
Rpar32 vss.t0 vss.t15 4.8983
Rpar33 vss.t0 vss.t16 58.5639
Rpar34 vss.t0 vss.t8 553.6703
Rpar35 vss.t2 vss.t3 38.2256
Rpar36 vss.t2 vss.t15 3.3810
Rpar37 vss.t2 vss.t16 44.2252
Rpar38 vss.t2 vss.t8 438.8820
Rpar39 vss.t3 vss.t15 35.3705
Rpar40 vss.t3 vss.t16 432.5084
Rpar41 vss.t3 vss.t8 3842.4266
Rpar42 vss.t15 vss.t16 28.5910
Rpar43 vss.t15 vss.t8 329.4668
Rpar44 vss.t16 vss.t8 169.1621
Cpar0 a_10011_10465.t0 vss 5.08521e-15
Cpar1 a_10011_10465.t2 vss 3.71064e-14
Cpar2 a_10011_10465.t3 vss 7.74182e-15
Cpar3 a_1719_10465.t0 vss 7.63353e-15
Cpar4 a_1719_10465.t2 vss 3.54534e-14
Cpar5 a_1719_10465.t3 vss 8.87508e-15
Cpar6 a_5218_6132.t0 vss 5.90398e-15
Cpar7 a_5218_6132.t1 vss 1.99392e-14
Cpar8 a_5218_6132.t2 vss 4.85515e-15
Cpar9 a_5394_4224.t0 vss 5.34066e-15
Cpar10 a_5394_4224.t4 vss 4.09210e-15
Cpar11 ib inp 1.82700e-17
Cpar12 ib vss 1.86325e-14
Cpar13 ib.t0 vss 2.48231e-15
Cpar14 ib.t1 vss 3.02494e-16
Cpar15 inn inp 5.19700e-17
Cpar16 inn vss 7.99939e-15
Cpar17 inn.t0 vss 9.59091e-16
Cpar18 inp out 1.07500e-17
Cpar19 inp vss 8.10846e-15
Cpar20 inp.t0 vss 9.53334e-16
Cpar21 out vdd 9.52631e-15
Cpar22 out vss 3.21652e-14
Cpar23 out.t0 vss 2.39147e-15
Cpar24 out.t1 vss 1.59357e-15
Cpar25 out.t8 vss 2.33586e-14
Cpar26 vdd vss 1.65134e-13
Cpar27 vdd.t0 vss 7.34300e-14
Cpar28 vdd.t1 vss 1.37919e-14
.ends opamp_dut

Vdd vdd 0 1.800000
Vss vss 0 0
Ibias vdd ib 9.580000e-08
Vinp inp 0 DC 0.895000 AC 1 PWL(0 0.895000 4.919688e-07 0.895000 5.411657e-07 0.905000)
Rfb out inn 1m
Cload out 0 2.000000e-12
Xdut vdd vss inp inn out ib opamp_dut
.end
