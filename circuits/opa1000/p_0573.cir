* opa1000[0573]: 2p/pmos_5t_3v3_1u_10u_subth (pmos_5t, VDD=3.3V, CL=2.0pF, Iref=1.3uA)
.include "pdk_opa.inc"
.temp 27
.option gmin=1e-12 rshunt=1e12 reltol=1e-3 abstol=1e-12 vntol=1e-5 method=gear
* Post-PEX R+C extracted netlist for pmos_5t_3v3_1u_10u_subth
.subckt opamp_dut vdd vss inp inn out ib
XMpar0 a_1522_6561.t0 inp.t0 a_2042_6561.t16 vdd.t10 pfet_03v3 w=8u l=2u ad=2.4800e-12 pd=9.3700e-06 as=2.4000e-12 ps=9.1000e-06 nf=1 m=64 par=64
XMpar1 a_1522_6561.t0 inn.t0 out.t0 vdd.t10 pfet_03v3 w=8u l=2u ad=2.4800e-12 pd=9.3700e-06 as=2.4000e-12 ps=9.1000e-06 nf=1 m=64 par=64
XMpar2 a_1522_6561.t128 a_2128_1204.t2 vdd.t1 vdd.t0 pfet_03v3 w=10u l=2u ad=2.8000e-12 pd=1.0560e-05 as=3.6000e-12 ps=1.3220e-05 nf=1 m=8 par=8
XMpar3 out.t18 a_2042_6561.t0 vss.t1 vss.t0 nfet_03v3 w=1.88u l=3.2u ad=5.2640e-13 pd=2.4400e-06 as=6.0160e-13 ps=2.7550e-06 nf=1 m=8 par=8
XMpar4 ib.t1 ib.t0 vss.t9 vss.t8 nfet_03v3 w=3.59u l=2u ad=2.1540e-12 pd=8.3800e-06 as=1.0052e-12 ps=4.1500e-06 nf=1 m=2 par=2
XMpar5 a_2128_1204.t0 ib.t0 vss.t9 vss.t8 nfet_03v3 w=3.59u l=2u ad=1.0052e-12 pd=4.1500e-06 as=1.0052e-12 ps=4.1500e-06 nf=1 m=2 par=2
XMpar6 a_2042_6561.t1 a_2042_6561.t0 vss.t1 vss.t0 nfet_03v3 w=1.88u l=3.2u ad=5.2640e-13 pd=2.4400e-06 as=6.0160e-13 ps=2.7550e-06 nf=1 m=8 par=8
XMpar7 a_2128_1204.t3 a_2128_1204.t2 vdd.t1 vdd.t0 pfet_03v3 w=10u l=2u ad=2.8000e-12 pd=1.0560e-05 as=2.8000e-12 ps=1.0560e-05 nf=1 m=2 par=2
Rpar0 a_1522_6561.t0 a_1522_6561.t128 53.6108
Rpar1 a_2042_6561.t0 a_2042_6561.t1 17.0234
Rpar2 a_2042_6561.t0 a_2042_6561.t16 160.0649
Rpar3 a_2042_6561.t1 a_2042_6561.t16 76.4526
Rpar4 a_2128_1204.t0 a_2128_1204.t2 136.6673
Rpar5 a_2128_1204.t0 a_2128_1204.t3 82.9553
Rpar6 a_2128_1204.t2 a_2128_1204.t3 25.4926
Rpar7 ib ib.t0 14.0392
Rpar8 ib ib.t1 3.7420
Rpar9 inn inn.t0 1.8269
Rpar10 inp inp.t0 1.8269
Rpar11 out out.t0 204.4410
Rpar12 out out.t18 5.6019
Rpar13 out.t0 out.t18 54.0648
Rpar14 vdd vdd.t0 112.8552
Rpar15 vdd vdd.t1 624.0304
Rpar16 vdd vdd.t10 20.1132
Rpar17 vdd.t0 vdd.t1 5.6627
Rpar18 vdd.t0 vdd.t10 341.9911
Rpar19 vdd.t1 vdd.t10 1891.0329
Rpar20 vss vss.t0 119.3554
Rpar21 vss vss.t1 370.0347
Rpar22 vss vss.t8 177.2962
Rpar23 vss vss.t9 268.2493
Rpar24 vss.t0 vss.t1 6.2951
Rpar25 vss.t0 vss.t8 7.6313
Rpar26 vss.t0 vss.t9 18.9849
Rpar27 vss.t1 vss.t8 33.5526
Rpar28 vss.t1 vss.t9 62.0352
Rpar29 vss.t8 vss.t9 17.2375
Cpar0 a_1522_6561.t0 vss 1.74442e-13
Cpar1 a_1522_6561.t128 vss 1.44615e-14
Cpar2 a_2042_6561.t0 vss 2.71778e-14
Cpar3 a_2042_6561.t1 vss 7.21184e-15
Cpar4 a_2042_6561.t16 vss 7.70038e-14
Cpar5 a_2128_1204.t0 vss 1.88577e-15
Cpar6 a_2128_1204.t2 vss 2.41688e-14
Cpar7 a_2128_1204.t3 vss 3.85115e-15
Cpar8 ib vss 9.61209e-15
Cpar9 ib.t0 vss 9.59889e-16
Cpar10 ib.t1 vss 2.51800e-16
Cpar11 inn inp 2.22320e-16
Cpar12 inn out 3.95749e-14
Cpar13 inn vdd 5.39917e-14
Cpar14 inn vss 1.08506e-14
Cpar15 inn.t0 vss 1.17401e-13
Cpar16 inp out 1.13600e-17
Cpar17 inp vdd 5.41610e-14
Cpar18 inp vss 1.09198e-14
Cpar19 inp.t0 vss 1.17531e-13
Cpar20 out vdd 1.28874e-14
Cpar21 out vss 1.33489e-14
Cpar22 out.t0 vss 9.72759e-14
Cpar23 out.t18 vss 6.67055e-15
Cpar24 vdd vss 6.47401e-13
Cpar25 vdd.t0 vss 1.64881e-14
Cpar26 vdd.t1 vss 6.18187e-15
Cpar27 vdd.t10 vss 1.55901e-13
.ends opamp_dut

Vdd vdd 0 3.300000
Vss vss 0 0
Ibias vdd ib 1.300000e-06
Vinp inp 0 DC 1.480000 AC 1 PWL(0 1.480000 2.471847e-08 1.480000 2.719032e-08 1.490000)
Rfb out inn 1m
Cload out 0 2.000000e-12
Xdut vdd vss inp inn out ib opamp_dut
.end
