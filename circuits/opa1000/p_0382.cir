* opa1000[0382]: 2p/nmos_5t_1v8_i1u_weak (nmos_5t, VDD=1.8V, CL=2.0pF, Iref=0.2875uA)
.include "pdk_opa.inc"
.temp 27
.option gmin=1e-12 rshunt=1e12 reltol=1e-3 abstol=1e-12 vntol=1e-5 method=gear
* Post-PEX R+C extracted netlist for nmos_5t_1v8_i1u_weak
.subckt opamp_dut vdd vss inp inn out ib
XMpar0 out.t0 a_1476_4579.t2 vdd.t1 vdd.t0 pfet_03v3 w=1.65u l=6.75u ad=6.3800e-13 pd=2.9733e-06 as=4.6200e-13 ps=2.2100e-06 nf=1 m=6 par=6
XMpar1 a_1476_4579.t0 inp.t0 a_3234_2775.t8 vss.t20 nfet_03v3 w=2.36u l=5u ad=6.6080e-13 pd=2.9200e-06 as=1.4160e-12 ps=5.9200e-06 nf=1 m=2 par=2
XMpar2 a_3234_2775.t0 ib.t0 vss.t1 vss.t0 nfet_03v3 w=0.4u l=2.1u ad=1.1200e-13 pd=9.6000e-07 as=1.4400e-13 ps=1.2200e-06 nf=1 m=8 par=8
XMpar3 a_1476_4579.t3 a_1476_4579.t2 vdd.t1 vdd.t0 pfet_03v3 w=1.65u l=6.75u ad=6.3800e-13 pd=2.9733e-06 as=4.6200e-13 ps=2.2100e-06 nf=1 m=6 par=6
XMpar4 ib.t1 ib.t0 vss.t1 vss.t0 nfet_03v3 w=0.4u l=2.1u ad=1.1200e-13 pd=9.6000e-07 as=1.1200e-13 ps=9.6000e-07 nf=1 m=2 par=2
XMpar5 a_3234_2775.t8 inn.t0 out.t3 vss.t20 nfet_03v3 w=2.36u l=5u ad=1.4160e-12 pd=5.9200e-06 as=6.6080e-13 ps=2.9200e-06 nf=1 m=2 par=2
X23 out.t8 vss.t24 cap_mim_2f0fF c_width=6.71u c_length=6.71u
Rpar0 a_1476_4579.t0 a_1476_4579.t2 194.6974
Rpar1 a_1476_4579.t0 a_1476_4579.t3 90.1979
Rpar2 a_1476_4579.t2 a_1476_4579.t3 8.6220
Rpar3 a_3234_2775.t0 a_3234_2775.t8 37.5661
Rpar4 ib ib.t0 18.3441
Rpar5 ib ib.t1 18.4305
Rpar6 ib.t0 ib.t1 100.9016
Rpar7 inn inn.t0 3.8247
Rpar8 inp inp.t0 3.8732
Rpar9 out out.t0 6.0419
Rpar10 out out.t3 132.8974
Rpar11 out out.t8 63.1720
Rpar12 out.t3 out.t8 214.2406
Rpar13 vdd vdd.t0 22.7560
Rpar14 vdd vdd.t1 180.6539
Rpar15 vdd.t0 vdd.t1 13.4195
Rpar16 vss vss.t0 29.6495
Rpar17 vss vss.t1 110.9697
Rpar18 vss vss.t20 156.0734
Rpar19 vss vss.t24 67.1416
Rpar20 vss.t0 vss.t1 7.0404
Rpar21 vss.t0 vss.t20 9.7775
Rpar22 vss.t0 vss.t24 107.9878
Rpar23 vss.t1 vss.t20 38.4060
Rpar24 vss.t1 vss.t24 353.0327
Rpar25 vss.t20 vss.t24 579.8200
Cpar0 a_1476_4579.t0 vss 3.23149e-15
Cpar1 a_1476_4579.t2 vss 5.30805e-14
Cpar2 a_1476_4579.t3 vss 1.13373e-14
Cpar3 a_3234_2775.t0 vss 2.99660e-15
Cpar4 a_3234_2775.t8 vss 4.64887e-15
Cpar5 ib inn 2.25500e-17
Cpar6 ib inp 2.16900e-17
Cpar7 ib out 1.93680e-16
Cpar8 ib vss 1.74543e-14
Cpar9 ib.t0 vss 2.62282e-15
Cpar10 ib.t1 vss 1.16401e-16
Cpar11 inn inp 5.12600e-17
Cpar12 inn out 4.13420e-16
Cpar13 inn vss 5.44962e-15
Cpar14 inn.t0 vss 8.29284e-16
Cpar15 inp vss 5.33224e-15
Cpar16 inp.t0 vss 8.55025e-16
Cpar17 out vdd 1.14041e-14
Cpar18 out vss 2.06202e-14
Cpar19 out.t0 vss 3.94922e-15
Cpar20 out.t3 vss 3.16893e-15
Cpar21 out.t8 vss 1.24882e-14
Cpar22 vdd vss 1.10197e-13
Cpar23 vdd.t0 vss 4.75542e-14
Cpar24 vdd.t1 vss 8.66048e-15
.ends opamp_dut

Vdd vdd 0 1.800000
Vss vss 0 0
Ibias vdd ib 2.875000e-07
Vinp inp 0 DC 0.895000 AC 1 PWL(0 0.895000 1.646163e-07 0.895000 1.810779e-07 0.905000)
Rfb out inn 1m
Cload out 0 2.000000e-12
Xdut vdd vss inp inn out ib opamp_dut
.end
