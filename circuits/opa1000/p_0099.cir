* opa1000[0099]: 200f/current_reuse_1v8_i20u_weak (current_reuse, VDD=1.8V, CL=0.2pF, Iref=3.2857uA)
.include "pdk_opa.inc"
.temp 27
.option gmin=1e-12 rshunt=1e12 reltol=1e-3 abstol=1e-12 vntol=1e-5 method=gear
* Post-PEX R+C extracted netlist for current_reuse_1v8_i20u_weak
.subckt opamp_dut vdd vss inp inn out ib
XMpar0 a_1055_8351.t0 inn.t8 a_905_8143.t0 vdd.t0 pfet_03v3 w=1.92u l=1.13u ad=6.0587e-13 pd=2.7644e-06 as=6.0587e-13 ps=2.7644e-06 nf=1 m=18 par=18
XMpar1 a_1055_8351.t0 inp.t8 a_2807_5940.t1 vdd.t0 pfet_03v3 w=1.92u l=1.13u ad=6.0587e-13 pd=2.7644e-06 as=6.0587e-13 ps=2.7644e-06 nf=1 m=18 par=18
XMpar2 a_2807_5940.t19 inp.t0 a_3874_8440.t0 vss.t0 nfet_03v3 w=1.64u l=1.13u ad=4.5920e-13 pd=2.2000e-06 as=5.9040e-13 ps=2.7700e-06 nf=1 m=8 par=8
XMpar3 a_3874_8440.t16 ib.t0 vss.t18 vss.t17 nfet_03v3 w=2.13u l=1.5u ad=1.2780e-12 pd=5.4600e-06 as=5.9640e-13 ps=2.6900e-06 nf=1 m=4 par=4
XMpar4 a_3874_8440.t0 inn.t0 a_905_8143.t16 vss.t0 nfet_03v3 w=1.64u l=1.13u ad=5.9040e-13 pd=2.7700e-06 as=4.5920e-13 ps=2.2000e-06 nf=1 m=8 par=8
XMpar5 out.t1 a_2807_5940.t28 vdd.t19 vdd.t18 pfet_03v3 w=5.03u l=0.75u ad=1.4084e-12 pd=5.5900e-06 as=1.7303e-12 ps=6.7240e-06 nf=1 m=10 par=10
XMpar6 out.t8 ib.t0 vss.t18 vss.t17 nfet_03v3 w=2.13u l=1.5u ad=1.0054e-12 pd=4.3520e-06 as=8.6904e-13 ps=3.7980e-06 nf=1 m=10 par=10
XMpar7 a_2807_5940.t27 a_905_8143.t26 vdd.t19 vdd.t18 pfet_03v3 w=5.03u l=0.75u ad=3.0180e-12 pd=1.1260e-05 as=1.4084e-12 ps=5.5900e-06 nf=1 m=1
XMpar8 ib.t1 ib.t0 vss.t18 vss.t17 nfet_03v3 w=2.13u l=1.5u ad=1.2780e-12 pd=5.4600e-06 as=5.9640e-13 ps=2.6900e-06 nf=1 m=2 par=2
XMpar9 a_905_8143.t27 a_905_8143.t26 vdd.t19 vdd.t18 pfet_03v3 w=5.03u l=0.75u ad=3.0180e-12 pd=1.1260e-05 as=1.4084e-12 ps=5.5900e-06 nf=1 m=1
XMpar10 a_1055_8351.t36 a_905_8143.t26 vdd.t19 vdd.t18 pfet_03v3 w=5.03u l=0.75u ad=1.4084e-12 pd=5.5900e-06 as=3.0180e-12 ps=1.1260e-05 nf=1 m=2 par=2
X23 a_2807_5940.t0 a_4401_5940.t0 vss.t8 ppolyf_u_1k r_width=1u r_length=7.31u
X33 a_4401_5940.t1 out.t0 cap_mim_2f0fF c_width=15u c_length=15u
Rpar0 a_1055_8351.t0 a_1055_8351.t36 48.0695
Rpar1 a_2807_5940.t0 a_2807_5940.t1 740.4940
Rpar2 a_2807_5940.t0 a_2807_5940.t19 330.9898
Rpar3 a_2807_5940.t0 a_2807_5940.t27 76.9284
Rpar4 a_2807_5940.t0 a_2807_5940.t28 161.6036
Rpar5 a_2807_5940.t1 a_2807_5940.t19 72.2689
Rpar6 a_2807_5940.t1 a_2807_5940.t27 352.6354
Rpar7 a_2807_5940.t1 a_2807_5940.t28 817.2096
Rpar8 a_2807_5940.t19 a_2807_5940.t27 157.6228
Rpar9 a_2807_5940.t19 a_2807_5940.t28 365.2806
Rpar10 a_2807_5940.t27 a_2807_5940.t28 84.8982
Rpar11 a_3874_8440.t0 a_3874_8440.t16 59.5994
Rpar12 a_4401_5940.t0 a_4401_5940.t1 76.5269
Rpar13 a_905_8143.t0 a_905_8143.t16 61.6069
Rpar14 a_905_8143.t0 a_905_8143.t26 254.5812
Rpar15 a_905_8143.t0 a_905_8143.t27 261.0236
Rpar16 a_905_8143.t16 a_905_8143.t26 148.4780
Rpar17 a_905_8143.t16 a_905_8143.t27 152.2354
Rpar18 a_905_8143.t26 a_905_8143.t27 35.8693
Rpar19 ib ib.t0 14.9110
Rpar20 ib ib.t1 8.1492
Rpar21 ib.t0 ib.t1 23.6348
Rpar22 inn inn.t0 2.1171
Rpar23 inn inn.t8 33.5101
Rpar24 inp inp.t0 2.1657
Rpar25 inp inp.t8 33.4615
Rpar26 out out.t0 251.5377
Rpar27 out out.t1 228.2994
Rpar28 out out.t8 2.8791
Rpar29 out.t0 out.t1 200.0914
Rpar30 out.t0 out.t8 159.5444
Rpar31 out.t1 out.t8 144.8048
Rpar32 vdd vdd.t0 28.5188
Rpar33 vdd vdd.t18 203.9894
Rpar34 vdd vdd.t19 167.8789
Rpar35 vdd.t0 vdd.t18 114.8853
Rpar36 vdd.t0 vdd.t19 94.5481
Rpar37 vdd.t18 vdd.t19 3.3094
Rpar38 vss vss.t0 52.9762
Rpar39 vss vss.t17 402.6780
Rpar40 vss vss.t18 60.5446
Rpar41 vss vss.t8 451.4822
Rpar42 vss.t0 vss.t17 46.8705
Rpar43 vss.t0 vss.t18 51.8530
Rpar44 vss.t0 vss.t8 10.0589
Rpar45 vss.t17 vss.t18 13.3146
Rpar46 vss.t17 vss.t8 1052.0539
Rpar47 vss.t18 vss.t8 490.9086
Cpar0 a_1055_8351.t0 vss 2.60593e-14
Cpar1 a_1055_8351.t36 vss 3.50931e-15
Cpar2 a_2807_5940.t0 vss 2.90394e-15
Cpar3 a_2807_5940.t1 vss 1.36715e-14
Cpar4 a_2807_5940.t19 vss 5.39627e-15
Cpar5 a_2807_5940.t27 vss 5.26882e-15
Cpar6 a_2807_5940.t28 vss 1.29759e-14
Cpar7 a_3874_8440.t0 vss 7.92083e-15
Cpar8 a_3874_8440.t16 vss 1.29701e-14
Cpar9 a_4401_5940.t0 vss 1.36370e-16
Cpar10 a_4401_5940.t1 vss 3.88871e-15
Cpar11 a_905_8143.t0 vss 1.49062e-14
Cpar12 a_905_8143.t16 vss 6.91618e-15
Cpar13 a_905_8143.t26 vss 7.00014e-15
Cpar14 a_905_8143.t27 vss 5.98072e-15
Cpar15 ib out 3.22314e-15
Cpar16 ib vdd 4.89500e-17
Cpar17 ib vss 2.66957e-14
Cpar18 ib.t0 vss 5.84745e-15
Cpar19 ib.t1 vss 9.85546e-16
Cpar20 inn inp 1.56400e-16
Cpar21 inn vdd 1.23302e-14
Cpar22 inn vss 1.04843e-14
Cpar23 inn.t0 vss 3.17984e-15
Cpar24 inn.t8 vss 1.47962e-14
Cpar25 inp vdd 1.29799e-14
Cpar26 inp vss 1.03733e-14
Cpar27 inp.t0 vss 3.43810e-15
Cpar28 inp.t8 vss 1.57544e-14
Cpar29 out vdd 1.00143e-14
Cpar30 out vss 2.01886e-14
Cpar31 out.t0 vss 7.98540e-15
Cpar32 out.t1 vss 6.55764e-15
Cpar33 out.t8 vss 5.76247e-15
Cpar34 vdd vss 1.29143e-13
Cpar35 vdd.t0 vss 3.49377e-14
Cpar36 vdd.t18 vss 1.54642e-14
Cpar37 vdd.t19 vss 1.32521e-14
.ends opamp_dut

Vdd vdd 0 1.800000
Vss vss 0 0
Ibias vdd ib 3.285700e-06
Vinp inp 0 DC 0.895000 AC 1 PWL(0 0.895000 3.759724e-09 0.895000 4.135696e-09 0.905000)
Rfb out inn 1m
Cload out 0 2.000000e-13
Xdut vdd vss inp inn out ib opamp_dut
.end
