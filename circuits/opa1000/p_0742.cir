* opa1000[0742]: 2p/rail_to_rail_3v3_i10u_weak (rail_to_rail, VDD=3.3V, CL=2.0pF, Iref=1.3125uA)
.include "pdk_opa.inc"
.temp 27
.option gmin=1e-12 rshunt=1e12 reltol=1e-3 abstol=1e-12 vntol=1e-5 method=gear
* Post-PEX R+C extracted netlist for rail_to_rail_3v3_i10u_weak
.subckt opamp_dut vdd vss inp inn out ib
XMpar0 a_3283_1249.t4 ib.t0 vss.t18 vss.t17 nfet_03v3 w=0.85u l=1.5u ad=5.1000e-13 pd=2.9000e-06 as=2.3800e-13 ps=1.4100e-06 nf=1 m=2 par=2
XMpar1 out.t9 ib.t0 vss.t18 vss.t17 nfet_03v3 w=0.85u l=1.5u ad=2.3800e-13 pd=1.4100e-06 as=4.4200e-13 ps=2.5275e-06 nf=1 m=8 par=8
XMpar2 a_1097_8126.t1 inn.t2 a_7264_5970.t0 vdd.t2 pfet_03v3 w=1.69u l=1.04u ad=7.4360e-13 pd=3.4150e-06 as=4.7320e-13 ps=2.2500e-06 nf=1 m=4 par=4
XMpar3 a_1217_7918.t4 ib.t0 vss.t18 vss.t17 nfet_03v3 w=0.85u l=1.5u ad=5.1000e-13 pd=2.9000e-06 as=2.3800e-13 ps=1.4100e-06 nf=1 m=2 par=2
XMpar4 a_6586_9357.t5 a_6586_9357.t4 vss.t3 vss.t0 nfet_03v3 w=0.4u l=1.17u ad=2.4000e-13 pd=2.0000e-06 as=1.1200e-13 ps=9.6000e-07 nf=1 m=2 par=2
XMpar5 a_7432_12523.t6 a_6586_9357.t4 vss.t3 vss.t0 nfet_03v3 w=0.4u l=1.17u ad=1.1200e-13 pd=9.6000e-07 as=1.1200e-13 ps=9.6000e-07 nf=1 m=2 par=2
XMpar6 a_1097_8126.t1 inp.t2 a_6586_9357.t0 vdd.t2 pfet_03v3 w=1.69u l=1.04u ad=7.4360e-13 pd=3.4150e-06 as=4.7320e-13 ps=2.2500e-06 nf=1 m=4 par=4
XMpar7 a_1071_6015.t1 inp.t0 a_3283_1249.t0 vss.t0 nfet_03v3 w=0.71u l=1.04u ad=1.9880e-13 pd=1.2700e-06 as=4.2600e-13 ps=2.6200e-06 nf=1 m=2 par=2
XMpar8 out.t2 a_1071_6015.t7 vdd.t9 vdd.t8 pfet_03v3 w=2.64u l=0.75u ad=7.3920e-13 pd=3.2000e-06 as=9.5040e-13 ps=4.0200e-06 nf=1 m=8 par=8
XMpar9 a_7432_12523.t3 a_7432_12523.t2 vdd.t9 vdd.t8 pfet_03v3 w=2.64u l=0.75u ad=7.3920e-13 pd=3.2000e-06 as=7.3920e-13 ps=3.2000e-06 nf=1 m=2 par=2
XMpar10 a_1071_6015.t0 a_7432_12523.t2 vdd.t9 vdd.t8 pfet_03v3 w=2.64u l=0.75u ad=1.5840e-12 pd=6.4800e-06 as=7.3920e-13 ps=3.2000e-06 nf=1 m=2 par=2
XMpar11 a_1071_6015.t4 a_7264_5970.t4 vss.t3 vss.t0 nfet_03v3 w=0.4u l=1.17u ad=2.4000e-13 pd=2.0000e-06 as=1.1200e-13 ps=9.6000e-07 nf=1 m=2 par=2
XMpar12 ib.t1 ib.t0 vss.t18 vss.t17 nfet_03v3 w=0.85u l=1.5u ad=5.1000e-13 pd=2.9000e-06 as=2.3800e-13 ps=1.4100e-06 nf=1 m=2 par=2
XMpar13 a_1097_8126.t0 a_1217_7918.t0 vdd.t1 vdd.t0 pfet_03v3 w=3.7u l=1.5u ad=2.2200e-12 pd=8.6000e-06 as=1.0360e-12 ps=4.2600e-06 nf=1 m=2 par=2
XMpar14 a_7264_5970.t5 a_7264_5970.t4 vss.t3 vss.t0 nfet_03v3 w=0.4u l=1.17u ad=1.1200e-13 pd=9.6000e-07 as=1.1200e-13 ps=9.6000e-07 nf=1 m=2 par=2
XMpar15 a_1217_7918.t1 a_1217_7918.t0 vdd.t1 vdd.t0 pfet_03v3 w=3.7u l=1.5u ad=1.0360e-12 pd=4.2600e-06 as=1.0360e-12 ps=4.2600e-06 nf=1 m=2 par=2
XMpar16 a_3283_1249.t0 inn.t0 a_7432_12523.t0 vss.t0 nfet_03v3 w=0.71u l=1.04u ad=4.2600e-13 pd=2.6200e-06 as=1.9880e-13 ps=1.2700e-06 nf=1 m=2 par=2
X14 a_13669_6264.t1 out.t0 cap_mim_2f0fF c_width=16.62u c_length=16.62u
X32 a_1071_6015.t3 a_13669_6264.t0 vss.t16 ppolyf_u_1k r_width=1u r_length=17.74u
X45 a_13669_6264.t1 out.t0 cap_mim_2f0fF c_width=16.62u c_length=16.62u
Rpar0 a_1071_6015.t0 a_1071_6015.t1 146.5029
Rpar1 a_1071_6015.t0 a_1071_6015.t7 465.4114
Rpar2 a_1071_6015.t0 a_1071_6015.t3 149.4045
Rpar3 a_1071_6015.t0 a_1071_6015.t4 323.9305
Rpar4 a_1071_6015.t1 a_1071_6015.t7 196.4722
Rpar5 a_1071_6015.t1 a_1071_6015.t3 108.4701
Rpar6 a_1071_6015.t1 a_1071_6015.t4 136.7464
Rpar7 a_1071_6015.t7 a_1071_6015.t3 344.5884
Rpar8 a_1071_6015.t7 a_1071_6015.t4 82.9355
Rpar9 a_1071_6015.t3 a_1071_6015.t4 239.8366
Rpar10 a_1097_8126.t0 a_1097_8126.t1 46.2719
Rpar11 a_1217_7918.t0 a_1217_7918.t1 24.3086
Rpar12 a_1217_7918.t0 a_1217_7918.t4 171.2867
Rpar13 a_1217_7918.t1 a_1217_7918.t4 86.9460
Rpar14 a_13669_6264.t0 a_13669_6264.t1 58.3512
Rpar15 a_3283_1249.t0 a_3283_1249.t4 78.7083
Rpar16 a_6586_9357.t0 a_6586_9357.t4 124.5380
Rpar17 a_6586_9357.t0 a_6586_9357.t5 79.2629
Rpar18 a_6586_9357.t4 a_6586_9357.t5 23.1234
Rpar19 a_7264_5970.t0 a_7264_5970.t4 126.0991
Rpar20 a_7264_5970.t0 a_7264_5970.t5 123.7496
Rpar21 a_7264_5970.t4 a_7264_5970.t5 30.6130
Rpar22 a_7432_12523.t0 a_7432_12523.t2 528.0536
Rpar23 a_7432_12523.t0 a_7432_12523.t3 190.4131
Rpar24 a_7432_12523.t0 a_7432_12523.t6 126.9718
Rpar25 a_7432_12523.t2 a_7432_12523.t3 29.4722
Rpar26 a_7432_12523.t2 a_7432_12523.t6 229.1383
Rpar27 a_7432_12523.t3 a_7432_12523.t6 82.6260
Rpar28 ib ib.t0 12.4797
Rpar29 ib ib.t1 12.3129
Rpar30 ib.t0 ib.t1 30.4664
Rpar31 inn inn.t0 8.7909
Rpar32 inn inn.t2 44.1031
Rpar33 inp inp.t0 8.8395
Rpar34 inp inp.t2 43.5433
Rpar35 out out.t0 125.6169
Rpar36 out out.t9 7.3866
Rpar37 out out.t2 104.9938
Rpar38 out.t0 out.t9 160.8284
Rpar39 out.t0 out.t2 196.4995
Rpar40 out.t9 out.t2 134.4244
Rpar41 vdd vdd.t0 1511.6121
Rpar42 vdd vdd.t1 2589.3923
Rpar43 vdd vdd.t8 75.0777
Rpar44 vdd vdd.t9 105.8018
Rpar45 vdd vdd.t2 129.6275
Rpar46 vdd.t0 vdd.t1 8.7866
Rpar47 vdd.t0 vdd.t8 287.2682
Rpar48 vdd.t0 vdd.t9 408.2540
Rpar49 vdd.t0 vdd.t2 125.6867
Rpar50 vdd.t1 vdd.t8 492.0906
Rpar51 vdd.t1 vdd.t9 699.3393
Rpar52 vdd.t1 vdd.t2 215.3013
Rpar53 vdd.t8 vdd.t9 3.7676
Rpar54 vdd.t8 vdd.t2 87.1679
Rpar55 vdd.t9 vdd.t2 123.2926
Rpar56 vss vss.t0 287.0952
Rpar57 vss vss.t3 417.9233
Rpar58 vss vss.t16 3518.1469
Rpar59 vss vss.t17 686.0483
Rpar60 vss vss.t18 56.6289
Rpar61 vss.t0 vss.t3 5.9359
Rpar62 vss.t0 vss.t16 35.6695
Rpar63 vss.t0 vss.t17 362.8235
Rpar64 vss.t0 vss.t18 201.3794
Rpar65 vss.t3 vss.t16 277.7856
Rpar66 vss.t3 vss.t17 1758.4669
Rpar67 vss.t3 vss.t18 307.6373
Rpar68 vss.t16 vss.t18 2567.4366
Rpar69 vss.t17 vss.t18 12.4330
Cpar0 a_1071_6015.t0 vss 3.90366e-15
Cpar1 a_1071_6015.t1 vss 2.52574e-15
Cpar2 a_1071_6015.t3 vss 3.44385e-15
Cpar3 a_1071_6015.t4 vss 2.84727e-15
Cpar4 a_1071_6015.t7 vss 6.34970e-15
Cpar5 a_1097_8126.t0 vss 5.92341e-15
Cpar6 a_1097_8126.t1 vss 5.03817e-15
Cpar7 a_1217_7918.t0 vss 5.48579e-15
Cpar8 a_1217_7918.t1 vss 3.11279e-15
Cpar9 a_1217_7918.t4 vss 5.36009e-15
Cpar10 a_13669_6264.t0 vss 8.43275e-17
Cpar11 a_13669_6264.t1 vss 4.63190e-15
Cpar12 a_3283_1249.t0 vss 5.55114e-15
Cpar13 a_3283_1249.t4 vss 7.96951e-15
Cpar14 a_6586_9357.t0 vss 1.88992e-15
Cpar15 a_6586_9357.t4 vss 2.56800e-15
Cpar16 a_6586_9357.t5 vss 1.32338e-15
Cpar17 a_7264_5970.t0 vss 2.12499e-15
Cpar18 a_7264_5970.t4 vss 2.61458e-15
Cpar19 a_7264_5970.t5 vss 1.09347e-15
Cpar20 a_7432_12523.t0 vss 2.02314e-15
Cpar21 a_7432_12523.t2 vss 2.92044e-15
Cpar22 a_7432_12523.t3 vss 2.79986e-15
Cpar23 a_7432_12523.t6 vss 1.86597e-15
Cpar24 ib out 1.82402e-15
Cpar25 ib vss 2.05230e-14
Cpar26 ib.t0 vss 7.00568e-15
Cpar27 ib.t1 vss 8.89548e-16
Cpar28 inn inp 1.07530e-16
Cpar29 inn vdd 2.79271e-15
Cpar30 inn vss 4.26572e-15
Cpar31 inn.t0 vss 4.71078e-16
Cpar32 inn.t2 vss 3.69301e-15
Cpar33 inp vdd 2.81739e-15
Cpar34 inp vss 4.13488e-15
Cpar35 inp.t0 vss 4.79817e-16
Cpar36 inp.t2 vss 3.61429e-15
Cpar37 out vdd 6.32853e-15
Cpar38 out vss 1.94336e-14
Cpar39 out.t0 vss 1.19596e-14
Cpar40 out.t2 vss 2.72592e-15
Cpar41 out.t9 vss 1.87429e-15
Cpar42 vdd vss 8.16720e-14
Cpar43 vdd.t0 vss 6.12578e-15
Cpar44 vdd.t1 vss 3.28126e-15
Cpar45 vdd.t2 vss 9.75511e-15
Cpar46 vdd.t8 vss 9.40618e-15
Cpar47 vdd.t9 vss 6.46326e-15
.ends opamp_dut

Vdd vdd 0 3.300000
Vss vss 0 0
Ibias vdd ib 1.312500e-06
Vinp inp 0 DC 1.645000 AC 1 PWL(0 1.645000 3.462014e-08 1.645000 3.808215e-08 1.655000)
Rfb out inn 1m
Cload out 0 2.000000e-12
Xdut vdd vss inp inn out ib opamp_dut
.end
