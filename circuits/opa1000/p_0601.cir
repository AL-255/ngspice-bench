* opa1000[0601]: 200f/pmos_miller_1v8_10u_100u_subth (pmos_miller, VDD=1.8V, CL=0.2pF, Iref=4.375uA)
.include "pdk_opa.inc"
.temp 27
.option gmin=1e-12 rshunt=1e12 reltol=1e-3 abstol=1e-12 vntol=1e-5 method=gear
* Post-PEX R+C extracted netlist for pmos_miller_1v8_10u_100u_subth
.subckt opamp_dut vdd vss inp inn out ib
XMpar0 a_2358_1249.t2 inp.t0 a_954_6658.t0 vdd.t14 pfet_03v3 w=1.94u l=0.28u ad=8.7559e-13 pd=2.9720e-06 as=8.7559e-13 ps=2.9720e-06 nf=1 m=30 par=30
XMpar1 a_2358_1249.t2 inn.t0 a_5720_3943.t0 vdd.t14 pfet_03v3 w=1.94u l=0.28u ad=8.7559e-13 pd=2.9720e-06 as=8.7559e-13 ps=2.9720e-06 nf=1 m=30 par=30
XMpar2 out.t3 a_4802_6570.t2 vdd.t1 vdd.t0 pfet_03v3 w=10u l=0.6u ad=3.4400e-12 pd=1.2688e-05 as=2.8000e-12 ps=1.0560e-05 nf=1 m=10 par=10
XMpar3 a_954_6658.t31 a_5720_3943.t30 vss.t1 vss.t0 nfet_03v3 w=5.23u l=0.63u ad=3.1380e-12 pd=1.1660e-05 as=1.4644e-12 ps=5.7900e-06 nf=1 m=2 par=2
XMpar4 a_4802_6570.t0 ib.t0 vss.t7 vss.t6 nfet_03v3 w=2.96u l=0.6u ad=8.2880e-13 pd=3.5200e-06 as=8.2880e-13 ps=3.5200e-06 nf=1 m=2 par=2
XMpar5 a_2358_1249.t0 a_4802_6570.t2 vdd.t1 vdd.t0 pfet_03v3 w=10u l=0.6u ad=2.8000e-12 pd=1.0560e-05 as=2.8000e-12 ps=1.0560e-05 nf=1 m=4 par=4
XMpar6 ib.t1 ib.t0 vss.t7 vss.t6 nfet_03v3 w=2.96u l=0.6u ad=1.7760e-12 pd=7.1200e-06 as=8.2880e-13 ps=3.5200e-06 nf=1 m=2 par=2
XMpar7 out.t0 a_954_6658.t33 vss.t1 vss.t0 nfet_03v3 w=5.23u l=0.63u ad=1.4644e-12 pd=5.7900e-06 as=1.7991e-12 ps=6.9640e-06 nf=1 m=10 par=10
XMpar8 a_5720_3943.t31 a_5720_3943.t30 vss.t1 vss.t0 nfet_03v3 w=5.23u l=0.63u ad=1.4644e-12 pd=5.7900e-06 as=1.4644e-12 ps=5.7900e-06 nf=1 m=2 par=2
XMpar9 a_4802_6570.t3 a_4802_6570.t2 vdd.t1 vdd.t0 pfet_03v3 w=10u l=0.6u ad=2.8000e-12 pd=1.0560e-05 as=2.8000e-12 ps=1.0560e-05 nf=1 m=2 par=2
X6 a_954_6658.t30 a_1688_6658.t0 vss.t28 ppolyf_u_1k r_width=1u r_length=3.01u
X23 a_1688_6658.t1 out.t16 cap_mim_2f0fF c_width=11.46u c_length=11.46u
Rpar0 a_1688_6658.t0 a_1688_6658.t1 49.9541
Rpar1 a_2358_1249.t0 a_2358_1249.t2 61.8047
Rpar2 a_4802_6570.t0 a_4802_6570.t2 177.3327
Rpar3 a_4802_6570.t0 a_4802_6570.t3 85.0879
Rpar4 a_4802_6570.t2 a_4802_6570.t3 27.8000
Rpar5 a_5720_3943.t0 a_5720_3943.t30 257.1425
Rpar6 a_5720_3943.t0 a_5720_3943.t31 62.3255
Rpar7 a_5720_3943.t30 a_5720_3943.t31 34.8221
Rpar8 a_954_6658.t0 a_954_6658.t30 318.8860
Rpar9 a_954_6658.t0 a_954_6658.t31 440.2841
Rpar10 a_954_6658.t0 a_954_6658.t33 53.6472
Rpar11 a_954_6658.t30 a_954_6658.t31 85.3226
Rpar12 a_954_6658.t30 a_954_6658.t33 236.8276
Rpar13 a_954_6658.t31 a_954_6658.t33 326.9864
Rpar14 ib ib.t0 24.5511
Rpar15 ib ib.t1 3.8865
Rpar16 ib.t0 ib.t1 213.0714
Rpar17 inn inn.t0 3.2716
Rpar18 inp inp.t0 3.2716
Rpar19 out out.t0 60.5253
Rpar20 out out.t3 55.9233
Rpar21 out out.t16 20.0570
Rpar22 out.t0 out.t3 34.1614
Rpar23 out.t0 out.t16 934.8356
Rpar24 out.t3 out.t16 863.7564
Rpar25 vdd vdd.t0 39.5818
Rpar26 vdd vdd.t1 350.6425
Rpar27 vdd vdd.t14 160.9543
Rpar28 vdd.t0 vdd.t1 5.1214
Rpar29 vdd.t0 vdd.t14 94.9601
Rpar30 vdd.t1 vdd.t14 841.2219
Rpar31 vss vss.t0 86.6574
Rpar32 vss vss.t1 179.3365
Rpar33 vss vss.t6 1598.5705
Rpar34 vss vss.t7 2420.2217
Rpar35 vss vss.t28 2152.1486
Rpar36 vss.t0 vss.t1 3.7512
Rpar37 vss.t0 vss.t6 136.0115
Rpar38 vss.t0 vss.t7 205.9260
Rpar39 vss.t0 vss.t28 13.1458
Rpar40 vss.t1 vss.t6 156.6267
Rpar41 vss.t1 vss.t7 237.1380
Rpar42 vss.t1 vss.t28 96.6695
Rpar43 vss.t6 vss.t7 9.4349
Cpar0 a_1688_6658.t0 vss 2.07910e-16
Cpar1 a_1688_6658.t1 vss 4.32081e-15
Cpar2 a_2358_1249.t0 vss 1.23910e-14
Cpar3 a_2358_1249.t2 vss 3.80580e-14
Cpar4 a_4802_6570.t0 vss 3.15063e-15
Cpar5 a_4802_6570.t2 vss 1.77647e-14
Cpar6 a_4802_6570.t3 vss 6.27358e-15
Cpar7 a_5720_3943.t0 vss 1.83058e-14
Cpar8 a_5720_3943.t30 vss 3.78707e-15
Cpar9 a_5720_3943.t31 vss 4.44231e-15
Cpar10 a_954_6658.t0 vss 1.43203e-14
Cpar11 a_954_6658.t30 vss 3.19694e-15
Cpar12 a_954_6658.t31 vss 5.37592e-15
Cpar13 a_954_6658.t33 vss 8.99450e-15
Cpar14 ib vdd 7.88400e-17
Cpar15 ib vss 6.05849e-15
Cpar16 ib.t0 vss 3.93853e-16
Cpar17 ib.t1 vss 2.92776e-16
Cpar18 inn inp 1.01430e-16
Cpar19 inn vdd 1.22934e-14
Cpar20 inn vss 7.69150e-15
Cpar21 inn.t0 vss 1.09171e-14
Cpar22 inp vdd 1.22819e-14
Cpar23 inp vss 7.71584e-15
Cpar24 inp.t0 vss 1.08921e-14
Cpar25 out vdd 1.79050e-14
Cpar26 out vss 1.58317e-14
Cpar27 out.t0 vss 6.83270e-15
Cpar28 out.t16 vss 6.03585e-15
Cpar29 out.t3 vss 1.39472e-14
Cpar30 vdd vss 1.44563e-13
Cpar31 vdd.t0 vss 2.56211e-14
Cpar32 vdd.t1 vss 1.01992e-14
Cpar33 vdd.t14 vss 4.18817e-14
.ends opamp_dut

Vdd vdd 0 1.800000
Vss vss 0 0
Ibias vdd ib 4.375000e-06
Vinp inp 0 DC 0.805000 AC 1 PWL(0 0.805000 3.000000e-09 0.805000 3.300000e-09 0.815000)
Rfb out inn 1m
Cload out 0 2.000000e-13
Xdut vdd vss inp inn out ib opamp_dut
.end
