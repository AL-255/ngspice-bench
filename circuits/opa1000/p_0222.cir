* opa1000[0222]: 2p/folded_cascode_nmos_1v8_i10u_subth (folded_cascode_nmos, VDD=1.8V, CL=2.0pF, Iref=2.8889uA)
.include "pdk_opa.inc"
.temp 27
.option gmin=1e-12 rshunt=1e12 reltol=1e-3 abstol=1e-12 vntol=1e-5 method=gear
* Post-PEX R+C extracted netlist for folded_cascode_nmos_1v8_i10u_subth
.subckt opamp_dut vdd vss inp inn out ib
XMpar0 a_3058_9620.t22 ib a_3366_9620.t4 vdd.t8 pfet_03v3 w=2.28u l=0.94u ad=7.2960e-13 pd=3.2050e-06 as=6.3840e-13 ps=2.8400e-06 nf=1 m=64 par=64
XMpar1 ib.t1 ib.t0 vss.t19 vss.t18 nfet_03v3 w=7.33u l=1.88u ad=4.3980e-12 pd=1.5860e-05 as=2.0524e-12 ps=7.8900e-06 nf=1 m=2 par=2
XMpar2 a_2338_1294.t0 inn.t0 a_8174_9620.t68 vss.t0 nfet_03v3 w=1.84u l=0.72u ad=5.8062e-13 pd=2.6756e-06 as=5.1520e-13 ps=2.4000e-06 nf=1 m=18 par=18
XMpar3 a_8174_9620.t4 ib out.t0 vdd.t8 pfet_03v3 w=2.28u l=0.94u ad=7.2960e-13 pd=3.2050e-06 as=6.3840e-13 ps=2.8400e-06 nf=1 m=64 par=64
XMpar4 a_2338_1294.t0 inp.t0 a_3058_9620.t0 vss.t0 nfet_03v3 w=1.84u l=0.72u ad=5.8062e-13 pd=2.6756e-06 as=5.1520e-13 ps=2.4000e-06 nf=1 m=18 par=18
XMpar5 a_3366_9620.t1 a_3366_9620.t0 vss.t19 vss.t18 nfet_03v3 w=7.33u l=1.88u ad=4.3980e-12 pd=1.5860e-05 as=2.0524e-12 ps=7.8900e-06 nf=1 m=2 par=2
XMpar6 a_3058_9620.t18 a_3314_1294.t0 vdd.t1 vdd.t0 pfet_03v3 w=10u l=1.8u ad=2.8000e-12 pd=1.0560e-05 as=4.4000e-12 ps=1.5880e-05 nf=1 m=4 par=4
XMpar7 a_8174_9620.t0 a_3314_1294.t0 vdd.t1 vdd.t0 pfet_03v3 w=10u l=1.8u ad=2.8000e-12 pd=1.0560e-05 as=4.4000e-12 ps=1.5880e-05 nf=1 m=4 par=4
XMpar8 a_2338_1294.t18 ib.t0 vss.t19 vss.t18 nfet_03v3 w=7.33u l=1.88u ad=2.0524e-12 pd=7.8900e-06 as=2.0524e-12 ps=7.8900e-06 nf=1 m=4 par=4
XMpar9 a_3314_1294.t1 a_3314_1294.t0 vdd.t1 vdd.t0 pfet_03v3 w=10u l=1.8u ad=2.8000e-12 pd=1.0560e-05 as=6.0000e-12 ps=2.1200e-05 nf=1 m=2 par=2
XMpar10 out.t24 a_3366_9620.t0 vss.t19 vss.t18 nfet_03v3 w=7.33u l=1.88u ad=2.0524e-12 pd=7.8900e-06 as=2.0524e-12 ps=7.8900e-06 nf=1 m=2 par=2
XMpar11 a_3314_1294.t4 ib.t0 vss.t19 vss.t18 nfet_03v3 w=7.33u l=1.88u ad=2.0524e-12 pd=7.8900e-06 as=2.0524e-12 ps=7.8900e-06 nf=1 m=2 par=2
Rpar0 a_2338_1294.t0 a_2338_1294.t18 47.5121
Rpar1 a_3058_9620.t0 a_3058_9620.t18 50.0554
Rpar2 a_3058_9620.t0 a_3058_9620.t22 68.1431
Rpar3 a_3058_9620.t18 a_3058_9620.t22 115.9604
Rpar4 a_3314_1294.t0 a_3314_1294.t1 22.7453
Rpar5 a_3314_1294.t0 a_3314_1294.t4 195.8829
Rpar6 a_3314_1294.t1 a_3314_1294.t4 205.0820
Rpar7 a_3366_9620.t0 a_3366_9620.t1 20.9345
Rpar8 a_3366_9620.t0 a_3366_9620.t4 318.3554
Rpar9 a_3366_9620.t1 a_3366_9620.t4 67.3107
Rpar10 a_8174_9620.t0 a_8174_9620.t4 115.9604
Rpar11 a_8174_9620.t0 a_8174_9620.t68 50.0554
Rpar12 a_8174_9620.t4 a_8174_9620.t68 68.1431
Rpar13 ib ib.t0 276.6159
Rpar14 ib ib.t1 75.5591
Rpar15 ib.t0 ib.t1 18.4672
Rpar16 inn inn.t0 1.8417
Rpar17 inp inp.t0 1.8903
Rpar18 out out.t0 2.2356
Rpar19 out out.t24 69.6362
Rpar20 vdd vdd.t0 306.4775
Rpar21 vdd vdd.t1 258.4715
Rpar22 vdd vdd.t8 21.1971
Rpar23 vdd.t0 vdd.t1 3.9408
Rpar24 vdd.t0 vdd.t8 111.8135
Rpar25 vdd.t1 vdd.t8 94.2993
Rpar26 vss vss.t0 45.3253
Rpar27 vss vss.t18 153.4051
Rpar28 vss vss.t19 228.1924
Rpar29 vss.t0 vss.t18 1.7066
Rpar30 vss.t0 vss.t19 4.1994
Rpar31 vss.t18 vss.t19 12.9050
Cpar0 a_2338_1294.t0 vss 1.72726e-14
Cpar1 a_2338_1294.t18 vss 7.90754e-15
Cpar2 a_3058_9620.t0 vss 1.15123e-14
Cpar3 a_3058_9620.t18 vss 9.60978e-15
Cpar4 a_3058_9620.t22 vss 4.07574e-14
Cpar5 a_3314_1294.t0 vss 2.05397e-14
Cpar6 a_3314_1294.t1 vss 4.01480e-15
Cpar7 a_3314_1294.t4 vss 3.47614e-15
Cpar8 a_3366_9620.t0 vss 1.18405e-14
Cpar9 a_3366_9620.t1 vss 9.21600e-15
Cpar10 a_3366_9620.t4 vss 3.45845e-14
Cpar11 a_8174_9620.t0 vss 9.70683e-15
Cpar12 a_8174_9620.t4 vss 4.11689e-14
Cpar13 a_8174_9620.t68 vss 1.16287e-14
Cpar14 ib inp 1.31900e-17
Cpar15 ib out 1.36086e-14
Cpar16 ib vdd 6.32899e-14
Cpar17 ib vss 1.09725e-13
Cpar18 ib.t0 vss 2.04580e-14
Cpar19 ib.t1 vss 7.96317e-15
Cpar20 inn inp 5.14200e-17
Cpar21 inn vdd 1.35700e-17
Cpar22 inn vss 1.15037e-14
Cpar23 inn.t0 vss 2.14446e-15
Cpar24 inp vss 1.14892e-14
Cpar25 inp.t0 vss 2.20406e-15
Cpar26 out vdd 9.28945e-15
Cpar27 out vss 1.52904e-14
Cpar28 out.t0 vss 3.68007e-14
Cpar29 out.t24 vss 8.92384e-15
Cpar30 vdd vss 2.67323e-13
Cpar31 vdd.t0 vss 2.27961e-14
Cpar32 vdd.t1 vss 1.36638e-14
Cpar33 vdd.t8 vss 7.66910e-14
.ends opamp_dut

Vdd vdd 0 1.800000
Vss vss 0 0
Ibias vdd ib 2.888900e-06
Vinp inp 0 DC 0.985000 AC 1 PWL(0 0.985000 2.116915e-08 0.985000 2.328607e-08 0.995000)
Rfb out inn 1m
Cload out 0 2.000000e-12
Xdut vdd vss inp inn out ib opamp_dut
.end
