* opa1000[0625]: 2p/pmos_miller_1v8_ulp_lt0p1uw_weak (pmos_miller, VDD=1.8V, CL=2.0pF, Iref=0.0026uA)
.include "pdk_opa.inc"
.temp 27
.option gmin=1e-12 rshunt=1e12 reltol=1e-3 abstol=1e-12 vntol=1e-5 method=gear
* Post-PEX R+C extracted netlist for pmos_miller_1v8_ulp_lt0p1uw_weak
.subckt opamp_dut vdd vss inp inn out ib
XMpar0 a_5118_1249.t0 inn.t0 a_6492_7034.t0 vdd.t0 pfet_03v3 w=0.4u l=9.5u ad=2.4000e-13 pd=2.0000e-06 as=2.4000e-13 ps=2.0000e-06 nf=1 m=2 par=2
XMpar1 out.t0 a_919_8899.t5 vss.t2 vss.t1 nfet_03v3 w=0.4u l=9.5u ad=1.3760e-13 pd=1.1680e-06 as=1.3760e-13 ps=1.1680e-06 nf=1 m=10 par=10
XMpar2 a_919_8899.t0 a_6492_7034.t2 vss.t2 vss.t1 nfet_03v3 w=0.4u l=9.5u ad=2.4000e-13 pd=2.0000e-06 as=1.1200e-13 ps=9.6000e-07 nf=1 m=2 par=2
XMpar3 a_1806_1041.t0 ib.t0 vss.t21 vss.t20 nfet_03v3 w=0.4u l=8u ad=2.4000e-13 pd=2.0000e-06 as=1.1200e-13 ps=9.6000e-07 nf=1 m=2 par=2
XMpar4 a_1806_1041.t3 a_1806_1041.t2 vdd.t2 vdd.t1 pfet_03v3 w=0.4u l=8u ad=2.4000e-13 pd=2.0000e-06 as=1.1200e-13 ps=9.6000e-07 nf=1 m=2 par=2
XMpar5 a_5118_1249.t0 inp.t0 a_919_8899.t2 vdd.t0 pfet_03v3 w=0.4u l=9.5u ad=2.4000e-13 pd=2.0000e-06 as=2.4000e-13 ps=2.0000e-06 nf=1 m=2 par=2
XMpar6 out.t1 a_1806_1041.t2 vdd.t2 vdd.t1 pfet_03v3 w=0.4u l=8u ad=1.8880e-13 pd=1.5840e-06 as=1.6320e-13 ps=1.3760e-06 nf=1 m=10 par=10
XMpar7 a_5118_1249.t4 a_1806_1041.t2 vdd.t2 vdd.t1 pfet_03v3 w=0.4u l=8u ad=2.4000e-13 pd=2.0000e-06 as=1.1200e-13 ps=9.6000e-07 nf=1 m=4 par=4
XMpar8 a_6492_7034.t3 a_6492_7034.t2 vss.t2 vss.t1 nfet_03v3 w=0.4u l=9.5u ad=1.1200e-13 pd=9.6000e-07 as=1.1200e-13 ps=9.6000e-07 nf=1 m=2 par=2
XMpar9 ib.t1 ib.t0 vss.t21 vss.t20 nfet_03v3 w=0.4u l=8u ad=2.4000e-13 pd=2.0000e-06 as=1.1200e-13 ps=9.6000e-07 nf=1 m=2 par=2
X1 a_919_14619.t0 a_4897_14099.t0 vss.t0 ppolyf_u_1k r_width=1u r_length=19.23u
X15 a_919_9419.t0 a_4897_9939.t0 vss.t0 ppolyf_u_1k r_width=1u r_length=19.23u
X17 a_4897_15139.t1 out.t10 cap_mim_2f0fF c_width=19.63u c_length=19.62u
X20 a_919_11499.t0 a_4897_10979.t0 vss.t0 ppolyf_u_1k r_width=1u r_length=19.23u
X21 a_919_9419.t0 a_4897_8899.t0 vss.t0 ppolyf_u_1k r_width=1u r_length=19.23u
X27 a_919_13579.t0 a_4897_14099.t0 vss.t0 ppolyf_u_1k r_width=1u r_length=19.23u
X28 a_919_10459.t0 a_4897_10979.t0 vss.t0 ppolyf_u_1k r_width=1u r_length=19.23u
X29 a_4897_15139.t1 out.t10 cap_mim_2f0fF c_width=19.63u c_length=19.62u
X31 a_919_13579.t0 a_4897_13059.t0 vss.t0 ppolyf_u_1k r_width=1u r_length=19.23u
X34 a_919_10459.t0 a_4897_9939.t0 vss.t0 ppolyf_u_1k r_width=1u r_length=19.23u
X35 a_4897_15139.t1 out.t10 cap_mim_2f0fF c_width=19.63u c_length=19.62u
X37 a_919_8899.t4 a_4897_8899.t0 vss.t0 ppolyf_u_1k r_width=1u r_length=19.23u
X41 a_919_12539.t0 a_4897_13059.t0 vss.t0 ppolyf_u_1k r_width=1u r_length=19.23u
X47 a_919_12539.t0 a_4897_12019.t0 vss.t0 ppolyf_u_1k r_width=1u r_length=19.23u
X50 a_4897_15139.t1 out.t10 cap_mim_2f0fF c_width=19.63u c_length=19.62u
X51 a_919_14619.t0 a_4897_15139.t0 vss.t0 ppolyf_u_1k r_width=1u r_length=19.23u
X53 a_919_11499.t0 a_4897_12019.t0 vss.t0 ppolyf_u_1k r_width=1u r_length=19.23u
Rpar0 a_1806_1041.t0 a_1806_1041.t2 153.4737
Rpar1 a_1806_1041.t0 a_1806_1041.t3 116.6174
Rpar2 a_1806_1041.t2 a_1806_1041.t3 18.9058
Rpar3 a_4897_15139.t0 a_4897_15139.t1 59.2375
Rpar4 a_5118_1249.t0 a_5118_1249.t4 81.4990
Rpar5 a_6492_7034.t0 a_6492_7034.t2 195.1778
Rpar6 a_6492_7034.t0 a_6492_7034.t3 167.3314
Rpar7 a_6492_7034.t2 a_6492_7034.t3 31.8326
Rpar8 a_919_8899.t0 a_919_8899.t5 88.9787
Rpar9 a_919_8899.t0 a_919_8899.t2 394.4965
Rpar10 a_919_8899.t0 a_919_8899.t4 155.7352
Rpar11 a_919_8899.t5 a_919_8899.t2 122.5854
Rpar12 a_919_8899.t5 a_919_8899.t4 48.3930
Rpar13 a_919_8899.t2 a_919_8899.t4 184.2854
Rpar14 ib ib.t0 15.9115
Rpar15 ib ib.t1 19.1082
Rpar16 ib.t0 ib.t1 24.3555
Rpar17 inn inn.t0 4.0671
Rpar18 inp inp.t0 4.0669
Rpar19 out out.t0 62.7414
Rpar20 out out.t1 195.6115
Rpar21 out out.t10 21.6435
Rpar22 out.t0 out.t1 88.4175
Rpar23 vdd vdd.t0 31.3955
Rpar24 vdd vdd.t1 136.4014
Rpar25 vdd vdd.t2 1455.6578
Rpar26 vdd.t0 vdd.t1 138.3628
Rpar27 vdd.t0 vdd.t2 1476.5900
Rpar28 vdd.t1 vdd.t2 13.0698
Rpar29 vss vss.t0 1331.9940
Rpar30 vss vss.t1 244.7264
Rpar31 vss vss.t2 252.3863
Rpar32 vss vss.t20 119.2568
Rpar33 vss vss.t21 734.7901
Rpar34 vss.t0 vss.t1 3.4944
Rpar35 vss.t0 vss.t2 38.2520
Rpar36 vss.t0 vss.t20 609.7663
Rpar37 vss.t1 vss.t2 6.6784
Rpar38 vss.t1 vss.t20 105.5419
Rpar39 vss.t1 vss.t21 693.5349
Rpar40 vss.t2 vss.t20 151.1931
Rpar41 vss.t2 vss.t21 941.3170
Rpar42 vss.t20 vss.t21 19.1829
Cpar0 a_1806_1041.t0 vss 1.17086e-14
Cpar1 a_1806_1041.t2 vss 7.92713e-14
Cpar2 a_1806_1041.t3 vss 1.37679e-14
Cpar3 a_4897_10979.t0 vss 3.89600e-17
Cpar4 a_4897_12019.t0 vss 3.89600e-17
Cpar5 a_4897_13059.t0 vss 3.74600e-17
Cpar6 a_4897_14099.t0 vss 4.28200e-17
Cpar7 a_4897_15139.t0 vss 8.66706e-17
Cpar8 a_4897_15139.t1 vss 1.20200e-14
Cpar9 a_4897_8899.t0 vss 3.72400e-17
Cpar10 a_4897_9939.t0 vss 3.97000e-17
Cpar11 a_5118_1249.t0 vss 2.05904e-14
Cpar12 a_5118_1249.t4 vss 3.56429e-14
Cpar13 a_6492_7034.t0 vss 3.89438e-15
Cpar14 a_6492_7034.t2 vss 8.13747e-15
Cpar15 a_6492_7034.t3 vss 2.55745e-15
Cpar16 a_919_10459.t0 vss 3.79000e-17
Cpar17 a_919_11499.t0 vss 3.79000e-17
Cpar18 a_919_12539.t0 vss 3.79000e-17
Cpar19 a_919_13579.t0 vss 3.86400e-17
Cpar20 a_919_14619.t0 vss 3.88400e-17
Cpar21 a_919_8899.t0 vss 2.42743e-15
Cpar22 a_919_8899.t2 vss 2.47964e-15
Cpar23 a_919_8899.t4 vss 2.01416e-15
Cpar24 a_919_8899.t5 vss 1.61300e-14
Cpar25 a_919_9419.t0 vss 4.05600e-17
Cpar26 ib out 2.38300e-17
Cpar27 ib vss 2.43057e-14
Cpar28 ib.t0 vss 3.75696e-15
Cpar29 ib.t1 vss 5.60405e-16
Cpar30 inn inp 1.03420e-16
Cpar31 inn out 3.44800e-17
Cpar32 inn vdd 8.02165e-15
Cpar33 inn vss 4.93928e-15
Cpar34 inn.t0 vss 5.89480e-15
Cpar35 inp out 3.42600e-17
Cpar36 inp vdd 8.04186e-15
Cpar37 inp vss 4.95131e-15
Cpar38 inp.t0 vss 5.90799e-15
Cpar39 out vdd 1.80784e-14
Cpar40 out vss 4.84294e-14
Cpar41 out.t0 vss 7.05726e-15
Cpar42 out.t1 vss 9.13224e-15
Cpar43 out.t10 vss 2.58944e-14
Cpar44 vdd vss 2.24995e-13
Cpar45 vdd.t0 vss 1.71061e-14
Cpar46 vdd.t1 vss 8.73857e-14
Cpar47 vdd.t2 vss 1.25105e-14
.ends opamp_dut

Vdd vdd 0 1.800000
Vss vss 0 0
Ibias vdd ib 2.600000e-09
Vinp inp 0 DC 0.805000 AC 1 PWL(0 0.805000 3.627188e-05 0.805000 3.989906e-05 0.815000)
Rfb out inn 1m
Cload out 0 2.000000e-12
Xdut vdd vss inp inn out ib opamp_dut
.end
