* opa1000[0486]: 2p/nmos_miller_3v3_i1u_subth (nmos_miller, VDD=3.3V, CL=2.0pF, Iref=0.1857uA)
.include "pdk_opa.inc"
.temp 27
.option gmin=1e-12 rshunt=1e12 reltol=1e-3 abstol=1e-12 vntol=1e-5 method=gear
* Post-PEX R+C extracted netlist for nmos_miller_3v3_i1u_subth
.subckt opamp_dut vdd vss inp inn out ib
XMpar0 a_6196_7266.t1 a_6196_7266.t0 vdd.t1 vdd.t0 pfet_03v3 w=3.96u l=1.44u ad=1.1088e-12 pd=4.5200e-06 as=1.1088e-12 ps=4.5200e-06 nf=1 m=2 par=2
XMpar1 out.t2 ib.t0 vss.t2 vss.t1 nfet_03v3 w=0.54u l=2.1u ad=2.5488e-13 pd=1.8080e-06 as=2.2032e-13 ps=1.5720e-06 nf=1 m=10 par=10
XMpar2 out.t0 a_1136_4165.t15 vdd.t1 vdd.t0 pfet_03v3 w=3.96u l=1.44u ad=1.3622e-12 pd=5.4400e-06 as=1.6157e-12 ps=6.3600e-06 nf=1 m=10 par=10
XMpar3 a_1136_4165.t0 inp.t0 a_4034_1249.t4 vss.t25 nfet_03v3 w=1.87u l=1.56u ad=5.2360e-13 pd=2.4300e-06 as=7.2307e-13 ps=3.2667e-06 nf=1 m=12 par=12
XMpar4 a_4034_1249.t4 inn.t0 a_6196_7266.t4 vss.t25 nfet_03v3 w=1.87u l=1.56u ad=7.2307e-13 pd=3.2667e-06 as=5.2360e-13 ps=2.4300e-06 nf=1 m=12 par=12
XMpar5 a_1136_4165.t12 a_6196_7266.t0 vdd.t1 vdd.t0 pfet_03v3 w=3.96u l=1.44u ad=2.3760e-12 pd=9.1200e-06 as=1.1088e-12 ps=4.5200e-06 nf=1 m=2 par=2
XMpar6 a_4034_1249.t0 ib.t0 vss.t2 vss.t1 nfet_03v3 w=0.54u l=2.1u ad=3.2400e-13 pd=2.2800e-06 as=1.5120e-13 ps=1.1000e-06 nf=1 m=4 par=4
XMpar7 ib.t1 ib.t0 vss.t2 vss.t1 nfet_03v3 w=0.54u l=2.1u ad=3.2400e-13 pd=2.2800e-06 as=1.5120e-13 ps=1.1000e-06 nf=1 m=2 par=2
X27 a_1136_4685.t0 a_4950_5205.t0 vss.t0 ppolyf_u_1k r_width=1u r_length=18.41u
X32 a_4950_5205.t1 out.t12 cap_mim_2f0fF c_width=16.58u c_length=16.59u
X50 a_4950_5205.t1 out.t12 cap_mim_2f0fF c_width=16.58u c_length=16.59u
X51 a_1136_4685.t0 a_4950_4165.t0 vss.t0 ppolyf_u_1k r_width=1u r_length=18.41u
X58 a_1136_4165.t14 a_4950_4165.t0 vss.t0 ppolyf_u_1k r_width=1u r_length=18.41u
Rpar0 a_1136_4165.t0 a_1136_4165.t12 212.4933
Rpar1 a_1136_4165.t0 a_1136_4165.t14 218.0318
Rpar2 a_1136_4165.t0 a_1136_4165.t15 341.9967
Rpar3 a_1136_4165.t12 a_1136_4165.t14 169.7467
Rpar4 a_1136_4165.t12 a_1136_4165.t15 78.0000
Rpar5 a_1136_4165.t14 a_1136_4165.t15 273.1982
Rpar6 a_4034_1249.t0 a_4034_1249.t4 65.6408
Rpar7 a_4950_5205.t0 a_4950_5205.t1 58.2573
Rpar8 a_6196_7266.t0 a_6196_7266.t1 23.9329
Rpar9 a_6196_7266.t0 a_6196_7266.t4 265.3479
Rpar10 a_6196_7266.t1 a_6196_7266.t4 106.4964
Rpar11 ib ib.t0 13.0945
Rpar12 ib ib.t1 13.2073
Rpar13 ib.t0 ib.t1 33.1993
Rpar14 inn inn.t0 2.3370
Rpar15 inp inp.t0 2.3370
Rpar16 out out.t0 3.0236
Rpar17 out out.t2 73.5402
Rpar18 out out.t12 61.4475
Rpar19 out.t2 out.t12 184.9294
Rpar20 vdd vdd.t0 90.7855
Rpar21 vdd vdd.t1 37.9597
Rpar22 vdd.t0 vdd.t1 5.2876
Rpar23 vss vss.t0 108.9890
Rpar24 vss vss.t1 70.6043
Rpar25 vss vss.t2 144.3682
Rpar26 vss vss.t25 28.6116
Rpar27 vss.t0 vss.t1 21.5037
Rpar28 vss.t0 vss.t2 112.4782
Rpar29 vss.t0 vss.t25 7.6483
Rpar30 vss.t1 vss.t2 32.6813
Rpar31 vss.t1 vss.t25 1.6725
Rpar32 vss.t2 vss.t25 18.1178
Cpar0 a_1136_4165.t0 vss 8.51029e-15
Cpar1 a_1136_4165.t12 vss 5.42824e-15
Cpar2 a_1136_4165.t14 vss 3.75297e-15
Cpar3 a_1136_4165.t15 vss 1.63731e-14
Cpar4 a_1136_4685.t0 vss 4.06400e-17
Cpar5 a_4034_1249.t0 vss 1.03839e-14
Cpar6 a_4034_1249.t4 vss 2.06497e-14
Cpar7 a_4950_4165.t0 vss 3.94000e-17
Cpar8 a_4950_5205.t0 vss 1.57795e-16
Cpar9 a_4950_5205.t1 vss 6.37557e-15
Cpar10 a_6196_7266.t0 vss 6.00610e-15
Cpar11 a_6196_7266.t1 vss 4.05916e-15
Cpar12 a_6196_7266.t4 vss 8.57761e-15
Cpar13 ib inn 1.45200e-17
Cpar14 ib out 2.18333e-15
Cpar15 ib vss 3.08896e-14
Cpar16 ib.t0 vss 5.72189e-15
Cpar17 ib.t1 vss 5.80405e-16
Cpar18 inn inp 1.02520e-16
Cpar19 inn vss 1.13983e-14
Cpar20 inn.t0 vss 3.91379e-15
Cpar21 inp vss 1.15425e-14
Cpar22 inp.t0 vss 3.90623e-15
Cpar23 out vdd 1.56631e-14
Cpar24 out vss 2.18654e-14
Cpar25 out.t0 vss 5.88540e-15
Cpar26 out.t12 vss 1.76038e-14
Cpar27 out.t2 vss 5.89948e-15
Cpar28 vdd vss 7.39613e-14
Cpar29 vdd.t0 vss 2.54456e-14
Cpar30 vdd.t1 vss 8.45487e-15
.ends opamp_dut

Vdd vdd 0 3.300000
Vss vss 0 0
Ibias vdd ib 1.857000e-07
Vinp inp 0 DC 1.645000 AC 1 PWL(0 1.645000 1.599927e-07 1.645000 1.759920e-07 1.655000)
Rfb out inn 1m
Cload out 0 2.000000e-12
Xdut vdd vss inp inn out ib opamp_dut
.end
