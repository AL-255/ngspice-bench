* opa1000[0934]: 200f/telescopic_pmos_1v8_10u_100u_subth (telescopic_pmos, VDD=1.8V, CL=0.2pF, Iref=8.5uA)
.include "pdk_opa.inc"
.temp 27
.option gmin=1e-12 rshunt=1e12 reltol=1e-3 abstol=1e-12 vntol=1e-5 method=gear
* Post-PEX R+C extracted netlist for telescopic_pmos_1v8_10u_100u_subth
.subckt opamp_dut vdd vss inp inn out ib
XMpar0 a_2002_11442.t64 vss.t122 a_2208_11442.t48 vdd.t0 pfet_03v3 w=2.64u l=0.28u ad=1.1880e-12 pd=3.7050e-06 as=1.1352e-12 ps=3.5000e-06 nf=1 m=64 par=64
XMpar1 a_9614_11442.t64 vss.t122 out.t0 vdd.t0 pfet_03v3 w=2.64u l=0.28u ad=1.1880e-12 pd=3.7050e-06 as=1.1352e-12 ps=3.5000e-06 nf=1 m=64 par=64
XMpar2 a_3474_1294.t0 inn.t0 a_9614_11442.t0 vdd.t26 pfet_03v3 w=8u l=0.35u ad=2.4000e-12 pd=9.1000e-06 as=2.2400e-12 ps=8.5600e-06 nf=1 m=64 par=64
XMpar3 a_2208_11442.t1 a_2208_11442.t0 a_3018_14669.t0 vss.t0 nfet_03v3 w=1.92u l=0.28u ad=9.2800e-13 pd=3.2067e-06 as=9.7920e-13 ps=3.4200e-06 nf=1 m=24 par=24
XMpar4 a_3978_14669.t0 a_2208_11442.t0 out.t8 vss.t0 nfet_03v3 w=1.92u l=0.28u ad=9.2800e-13 pd=3.2067e-06 as=9.2800e-13 ps=3.2067e-06 nf=1 m=24 par=24
XMpar5 a_9656_6710.t3 a_9656_6710.t2 vdd.t16 vdd.t15 pfet_03v3 w=10u l=0.8u ad=2.8000e-12 pd=1.0560e-05 as=2.8000e-12 ps=1.0560e-05 nf=1 m=2 par=2
XMpar6 a_2002_11442.t0 inp.t0 a_3474_1294.t0 vdd.t26 pfet_03v3 w=8u l=0.35u ad=2.2400e-12 pd=8.5600e-06 as=2.4000e-12 ps=9.1000e-06 nf=1 m=64 par=64
XMpar7 a_3018_14669.t3 a_2208_11442.t136 vss.t4 vss.t0 nfet_03v3 w=1.99u l=0.8u ad=5.5720e-13 pd=2.5500e-06 as=6.3680e-13 ps=2.8787e-06 nf=1 m=16 par=16
XMpar8 a_3978_14669.t2 a_2208_11442.t136 vss.t4 vss.t0 nfet_03v3 w=1.99u l=0.8u ad=5.5720e-13 pd=2.5500e-06 as=5.5720e-13 ps=2.5500e-06 nf=1 m=16 par=16
XMpar9 a_3474_1294.t64 a_9656_6710.t2 vdd.t16 vdd.t15 pfet_03v3 w=10u l=0.8u ad=2.8000e-12 pd=1.0560e-05 as=3.6000e-12 ps=1.3220e-05 nf=1 m=8 par=8
XMpar10 a_9656_6710.t0 ib.t0 vss.t52 vss.t51 nfet_03v3 w=7.91u l=0.8u ad=2.2148e-12 pd=8.4700e-06 as=2.2148e-12 ps=8.4700e-06 nf=1 m=2 par=2
XMpar11 ib.t1 ib.t0 vss.t52 vss.t51 nfet_03v3 w=7.91u l=0.8u ad=4.7460e-12 pd=1.7020e-05 as=2.2148e-12 ps=8.4700e-06 nf=1 m=2 par=2
X208 out.t88 vss.t47 cap_mim_2f0fF c_width=15.41u c_length=15.41u
X275 out.t88 vss.t47 cap_mim_2f0fF c_width=15.41u c_length=15.41u
Rpar0 a_2002_11442.t0 a_2002_11442.t64 48.8828
Rpar1 a_2208_11442.t0 a_2208_11442.t1 17.1926
Rpar2 a_2208_11442.t0 a_2208_11442.t48 361.1752
Rpar3 a_2208_11442.t0 a_2208_11442.t136 357.6999
Rpar4 a_2208_11442.t1 a_2208_11442.t48 81.3492
Rpar5 a_2208_11442.t1 a_2208_11442.t136 80.5664
Rpar6 a_2208_11442.t48 a_2208_11442.t136 70.1818
Rpar7 a_3018_14669.t0 a_3018_14669.t3 66.1009
Rpar8 a_3474_1294.t0 a_3474_1294.t64 62.8092
Rpar9 a_3978_14669.t0 a_3978_14669.t2 47.2143
Rpar10 a_9614_11442.t0 a_9614_11442.t64 48.8828
Rpar11 a_9656_6710.t0 a_9656_6710.t2 164.3190
Rpar12 a_9656_6710.t0 a_9656_6710.t3 71.2487
Rpar13 a_9656_6710.t2 a_9656_6710.t3 27.9151
Rpar14 ib ib.t0 29.1305
Rpar15 ib ib.t1 3.3515
Rpar16 ib.t0 ib.t1 182.7118
Rpar17 inn inn.t0 3.3111
Rpar18 inp inp.t0 3.3111
Rpar19 out out.t0 90.4532
Rpar20 out out.t8 256.9584
Rpar21 out out.t88 16.5808
Rpar22 out.t0 out.t8 51.7448
Rpar23 vdd vdd.t0 100.4314
Rpar24 vdd vdd.t26 218.2487
Rpar25 vdd vdd.t15 1504.8886
Rpar26 vdd vdd.t16 5290.4260
Rpar27 vdd.t0 vdd.t26 89.5859
Rpar28 vdd.t0 vdd.t15 617.7209
Rpar29 vdd.t0 vdd.t16 2171.5937
Rpar30 vdd.t26 vdd.t15 55.8004
Rpar31 vdd.t26 vdd.t16 196.1661
Rpar32 vdd.t15 vdd.t16 5.6587
Rpar33 vss vss.t0 261.7148
Rpar34 vss vss.t4 3784.1834
Rpar35 vss vss.t122 109.4355
Rpar36 vss vss.t47 124.5872
Rpar37 vss vss.t51 203.0921
Rpar38 vss vss.t52 304.4830
Rpar39 vss.t0 vss.t4 3.2030
Rpar40 vss.t0 vss.t122 78.0693
Rpar41 vss.t0 vss.t47 555.9900
Rpar42 vss.t0 vss.t51 858.0371
Rpar43 vss.t0 vss.t52 1286.3870
Rpar44 vss.t4 vss.t122 1128.6347
Rpar45 vss.t4 vss.t47 8040.5454
Rpar46 vss.t122 vss.t47 232.6795
Rpar47 vss.t122 vss.t51 379.1766
Rpar48 vss.t122 vss.t52 568.4752
Rpar49 vss.t47 vss.t51 229.1557
Rpar50 vss.t47 vss.t52 343.5585
Rpar51 vss.t51 vss.t52 10.1633
Cpar0 a_2002_11442.t0 vss 1.13637e-13
Cpar1 a_2002_11442.t64 vss 5.66259e-14
Cpar2 a_2208_11442.t0 vss 1.38828e-14
Cpar3 a_2208_11442.t1 vss 1.48743e-14
Cpar4 a_2208_11442.t136 vss 1.73714e-14
Cpar5 a_2208_11442.t48 vss 3.19823e-14
Cpar6 a_3018_14669.t0 vss 1.81512e-14
Cpar7 a_3018_14669.t3 vss 1.28818e-14
Cpar8 a_3474_1294.t0 vss 2.42799e-13
Cpar9 a_3474_1294.t64 vss 2.15460e-14
Cpar10 a_3978_14669.t0 vss 2.01903e-14
Cpar11 a_3978_14669.t2 vss 1.27384e-14
Cpar12 a_9614_11442.t0 vss 1.15884e-13
Cpar13 a_9614_11442.t64 vss 5.77455e-14
Cpar14 a_9656_6710.t0 vss 2.63510e-15
Cpar15 a_9656_6710.t2 vss 1.20486e-14
Cpar16 a_9656_6710.t3 vss 4.23790e-15
Cpar17 ib out 1.48800e-17
Cpar18 ib vdd 1.11660e-16
Cpar19 ib vss 9.20896e-15
Cpar20 ib.t0 vss 5.39488e-16
Cpar21 ib.t1 vss 4.77973e-16
Cpar22 inn inp 1.03940e-16
Cpar23 inn vdd 2.16693e-14
Cpar24 inn vss 1.16453e-14
Cpar25 inn.t0 vss 3.30004e-14
Cpar26 inp vdd 2.15709e-14
Cpar27 inp vss 1.17788e-14
Cpar28 inp.t0 vss 3.29132e-14
Cpar29 out vdd 1.36922e-14
Cpar30 out vss 3.59193e-14
Cpar31 out.t0 vss 1.23979e-14
Cpar32 out.t8 vss 5.75475e-15
Cpar33 out.t88 vss 5.05988e-14
Cpar34 vdd vss 4.83539e-13
Cpar35 vdd.t0 vss 4.41176e-14
Cpar36 vdd.t15 vss 9.82601e-15
Cpar37 vdd.t16 vss 4.84791e-15
Cpar38 vdd.t26 vss 6.07887e-14
.ends opamp_dut

Vdd vdd 0 1.800000
Vss vss 0 0
Ibias vdd ib 8.500000e-06
Vinp inp 0 DC 0.805000 AC 1 PWL(0 0.805000 3.000000e-09 0.805000 3.300000e-09 0.815000)
Rfb out inn 1m
Cload out 0 2.000000e-13
Xdut vdd vss inp inn out ib opamp_dut
.end
