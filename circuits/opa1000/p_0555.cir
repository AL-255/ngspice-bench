* opa1000[0555]: 2p/pmos_5t_1v8_i10u_weak (pmos_5t, VDD=1.8V, CL=2.0pF, Iref=2.3uA)
.include "pdk_opa.inc"
.temp 27
.option gmin=1e-12 rshunt=1e12 reltol=1e-3 abstol=1e-12 vntol=1e-5 method=gear
* Post-PEX R+C extracted netlist for pmos_5t_1v8_i10u_weak
.subckt opamp_dut vdd vss inp inn out ib
XMpar0 a_1696_7354.t0 inp.t0 a_2206_7354.t8 vdd.t16 pfet_03v3 w=2.71u l=1.95u ad=8.6720e-13 pd=3.6888e-06 as=8.1300e-13 ps=3.4794e-06 nf=1 m=64 par=64
XMpar1 a_1696_7354.t0 inn.t0 out.t0 vdd.t16 pfet_03v3 w=2.71u l=1.95u ad=8.6720e-13 pd=3.6888e-06 as=8.1300e-13 ps=3.4794e-06 nf=1 m=64 par=64
XMpar2 a_1696_7354.t128 a_5759_4551.t2 vdd.t1 vdd.t0 pfet_03v3 w=5.07u l=1.2u ad=1.4196e-12 pd=5.6300e-06 as=1.8252e-12 ps=7.0575e-06 nf=1 m=8 par=8
XMpar3 ib.t1 ib.t0 vss.t13 vss.t12 nfet_03v3 w=1.15u l=1.2u ad=6.9000e-13 pd=3.5000e-06 as=3.2200e-13 ps=1.7100e-06 nf=1 m=2 par=2
XMpar4 out.t12 a_2206_7354.t0 vss.t1 vss.t0 nfet_03v3 w=1.63u l=1.8u ad=4.5640e-13 pd=2.1900e-06 as=4.5640e-13 ps=2.1900e-06 nf=1 m=4 par=4
XMpar5 a_2206_7354.t1 a_2206_7354.t0 vss.t1 vss.t0 nfet_03v3 w=1.63u l=1.8u ad=9.7800e-13 pd=4.4600e-06 as=4.5640e-13 ps=2.1900e-06 nf=1 m=4 par=4
XMpar6 a_5759_4551.t0 ib.t0 vss.t13 vss.t12 nfet_03v3 w=1.15u l=1.2u ad=3.2200e-13 pd=1.7100e-06 as=3.2200e-13 ps=1.7100e-06 nf=1 m=2 par=2
XMpar7 a_5759_4551.t3 a_5759_4551.t2 vdd.t1 vdd.t0 pfet_03v3 w=5.07u l=1.2u ad=1.4196e-12 pd=5.6300e-06 as=1.4196e-12 ps=5.6300e-06 nf=1 m=2 par=2
X39 out.t68 vss.t20 cap_mim_2f0fF c_width=16.58u c_length=16.59u
Rpar0 a_1696_7354.t0 a_1696_7354.t128 50.9525
Rpar1 a_2206_7354.t0 a_2206_7354.t1 9.1237
Rpar2 a_2206_7354.t0 a_2206_7354.t8 193.5391
Rpar3 a_2206_7354.t1 a_2206_7354.t8 76.2300
Rpar4 a_5759_4551.t0 a_5759_4551.t2 197.8844
Rpar5 a_5759_4551.t0 a_5759_4551.t3 80.6341
Rpar6 a_5759_4551.t2 a_5759_4551.t3 23.1201
Rpar7 ib ib.t0 16.3998
Rpar8 ib ib.t1 6.9332
Rpar9 ib.t0 ib.t1 164.9694
Rpar10 inn inn.t0 1.4356
Rpar11 inp inp.t0 1.4356
Rpar12 out out.t0 162.8088
Rpar13 out out.t12 68.6606
Rpar14 out out.t68 15.6898
Rpar15 out.t0 out.t12 108.2312
Rpar16 out.t0 out.t68 1399.0617
Rpar17 out.t12 out.t68 590.0198
Rpar18 vdd vdd.t0 205.8367
Rpar19 vdd vdd.t1 622.5460
Rpar20 vdd vdd.t16 49.7576
Rpar21 vdd.t0 vdd.t1 5.2962
Rpar22 vdd.t0 vdd.t16 30.0832
Rpar23 vdd.t1 vdd.t16 90.9857
Rpar24 vss vss.t0 333.7771
Rpar25 vss vss.t1 69.3017
Rpar26 vss vss.t12 248.9848
Rpar27 vss vss.t13 636.8291
Rpar28 vss vss.t20 74.2198
Rpar29 vss.t0 vss.t1 15.8725
Rpar30 vss.t0 vss.t12 458.1375
Rpar31 vss.t0 vss.t13 1172.3793
Rpar32 vss.t0 vss.t20 777.9288
Rpar33 vss.t1 vss.t12 126.7859
Rpar34 vss.t1 vss.t13 324.2917
Rpar35 vss.t1 vss.t20 161.5203
Rpar36 vss.t12 vss.t13 11.1353
Rpar37 vss.t12 vss.t20 580.3046
Rpar38 vss.t13 vss.t20 1484.2470
Cpar0 a_1696_7354.t0 vss 1.09616e-13
Cpar1 a_1696_7354.t128 vss 1.10832e-14
Cpar2 a_2206_7354.t0 vss 1.18191e-14
Cpar3 a_2206_7354.t1 vss 6.88293e-15
Cpar4 a_2206_7354.t8 vss 5.53694e-14
Cpar5 a_5759_4551.t0 vss 1.57410e-15
Cpar6 a_5759_4551.t2 vss 1.41989e-14
Cpar7 a_5759_4551.t3 vss 3.70678e-15
Cpar8 ib out 1.08670e-16
Cpar9 ib vdd 3.08100e-17
Cpar10 ib vss 6.29350e-15
Cpar11 ib.t0 vss 7.44063e-16
Cpar12 ib.t1 vss 1.02353e-16
Cpar13 inn inp 2.38900e-16
Cpar14 inn out 2.29462e-14
Cpar15 inn vdd 5.06682e-14
Cpar16 inn vss 5.88020e-15
Cpar17 inn.t0 vss 8.51742e-14
Cpar18 inp vdd 5.11041e-14
Cpar19 inp vss 5.89614e-15
Cpar20 inp.t0 vss 8.53480e-14
Cpar21 out vdd 1.14007e-14
Cpar22 out vss 1.98340e-14
Cpar23 out.t0 vss 2.37386e-14
Cpar24 out.t12 vss 3.29725e-15
Cpar25 out.t68 vss 4.49952e-14
Cpar26 vdd vss 3.71488e-13
Cpar27 vdd.t0 vss 1.18683e-14
Cpar28 vdd.t1 vss 6.09945e-15
Cpar29 vdd.t16 vss 1.35797e-13
.ends opamp_dut

Vdd vdd 0 1.800000
Vss vss 0 0
Ibias vdd ib 2.300000e-06
Vinp inp 0 DC 0.805000 AC 1 PWL(0 0.805000 2.084377e-08 0.805000 2.292815e-08 0.815000)
Rfb out inn 1m
Cload out 0 2.000000e-12
Xdut vdd vss inp inn out ib opamp_dut
.end
