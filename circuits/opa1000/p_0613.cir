* opa1000[0613]: 200f/pmos_miller_3v3_i2u_subth (pmos_miller, VDD=3.3V, CL=0.2pF, Iref=0.25uA)
.include "pdk_opa.inc"
.temp 27
.option gmin=1e-12 rshunt=1e12 reltol=1e-3 abstol=1e-12 vntol=1e-5 method=gear
* Post-PEX R+C extracted netlist for pmos_miller_3v3_i2u_subth
.subckt opamp_dut vdd vss inp inn out ib
XMpar0 a_1035_1290.t2 inp.t0 a_1782_8609.t0 vdd.t2 pfet_03v3 w=2.65u l=1.9u ad=7.9500e-13 pd=3.4156e-06 as=8.2150e-13 ps=3.5184e-06 nf=1 m=64 par=64
XMpar1 a_1782_8609.t0 inn.t0 a_7832_1041.t4 vdd.t2 pfet_03v3 w=2.65u l=1.9u ad=8.2150e-13 pd=3.5184e-06 as=7.9500e-13 ps=3.4156e-06 nf=1 m=64 par=64
XMpar2 a_1035_1290.t0 a_7832_1041.t0 vss.t1 vss.t0 nfet_03v3 w=1.09u l=1.35u ad=6.5400e-13 pd=3.3800e-06 as=3.0520e-13 ps=1.6500e-06 nf=1 m=2 par=2
XMpar3 a_1782_8609.t64 a_5544_5385.t0 vdd.t1 vdd.t0 pfet_03v3 w=4.14u l=2.6u ad=1.1592e-12 pd=4.7000e-06 as=1.1592e-12 ps=4.7000e-06 nf=1 m=4 par=4
XMpar4 out.t0 a_1035_1290.t67 vss.t1 vss.t0 nfet_03v3 w=1.09u l=1.35u ad=3.0520e-13 pd=1.6500e-06 as=3.7496e-13 ps=1.9960e-06 nf=1 m=10 par=10
XMpar5 a_5544_5385.t4 ib.t0 vss.t28 vss.t27 nfet_03v3 w=0.92u l=2.6u ad=2.5760e-13 pd=1.4800e-06 as=2.5760e-13 ps=1.4800e-06 nf=1 m=2 par=2
XMpar6 a_5544_5385.t1 a_5544_5385.t0 vdd.t1 vdd.t0 pfet_03v3 w=4.14u l=2.6u ad=1.1592e-12 pd=4.7000e-06 as=1.1592e-12 ps=4.7000e-06 nf=1 m=2 par=2
XMpar7 out.t4 a_5544_5385.t0 vdd.t1 vdd.t0 pfet_03v3 w=4.14u l=2.6u ad=1.4242e-12 pd=5.6560e-06 as=1.1592e-12 ps=4.7000e-06 nf=1 m=10 par=10
XMpar8 ib.t1 ib.t0 vss.t28 vss.t27 nfet_03v3 w=0.92u l=2.6u ad=5.5200e-13 pd=3.0400e-06 as=2.5760e-13 ps=1.4800e-06 nf=1 m=2 par=2
XMpar9 a_7832_1041.t1 a_7832_1041.t0 vss.t1 vss.t0 nfet_03v3 w=1.09u l=1.35u ad=3.0520e-13 pd=1.6500e-06 as=3.0520e-13 ps=1.6500e-06 nf=1 m=2 par=2
X29 a_1035_1810.t0 a_5001_2330.t0 vss.t8 ppolyf_u_1k r_width=1u r_length=19.17u
X44 a_1035_1810.t0 a_5001_1290.t0 vss.t8 ppolyf_u_1k r_width=1u r_length=19.17u
X64 a_5001_2330.t1 out.t14 cap_mim_2f0fF c_width=15.66u c_length=15.65u
X118 a_1035_1290.t66 a_5001_1290.t0 vss.t8 ppolyf_u_1k r_width=1u r_length=19.17u
Rpar0 a_1035_1290.t0 a_1035_1290.t2 361.2709
Rpar1 a_1035_1290.t0 a_1035_1290.t66 157.7016
Rpar2 a_1035_1290.t0 a_1035_1290.t67 50.9314
Rpar3 a_1035_1290.t2 a_1035_1290.t66 105.5212
Rpar4 a_1035_1290.t2 a_1035_1290.t67 259.8964
Rpar5 a_1035_1290.t66 a_1035_1290.t67 113.4497
Rpar6 a_1782_8609.t0 a_1782_8609.t64 31.3938
Rpar7 a_5001_2330.t0 a_5001_2330.t1 72.2705
Rpar8 a_5544_5385.t0 a_5544_5385.t1 24.6649
Rpar9 a_5544_5385.t0 a_5544_5385.t4 166.7703
Rpar10 a_5544_5385.t1 a_5544_5385.t4 162.8086
Rpar11 a_7832_1041.t0 a_7832_1041.t1 29.1101
Rpar12 a_7832_1041.t0 a_7832_1041.t4 154.2774
Rpar13 a_7832_1041.t1 a_7832_1041.t4 131.9030
Rpar14 ib ib.t0 16.5441
Rpar15 ib ib.t1 7.5584
Rpar16 ib.t0 ib.t1 95.3306
Rpar17 inn inn.t0 1.3737
Rpar18 inp inp.t0 1.3737
Rpar19 out out.t0 191.0256
Rpar20 out out.t4 189.9475
Rpar21 out out.t14 19.5863
Rpar22 out.t0 out.t4 40.2692
Rpar23 vdd vdd.t0 88.4478
Rpar24 vdd vdd.t1 480.1703
Rpar25 vdd vdd.t2 212.3733
Rpar26 vdd.t0 vdd.t1 5.2108
Rpar27 vdd.t0 vdd.t2 27.9625
Rpar28 vdd.t1 vdd.t2 151.8046
Rpar29 vss vss.t0 33.4135
Rpar30 vss vss.t1 118.1519
Rpar31 vss vss.t27 446.5020
Rpar32 vss vss.t28 541.5335
Rpar33 vss vss.t8 217.8814
Rpar34 vss.t0 vss.t1 3.7750
Rpar35 vss.t0 vss.t27 107.6434
Rpar36 vss.t0 vss.t28 130.5619
Rpar37 vss.t0 vss.t8 51.1745
Rpar38 vss.t1 vss.t27 312.7929
Rpar39 vss.t1 vss.t28 379.3906
Rpar40 vss.t1 vss.t8 199.0964
Rpar41 vss.t27 vss.t28 15.9877
Rpar42 vss.t27 vss.t8 2916.9867
Rpar43 vss.t28 vss.t8 3537.8628
Cpar0 a_1035_1290.t0 vss 3.95688e-15
Cpar1 a_1035_1290.t2 vss 5.09388e-14
Cpar2 a_1035_1290.t66 vss 5.71413e-15
Cpar3 a_1035_1290.t67 vss 1.14692e-14
Cpar4 a_1035_1810.t0 vss 4.21000e-17
Cpar5 a_1782_8609.t0 vss 1.07526e-13
Cpar6 a_1782_8609.t64 vss 9.32446e-15
Cpar7 a_5001_1290.t0 vss 4.09000e-17
Cpar8 a_5001_2330.t0 vss 2.50310e-16
Cpar9 a_5001_2330.t1 vss 5.92289e-15
Cpar10 a_5544_5385.t0 vss 3.92155e-14
Cpar11 a_5544_5385.t1 vss 6.36008e-15
Cpar12 a_5544_5385.t4 vss 4.22661e-15
Cpar13 a_7832_1041.t0 vss 6.39967e-15
Cpar14 a_7832_1041.t1 vss 3.52376e-15
Cpar15 a_7832_1041.t4 vss 5.95416e-14
Cpar16 ib out 2.44440e-16
Cpar17 ib vdd 1.04400e-17
Cpar18 ib vss 9.41144e-15
Cpar19 ib.t0 vss 1.20759e-15
Cpar20 ib.t1 vss 1.00687e-16
Cpar21 inn inp 2.20610e-16
Cpar22 inn vdd 4.96273e-14
Cpar23 inn vss 6.03650e-15
Cpar24 inn.t0 vss 8.18021e-14
Cpar25 inp out 4.65300e-17
Cpar26 inp vdd 4.94387e-14
Cpar27 inp vss 6.03519e-15
Cpar28 inp.t0 vss 8.15597e-14
Cpar29 out vdd 1.02371e-14
Cpar30 out vss 2.47867e-14
Cpar31 out.t0 vss 4.83014e-15
Cpar32 out.t14 vss 7.31930e-15
Cpar33 out.t4 vss 1.07222e-14
Cpar34 vdd vss 3.99293e-13
Cpar35 vdd.t0 vss 3.35084e-14
Cpar36 vdd.t1 vss 9.33452e-15
Cpar37 vdd.t2 vss 1.34883e-13
.ends opamp_dut

Vdd vdd 0 3.300000
Vss vss 0 0
Ibias vdd ib 2.500000e-07
Vinp inp 0 DC 1.480000 AC 1 PWL(0 1.480000 5.057603e-08 1.480000 5.563364e-08 1.490000)
Rfb out inn 1m
Cload out 0 2.000000e-13
Xdut vdd vss inp inn out ib opamp_dut
.end
