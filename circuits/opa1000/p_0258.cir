* opa1000[0258]: 200f/folded_cascode_pmos_1v8_i1u_subth (folded_cascode_pmos, VDD=1.8V, CL=0.2pF, Iref=0.2889uA)
.include "pdk_opa.inc"
.temp 27
.option gmin=1e-12 rshunt=1e12 reltol=1e-3 abstol=1e-12 vntol=1e-5 method=gear
* Post-PEX R+C extracted netlist for folded_cascode_pmos_1v8_i1u_subth
.subckt opamp_dut vdd vss inp inn out ib
XMpar0 a_1698_9909.t0 inn.t0 a_8334_2839.t0 vdd.t12 pfet_03v3 w=1.99u l=2.6u ad=6.4817e-13 pd=2.9257e-06 as=6.0269e-13 ps=2.7379e-06 nf=1 m=56 par=56
XMpar1 a_1698_9909.t0 inp.t0 a_2338_9909.t0 vdd.t12 pfet_03v3 w=1.99u l=2.6u ad=6.4817e-13 pd=2.9257e-06 as=6.0269e-13 ps=2.7379e-06 nf=1 m=56 par=56
XMpar2 a_8334_2839.t56 ib.t0 vss.t5 vss.t4 nfet_03v3 w=0.84u l=2.1u ad=2.3520e-13 pd=1.4000e-06 as=3.6960e-13 ps=2.1400e-06 nf=1 m=4 par=4
XMpar3 a_1698_9909.t112 a_2120_1204.t2 vdd.t1 vdd.t0 pfet_03v3 w=5.31u l=4.5u ad=1.4868e-12 pd=5.8700e-06 as=2.3364e-12 ps=8.8450e-06 nf=1 m=4 par=4
XMpar4 a_2120_1204.t0 ib.t0 vss.t5 vss.t4 nfet_03v3 w=0.84u l=2.1u ad=2.3520e-13 pd=1.4000e-06 as=2.3520e-13 ps=1.4000e-06 nf=1 m=2 par=2
XMpar5 a_6292_4669.t3 a_6292_4669.t2 vdd.t1 vdd.t0 pfet_03v3 w=5.31u l=4.5u ad=3.1860e-12 pd=1.1820e-05 as=1.4868e-12 ps=5.8700e-06 nf=1 m=2 par=2
XMpar6 ib.t1 ib.t0 vss.t5 vss.t4 nfet_03v3 w=0.84u l=2.1u ad=5.0400e-13 pd=2.8800e-06 as=2.3520e-13 ps=1.4000e-06 nf=1 m=2 par=2
XMpar7 out.t0 a_6292_4669.t2 vdd.t1 vdd.t0 pfet_03v3 w=5.31u l=4.5u ad=1.4868e-12 pd=5.8700e-06 as=1.4868e-12 ps=5.8700e-06 nf=1 m=2 par=2
XMpar8 a_2120_1204.t3 a_2120_1204.t2 vdd.t1 vdd.t0 pfet_03v3 w=5.31u l=4.5u ad=1.4868e-12 pd=5.8700e-06 as=1.4868e-12 ps=5.8700e-06 nf=1 m=2 par=2
XMpar9 a_8334_2839.t60 a_2120_1204.t6 out.t1 vss.t0 nfet_03v3 w=2.27u l=1.7u ad=1.3620e-12 pd=5.7400e-06 as=6.3560e-13 ps=2.8300e-06 nf=1 m=2 par=2
XMpar10 a_2338_9909.t56 ib.t0 vss.t5 vss.t4 nfet_03v3 w=0.84u l=2.1u ad=2.3520e-13 pd=1.4000e-06 as=3.6960e-13 ps=2.1400e-06 nf=1 m=4 par=4
XMpar11 a_2338_9909.t60 a_2120_1204.t6 a_6292_4669.t0 vss.t0 nfet_03v3 w=2.27u l=1.7u ad=1.3620e-12 pd=5.7400e-06 as=6.3560e-13 ps=2.8300e-06 nf=1 m=2 par=2
X110 out.t4 vss.t1 cap_mim_2f0fF c_width=14.79u c_length=14.79u
Rpar0 a_1698_9909.t0 a_1698_9909.t112 62.3803
Rpar1 a_2120_1204.t0 a_2120_1204.t2 392.8150
Rpar2 a_2120_1204.t0 a_2120_1204.t3 287.3344
Rpar3 a_2120_1204.t0 a_2120_1204.t6 83.0688
Rpar4 a_2120_1204.t2 a_2120_1204.t3 23.3273
Rpar5 a_2120_1204.t2 a_2120_1204.t6 408.5835
Rpar6 a_2120_1204.t3 a_2120_1204.t6 298.8687
Rpar7 a_2338_9909.t0 a_2338_9909.t56 194.5616
Rpar8 a_2338_9909.t0 a_2338_9909.t60 95.5577
Rpar9 a_2338_9909.t56 a_2338_9909.t60 48.5757
Rpar10 a_6292_4669.t0 a_6292_4669.t2 188.2695
Rpar11 a_6292_4669.t0 a_6292_4669.t3 54.0845
Rpar12 a_6292_4669.t2 a_6292_4669.t3 18.3980
Rpar13 a_8334_2839.t0 a_8334_2839.t56 194.5616
Rpar14 a_8334_2839.t0 a_8334_2839.t60 95.5577
Rpar15 a_8334_2839.t56 a_8334_2839.t60 48.5757
Rpar16 ib ib.t0 10.3432
Rpar17 ib ib.t1 7.1808
Rpar18 ib.t0 ib.t1 494.0021
Rpar19 inn inn.t0 1.5462
Rpar20 inp inp.t0 1.5462
Rpar21 out out.t0 44.4471
Rpar22 out out.t1 92.0822
Rpar23 out out.t4 15.0010
Rpar24 out.t0 out.t1 143.7929
Rpar25 vdd vdd.t0 299.0293
Rpar26 vdd vdd.t1 577.9613
Rpar27 vdd vdd.t12 20.3744
Rpar28 vdd.t0 vdd.t1 4.0530
Rpar29 vdd.t0 vdd.t12 106.2969
Rpar30 vdd.t1 vdd.t12 205.4498
Rpar31 vss vss.t0 177.5723
Rpar32 vss vss.t1 133.6772
Rpar33 vss vss.t4 49.2165
Rpar34 vss vss.t5 64.0630
Rpar35 vss.t0 vss.t1 321.1589
Rpar36 vss.t0 vss.t4 6.1560
Rpar37 vss.t0 vss.t5 27.7967
Rpar38 vss.t1 vss.t4 134.3549
Rpar39 vss.t1 vss.t5 142.8408
Rpar40 vss.t4 vss.t5 5.4525
Cpar0 a_1698_9909.t0 vss 9.84705e-14
Cpar1 a_1698_9909.t112 vss 1.00444e-14
Cpar2 a_2120_1204.t0 vss 2.20094e-15
Cpar3 a_2120_1204.t2 vss 1.95848e-14
Cpar4 a_2120_1204.t3 vss 4.09718e-15
Cpar5 a_2120_1204.t6 vss 4.58160e-15
Cpar6 a_2338_9909.t0 vss 5.28352e-14
Cpar7 a_2338_9909.t56 vss 4.41825e-15
Cpar8 a_2338_9909.t60 vss 6.81353e-15
Cpar9 a_6292_4669.t0 vss 1.48199e-15
Cpar10 a_6292_4669.t2 vss 1.51477e-14
Cpar11 a_6292_4669.t3 vss 4.64198e-15
Cpar12 a_8334_2839.t0 vss 5.43820e-14
Cpar13 a_8334_2839.t56 vss 4.54760e-15
Cpar14 a_8334_2839.t60 vss 7.01301e-15
Cpar15 ib out 1.12800e-17
Cpar16 ib vss 2.20586e-14
Cpar17 ib.t0 vss 2.61023e-15
Cpar18 ib.t1 vss 9.63218e-17
Cpar19 inn inp 1.57480e-16
Cpar20 inn vdd 5.57657e-14
Cpar21 inn vss 5.15095e-15
Cpar22 inn.t0 vss 8.63195e-14
Cpar23 inp vdd 5.52319e-14
Cpar24 inp vss 5.15534e-15
Cpar25 inp.t0 vss 8.59364e-14
Cpar26 out vdd 3.35546e-15
Cpar27 out vss 9.96607e-15
Cpar28 out.t0 vss 5.42682e-16
Cpar29 out.t1 vss 3.73216e-16
Cpar30 out.t4 vss 9.32801e-15
Cpar31 vdd vss 4.24534e-13
Cpar32 vdd.t0 vss 3.00711e-14
Cpar33 vdd.t1 vss 1.80764e-14
Cpar34 vdd.t12 vss 1.39534e-13
.ends opamp_dut

Vdd vdd 0 1.800000
Vss vss 0 0
Ibias vdd ib 2.889000e-07
Vinp inp 0 DC 0.751000 AC 1 PWL(0 0.751000 6.767351e-08 0.751000 7.444087e-08 0.761000)
Rfb out inn 1m
Cload out 0 2.000000e-13
Xdut vdd vss inp inn out ib opamp_dut
.end
