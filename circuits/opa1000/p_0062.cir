* opa1000[0062]: 2p/cherry_hooper_1v8_i500u_weak (cherry_hooper, VDD=1.8V, CL=2.0pF, Iref=26.5625uA)
.include "pdk_opa.inc"
.temp 27
.option gmin=1e-12 rshunt=1e12 reltol=1e-3 abstol=1e-12 vntol=1e-5 method=gear
* Post-PEX R+C extracted netlist for cherry_hooper_1v8_i500u_weak
.subckt opamp_dut vdd vss inp inn out ib
XMpar0 a_1652_14602.t1 a_1652_14602.t0 vdd.t0 vdd.t0 pfet_03v3 w=10u l=0.32u ad=2.8000e-12 pd=1.0560e-05 as=3.0000e-12 ps=1.1225e-05 nf=1 m=64 par=64
XMpar1 a_14694_19260.t0 a_14574_16700.t35 a_1675_1294.t0 vss.t0 nfet_03v3 w=9.52u l=0.36u ad=2.6656e-12 pd=1.0080e-05 as=3.1008e-12 ps=1.1531e-05 nf=1 m=14 par=14
XMpar2 a_1675_1294.t20 ib.t0 vss.t47 vss.t47 nfet_03v3 w=9.13u l=0.36u ad=2.8220e-12 pd=1.0578e-05 as=2.5564e-12 ps=9.6900e-06 nf=1 m=88 par=88
XMpar3 a_2419_1294.t28 ib.t0 vss.t47 vss.t47 nfet_03v3 w=9.13u l=0.36u ad=2.8220e-12 pd=1.0578e-05 as=2.5564e-12 ps=9.6900e-06 nf=1 m=44 par=44
XMpar4 a_14694_19260.t15 a_14694_19260.t14 vdd.t0 vdd.t0 pfet_03v3 w=10u l=0.32u ad=2.8000e-12 pd=1.0560e-05 as=3.0000e-12 ps=1.1225e-05 nf=1 m=64 par=64
XMpar5 a_11860_22436.t1 a_11860_22436.t0 vdd.t0 vdd.t0 pfet_03v3 w=10u l=0.32u ad=2.8000e-12 pd=1.0560e-05 as=3.2000e-12 ps=1.1890e-05 nf=1 m=16 par=16
XMpar6 a_1287_21438.t4 ib.t0 vss.t47 vss.t47 nfet_03v3 w=9.13u l=0.36u ad=2.5564e-12 pd=9.6900e-06 as=2.8220e-12 ps=1.0578e-05 nf=1 m=22 par=22
XMpar7 a_2419_1294.t0 inp.t0 a_9298_14810.t2 vss.t0 nfet_03v3 w=1.9u l=0.36u ad=5.7543e-13 pd=2.6414e-06 as=5.3200e-13 ps=2.4600e-06 nf=1 m=28 par=28
XMpar8 a_1652_14602.t128 a_9298_14810.t35 a_1675_1294.t0 vss.t0 nfet_03v3 w=9.52u l=0.36u ad=2.6656e-12 pd=1.0080e-05 as=3.1008e-12 ps=1.1531e-05 nf=1 m=14 par=14
XMpar9 a_4973_11300.t0 a_4973_11300.t9 vdd.t0 vdd.t0 pfet_03v3 w=10u l=0.32u ad=2.8000e-12 pd=1.0560e-05 as=3.2000e-12 ps=1.1890e-05 nf=1 m=16 par=16
XMpar10 a_14574_16700.t2 inn.t0 a_2419_1294.t0 vss.t0 nfet_03v3 w=1.9u l=0.36u ad=5.3200e-13 pd=2.4600e-06 as=5.7543e-13 ps=2.6414e-06 nf=1 m=28 par=28
XMpar11 a_11860_22436.t32 a_1652_14602.t145 a_1287_21438.t0 vss.t7 nfet_03v3 w=8.33u l=0.36u ad=2.3324e-12 pd=8.8900e-06 as=3.6652e-12 ps=1.3375e-05 nf=1 m=4 par=4
XMpar12 ib.t1 ib.t0 vss.t47 vss.t47 nfet_03v3 w=9.13u l=0.36u ad=2.8220e-12 pd=1.0578e-05 as=2.8220e-12 ps=1.0578e-05 nf=1 m=11 par=11
XMpar13 a_1287_11301.t0 ib.t0 vss.t47 vss.t47 nfet_03v3 w=9.13u l=0.36u ad=2.8220e-12 pd=1.0578e-05 as=2.8220e-12 ps=1.0578e-05 nf=1 m=11 par=11
XMpar14 a_1287_11301.t12 a_1287_11301.t11 a_4973_11300.t0 vdd.t0 pfet_03v3 w=10u l=0.32u ad=2.8000e-12 pd=1.0560e-05 as=3.2000e-12 ps=1.1890e-05 nf=1 m=16 par=16
XMpar15 out.t0 a_11860_22436.t0 vdd.t0 vdd.t0 pfet_03v3 w=10u l=0.32u ad=2.8000e-12 pd=1.0560e-05 as=2.8000e-12 ps=1.0560e-05 nf=1 m=16 par=16
XMpar16 a_14574_16700.t0 a_1287_11301.t43 a_14694_19260.t142 vdd.t47 pfet_03v3 w=6.29u l=0.32u ad=2.4321e-12 pd=9.1600e-06 as=2.4321e-12 ps=9.1600e-06 nf=1 m=3 par=3
XMpar17 a_1287_21438.t0 a_14694_19260.t145 out.t1 vss.t7 nfet_03v3 w=8.33u l=0.36u ad=3.6652e-12 pd=1.3375e-05 as=2.3324e-12 ps=8.8900e-06 nf=1 m=4 par=4
XMpar18 a_5017_7849.t12 a_5017_7849.t11 vdd.t160 vdd.t159 pfet_03v3 w=7.35u l=0.36u ad=2.0580e-12 pd=7.9100e-06 as=4.4100e-12 ps=1.5900e-05 nf=1 m=2 par=2
XMpar19 a_5017_7849.t0 ib.t0 vss.t47 vss.t47 nfet_03v3 w=9.13u l=0.36u ad=2.8220e-12 pd=1.0578e-05 as=2.8220e-12 ps=1.0578e-05 nf=1 m=11 par=11
XMpar20 a_1652_14602.t142 a_1287_11301.t43 a_9298_14810.t0 vdd.t47 pfet_03v3 w=6.29u l=0.32u ad=2.4321e-12 pd=9.1600e-06 as=2.4321e-12 ps=9.1600e-06 nf=1 m=3 par=3
XMpar21 a_14574_16700.t31 a_5017_7849.t11 vdd.t160 vdd.t159 pfet_03v3 w=7.35u l=0.36u ad=2.0580e-12 pd=7.9100e-06 as=3.2340e-12 ps=1.1905e-05 nf=1 m=4 par=4
XMpar22 a_9298_14810.t31 a_5017_7849.t11 vdd.t160 vdd.t159 pfet_03v3 w=7.35u l=0.36u ad=2.0580e-12 pd=7.9100e-06 as=3.2340e-12 ps=1.1905e-05 nf=1 m=4 par=4
X155 out.t20 vss.t5 cap_mim_2f0fF c_width=19.37u c_length=19.37u
X217 out.t20 vss.t5 cap_mim_2f0fF c_width=19.37u c_length=19.37u
X281 out.t20 vss.t5 cap_mim_2f0fF c_width=19.37u c_length=19.37u
X324 out.t20 vss.t5 cap_mim_2f0fF c_width=19.37u c_length=19.37u
Rpar0 a_11860_22436.t0 a_11860_22436.t1 18.8169
Rpar1 a_11860_22436.t0 a_11860_22436.t32 560.7808
Rpar2 a_11860_22436.t1 a_11860_22436.t32 76.4270
Rpar3 a_1287_11301.t0 a_1287_11301.t11 800.2503
Rpar4 a_1287_11301.t0 a_1287_11301.t12 46.6787
Rpar5 a_1287_11301.t0 a_1287_11301.t43 267.9760
Rpar6 a_1287_11301.t11 a_1287_11301.t12 22.5477
Rpar7 a_1287_11301.t11 a_1287_11301.t43 3034.6086
Rpar8 a_1287_11301.t12 a_1287_11301.t43 177.0092
Rpar9 a_1287_21438.t0 a_1287_21438.t4 57.0715
Rpar10 a_14574_16700.t0 a_14574_16700.t2 59.1896
Rpar11 a_14574_16700.t0 a_14574_16700.t31 471.7395
Rpar12 a_14574_16700.t0 a_14574_16700.t35 355.6874
Rpar13 a_14574_16700.t2 a_14574_16700.t31 126.6932
Rpar14 a_14574_16700.t2 a_14574_16700.t35 95.5256
Rpar15 a_14574_16700.t31 a_14574_16700.t35 56.7274
Rpar16 a_14694_19260.t0 a_14694_19260.t14 4937.0710
Rpar17 a_14694_19260.t0 a_14694_19260.t15 109.2855
Rpar18 a_14694_19260.t0 a_14694_19260.t142 145.4126
Rpar19 a_14694_19260.t0 a_14694_19260.t145 373.6423
Rpar20 a_14694_19260.t14 a_14694_19260.t15 8.4946
Rpar21 a_14694_19260.t14 a_14694_19260.t142 4444.5902
Rpar22 a_14694_19260.t15 a_14694_19260.t142 98.3841
Rpar23 a_14694_19260.t15 a_14694_19260.t145 252.8011
Rpar24 a_14694_19260.t142 a_14694_19260.t145 89.9986
Rpar25 a_1652_14602.t0 a_1652_14602.t1 8.4869
Rpar26 a_1652_14602.t0 a_1652_14602.t128 7263.6823
Rpar27 a_1652_14602.t0 a_1652_14602.t142 5183.0687
Rpar28 a_1652_14602.t1 a_1652_14602.t128 160.7867
Rpar29 a_1652_14602.t1 a_1652_14602.t142 114.7309
Rpar30 a_1652_14602.t1 a_1652_14602.t145 294.8045
Rpar31 a_1652_14602.t128 a_1652_14602.t142 152.8154
Rpar32 a_1652_14602.t128 a_1652_14602.t145 392.6639
Rpar33 a_1652_14602.t142 a_1652_14602.t145 86.0637
Rpar34 a_1675_1294.t0 a_1675_1294.t20 65.7985
Rpar35 a_2419_1294.t0 a_2419_1294.t28 98.9143
Rpar36 a_4973_11300.t0 a_4973_11300.t9 21.7905
Rpar37 a_5017_7849.t0 a_5017_7849.t11 154.5498
Rpar38 a_5017_7849.t0 a_5017_7849.t12 59.1775
Rpar39 a_5017_7849.t11 a_5017_7849.t12 49.5684
Rpar40 a_9298_14810.t0 a_9298_14810.t2 78.3940
Rpar41 a_9298_14810.t0 a_9298_14810.t31 991.6006
Rpar42 a_9298_14810.t0 a_9298_14810.t35 530.9410
Rpar43 a_9298_14810.t2 a_9298_14810.t31 186.3031
Rpar44 a_9298_14810.t2 a_9298_14810.t35 99.7538
Rpar45 a_9298_14810.t31 a_9298_14810.t35 66.8964
Rpar46 ib ib.t0 4.6179
Rpar47 ib ib.t1 195.5961
Rpar48 ib.t0 ib.t1 15.4530
Rpar49 inn inn.t0 1.5620
Rpar50 inp inp.t0 1.9468
Rpar51 out out.t0 226.9762
Rpar52 out out.t1 226.3076
Rpar53 out out.t20 17.8050
Rpar54 out.t0 out.t1 43.9941
Rpar55 out.t0 out.t20 895.4572
Rpar56 out.t1 out.t20 892.8195
Rpar57 vdd vdd.t0 71.5344
Rpar58 vdd vdd.t47 229.2057
Rpar59 vdd.t0 vdd.t159 78.0279
Rpar60 vdd.t0 vdd.t160 86.9747
Rpar61 vdd.t0 vdd.t47 30.1659
Rpar62 vdd.t159 vdd.t160 4.7370
Rpar63 vdd.t159 vdd.t47 1937.9070
Rpar64 vdd.t160 vdd.t47 2160.1110
Rpar65 vss vss.t0 256.2492
Rpar66 vss vss.t47 174.2790
Rpar67 vss vss.t7 261.3478
Rpar68 vss vss.t5 81.6432
Rpar69 vss.t0 vss.t47 10.3345
Rpar70 vss.t0 vss.t7 795.8823
Rpar71 vss.t0 vss.t5 304.4038
Rpar72 vss.t47 vss.t7 59.1860
Rpar73 vss.t47 vss.t5 215.9300
Rpar74 vss.t7 vss.t5 503.2560
Cpar0 a_11860_22436.t0 vss 2.70123e-14
Cpar1 a_11860_22436.t1 vss 3.51121e-14
Cpar2 a_11860_22436.t32 vss 8.54681e-15
Cpar3 a_1287_11301.t0 vss 1.75285e-14
Cpar4 a_1287_11301.t11 vss 9.44958e-15
Cpar5 a_1287_11301.t12 vss 2.75418e-14
Cpar6 a_1287_11301.t43 vss 6.71310e-15
Cpar7 a_1287_21438.t0 vss 7.31346e-15
Cpar8 a_1287_21438.t4 vss 1.33489e-14
Cpar9 a_14574_16700.t0 vss 7.05968e-15
Cpar10 a_14574_16700.t2 vss 1.68074e-14
Cpar11 a_14574_16700.t31 vss 7.90358e-15
Cpar12 a_14574_16700.t35 vss 1.34435e-14
Cpar13 a_14694_19260.t0 vss 2.83133e-14
Cpar14 a_14694_19260.t14 vss 5.68327e-14
Cpar15 a_14694_19260.t142 vss 8.53937e-15
Cpar16 a_14694_19260.t145 vss 4.30055e-15
Cpar17 a_14694_19260.t15 vss 1.33103e-13
Cpar18 a_1652_14602.t0 vss 5.69340e-14
Cpar19 a_1652_14602.t1 vss 1.33615e-13
Cpar20 a_1652_14602.t128 vss 2.84469e-14
Cpar21 a_1652_14602.t142 vss 9.21526e-15
Cpar22 a_1652_14602.t145 vss 4.56703e-15
Cpar23 a_1675_1294.t0 vss 2.39869e-14
Cpar24 a_1675_1294.t20 vss 7.16437e-14
Cpar25 a_2419_1294.t0 vss 1.59745e-14
Cpar26 a_2419_1294.t28 vss 5.03339e-14
Cpar27 a_4973_11300.t0 vss 7.82003e-14
Cpar28 a_4973_11300.t9 vss 1.42345e-14
Cpar29 a_5017_7849.t0 vss 1.04660e-14
Cpar30 a_5017_7849.t11 vss 4.26116e-15
Cpar31 a_5017_7849.t12 vss 2.98657e-15
Cpar32 a_9298_14810.t0 vss 6.91754e-15
Cpar33 a_9298_14810.t2 vss 1.59205e-14
Cpar34 a_9298_14810.t31 vss 7.53558e-15
Cpar35 a_9298_14810.t35 vss 1.37039e-14
Cpar36 ib vdd 3.44660e-16
Cpar37 ib vss 1.40960e-13
Cpar38 ib.t0 vss 2.95755e-14
Cpar39 ib.t1 vss 4.55449e-15
Cpar40 inn inp 5.22700e-17
Cpar41 inn vdd 3.62600e-17
Cpar42 inn vss 1.35136e-14
Cpar43 inn.t0 vss 1.54529e-15
Cpar44 inp vdd 4.09100e-17
Cpar45 inp vss 1.30889e-14
Cpar46 inp.t0 vss 2.00676e-15
Cpar47 out vdd 4.22371e-14
Cpar48 out vss 3.49169e-14
Cpar49 out.t0 vss 3.27433e-15
Cpar50 out.t1 vss 9.91535e-16
Cpar51 out.t20 vss 5.80215e-14
Cpar52 vdd vss 4.91833e-13
Cpar53 vdd.t0 vss 4.95757e-13
Cpar54 vdd.t159 vss 2.03784e-14
Cpar55 vdd.t160 vss 1.95399e-14
Cpar56 vdd.t47 vss 1.51024e-14
.ends opamp_dut

Vdd vdd 0 1.800000
Vss vss 0 0
Ibias vdd ib 2.656250e-05
Vinp inp 0 DC 1.205600 AC 1 PWL(0 1.205600 3.000000e-09 1.205600 3.300000e-09 1.215600)
Rfb out inn 1m
Cload out 0 2.000000e-12
Xdut vdd vss inp inn out ib opamp_dut
.end
