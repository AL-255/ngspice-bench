* opa1000[0610]: 200f/pmos_miller_3v3_0p1u_1u_weak (pmos_miller, VDD=3.3V, CL=0.2pF, Iref=0.0719uA)
.include "pdk_opa.inc"
.temp 27
.option gmin=1e-12 rshunt=1e12 reltol=1e-3 abstol=1e-12 vntol=1e-5 method=gear
* Post-PEX R+C extracted netlist for pmos_miller_3v3_0p1u_1u_weak
.subckt opamp_dut vdd vss inp inn out ib
XMpar0 out.t0 a_1894_5062.t2 vdd.t1 vdd.t0 pfet_03v3 w=1.18u l=7.5u ad=5.5696e-13 pd=2.8320e-06 as=4.8144e-13 ps=2.4680e-06 nf=1 m=10 par=10
XMpar1 out.t4 a_1006_12904.t7 vss.t1 vss.t0 nfet_03v3 w=0.4u l=3.13u ad=1.3760e-13 pd=1.1680e-06 as=1.3760e-13 ps=1.1680e-06 nf=1 m=10 par=10
XMpar2 a_1894_5062.t3 a_1894_5062.t2 vdd.t1 vdd.t0 pfet_03v3 w=1.18u l=7.5u ad=7.0800e-13 pd=3.5600e-06 as=3.3040e-13 ps=1.7400e-06 nf=1 m=2 par=2
XMpar3 a_1006_12904.t5 a_8124_8713.t4 vss.t1 vss.t0 nfet_03v3 w=0.4u l=3.13u ad=2.4000e-13 pd=2.0000e-06 as=1.1200e-13 ps=9.6000e-07 nf=1 m=2 par=2
XMpar4 a_4114_1249.t0 a_1894_5062.t2 vdd.t1 vdd.t0 pfet_03v3 w=1.18u l=7.5u ad=7.0800e-13 pd=3.5600e-06 as=3.3040e-13 ps=1.7400e-06 nf=1 m=4 par=4
XMpar5 a_8124_8713.t5 a_8124_8713.t4 vss.t1 vss.t0 nfet_03v3 w=0.4u l=3.13u ad=2.4000e-13 pd=2.0000e-06 as=1.1200e-13 ps=9.6000e-07 nf=1 m=2 par=2
XMpar6 a_1894_5062.t0 ib.t0 vss.t4 vss.t3 nfet_03v3 w=0.4u l=7.5u ad=2.4000e-13 pd=2.0000e-06 as=1.1200e-13 ps=9.6000e-07 nf=1 m=2 par=2
XMpar7 a_4114_1249.t1 inn.t0 a_8124_8713.t0 vdd.t18 pfet_03v3 w=1.98u l=10u ad=1.1880e-12 pd=5.1600e-06 as=8.7120e-13 ps=3.8500e-06 nf=1 m=4 par=4
XMpar8 ib.t1 ib.t0 vss.t4 vss.t3 nfet_03v3 w=0.4u l=7.5u ad=2.4000e-13 pd=2.0000e-06 as=1.1200e-13 ps=9.6000e-07 nf=1 m=2 par=2
XMpar9 a_1006_12904.t0 inp.t0 a_4114_1249.t1 vdd.t18 pfet_03v3 w=1.98u l=10u ad=8.7120e-13 pd=3.8500e-06 as=1.1880e-12 ps=5.1600e-06 nf=1 m=4 par=4
X0 a_1006_13424.t0 a_4878_12904.t0 vss.t2 ppolyf_u_1k r_width=1u r_length=18.7u
X4 a_1006_18624.t1 out.t16 cap_mim_2f0fF c_width=11.46u c_length=11.46u
X5 a_1006_12904.t4 a_4878_12904.t0 vss.t2 ppolyf_u_1k r_width=1u r_length=18.7u
X6 a_1006_15504.t0 a_4878_16024.t0 vss.t2 ppolyf_u_1k r_width=1u r_length=18.7u
X9 a_1006_18624.t0 a_4878_18104.t0 vss.t2 ppolyf_u_1k r_width=1u r_length=18.7u
X10 a_1006_15504.t0 a_4878_14984.t0 vss.t2 ppolyf_u_1k r_width=1u r_length=18.7u
X16 a_1006_17584.t0 a_4878_18104.t0 vss.t2 ppolyf_u_1k r_width=1u r_length=18.7u
X32 a_1006_14464.t0 a_4878_14984.t0 vss.t2 ppolyf_u_1k r_width=1u r_length=18.7u
X38 a_1006_17584.t0 a_4878_17064.t0 vss.t2 ppolyf_u_1k r_width=1u r_length=18.7u
X39 a_1006_14464.t0 a_4878_13944.t0 vss.t2 ppolyf_u_1k r_width=1u r_length=18.7u
X45 a_1006_13424.t0 a_4878_13944.t0 vss.t2 ppolyf_u_1k r_width=1u r_length=18.7u
X47 a_1006_16544.t0 a_4878_17064.t0 vss.t2 ppolyf_u_1k r_width=1u r_length=18.7u
X53 a_1006_16544.t0 a_4878_16024.t0 vss.t2 ppolyf_u_1k r_width=1u r_length=18.7u
Rpar0 a_1006_12904.t0 a_1006_12904.t7 225.2346
Rpar1 a_1006_12904.t0 a_1006_12904.t4 679.0665
Rpar2 a_1006_12904.t0 a_1006_12904.t5 121.7233
Rpar3 a_1006_12904.t7 a_1006_12904.t4 51.1553
Rpar4 a_1006_12904.t7 a_1006_12904.t5 226.7583
Rpar5 a_1006_12904.t4 a_1006_12904.t5 683.6603
Rpar6 a_1006_18624.t0 a_1006_18624.t1 60.9475
Rpar7 a_1894_5062.t0 a_1894_5062.t2 181.3954
Rpar8 a_1894_5062.t0 a_1894_5062.t3 111.8466
Rpar9 a_1894_5062.t2 a_1894_5062.t3 16.7621
Rpar10 a_4114_1249.t0 a_4114_1249.t1 53.7399
Rpar11 a_8124_8713.t0 a_8124_8713.t4 163.8629
Rpar12 a_8124_8713.t0 a_8124_8713.t5 174.4398
Rpar13 a_8124_8713.t4 a_8124_8713.t5 15.9540
Rpar14 ib ib.t0 15.4656
Rpar15 ib ib.t1 18.7651
Rpar16 ib.t0 ib.t1 24.5546
Rpar17 inn inn.t0 4.3277
Rpar18 inp inp.t0 4.3278
Rpar19 out out.t0 93.1002
Rpar20 out out.t4 4.6403
Rpar21 out out.t16 94.1044
Rpar22 out.t0 out.t16 80.8364
Rpar23 vdd vdd.t0 475.3924
Rpar24 vdd vdd.t1 3098.2097
Rpar25 vdd vdd.t18 170.5288
Rpar26 vdd.t0 vdd.t1 14.1736
Rpar27 vdd.t0 vdd.t18 26.4383
Rpar28 vdd.t1 vdd.t18 172.3030
Rpar29 vss vss.t0 65.2208
Rpar30 vss vss.t1 368.4599
Rpar31 vss vss.t2 1297.7100
Rpar32 vss vss.t3 1736.2075
Rpar33 vss vss.t4 920.0308
Rpar34 vss.t0 vss.t1 8.0827
Rpar35 vss.t0 vss.t2 45.8456
Rpar36 vss.t0 vss.t3 117.2731
Rpar37 vss.t0 vss.t4 75.2889
Rpar38 vss.t1 vss.t2 268.1867
Rpar39 vss.t1 vss.t3 711.0308
Rpar40 vss.t1 vss.t4 433.4406
Rpar41 vss.t2 vss.t3 921.8495
Rpar42 vss.t2 vss.t4 494.2991
Rpar43 vss.t3 vss.t4 21.5486
Cpar0 a_1006_12904.t0 vss 9.80518e-15
Cpar1 a_1006_12904.t4 vss 2.82325e-15
Cpar2 a_1006_12904.t5 vss 5.97991e-15
Cpar3 a_1006_12904.t7 vss 1.38360e-14
Cpar4 a_1006_13424.t0 vss 4.25800e-17
Cpar5 a_1006_14464.t0 vss 3.84800e-17
Cpar6 a_1006_15504.t0 vss 3.84800e-17
Cpar7 a_1006_16544.t0 vss 3.84800e-17
Cpar8 a_1006_17584.t0 vss 4.25800e-17
Cpar9 a_1006_18624.t0 vss 6.00150e-16
Cpar10 a_1006_18624.t1 vss 7.44395e-15
Cpar11 a_1894_5062.t0 vss 8.18707e-15
Cpar12 a_1894_5062.t2 vss 8.02234e-14
Cpar13 a_1894_5062.t3 vss 1.13195e-14
Cpar14 a_4114_1249.t0 vss 2.50295e-14
Cpar15 a_4114_1249.t1 vss 3.35531e-14
Cpar16 a_4878_12904.t0 vss 3.80600e-17
Cpar17 a_4878_13944.t0 vss 3.63000e-17
Cpar18 a_4878_14984.t0 vss 3.55600e-17
Cpar19 a_4878_16024.t0 vss 3.55600e-17
Cpar20 a_4878_17064.t0 vss 3.63000e-17
Cpar21 a_4878_18104.t0 vss 3.66400e-17
Cpar22 a_8124_8713.t0 vss 9.46772e-15
Cpar23 a_8124_8713.t4 vss 6.78455e-15
Cpar24 a_8124_8713.t5 vss 3.19751e-15
Cpar25 ib vdd 8.20300e-17
Cpar26 ib vss 2.32578e-14
Cpar27 ib.t0 vss 3.65330e-15
Cpar28 ib.t1 vss 5.41186e-16
Cpar29 inn inp 5.19700e-17
Cpar30 inn vdd 1.68001e-14
Cpar31 inn vss 4.96527e-15
Cpar32 inn.t0 vss 1.89362e-14
Cpar33 inp vdd 1.68739e-14
Cpar34 inp vss 4.89222e-15
Cpar35 inp.t0 vss 1.90066e-14
Cpar36 out vdd 1.87574e-14
Cpar37 out vss 2.47387e-14
Cpar38 out.t0 vss 1.74622e-14
Cpar39 out.t16 vss 1.09288e-14
Cpar40 out.t4 vss 2.94424e-15
Cpar41 vdd vss 3.00624e-13
Cpar42 vdd.t0 vss 7.43594e-14
Cpar43 vdd.t1 vss 1.34364e-14
Cpar44 vdd.t18 vss 6.22431e-14
.ends opamp_dut

Vdd vdd 0 3.300000
Vss vss 0 0
Ibias vdd ib 7.190000e-08
Vinp inp 0 DC 1.480000 AC 1 PWL(0 1.480000 1.396139e-07 1.480000 1.535753e-07 1.490000)
Rfb out inn 1m
Cload out 0 2.000000e-13
Xdut vdd vss inp inn out ib opamp_dut
.end
