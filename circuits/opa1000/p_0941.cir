* opa1000[0941]: 200f/telescopic_pmos_3v3_i200n_subth (telescopic_pmos, VDD=3.3V, CL=0.2pF, Iref=0.046uA)
.include "pdk_opa.inc"
.temp 27
.option gmin=1e-12 rshunt=1e12 reltol=1e-3 abstol=1e-12 vntol=1e-5 method=gear
* Post-PEX R+C extracted netlist for telescopic_pmos_3v3_i200n_subth
.subckt opamp_dut vdd vss inp inn out ib
XMpar0 a_2034_14407.t0 a_1243_16038.t0 vdd.t1 vdd.t0 pfet_03v3 w=1.5u l=5u ad=4.2000e-13 pd=2.0600e-06 as=5.4000e-13 ps=2.5950e-06 nf=1 m=8 par=8
XMpar1 a_5932_10253.t8 a_3872_10045.t0 out.t0 vdd.t2 pfet_03v3 w=2.66u l=4.2u ad=1.1704e-12 pd=4.8700e-06 as=7.4480e-13 ps=3.2200e-06 nf=1 m=8 par=8
XMpar2 a_4872_1204.t0 a_3872_10045.t20 vss.t1 vss.t0 nfet_03v3 w=0.59u l=6.5u ad=3.5400e-13 pd=2.3800e-06 as=1.6520e-13 ps=1.1500e-06 nf=1 m=2 par=2
XMpar3 a_6884_2858.t2 a_3872_10045.t12 out.t6 vss.t8 nfet_03v3 w=2.34u l=4.2u ad=1.4040e-12 pd=5.8800e-06 as=6.5520e-13 ps=2.9000e-06 nf=1 m=2 par=2
XMpar4 a_2730_14407.t0 a_3872_10045.t0 a_3872_10045.t1 vdd.t2 pfet_03v3 w=2.66u l=4.2u ad=1.5960e-12 pd=6.5200e-06 as=7.4480e-13 ps=3.2200e-06 nf=1 m=8 par=8
XMpar5 a_3872_10045.t13 a_3872_10045.t12 a_4872_1204.t1 vss.t8 nfet_03v3 w=2.34u l=4.2u ad=1.4040e-12 pd=5.8800e-06 as=1.4040e-12 ps=5.8800e-06 nf=1 m=2 par=2
XMpar6 a_2034_14407.t1 inp.t0 a_2730_14407.t8 vdd.t9 pfet_03v3 w=2.54u l=2.88u ad=9.1440e-13 pd=3.8950e-06 as=7.1120e-13 ps=3.1000e-06 nf=1 m=8 par=8
XMpar7 a_2034_14407.t1 inn.t0 a_5932_10253.t0 vdd.t9 pfet_03v3 w=2.54u l=2.88u ad=9.1440e-13 pd=3.8950e-06 as=7.1120e-13 ps=3.1000e-06 nf=1 m=8 par=8
XMpar8 a_1243_16038.t1 a_1243_16038.t0 vdd.t1 vdd.t0 pfet_03v3 w=1.5u l=5u ad=4.2000e-13 pd=2.0600e-06 as=4.2000e-13 ps=2.0600e-06 nf=1 m=2 par=2
XMpar9 a_6884_2858.t0 a_3872_10045.t20 vss.t1 vss.t0 nfet_03v3 w=0.59u l=6.5u ad=1.6520e-13 pd=1.1500e-06 as=1.6520e-13 ps=1.1500e-06 nf=1 m=2 par=2
XMpar10 a_1243_16038.t4 ib.t0 vss.t11 vss.t10 nfet_03v3 w=0.4u l=5u ad=2.4000e-13 pd=2.0000e-06 as=1.1200e-13 ps=9.6000e-07 nf=1 m=2 par=2
XMpar11 ib.t1 ib.t0 vss.t11 vss.t10 nfet_03v3 w=0.4u l=5u ad=2.4000e-13 pd=2.0000e-06 as=1.1200e-13 ps=9.6000e-07 nf=1 m=2 par=2
X33 out.t10 vss.t4 cap_mim_2f0fF c_width=17.91u c_length=17.91u
X55 out.t10 vss.t4 cap_mim_2f0fF c_width=17.91u c_length=17.91u
Rpar0 a_1243_16038.t0 a_1243_16038.t1 27.3534
Rpar1 a_1243_16038.t0 a_1243_16038.t4 115.2606
Rpar2 a_1243_16038.t1 a_1243_16038.t4 142.5280
Rpar3 a_2034_14407.t0 a_2034_14407.t1 47.2023
Rpar4 a_2730_14407.t0 a_2730_14407.t8 56.8318
Rpar5 a_3872_10045.t0 a_3872_10045.t1 9.0734
Rpar6 a_3872_10045.t0 a_3872_10045.t12 927.1374
Rpar7 a_3872_10045.t0 a_3872_10045.t13 415.2161
Rpar8 a_3872_10045.t0 a_3872_10045.t20 580.4212
Rpar9 a_3872_10045.t1 a_3872_10045.t12 433.6346
Rpar10 a_3872_10045.t1 a_3872_10045.t13 194.2022
Rpar11 a_3872_10045.t1 a_3872_10045.t20 271.4708
Rpar12 a_3872_10045.t12 a_3872_10045.t13 20.9498
Rpar13 a_3872_10045.t12 a_3872_10045.t20 229.1255
Rpar14 a_3872_10045.t13 a_3872_10045.t20 102.6133
Rpar15 a_4872_1204.t0 a_4872_1204.t1 62.6758
Rpar16 a_5932_10253.t0 a_5932_10253.t8 38.0193
Rpar17 a_6884_2858.t0 a_6884_2858.t2 60.9369
Rpar18 ib ib.t0 9.4990
Rpar19 ib ib.t1 11.8304
Rpar20 ib.t0 ib.t1 43.3716
Rpar21 inn inn.t0 1.3757
Rpar22 inp inp.t0 1.4243
Rpar23 out out.t0 69.4388
Rpar24 out out.t10 17.0157
Rpar25 out out.t6 77.0900
Rpar26 out.t0 out.t6 239.9690
Rpar27 vdd vdd.t0 29.6691
Rpar28 vdd vdd.t1 108.5372
Rpar29 vdd vdd.t9 281.8348
Rpar30 vdd vdd.t2 233.6008
Rpar31 vdd.t0 vdd.t1 5.8151
Rpar32 vdd.t0 vdd.t9 179.3636
Rpar33 vdd.t0 vdd.t2 148.6668
Rpar34 vdd.t1 vdd.t9 656.1594
Rpar35 vdd.t1 vdd.t2 543.8625
Rpar36 vdd.t9 vdd.t2 2.5262
Rpar37 vss vss.t0 74.4174
Rpar38 vss vss.t1 309.0719
Rpar39 vss vss.t10 322.1730
Rpar40 vss vss.t11 220.8946
Rpar41 vss vss.t8 70.7046
Rpar42 vss vss.t4 257.7525
Rpar43 vss.t0 vss.t1 21.9101
Rpar44 vss.t0 vss.t10 254.4579
Rpar45 vss.t0 vss.t11 244.4497
Rpar46 vss.t0 vss.t8 3.9837
Rpar47 vss.t0 vss.t4 301.8041
Rpar48 vss.t1 vss.t10 1071.2298
Rpar49 vss.t1 vss.t11 1088.0971
Rpar50 vss.t1 vss.t8 20.7989
Rpar51 vss.t1 vss.t4 1359.2021
Rpar52 vss.t10 vss.t11 23.5523
Rpar53 vss.t10 vss.t8 241.7912
Rpar54 vss.t10 vss.t4 184.0806
Rpar55 vss.t11 vss.t8 232.3918
Rpar56 vss.t11 vss.t4 116.8303
Rpar57 vss.t8 vss.t4 286.9448
Cpar0 a_1243_16038.t0 vss 3.37170e-14
Cpar1 a_1243_16038.t1 vss 5.26836e-15
Cpar2 a_1243_16038.t4 vss 7.11587e-15
Cpar3 a_2034_14407.t0 vss 1.02220e-14
Cpar4 a_2034_14407.t1 vss 1.93143e-14
Cpar5 a_2730_14407.t0 vss 2.11282e-14
Cpar6 a_2730_14407.t8 vss 8.80594e-15
Cpar7 a_3872_10045.t0 vss 3.81260e-14
Cpar8 a_3872_10045.t1 vss 1.02083e-14
Cpar9 a_3872_10045.t12 vss 9.43861e-15
Cpar10 a_3872_10045.t13 vss 4.33815e-15
Cpar11 a_3872_10045.t20 vss 9.15050e-15
Cpar12 a_4872_1204.t0 vss 3.59928e-15
Cpar13 a_4872_1204.t1 vss 4.24280e-15
Cpar14 a_5932_10253.t0 vss 1.06527e-14
Cpar15 a_5932_10253.t8 vss 2.33298e-14
Cpar16 a_6884_2858.t0 vss 4.00167e-15
Cpar17 a_6884_2858.t2 vss 6.00038e-15
Cpar18 ib out 1.48100e-17
Cpar19 ib vss 1.75939e-14
Cpar20 ib.t0 vss 2.60204e-15
Cpar21 ib.t1 vss 3.24306e-16
Cpar22 inn inp 5.19700e-17
Cpar23 inn vdd 1.19529e-14
Cpar24 inn vss 5.29760e-15
Cpar25 inn.t0 vss 1.08538e-14
Cpar26 inp out 2.23400e-17
Cpar27 inp vdd 1.16115e-14
Cpar28 inp vss 5.03955e-15
Cpar29 inp.t0 vss 1.07840e-14
Cpar30 out vdd 1.21547e-14
Cpar31 out vss 2.64847e-14
Cpar32 out.t0 vss 1.70531e-15
Cpar33 out.t10 vss 2.60348e-14
Cpar34 out.t6 vss 6.69994e-16
Cpar35 vdd vss 2.42427e-13
Cpar36 vdd.t0 vss 2.40932e-14
Cpar37 vdd.t1 vss 7.63330e-15
Cpar38 vdd.t2 vss 5.18150e-14
Cpar39 vdd.t9 vss 3.62173e-14
.ends opamp_dut

Vdd vdd 0 3.300000
Vss vss 0 0
Ibias vdd ib 4.600000e-08
Vinp inp 0 DC 1.480000 AC 1 PWL(0 1.480000 4.778366e-07 1.480000 5.256202e-07 1.490000)
Rfb out inn 1m
Cload out 0 2.000000e-13
Xdut vdd vss inp inn out ib opamp_dut
.end
