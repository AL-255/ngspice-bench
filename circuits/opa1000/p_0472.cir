* opa1000[0472]: 2p/nmos_miller_1v8_i10u_weak (nmos_miller, VDD=1.8V, CL=2.0pF, Iref=1.8571uA)
.include "pdk_opa.inc"
.temp 27
.option gmin=1e-12 rshunt=1e12 reltol=1e-3 abstol=1e-12 vntol=1e-5 method=gear
* Post-PEX R+C extracted netlist for nmos_miller_1v8_i10u_weak
.subckt opamp_dut vdd vss inp inn out ib
XMpar0 out.t0 ib.t0 vss.t4 vss.t3 nfet_03v3 w=1.93u l=2.25u ad=9.1096e-13 pd=4.0320e-06 as=7.8744e-13 ps=3.5180e-06 nf=1 m=10 par=10
XMpar1 out.t3 a_944_4440.t5 vdd.t1 vdd.t0 pfet_03v3 w=7.85u l=1.13u ad=2.1980e-12 pd=8.4100e-06 as=2.7004e-12 ps=1.0108e-05 nf=1 m=10 par=10
XMpar2 a_2843_6153.t0 inp.t0 a_944_4440.t1 vss.t1 nfet_03v3 w=1.66u l=1.3u ad=9.9600e-13 pd=4.5200e-06 as=4.6480e-13 ps=2.2200e-06 nf=1 m=2 par=2
XMpar3 a_2843_6153.t2 ib.t0 vss.t4 vss.t3 nfet_03v3 w=1.93u l=2.25u ad=1.1580e-12 pd=5.0600e-06 as=5.4040e-13 ps=2.4900e-06 nf=1 m=4 par=4
XMpar4 a_6160_1041.t3 a_6160_1041.t2 vdd.t1 vdd.t0 pfet_03v3 w=7.85u l=1.13u ad=2.1980e-12 pd=8.4100e-06 as=2.1980e-12 ps=8.4100e-06 nf=1 m=2 par=2
XMpar5 ib.t1 ib.t0 vss.t4 vss.t3 nfet_03v3 w=1.93u l=2.25u ad=1.1580e-12 pd=5.0600e-06 as=5.4040e-13 ps=2.4900e-06 nf=1 m=2 par=2
XMpar6 a_944_4440.t3 a_6160_1041.t2 vdd.t1 vdd.t0 pfet_03v3 w=7.85u l=1.13u ad=4.7100e-12 pd=1.6900e-05 as=2.1980e-12 ps=8.4100e-06 nf=1 m=2 par=2
XMpar7 a_2843_6153.t0 inn.t0 a_6160_1041.t0 vss.t1 nfet_03v3 w=1.66u l=1.3u ad=9.9600e-13 pd=4.5200e-06 as=4.6480e-13 ps=2.2200e-06 nf=1 m=2 par=2
X18 a_3160_4440.t1 out.t7 cap_mim_2f0fF c_width=14.37u c_length=14.36u
X21 a_3160_4440.t1 out.t7 cap_mim_2f0fF c_width=14.37u c_length=14.36u
X26 a_944_4440.t0 a_3160_4440.t0 vss.t0 ppolyf_u_1k r_width=1u r_length=10.42u
Rpar0 a_2843_6153.t0 a_2843_6153.t2 50.9024
Rpar1 a_3160_4440.t0 a_3160_4440.t1 66.2641
Rpar2 a_6160_1041.t0 a_6160_1041.t2 199.7145
Rpar3 a_6160_1041.t0 a_6160_1041.t3 56.2571
Rpar4 a_6160_1041.t2 a_6160_1041.t3 30.5249
Rpar5 a_944_4440.t0 a_944_4440.t1 99.0211
Rpar6 a_944_4440.t0 a_944_4440.t5 273.0374
Rpar7 a_944_4440.t0 a_944_4440.t3 139.9004
Rpar8 a_944_4440.t1 a_944_4440.t5 226.4627
Rpar9 a_944_4440.t1 a_944_4440.t3 116.0362
Rpar10 a_944_4440.t5 a_944_4440.t3 47.7942
Rpar11 ib ib.t0 15.0460
Rpar12 ib ib.t1 9.3362
Rpar13 ib.t0 ib.t1 24.5368
Rpar14 inn inn.t0 9.3677
Rpar15 inp inp.t0 9.4163
Rpar16 out out.t0 76.4939
Rpar17 out out.t3 132.3052
Rpar18 out out.t7 22.0350
Rpar19 out.t0 out.t3 41.5428
Rpar20 out.t0 out.t7 508.4649
Rpar21 out.t3 out.t7 879.4500
Rpar22 vdd vdd.t0 71.1756
Rpar23 vdd vdd.t1 229.8495
Rpar24 vdd.t0 vdd.t1 3.2033
Rpar25 vss vss.t0 570.5859
Rpar26 vss vss.t1 72.0664
Rpar27 vss vss.t3 45.8177
Rpar28 vss vss.t4 666.1941
Rpar29 vss.t0 vss.t1 23.8970
Rpar30 vss.t0 vss.t3 7.8149
Rpar31 vss.t0 vss.t4 219.4804
Rpar32 vss.t1 vss.t3 1.7683
Rpar33 vss.t1 vss.t4 31.0046
Rpar34 vss.t3 vss.t4 19.2842
Cpar0 a_2843_6153.t0 vss 3.99675e-15
Cpar1 a_2843_6153.t2 vss 1.16560e-14
Cpar2 a_3160_4440.t0 vss 1.72307e-16
Cpar3 a_3160_4440.t1 vss 5.90970e-15
Cpar4 a_6160_1041.t0 vss 1.23833e-15
Cpar5 a_6160_1041.t2 vss 6.21742e-15
Cpar6 a_6160_1041.t3 vss 3.73705e-15
Cpar7 a_944_4440.t0 vss 2.03099e-15
Cpar8 a_944_4440.t1 vss 1.83118e-15
Cpar9 a_944_4440.t3 vss 5.58570e-15
Cpar10 a_944_4440.t5 vss 1.41483e-14
Cpar11 ib out 3.28546e-15
Cpar12 ib vdd 5.42500e-17
Cpar13 ib vss 3.35042e-14
Cpar14 ib.t0 vss 7.22928e-15
Cpar15 ib.t1 vss 8.80196e-16
Cpar16 inn inp 5.16000e-17
Cpar17 inn vdd 4.45600e-17
Cpar18 inn vss 2.06343e-15
Cpar19 inn.t0 vss 3.52076e-16
Cpar20 inp vdd 1.04400e-17
Cpar21 inp vss 2.06068e-15
Cpar22 inp.t0 vss 3.32387e-16
Cpar23 out vdd 1.23361e-14
Cpar24 out vss 1.97774e-14
Cpar25 out.t0 vss 6.68078e-15
Cpar26 out.t3 vss 7.34081e-15
Cpar27 out.t7 vss 1.22872e-14
Cpar28 vdd vss 7.18495e-14
Cpar29 vdd.t0 vss 2.13048e-14
Cpar30 vdd.t1 vss 9.68044e-15
.ends opamp_dut

Vdd vdd 0 1.800000
Vss vss 0 0
Ibias vdd ib 1.857100e-06
Vinp inp 0 DC 0.895000 AC 1 PWL(0 0.895000 2.303696e-08 0.895000 2.534066e-08 0.905000)
Rfb out inn 1m
Cload out 0 2.000000e-12
Xdut vdd vss inp inn out ib opamp_dut
.end
