* opa1000[0516]: 200f/pmos_5t_1v8_10u_100u_weak (pmos_5t, VDD=1.8V, CL=0.2pF, Iref=8.5uA)
.include "pdk_opa.inc"
.temp 27
.option gmin=1e-12 rshunt=1e12 reltol=1e-3 abstol=1e-12 vntol=1e-5 method=gear
* Post-PEX R+C extracted netlist for pmos_5t_1v8_10u_100u_weak
.subckt opamp_dut vdd vss inp inn out ib
XMpar0 a_1240_1204.t0 inn.t0 out.t0 vdd.t4 pfet_03v3 w=2.02u l=0.8u ad=6.2815e-13 pd=2.8374e-06 as=5.8645e-13 ps=2.6658e-06 nf=1 m=62 par=62
XMpar1 a_1240_1204.t0 inp.t0 a_1706_6958.t0 vdd.t4 pfet_03v3 w=2.02u l=0.8u ad=6.2815e-13 pd=2.8374e-06 as=5.8645e-13 ps=2.6658e-06 nf=1 m=62 par=62
XMpar2 a_1240_1204.t124 a_1120_996.t2 vdd.t1 vdd.t0 pfet_03v3 w=8.15u l=0.6u ad=2.2820e-12 pd=8.7100e-06 as=2.9340e-12 ps=1.0908e-05 nf=1 m=8 par=8
XMpar3 out.t2 a_1706_6958.t62 vss.t1 vss.t0 nfet_03v3 w=1.89u l=1.6u ad=5.2920e-13 pd=2.4500e-06 as=6.0480e-13 ps=2.7663e-06 nf=1 m=8 par=8
XMpar4 a_1120_996.t0 ib.t0 vss.t28 vss.t27 nfet_03v3 w=2.11u l=0.6u ad=5.9080e-13 pd=2.6700e-06 as=5.9080e-13 ps=2.6700e-06 nf=1 m=2 par=2
XMpar5 a_1706_6958.t63 a_1706_6958.t62 vss.t1 vss.t0 nfet_03v3 w=1.89u l=1.6u ad=5.2920e-13 pd=2.4500e-06 as=6.0480e-13 ps=2.7663e-06 nf=1 m=8 par=8
XMpar6 ib.t1 ib.t0 vss.t28 vss.t27 nfet_03v3 w=2.11u l=0.6u ad=1.2660e-12 pd=5.4200e-06 as=5.9080e-13 ps=2.6700e-06 nf=1 m=2 par=2
XMpar7 a_1120_996.t3 a_1120_996.t2 vdd.t1 vdd.t0 pfet_03v3 w=8.15u l=0.6u ad=2.2820e-12 pd=8.7100e-06 as=2.2820e-12 ps=8.7100e-06 nf=1 m=2 par=2
X128 out.t70 vss.t10 cap_mim_2f0fF c_width=11.18u c_length=11.18u
Rpar0 a_1120_996.t0 a_1120_996.t2 234.0336
Rpar1 a_1120_996.t0 a_1120_996.t3 70.7506
Rpar2 a_1120_996.t2 a_1120_996.t3 28.2347
Rpar3 a_1240_1204.t0 a_1240_1204.t124 29.2000
Rpar4 a_1706_6958.t0 a_1706_6958.t62 206.6722
Rpar5 a_1706_6958.t0 a_1706_6958.t63 79.4932
Rpar6 a_1706_6958.t62 a_1706_6958.t63 15.9177
Rpar7 ib ib.t0 19.7048
Rpar8 ib ib.t1 4.1695
Rpar9 inn inn.t0 1.7011
Rpar10 inp inp.t0 1.7011
Rpar11 out out.t0 111.8739
Rpar12 out out.t2 58.8183
Rpar13 out out.t70 14.7297
Rpar14 out.t0 out.t2 50.5322
Rpar15 vdd vdd.t0 172.4936
Rpar16 vdd vdd.t1 484.7777
Rpar17 vdd vdd.t4 22.6379
Rpar18 vdd.t0 vdd.t1 5.3803
Rpar19 vdd.t0 vdd.t4 369.2612
Rpar20 vdd.t1 vdd.t4 1037.7754
Rpar21 vss vss.t0 41.3996
Rpar22 vss vss.t1 200.5717
Rpar23 vss vss.t10 57.9647
Rpar24 vss vss.t27 126.0457
Rpar25 vss vss.t28 171.2396
Rpar26 vss.t0 vss.t1 5.6367
Rpar27 vss.t0 vss.t10 152.0551
Rpar28 vss.t0 vss.t27 1.8878
Rpar29 vss.t0 vss.t28 10.8965
Rpar30 vss.t1 vss.t10 1013.9638
Rpar31 vss.t1 vss.t27 18.2442
Rpar32 vss.t1 vss.t28 99.1441
Rpar33 vss.t10 vss.t27 454.0309
Rpar34 vss.t10 vss.t28 501.8858
Rpar35 vss.t27 vss.t28 28.9257
Cpar0 a_1120_996.t0 vss 2.10154e-15
Cpar1 a_1120_996.t2 vss 8.90645e-15
Cpar2 a_1120_996.t3 vss 4.44262e-15
Cpar3 a_1240_1204.t0 vss 8.02942e-14
Cpar4 a_1240_1204.t124 vss 1.57611e-14
Cpar5 a_1706_6958.t0 vss 3.02836e-14
Cpar6 a_1706_6958.t62 vss 1.73628e-14
Cpar7 a_1706_6958.t63 vss 6.46878e-15
Cpar8 ib vdd 1.79620e-16
Cpar9 ib vss 5.60777e-15
Cpar10 ib.t0 vss 3.61615e-16
Cpar11 ib.t1 vss 2.08530e-16
Cpar12 inn inp 1.50370e-16
Cpar13 inn out 1.20341e-14
Cpar14 inn vdd 2.81417e-14
Cpar15 inn vss 5.63899e-15
Cpar16 inn.t0 vss 4.34052e-14
Cpar17 inp vdd 2.81156e-14
Cpar18 inp vss 5.66318e-15
Cpar19 inp.t0 vss 4.33594e-14
Cpar20 out vdd 9.84811e-15
Cpar21 out vss 1.47520e-14
Cpar22 out.t0 vss 2.02163e-14
Cpar23 out.t2 vss 4.48415e-15
Cpar24 out.t70 vss 2.74704e-14
Cpar25 vdd vss 2.17788e-13
Cpar26 vdd.t0 vss 1.35178e-14
Cpar27 vdd.t1 vss 7.07397e-15
Cpar28 vdd.t4 vss 7.70658e-14
.ends opamp_dut

Vdd vdd 0 1.800000
Vss vss 0 0
Ibias vdd ib 8.500000e-06
Vinp inp 0 DC 0.805000 AC 1 PWL(0 0.805000 3.000000e-09 0.805000 3.300000e-09 0.815000)
Rfb out inn 1m
Cload out 0 2.000000e-13
Xdut vdd vss inp inn out ib opamp_dut
.end
