* opa1000[0633]: 2p/pmos_miller_1v8_i1u_subth (pmos_miller, VDD=1.8V, CL=2.0pF, Iref=0.1625uA)
.include "pdk_opa.inc"
.temp 27
.option gmin=1e-12 rshunt=1e12 reltol=1e-3 abstol=1e-12 vntol=1e-5 method=gear
* Post-PEX R+C extracted netlist for pmos_miller_1v8_i1u_subth
.subckt opamp_dut vdd vss inp inn out ib
XMpar0 a_2482_11046.t0 inn.t0 a_6652_996.t0 vdd.t6 pfet_03v3 w=2.06u l=2.6u ad=7.4160e-13 pd=3.2950e-06 as=5.7680e-13 ps=2.6200e-06 nf=1 m=16 par=16
XMpar1 ib.t1 ib.t0 vss.t24 vss.t23 nfet_03v3 w=0.47u l=2.1u ad=2.8200e-13 pd=2.1400e-06 as=1.3160e-13 ps=1.0300e-06 nf=1 m=2 par=2
XMpar2 out.t1 a_1341_8663.t0 vdd.t1 vdd.t0 pfet_03v3 w=2.17u l=2.1u ad=7.4648e-13 pd=3.2920e-06 as=6.0760e-13 ps=2.7300e-06 nf=1 m=10 par=10
XMpar3 out.t2 a_794_1290.t19 vss.t1 vss.t0 nfet_03v3 w=1.34u l=2.7u ad=3.7520e-13 pd=1.9000e-06 as=4.6096e-13 ps=2.2960e-06 nf=1 m=10 par=10
XMpar4 a_2482_11046.t0 inp.t0 a_794_1290.t0 vdd.t6 pfet_03v3 w=2.06u l=2.6u ad=7.4160e-13 pd=3.2950e-06 as=5.7680e-13 ps=2.6200e-06 nf=1 m=16 par=16
XMpar5 a_6652_996.t17 a_6652_996.t16 vss.t1 vss.t0 nfet_03v3 w=1.34u l=2.7u ad=3.7520e-13 pd=1.9000e-06 as=3.7520e-13 ps=1.9000e-06 nf=1 m=2 par=2
XMpar6 a_1341_8663.t1 a_1341_8663.t0 vdd.t1 vdd.t0 pfet_03v3 w=2.17u l=2.1u ad=6.0760e-13 pd=2.7300e-06 as=6.0760e-13 ps=2.7300e-06 nf=1 m=2 par=2
XMpar7 a_2482_11046.t32 a_1341_8663.t0 vdd.t1 vdd.t0 pfet_03v3 w=2.17u l=2.1u ad=6.0760e-13 pd=2.7300e-06 as=6.0760e-13 ps=2.7300e-06 nf=1 m=4 par=4
XMpar8 a_1341_8663.t4 ib.t0 vss.t24 vss.t23 nfet_03v3 w=0.47u l=2.1u ad=1.3160e-13 pd=1.0300e-06 as=1.3160e-13 ps=1.0300e-06 nf=1 m=2 par=2
XMpar9 a_794_1290.t16 a_6652_996.t16 vss.t1 vss.t0 nfet_03v3 w=1.34u l=2.7u ad=8.0400e-13 pd=3.8800e-06 as=3.7520e-13 ps=1.9000e-06 nf=1 m=2 par=2
X12 a_794_1810.t0 a_4872_2330.t0 vss.t2 ppolyf_u_1k r_width=1u r_length=19.73u
X19 a_794_1810.t0 a_4872_1290.t0 vss.t2 ppolyf_u_1k r_width=1u r_length=19.73u
X45 a_794_1290.t18 a_4872_1290.t0 vss.t2 ppolyf_u_1k r_width=1u r_length=19.73u
X49 a_794_2850.t1 out.t0 cap_mim_2f0fF c_width=14.37u c_length=14.36u
X61 a_794_2850.t1 out.t0 cap_mim_2f0fF c_width=14.37u c_length=14.36u
X71 a_794_2850.t0 a_4872_2330.t0 vss.t2 ppolyf_u_1k r_width=1u r_length=19.73u
Rpar0 a_1341_8663.t0 a_1341_8663.t1 25.0983
Rpar1 a_1341_8663.t0 a_1341_8663.t4 121.8594
Rpar2 a_1341_8663.t1 a_1341_8663.t4 127.2426
Rpar3 a_2482_11046.t0 a_2482_11046.t32 102.0964
Rpar4 a_6652_996.t0 a_6652_996.t16 153.8283
Rpar5 a_6652_996.t0 a_6652_996.t17 137.5835
Rpar6 a_6652_996.t16 a_6652_996.t17 27.9772
Rpar7 a_794_1290.t0 a_794_1290.t16 286.1261
Rpar8 a_794_1290.t0 a_794_1290.t18 410.3510
Rpar9 a_794_1290.t0 a_794_1290.t19 76.3109
Rpar10 a_794_1290.t16 a_794_1290.t18 67.6819
Rpar11 a_794_1290.t16 a_794_1290.t19 146.8850
Rpar12 a_794_1290.t18 a_794_1290.t19 210.6568
Rpar13 a_794_2850.t0 a_794_2850.t1 75.9836
Rpar14 ib ib.t0 11.8717
Rpar15 ib ib.t1 7.9023
Rpar16 inn inn.t0 1.6222
Rpar17 inp inp.t0 1.6222
Rpar18 out out.t0 73.9780
Rpar19 out out.t1 51.3285
Rpar20 out out.t2 4.1916
Rpar21 out.t0 out.t1 280.8612
Rpar22 vdd vdd.t0 75.3288
Rpar23 vdd vdd.t1 385.2579
Rpar24 vdd vdd.t6 24.2818
Rpar25 vdd.t0 vdd.t1 4.7202
Rpar26 vdd.t0 vdd.t6 233.1125
Rpar27 vdd.t1 vdd.t6 1192.2191
Rpar28 vss vss.t0 23.5288
Rpar29 vss vss.t1 170.9672
Rpar30 vss vss.t2 151.2564
Rpar31 vss vss.t23 108.5045
Rpar32 vss vss.t24 703.0393
Rpar33 vss.t0 vss.t1 4.3020
Rpar34 vss.t0 vss.t2 4.6473
Rpar35 vss.t0 vss.t23 1.8485
Rpar36 vss.t0 vss.t24 15.5100
Rpar37 vss.t1 vss.t2 48.5566
Rpar38 vss.t1 vss.t23 21.0174
Rpar39 vss.t1 vss.t24 201.8866
Rpar40 vss.t2 vss.t23 13.7089
Rpar41 vss.t2 vss.t24 82.9292
Rpar42 vss.t23 vss.t24 35.8619
Cpar0 a_1341_8663.t0 vss 2.85854e-14
Cpar1 a_1341_8663.t1 vss 4.77533e-15
Cpar2 a_1341_8663.t4 vss 3.07815e-15
Cpar3 a_2482_11046.t0 vss 3.43435e-14
Cpar4 a_2482_11046.t32 vss 1.30067e-14
Cpar5 a_4872_1290.t0 vss 3.87000e-17
Cpar6 a_4872_2330.t0 vss 3.62800e-17
Cpar7 a_6652_996.t0 vss 1.09942e-14
Cpar8 a_6652_996.t16 vss 6.79901e-15
Cpar9 a_6652_996.t17 vss 2.71141e-15
Cpar10 a_794_1290.t0 vss 8.17443e-15
Cpar11 a_794_1290.t16 vss 2.76818e-15
Cpar12 a_794_1290.t18 vss 2.30299e-15
Cpar13 a_794_1290.t19 vss 1.15202e-14
Cpar14 a_794_1810.t0 vss 3.46800e-17
Cpar15 a_794_2850.t0 vss 2.10891e-16
Cpar16 a_794_2850.t1 vss 6.75912e-15
Cpar17 ib vss 8.16106e-15
Cpar18 ib.t0 vss 9.16231e-16
Cpar19 ib.t1 vss 6.39300e-17
Cpar20 inn inp 1.03350e-16
Cpar21 inn vdd 1.83315e-14
Cpar22 inn vss 4.72052e-15
Cpar23 inn.t0 vss 2.29063e-14
Cpar24 inp vdd 1.87120e-14
Cpar25 inp vss 4.66958e-15
Cpar26 inp.t0 vss 2.30014e-14
Cpar27 out vdd 7.73207e-15
Cpar28 out vss 1.90240e-14
Cpar29 out.t0 vss 1.28079e-14
Cpar30 out.t1 vss 4.97365e-15
Cpar31 out.t2 vss 1.06869e-15
Cpar32 vdd vss 1.73859e-13
Cpar33 vdd.t0 vss 2.67821e-14
Cpar34 vdd.t1 vss 7.26125e-15
Cpar35 vdd.t6 vss 5.20550e-14
.ends opamp_dut

Vdd vdd 0 1.800000
Vss vss 0 0
Ibias vdd ib 1.625000e-07
Vinp inp 0 DC 0.805000 AC 1 PWL(0 0.805000 1.671454e-07 0.805000 1.838599e-07 0.815000)
Rfb out inn 1m
Cload out 0 2.000000e-12
Xdut vdd vss inp inn out ib opamp_dut
.end
