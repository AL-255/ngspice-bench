* opa1000[0547]: 2p/pmos_5t_1v8_0p1u_1u_subth (pmos_5t, VDD=1.8V, CL=2.0pF, Iref=0.13uA)
.include "pdk_opa.inc"
.temp 27
.option gmin=1e-12 rshunt=1e12 reltol=1e-3 abstol=1e-12 vntol=1e-5 method=gear
* Post-PEX R+C extracted netlist for pmos_5t_1v8_0p1u_1u_subth
.subckt opamp_dut vdd vss inp inn out ib
XMpar0 a_2002_1294.t4 inn.t0 out.t2 vdd.t10 pfet_03v3 w=8u l=6.5u ad=2.8800e-12 pd=1.0720e-05 as=2.2400e-12 ps=8.5600e-06 nf=1 m=64 par=64
XMpar1 a_2002_1294.t4 inp.t0 a_3422_1294.t0 vdd.t10 pfet_03v3 w=8u l=6.5u ad=2.8800e-12 pd=1.0720e-05 as=2.2400e-12 ps=8.5600e-06 nf=1 m=64 par=64
XMpar2 a_1248_20249.t1 a_1248_20249.t0 vdd.t1 vdd.t0 pfet_03v3 w=3.37u l=4u ad=9.4360e-13 pd=3.9300e-06 as=9.4360e-13 ps=3.9300e-06 nf=1 m=2 par=2
XMpar3 a_2002_1294.t0 a_1248_20249.t0 vdd.t1 vdd.t0 pfet_03v3 w=3.37u l=4u ad=9.4360e-13 pd=3.9300e-06 as=1.2132e-12 ps=4.9325e-06 nf=1 m=8 par=8
XMpar4 ib.t1 ib.t0 vss.t6 vss.t5 nfet_03v3 w=0.78u l=4u ad=4.6800e-13 pd=2.7600e-06 as=2.1840e-13 ps=1.3400e-06 nf=1 m=2 par=2
XMpar5 a_1248_20249.t4 ib.t0 vss.t6 vss.t5 nfet_03v3 w=0.78u l=4u ad=2.1840e-13 pd=1.3400e-06 as=2.1840e-13 ps=1.3400e-06 nf=1 m=2 par=2
XMpar6 a_3422_1294.t65 a_3422_1294.t64 vss.t1 vss.t0 nfet_03v3 w=1.25u l=5u ad=7.5000e-13 pd=3.7000e-06 as=3.5000e-13 ps=1.8100e-06 nf=1 m=2 par=2
XMpar7 out.t0 a_3422_1294.t64 vss.t1 vss.t0 nfet_03v3 w=1.25u l=5u ad=7.5000e-13 pd=3.7000e-06 as=3.5000e-13 ps=1.8100e-06 nf=1 m=2 par=2
X31 out.t66 vss.t2 cap_mim_2f0fF c_width=6.71u c_length=6.71u
Rpar0 a_1248_20249.t0 a_1248_20249.t1 25.2198
Rpar1 a_1248_20249.t0 a_1248_20249.t4 152.4649
Rpar2 a_1248_20249.t1 a_1248_20249.t4 63.1053
Rpar3 a_2002_1294.t0 a_2002_1294.t4 52.1743
Rpar4 a_3422_1294.t0 a_3422_1294.t64 107.0891
Rpar5 a_3422_1294.t0 a_3422_1294.t65 105.0318
Rpar6 a_3422_1294.t64 a_3422_1294.t65 13.9308
Rpar7 ib ib.t0 11.7599
Rpar8 ib ib.t1 7.4533
Rpar9 inn inn.t0 1.7120
Rpar10 inp inp.t0 1.7120
Rpar11 out out.t0 10.4825
Rpar12 out out.t2 201.9378
Rpar13 out out.t66 128.4613
Rpar14 out.t0 out.t2 194.1656
Rpar15 out.t0 out.t66 123.5171
Rpar16 out.t2 out.t66 132.8761
Rpar17 vdd vdd.t0 147.1659
Rpar18 vdd vdd.t1 371.0846
Rpar19 vdd vdd.t10 83.3095
Rpar20 vdd.t0 vdd.t1 5.5582
Rpar21 vdd.t0 vdd.t10 90.7255
Rpar22 vdd.t1 vdd.t10 228.7679
Rpar23 vss vss.t0 922.9114
Rpar24 vss vss.t1 384.3828
Rpar25 vss vss.t6 1300.7824
Rpar26 vss vss.t5 355.0282
Rpar27 vss vss.t2 219.2256
Rpar28 vss.t0 vss.t1 60.7813
Rpar29 vss.t0 vss.t6 42.5522
Rpar30 vss.t0 vss.t5 8.2341
Rpar31 vss.t0 vss.t2 350.3780
Rpar32 vss.t1 vss.t6 147.5789
Rpar33 vss.t1 vss.t5 26.3675
Rpar34 vss.t1 vss.t2 145.9287
Rpar35 vss.t6 vss.t5 15.0812
Rpar36 vss.t6 vss.t2 493.8346
Rpar37 vss.t5 vss.t2 134.7844
Cpar0 a_1248_20249.t0 vss 3.14770e-14
Cpar1 a_1248_20249.t1 vss 4.19108e-15
Cpar2 a_1248_20249.t4 vss 2.43495e-15
Cpar3 a_2002_1294.t0 vss 9.89372e-15
Cpar4 a_2002_1294.t4 vss 2.55343e-13
Cpar5 a_3422_1294.t0 vss 1.36650e-13
Cpar6 a_3422_1294.t64 vss 1.58535e-14
Cpar7 a_3422_1294.t65 vss 5.62818e-15
Cpar8 ib vdd 1.05080e-16
Cpar9 ib vss 1.26927e-14
Cpar10 ib.t0 vss 1.54280e-15
Cpar11 ib.t1 vss 9.20200e-17
Cpar12 inn inp 4.13410e-16
Cpar13 inn out 6.91734e-14
Cpar14 inn vdd 1.34440e-13
Cpar15 inn vss 1.50553e-14
Cpar16 inn.t0 vss 2.48825e-13
Cpar17 inp vdd 1.34530e-13
Cpar18 inp vss 1.42303e-14
Cpar19 inp.t0 vss 2.49399e-13
Cpar20 out vdd 1.95470e-14
Cpar21 out vss 2.24792e-14
Cpar22 out.t0 vss 2.88849e-15
Cpar23 out.t2 vss 1.24386e-13
Cpar24 out.t66 vss 1.92972e-14
Cpar25 vdd vss 1.51236e-12
Cpar26 vdd.t0 vss 1.26507e-14
Cpar27 vdd.t1 vss 5.58031e-15
Cpar28 vdd.t10 vss 3.47360e-13
.ends opamp_dut

Vdd vdd 0 1.800000
Vss vss 0 0
Ibias vdd ib 1.300000e-07
Vinp inp 0 DC 0.805000 AC 1 PWL(0 0.805000 2.666288e-07 0.805000 2.932917e-07 0.815000)
Rfb out inn 1m
Cload out 0 2.000000e-12
Xdut vdd vss inp inn out ib opamp_dut
.end
