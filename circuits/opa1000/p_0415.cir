* opa1000[0415]: 2p/nmos_5t_3v3_i500u_subth (nmos_5t, VDD=3.3V, CL=2.0pF, Iref=143.75uA)
.include "pdk_opa.inc"
.temp 27
.option gmin=1e-12 rshunt=1e12 reltol=1e-3 abstol=1e-12 vntol=1e-5 method=gear
* Post-PEX R+C extracted netlist for nmos_5t_3v3_i500u_subth
.subckt opamp_dut vdd vss inp inn out ib
XMpar0 a_1640_4263.t161 a_1640_4263.t160 vdd.t1 vdd.t0 pfet_03v3 w=7.95u l=0.63u ad=2.4804e-12 pd=9.3690e-06 as=2.2260e-12 ps=8.5100e-06 nf=1 m=160 par=160
XMpar1 a_1196_1204.t0 inn.t0 out.t8 vss.t0 nfet_03v3 w=14u l=0.45u ad=4.0320e-12 pd=1.4926e-05 as=3.9760e-12 ps=1.4743e-05 nf=1 m=160 par=160
XMpar2 a_1196_1204.t160 ib.t0 vss.t108 vss.t0 nfet_03v3 w=7.84u l=0.36u ad=2.1952e-12 pd=8.4000e-06 as=2.2736e-12 ps=8.6650e-06 nf=1 m=64 par=64
XMpar3 a_1196_1204.t0 inp.t0 a_1640_4263.t0 vss.t0 nfet_03v3 w=14u l=0.45u ad=4.0334e-12 pd=1.4931e-05 as=3.9200e-12 ps=1.4560e-05 nf=1 m=158 par=158
XMpar4 out.t0 a_1640_4263.t160 vdd.t1 vdd.t0 pfet_03v3 w=7.95u l=0.63u ad=2.4804e-12 pd=9.3690e-06 as=2.3532e-12 ps=8.9395e-06 nf=1 m=160 par=160
XMpar5 a_1196_1204.t0 inp.t0 a_1640_4263.t0 vss.t225 nfet_03v3 w=14u l=0.45u ad=3.9200e-12 pd=1.4560e-05 as=8.4000e-12 ps=2.9200e-05 nf=1 m=2 par=2
XMpar6 ib.t1 ib.t0 vss.t108 vss.t0 nfet_03v3 w=7.84u l=0.36u ad=2.1952e-12 pd=8.4000e-06 as=2.1952e-12 ps=8.4000e-06 nf=1 m=15 par=15
XMpar7 ib.t1 ib.t0 vss.t108 vss.t225 nfet_03v3 w=7.84u l=0.36u ad=2.1952e-12 pd=8.4000e-06 as=2.1952e-12 ps=8.4000e-06 nf=1 m=1
Rpar0 a_1196_1204.t0 a_1196_1204.t160 28.9232
Rpar1 a_1640_4263.t0 a_1640_4263.t160 226.7592
Rpar2 a_1640_4263.t0 a_1640_4263.t161 46.9232
Rpar3 a_1640_4263.t160 a_1640_4263.t161 3.9096
Rpar4 ib ib.t0 12.9655
Rpar5 ib ib.t1 3.4361
Rpar6 inn inn.t0 2.5985
Rpar7 inp inp.t0 2.5985
Rpar8 out out.t0 2.4391
Rpar9 out.t0 out.t8 44.3214
Rpar10 vdd vdd.t0 18.8895
Rpar11 vdd.t0 vdd.t1 9.8435
Rpar12 vss vss.t0 26.7030
Rpar13 vss vss.t108 1455.3924
Rpar14 vss vss.t225 5144.7445
Rpar15 vss.t0 vss.t108 2.3368
Rpar16 vss.t0 vss.t225 4.0020
Rpar17 vss.t108 vss.t225 207.8095
Cpar0 a_1196_1204.t0 vss 7.69313e-13
Cpar1 a_1196_1204.t160 vss 9.11492e-14
Cpar2 a_1640_4263.t0 vss 3.42658e-13
Cpar3 a_1640_4263.t160 vss 3.81290e-13
Cpar4 a_1640_4263.t161 vss 2.57012e-13
Cpar5 ib inn 1.66500e-17
Cpar6 ib inp 6.15500e-17
Cpar7 ib vss 7.93678e-14
Cpar8 ib.t0 vss 1.11346e-14
Cpar9 ib.t1 vss 4.55782e-15
Cpar10 inn inp 1.05030e-16
Cpar11 inn out 5.31424e-14
Cpar12 inn vdd 2.43600e-17
Cpar13 inn vss 6.98604e-14
Cpar14 inn.t0 vss 8.73201e-14
Cpar15 inp vdd 2.40000e-17
Cpar16 inp vss 7.01042e-14
Cpar17 inp.t0 vss 8.74663e-14
Cpar18 out vdd 2.15930e-13
Cpar19 out vss 2.88547e-14
Cpar20 out.t0 vss 3.04370e-13
Cpar21 out.t8 vss 4.31453e-13
Cpar22 vdd vss 7.26677e-13
Cpar23 vdd.t0 vss 4.99524e-13
Cpar24 vdd.t1 vss 1.56871e-13
.ends opamp_dut

Vdd vdd 0 3.300000
Vss vss 0 0
Ibias vdd ib 1.437500e-04
Vinp inp 0 DC 1.645000 AC 1 PWL(0 1.645000 3.000000e-09 1.645000 3.300000e-09 1.655000)
Rfb out inn 1m
Cload out 0 2.000000e-12
Xdut vdd vss inp inn out ib opamp_dut
.end
