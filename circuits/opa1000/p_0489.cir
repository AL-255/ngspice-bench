* opa1000[0489]: 2p/nmos_miller_3v3_1u_10u_subth (nmos_miller, VDD=3.3V, CL=2.0pF, Iref=0.7143uA)
.include "pdk_opa.inc"
.temp 27
.option gmin=1e-12 rshunt=1e12 reltol=1e-3 abstol=1e-12 vntol=1e-5 method=gear
* Post-PEX R+C extracted netlist for nmos_miller_3v3_1u_10u_subth
.subckt opamp_dut vdd vss inp inn out ib
XMpar0 a_3184_5816.t0 inp.t0 a_842_8887.t3 vss.t0 nfet_03v3 w=1.84u l=1u ad=8.0960e-13 pd=3.6400e-06 as=5.1520e-13 ps=2.4000e-06 nf=1 m=4 par=4
XMpar1 out.t2 a_842_8887.t7 vdd.t1 vdd.t0 pfet_03v3 w=7.38u l=0.65u ad=2.0664e-12 pd=7.9400e-06 as=2.5387e-12 ps=9.5440e-06 nf=1 m=10 par=10
XMpar2 out.t0 ib.t0 vss.t6 vss.t5 nfet_03v3 w=1.54u l=1.6u ad=5.2976e-13 pd=2.5360e-06 as=4.3120e-13 ps=2.1000e-06 nf=1 m=10 par=10
XMpar3 a_3184_5816.t4 ib.t0 vss.t6 vss.t5 nfet_03v3 w=1.54u l=1.6u ad=4.3120e-13 pd=2.1000e-06 as=4.3120e-13 ps=2.1000e-06 nf=1 m=4 par=4
XMpar4 a_3184_5816.t0 inn.t0 a_6672_8728.t0 vss.t0 nfet_03v3 w=1.84u l=1u ad=8.0960e-13 pd=3.6400e-06 as=5.1520e-13 ps=2.4000e-06 nf=1 m=4 par=4
XMpar5 a_842_8887.t1 a_6672_8728.t4 vdd.t1 vdd.t0 pfet_03v3 w=7.38u l=0.65u ad=4.4280e-12 pd=1.5960e-05 as=2.0664e-12 ps=7.9400e-06 nf=1 m=2 par=2
XMpar6 ib.t1 ib.t0 vss.t6 vss.t5 nfet_03v3 w=1.54u l=1.6u ad=4.3120e-13 pd=2.1000e-06 as=4.3120e-13 ps=2.1000e-06 nf=1 m=2 par=2
XMpar7 a_6672_8728.t5 a_6672_8728.t4 vdd.t1 vdd.t0 pfet_03v3 w=7.38u l=0.65u ad=2.0664e-12 pd=7.9400e-06 as=2.0664e-12 ps=7.9400e-06 nf=1 m=2 par=2
X12 a_842_8887.t0 a_4390_8887.t0 vss.t4 ppolyf_u_1k r_width=1u r_length=17.08u
X14 a_4390_8887.t1 out.t3 cap_mim_2f0fF c_width=14.37u c_length=14.36u
X21 a_4390_8887.t1 out.t3 cap_mim_2f0fF c_width=14.37u c_length=14.36u
Rpar0 a_3184_5816.t0 a_3184_5816.t4 33.0890
Rpar1 a_4390_8887.t0 a_4390_8887.t1 63.1026
Rpar2 a_6672_8728.t0 a_6672_8728.t4 332.8254
Rpar3 a_6672_8728.t0 a_6672_8728.t5 73.1236
Rpar4 a_6672_8728.t4 a_6672_8728.t5 36.2770
Rpar5 a_842_8887.t0 a_842_8887.t1 106.7183
Rpar6 a_842_8887.t0 a_842_8887.t7 168.6521
Rpar7 a_842_8887.t0 a_842_8887.t3 117.5202
Rpar8 a_842_8887.t1 a_842_8887.t7 291.5367
Rpar9 a_842_8887.t1 a_842_8887.t3 67.3894
Rpar10 a_842_8887.t7 a_842_8887.t3 321.0456
Rpar11 ib ib.t0 22.7644
Rpar12 ib ib.t1 14.1357
Rpar13 ib.t0 ib.t1 64.5152
Rpar14 inn inn.t0 4.9526
Rpar15 inp inp.t0 5.0012
Rpar16 out out.t0 2.7602
Rpar17 out out.t2 269.1854
Rpar18 out out.t3 465.8892
Rpar19 out.t0 out.t2 95.0646
Rpar20 out.t0 out.t3 164.5319
Rpar21 out.t2 out.t3 127.8947
Rpar22 vdd vdd.t0 88.7606
Rpar23 vdd vdd.t1 152.2282
Rpar24 vdd.t0 vdd.t1 3.5317
Rpar25 vss vss.t0 683.0098
Rpar26 vss vss.t6 452.4029
Rpar27 vss vss.t5 64.3875
Rpar28 vss vss.t4 3834.2054
Rpar29 vss.t0 vss.t6 314.8052
Rpar30 vss.t0 vss.t5 41.3377
Rpar31 vss.t0 vss.t4 1197.3698
Rpar32 vss.t6 vss.t5 4.4884
Rpar33 vss.t6 vss.t4 372.4568
Rpar34 vss.t5 vss.t4 37.7100
Cpar0 a_3184_5816.t0 vss 7.85258e-15
Cpar1 a_3184_5816.t4 vss 5.36253e-15
Cpar2 a_4390_8887.t0 vss 1.03491e-16
Cpar3 a_4390_8887.t1 vss 4.10978e-15
Cpar4 a_6672_8728.t0 vss 3.07502e-15
Cpar5 a_6672_8728.t4 vss 4.10909e-15
Cpar6 a_6672_8728.t5 vss 4.53702e-15
Cpar7 a_842_8887.t0 vss 2.59229e-15
Cpar8 a_842_8887.t1 vss 4.81508e-15
Cpar9 a_842_8887.t3 vss 2.67945e-15
Cpar10 a_842_8887.t7 vss 9.69463e-15
Cpar11 ib out 1.36029e-15
Cpar12 ib vss 2.28656e-14
Cpar13 ib.t0 vss 4.28290e-15
Cpar14 ib.t1 vss 2.08332e-16
Cpar15 inn inp 5.14200e-17
Cpar16 inn vdd 1.87700e-17
Cpar17 inn vss 3.29618e-15
Cpar18 inn.t0 vss 5.58304e-16
Cpar19 inp vdd 1.72800e-17
Cpar20 inp vss 3.32640e-15
Cpar21 inp.t0 vss 5.54864e-16
Cpar22 out vdd 1.29685e-14
Cpar23 out vss 1.68549e-14
Cpar24 out.t0 vss 2.36667e-15
Cpar25 out.t2 vss 7.33369e-15
Cpar26 out.t3 vss 1.35683e-14
Cpar27 vdd vss 6.14518e-14
Cpar28 vdd.t0 vss 1.65034e-14
Cpar29 vdd.t1 vss 1.03576e-14
.ends opamp_dut

Vdd vdd 0 3.300000
Vss vss 0 0
Ibias vdd ib 7.143000e-07
Vinp inp 0 DC 1.645000 AC 1 PWL(0 1.645000 3.791736e-08 1.645000 4.170910e-08 1.655000)
Rfb out inn 1m
Cload out 0 2.000000e-12
Xdut vdd vss inp inn out ib opamp_dut
.end
