* opa1000[0593]: 200f/pmos_miller_1v8_i2u_subth (pmos_miller, VDD=1.8V, CL=0.2pF, Iref=0.175uA)
.include "pdk_opa.inc"
.temp 27
.option gmin=1e-12 rshunt=1e12 reltol=1e-3 abstol=1e-12 vntol=1e-5 method=gear
* Post-PEX R+C extracted netlist for pmos_miller_1v8_i2u_subth
.subckt opamp_dut vdd vss inp inn out ib
XMpar0 a_6660_1086.t13 a_6660_1086.t12 vss.t2 vss.t1 nfet_03v3 w=0.55u l=1.08u ad=1.5400e-13 pd=1.1100e-06 as=1.5400e-13 ps=1.1100e-06 nf=1 m=2 par=2
XMpar1 out.t0 a_1947_9443.t0 vdd.t1 vdd.t0 pfet_03v3 w=3.66u l=3.25u ad=1.7275e-12 pd=6.8000e-06 as=1.4933e-12 ps=5.9400e-06 nf=1 m=10 par=10
XMpar2 a_3359_9652.t1 inn.t0 a_6660_1086.t0 vdd.t5 pfet_03v3 w=1.85u l=1.52u ad=7.1533e-13 pd=3.2400e-06 as=5.1800e-13 ps=2.4100e-06 nf=1 m=12 par=12
XMpar3 a_3359_9652.t0 a_1947_9443.t0 vdd.t1 vdd.t0 pfet_03v3 w=3.66u l=3.25u ad=2.1960e-12 pd=8.5200e-06 as=1.0248e-12 ps=4.2200e-06 nf=1 m=4 par=4
XMpar4 out.t2 a_1015_3070.t15 vss.t2 vss.t1 nfet_03v3 w=0.55u l=1.08u ad=1.5400e-13 pd=1.1100e-06 as=1.8920e-13 ps=1.3480e-06 nf=1 m=10 par=10
XMpar5 ib.t1 ib.t0 vss.t26 vss.t25 nfet_03v3 w=0.83u l=3.25u ad=4.9800e-13 pd=2.8600e-06 as=2.3240e-13 ps=1.3900e-06 nf=1 m=2 par=2
XMpar6 a_1015_3070.t0 inp.t0 a_3359_9652.t1 vdd.t5 pfet_03v3 w=1.85u l=1.52u ad=5.1800e-13 pd=2.4100e-06 as=7.1533e-13 ps=3.2400e-06 nf=1 m=12 par=12
XMpar7 a_1015_3070.t12 a_6660_1086.t12 vss.t2 vss.t1 nfet_03v3 w=0.55u l=1.08u ad=3.3000e-13 pd=2.3000e-06 as=1.5400e-13 ps=1.1100e-06 nf=1 m=2 par=2
XMpar8 a_1947_9443.t1 a_1947_9443.t0 vdd.t1 vdd.t0 pfet_03v3 w=3.66u l=3.25u ad=2.1960e-12 pd=8.5200e-06 as=1.0248e-12 ps=4.2200e-06 nf=1 m=2 par=2
XMpar9 a_1947_9443.t4 ib.t0 vss.t26 vss.t25 nfet_03v3 w=0.83u l=3.25u ad=2.3240e-13 pd=1.3900e-06 as=2.3240e-13 ps=1.3900e-06 nf=1 m=2 par=2
X13 a_1015_3590.t0 a_4577_3070.t0 vss.t0 ppolyf_u_1k r_width=1u r_length=17.15u
X26 a_1015_3070.t14 a_4577_3070.t0 vss.t0 ppolyf_u_1k r_width=1u r_length=17.15u
X42 a_1015_4630.t0 a_4577_5150.t0 vss.t0 ppolyf_u_1k r_width=1u r_length=17.15u
X48 a_1015_4630.t0 a_4577_4110.t0 vss.t0 ppolyf_u_1k r_width=1u r_length=17.15u
X49 a_4577_5150.t1 out.t20 cap_mim_2f0fF c_width=11.46u c_length=11.46u
X58 a_1015_3590.t0 a_4577_4110.t0 vss.t0 ppolyf_u_1k r_width=1u r_length=17.15u
Rpar0 a_1015_3070.t0 a_1015_3070.t12 371.1194
Rpar1 a_1015_3070.t0 a_1015_3070.t14 154.8493
Rpar2 a_1015_3070.t0 a_1015_3070.t15 149.4349
Rpar3 a_1015_3070.t12 a_1015_3070.t14 173.7854
Rpar4 a_1015_3070.t12 a_1015_3070.t15 49.3552
Rpar5 a_1015_3070.t14 a_1015_3070.t15 69.9764
Rpar6 a_1947_9443.t0 a_1947_9443.t1 12.0804
Rpar7 a_1947_9443.t0 a_1947_9443.t4 252.6877
Rpar8 a_1947_9443.t1 a_1947_9443.t4 104.8744
Rpar9 a_3359_9652.t0 a_3359_9652.t1 48.7567
Rpar10 a_4577_5150.t0 a_4577_5150.t1 70.0501
Rpar11 a_6660_1086.t0 a_6660_1086.t12 115.3515
Rpar12 a_6660_1086.t0 a_6660_1086.t13 107.3469
Rpar13 a_6660_1086.t12 a_6660_1086.t13 30.4732
Rpar14 ib ib.t0 11.7968
Rpar15 ib ib.t1 7.2778
Rpar16 inn inn.t0 2.3271
Rpar17 inp inp.t0 2.3271
Rpar18 out out.t0 66.5558
Rpar19 out out.t2 3.5539
Rpar20 out out.t20 68.8672
Rpar21 out.t0 out.t20 349.8564
Rpar22 vdd vdd.t0 25.0644
Rpar23 vdd vdd.t1 337.1072
Rpar24 vdd vdd.t5 88.4753
Rpar25 vdd.t0 vdd.t1 12.3250
Rpar26 vdd.t0 vdd.t5 98.0101
Rpar27 vdd.t1 vdd.t5 1318.2028
Rpar28 vss vss.t0 510.3148
Rpar29 vss vss.t1 45.3136
Rpar30 vss vss.t2 193.9446
Rpar31 vss vss.t25 221.8080
Rpar32 vss vss.t26 971.4225
Rpar33 vss.t0 vss.t1 101.4900
Rpar34 vss.t0 vss.t2 428.3910
Rpar35 vss.t0 vss.t25 312.6105
Rpar36 vss.t0 vss.t26 1057.6097
Rpar37 vss.t1 vss.t2 4.1788
Rpar38 vss.t1 vss.t25 1.5246
Rpar39 vss.t1 vss.t26 14.6369
Rpar40 vss.t2 vss.t25 18.1771
Rpar41 vss.t2 vss.t26 110.2316
Rpar42 vss.t25 vss.t26 31.9088
Cpar0 a_1015_3070.t0 vss 5.87166e-15
Cpar1 a_1015_3070.t12 vss 1.32586e-15
Cpar2 a_1015_3070.t14 vss 1.98306e-15
Cpar3 a_1015_3070.t15 vss 4.59330e-15
Cpar4 a_1015_3590.t0 vss 4.16000e-17
Cpar5 a_1015_4630.t0 vss 3.85200e-17
Cpar6 a_1947_9443.t0 vss 4.53625e-14
Cpar7 a_1947_9443.t1 vss 9.13299e-15
Cpar8 a_1947_9443.t4 vss 3.56618e-15
Cpar9 a_3359_9652.t0 vss 1.81333e-14
Cpar10 a_3359_9652.t1 vss 2.20279e-14
Cpar11 a_4577_3070.t0 vss 3.06200e-17
Cpar12 a_4577_4110.t0 vss 3.39000e-17
Cpar13 a_4577_5150.t0 vss 1.97340e-16
Cpar14 a_4577_5150.t1 vss 2.46652e-15
Cpar15 a_6660_1086.t0 vss 1.05185e-14
Cpar16 a_6660_1086.t12 vss 4.03942e-15
Cpar17 a_6660_1086.t13 vss 1.98645e-15
Cpar18 ib out 1.00600e-17
Cpar19 ib vss 1.10142e-14
Cpar20 ib.t0 vss 1.25478e-15
Cpar21 ib.t1 vss 7.97800e-17
Cpar22 inn inp 1.03350e-16
Cpar23 inn vdd 9.83904e-15
Cpar24 inn vss 3.75546e-15
Cpar25 inn.t0 vss 1.14389e-14
Cpar26 inp vdd 9.77446e-15
Cpar27 inp vss 3.73481e-15
Cpar28 inp.t0 vss 1.13450e-14
Cpar29 out vdd 1.37356e-14
Cpar30 out vss 1.67133e-14
Cpar31 out.t0 vss 1.73305e-14
Cpar32 out.t2 vss 9.37764e-16
Cpar33 out.t20 vss 9.18780e-15
Cpar34 vdd vss 1.79347e-13
Cpar35 vdd.t0 vss 4.74368e-14
Cpar36 vdd.t1 vss 8.31877e-15
Cpar37 vdd.t5 vss 2.76718e-14
.ends opamp_dut

Vdd vdd 0 1.800000
Vss vss 0 0
Ibias vdd ib 1.750000e-07
Vinp inp 0 DC 0.805000 AC 1 PWL(0 0.805000 4.583596e-08 0.805000 5.041956e-08 0.815000)
Rfb out inn 1m
Cload out 0 2.000000e-13
Xdut vdd vss inp inn out ib opamp_dut
.end
