* opa1000[0548]: 2p/pmos_5t_1v8_0p1u_1u_weak (pmos_5t, VDD=1.8V, CL=2.0pF, Iref=0.13uA)
.include "pdk_opa.inc"
.temp 27
.option gmin=1e-12 rshunt=1e12 reltol=1e-3 abstol=1e-12 vntol=1e-5 method=gear
* Post-PEX R+C extracted netlist for pmos_5t_1v8_0p1u_1u_weak
.subckt opamp_dut vdd vss inp inn out ib
XMpar0 a_1682_4587.t0 inp.t0 a_3802_4587.t0 vdd.t8 pfet_03v3 w=1.95u l=10u ad=7.8600e-13 pd=3.5062e-06 as=7.3800e-13 ps=3.3069e-06 nf=1 m=26 par=26
XMpar1 a_1098_996.t0 ib.t0 vss.t1 vss.t0 nfet_03v3 w=0.4u l=3.25u ad=1.1200e-13 pd=9.6000e-07 as=1.1200e-13 ps=9.6000e-07 nf=1 m=2 par=2
XMpar2 a_1682_4587.t52 a_1098_996.t2 vdd.t1 vdd.t0 pfet_03v3 w=0.83u l=3.25u ad=2.3240e-13 pd=1.3900e-06 as=2.9880e-13 ps=1.7575e-06 nf=1 m=8 par=8
XMpar3 a_1682_4587.t0 inn.t0 out.t0 vdd.t8 pfet_03v3 w=1.95u l=10u ad=7.8600e-13 pd=3.5062e-06 as=7.3800e-13 ps=3.3069e-06 nf=1 m=26 par=26
XMpar4 out.t25 a_3802_4587.t26 vss.t9 vss.t8 nfet_03v3 w=0.5u l=5u ad=1.4000e-13 pd=1.0600e-06 as=1.4000e-13 ps=1.0600e-06 nf=1 m=2 par=2
XMpar5 a_3802_4587.t27 a_3802_4587.t26 vss.t9 vss.t8 nfet_03v3 w=0.5u l=5u ad=3.0000e-13 pd=2.2000e-06 as=1.4000e-13 ps=1.0600e-06 nf=1 m=2 par=2
XMpar6 ib.t1 ib.t0 vss.t1 vss.t0 nfet_03v3 w=0.4u l=3.25u ad=2.4000e-13 pd=2.0000e-06 as=1.1200e-13 ps=9.6000e-07 nf=1 m=2 par=2
XMpar7 a_1098_996.t3 a_1098_996.t2 vdd.t1 vdd.t0 pfet_03v3 w=0.83u l=3.25u ad=2.3240e-13 pd=1.3900e-06 as=2.3240e-13 ps=1.3900e-06 nf=1 m=2 par=2
X49 out.t28 vss.t12 cap_mim_2f0fF c_width=7.75u c_length=7.75u
Rpar0 a_1098_996.t0 a_1098_996.t2 152.1132
Rpar1 a_1098_996.t0 a_1098_996.t3 118.9353
Rpar2 a_1098_996.t2 a_1098_996.t3 28.8023
Rpar3 a_1682_4587.t0 a_1682_4587.t52 52.6487
Rpar4 a_3802_4587.t0 a_3802_4587.t26 157.6925
Rpar5 a_3802_4587.t0 a_3802_4587.t27 113.9817
Rpar6 a_3802_4587.t26 a_3802_4587.t27 21.1207
Rpar7 ib ib.t0 16.5165
Rpar8 ib ib.t1 9.1025
Rpar9 ib.t0 ib.t1 93.6366
Rpar10 inn inn.t0 2.1466
Rpar11 inp inp.t0 2.1467
Rpar12 out out.t0 89.0098
Rpar13 out out.t25 61.6179
Rpar14 out out.t28 14.8350
Rpar15 out.t0 out.t25 165.3884
Rpar16 out.t0 out.t28 1449.2808
Rpar17 out.t25 out.t28 1003.2791
Rpar18 vdd vdd.t0 201.5567
Rpar19 vdd vdd.t1 556.2753
Rpar20 vdd vdd.t8 20.8942
Rpar21 vdd.t0 vdd.t1 6.0701
Rpar22 vdd.t0 vdd.t8 214.9170
Rpar23 vdd.t1 vdd.t8 593.1484
Rpar24 vss vss.t0 61.5623
Rpar25 vss vss.t1 187.9134
Rpar26 vss vss.t8 159.2564
Rpar27 vss vss.t9 300.6401
Rpar28 vss vss.t12 66.1682
Rpar29 vss.t0 vss.t1 16.8154
Rpar30 vss.t0 vss.t8 17.0670
Rpar31 vss.t0 vss.t9 33.3868
Rpar32 vss.t0 vss.t12 138.8507
Rpar33 vss.t1 vss.t8 55.0919
Rpar34 vss.t1 vss.t9 113.3557
Rpar35 vss.t1 vss.t12 423.8292
Rpar36 vss.t8 vss.t9 23.1845
Rpar37 vss.t8 vss.t12 359.1947
Rpar38 vss.t9 vss.t12 678.0786
Cpar0 a_1098_996.t0 vss 3.83091e-15
Cpar1 a_1098_996.t2 vss 2.12929e-14
Cpar2 a_1098_996.t3 vss 3.91421e-15
Cpar3 a_1682_4587.t0 vss 1.14513e-13
Cpar4 a_1682_4587.t52 vss 8.88013e-15
Cpar5 a_3802_4587.t0 vss 5.76281e-14
Cpar6 a_3802_4587.t26 vss 1.28724e-14
Cpar7 a_3802_4587.t27 vss 5.03965e-15
Cpar8 ib vdd 1.83040e-16
Cpar9 ib vss 1.08719e-14
Cpar10 ib.t0 vss 1.26405e-15
Cpar11 ib.t1 vss 8.40174e-17
Cpar12 inn inp 4.13460e-16
Cpar13 inn out 2.50405e-14
Cpar14 inn vdd 8.25423e-14
Cpar15 inn vss 6.99733e-15
Cpar16 inn.t0 vss 1.16958e-13
Cpar17 inp vdd 8.23778e-14
Cpar18 inp vss 6.99386e-15
Cpar19 inp.t0 vss 1.16770e-13
Cpar20 out vdd 1.46416e-14
Cpar21 out vss 1.48104e-14
Cpar22 out.t0 vss 4.56340e-14
Cpar23 out.t25 vss 3.23642e-15
Cpar24 out.t28 vss 2.24028e-14
Cpar25 vdd vss 5.39328e-13
Cpar26 vdd.t0 vss 1.69820e-14
Cpar27 vdd.t1 vss 5.95459e-15
Cpar28 vdd.t8 vss 2.00199e-13
.ends opamp_dut

Vdd vdd 0 1.800000
Vss vss 0 0
Ibias vdd ib 1.300000e-07
Vinp inp 0 DC 0.805000 AC 1 PWL(0 0.805000 2.951570e-07 0.805000 3.246727e-07 0.815000)
Rfb out inn 1m
Cload out 0 2.000000e-12
Xdut vdd vss inp inn out ib opamp_dut
.end
