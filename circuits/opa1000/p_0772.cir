* opa1000[0772]: 200f/symmetrical_ota_3v3_i50n_subth (symmetrical_ota, VDD=3.3V, CL=0.2pF, Iref=0.0083uA)
.include "pdk_opa.inc"
.temp 27
.option gmin=1e-12 rshunt=1e12 reltol=1e-3 abstol=1e-12 vntol=1e-5 method=gear
* Post-PEX R+C extracted netlist for symmetrical_ota_3v3_i50n_subth
.subckt opamp_dut vdd vss inp inn out ib
XMpar0 a_4474_7243.t4 ib.t0 vss.t12 vss.t11 nfet_03v3 w=0.4u l=5u ad=1.1200e-13 pd=9.6000e-07 as=1.7600e-13 ps=1.4800e-06 nf=1 m=4 par=4
XMpar1 a_8090_4061.t3 a_8090_4061.t2 vdd.t1 vdd.t0 pfet_03v3 w=0.4u l=6.5u ad=2.4000e-13 pd=2.0000e-06 as=1.1200e-13 ps=9.6000e-07 nf=1 m=2 par=2
XMpar2 out.t0 a_4598_1041.t4 vss.t1 vss.t0 nfet_03v3 w=0.4u l=6.5u ad=2.4000e-13 pd=2.0000e-06 as=1.1200e-13 ps=9.6000e-07 nf=1 m=4 par=4
XMpar3 a_1749_4061.t3 a_1749_4061.t2 vdd.t1 vdd.t0 pfet_03v3 w=0.4u l=6.5u ad=2.4000e-13 pd=2.0000e-06 as=1.1200e-13 ps=9.6000e-07 nf=1 m=2 par=2
XMpar4 out.t2 a_1749_4061.t2 vdd.t1 vdd.t0 pfet_03v3 w=0.4u l=6.5u ad=2.4000e-13 pd=2.0000e-06 as=1.7600e-13 ps=1.4800e-06 nf=1 m=4 par=4
XMpar5 a_4598_1041.t5 a_4598_1041.t4 vss.t1 vss.t0 nfet_03v3 w=0.4u l=6.5u ad=1.1200e-13 pd=9.6000e-07 as=1.1200e-13 ps=9.6000e-07 nf=1 m=4 par=4
XMpar6 ib.t1 ib.t0 vss.t12 vss.t11 nfet_03v3 w=0.4u l=5u ad=1.1200e-13 pd=9.6000e-07 as=1.1200e-13 ps=9.6000e-07 nf=1 m=2 par=2
XMpar7 a_1749_4061.t0 inp.t0 a_4474_7243.t0 vss.t2 nfet_03v3 w=1.08u l=5.5u ad=3.0240e-13 pd=1.6400e-06 as=6.4800e-13 ps=3.3600e-06 nf=1 m=2 par=2
XMpar8 a_4598_1041.t0 a_8090_4061.t2 vdd.t1 vdd.t0 pfet_03v3 w=0.4u l=6.5u ad=2.4000e-13 pd=2.0000e-06 as=1.7600e-13 ps=1.4800e-06 nf=1 m=4 par=4
XMpar9 a_4474_7243.t0 inn.t0 a_8090_4061.t0 vss.t2 nfet_03v3 w=1.08u l=5.5u ad=6.4800e-13 pd=3.3600e-06 as=3.0240e-13 ps=1.6400e-06 nf=1 m=2 par=2
X4 out.t8 vss.t26 cap_mim_2f0fF c_width=10u c_length=10u
Rpar0 a_1749_4061.t0 a_1749_4061.t2 100.9223
Rpar1 a_1749_4061.t0 a_1749_4061.t3 151.5186
Rpar2 a_1749_4061.t2 a_1749_4061.t3 15.8939
Rpar3 a_4474_7243.t0 a_4474_7243.t4 61.6223
Rpar4 a_4598_1041.t0 a_4598_1041.t4 91.6220
Rpar5 a_4598_1041.t0 a_4598_1041.t5 86.0279
Rpar6 a_4598_1041.t4 a_4598_1041.t5 15.1338
Rpar7 a_8090_4061.t0 a_8090_4061.t2 100.9221
Rpar8 a_8090_4061.t0 a_8090_4061.t3 151.5191
Rpar9 a_8090_4061.t2 a_8090_4061.t3 15.8939
Rpar10 ib ib.t0 20.6783
Rpar11 ib ib.t1 19.4533
Rpar12 ib.t0 ib.t1 91.1507
Rpar13 inn inn.t0 3.4811
Rpar14 inp inp.t0 3.5296
Rpar15 out out.t0 8.1718
Rpar16 out out.t2 113.4400
Rpar17 out out.t8 331.7153
Rpar18 out.t0 out.t2 152.6966
Rpar19 out.t0 out.t8 446.5074
Rpar20 out.t2 out.t8 81.1923
Rpar21 vdd vdd.t0 225.3680
Rpar22 vdd vdd.t1 91.4043
Rpar23 vdd.t0 vdd.t1 7.5622
Rpar24 vss vss.t0 77.4494
Rpar25 vss vss.t1 281.8364
Rpar26 vss vss.t11 359.7058
Rpar27 vss vss.t12 1625.7256
Rpar28 vss vss.t2 725.0566
Rpar29 vss vss.t26 7084.8648
Rpar30 vss.t0 vss.t1 18.9003
Rpar31 vss.t0 vss.t11 87.7625
Rpar32 vss.t0 vss.t12 396.3300
Rpar33 vss.t0 vss.t2 177.0094
Rpar34 vss.t0 vss.t26 1734.2044
Rpar35 vss.t1 vss.t11 319.2754
Rpar36 vss.t1 vss.t12 1441.7618
Rpar37 vss.t1 vss.t2 643.9680
Rpar38 vss.t1 vss.t26 6309.7282
Rpar39 vss.t11 vss.t12 10.4994
Rpar40 vss.t11 vss.t2 5.8178
Rpar41 vss.t11 vss.t26 95.1084
Rpar42 vss.t12 vss.t2 24.2056
Rpar43 vss.t12 vss.t26 300.2595
Rpar44 vss.t2 vss.t26 214.9463
Cpar0 a_1749_4061.t0 vss 4.12466e-15
Cpar1 a_1749_4061.t2 vss 2.73621e-14
Cpar2 a_1749_4061.t3 vss 6.21456e-15
Cpar3 a_4474_7243.t0 vss 4.58523e-15
Cpar4 a_4474_7243.t4 vss 4.54788e-15
Cpar5 a_4598_1041.t0 vss 4.46807e-15
Cpar6 a_4598_1041.t4 vss 1.32275e-14
Cpar7 a_4598_1041.t5 vss 2.72352e-15
Cpar8 a_8090_4061.t0 vss 3.87501e-15
Cpar9 a_8090_4061.t2 vss 2.57059e-14
Cpar10 a_8090_4061.t3 vss 5.83840e-15
Cpar11 ib inn 2.40300e-17
Cpar12 ib inp 1.83000e-17
Cpar13 ib out 1.88700e-17
Cpar14 ib vdd 9.13900e-17
Cpar15 ib vss 2.12324e-14
Cpar16 ib.t0 vss 2.95765e-15
Cpar17 ib.t1 vss 1.35146e-16
Cpar18 inn inp 5.23500e-17
Cpar19 inn vdd 3.92100e-17
Cpar20 inn vss 6.00091e-15
Cpar21 inn.t0 vss 5.73400e-16
Cpar22 inp vdd 1.46930e-16
Cpar23 inp vss 5.91588e-15
Cpar24 inp.t0 vss 6.52588e-16
Cpar25 out vdd 7.63723e-15
Cpar26 out vss 2.06385e-14
Cpar27 out.t0 vss 1.78839e-15
Cpar28 out.t2 vss 3.21348e-15
Cpar29 out.t8 vss 1.44703e-14
Cpar30 vdd vss 1.16471e-13
Cpar31 vdd.t0 vss 5.16064e-14
Cpar32 vdd.t1 vss 1.13488e-14
.ends opamp_dut

Vdd vdd 0 3.300000
Vss vss 0 0
Ibias vdd ib 8.300000e-09
Vinp inp 0 DC 1.645000 AC 1 PWL(0 1.645000 7.336369e-07 1.645000 8.070006e-07 1.655000)
Rfb out inn 1m
Cload out 0 2.000000e-13
Xdut vdd vss inp inn out ib opamp_dut
.end
