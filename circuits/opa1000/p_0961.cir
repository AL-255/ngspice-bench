* opa1000[0961]: 2p/telescopic_pmos_1v8_i50n_subth (telescopic_pmos, VDD=1.8V, CL=2.0pF, Iref=0.013uA)
.include "pdk_opa.inc"
.temp 27
.option gmin=1e-12 rshunt=1e12 reltol=1e-3 abstol=1e-12 vntol=1e-5 method=gear
* Post-PEX R+C extracted netlist for telescopic_pmos_1v8_i50n_subth
.subckt opamp_dut vdd vss inp inn out ib
XMpar0 a_7464_11247.t2 a_3852_12769.t8 vss.t10 vss.t9 nfet_03v3 w=0.4u l=9.75u ad=1.1200e-13 pd=9.6000e-07 as=1.1200e-13 ps=9.6000e-07 nf=1 m=2 par=2
XMpar1 a_4437_6576.t3 a_4437_6576.t2 vdd.t2 vdd.t1 pfet_03v3 w=0.53u l=6.25u ad=3.1800e-13 pd=2.2600e-06 as=1.4840e-13 ps=1.0900e-06 nf=1 m=2 par=2
XMpar2 a_1746_1249.t3 inn.t0 a_8014_9604.t0 vdd.t9 pfet_03v3 w=8u l=6.88u ad=3.5200e-12 pd=1.2880e-05 as=2.2400e-12 ps=8.5600e-06 nf=1 m=8 par=8
XMpar3 ib.t1 ib.t0 vss.t2 vss.t1 nfet_03v3 w=0.4u l=6.25u ad=2.4000e-13 pd=2.0000e-06 as=1.1200e-13 ps=9.6000e-07 nf=1 m=2 par=2
XMpar4 a_1746_1249.t3 inp.t0 a_3242_1249.t0 vdd.t9 pfet_03v3 w=8u l=6.88u ad=3.5200e-12 pd=1.2880e-05 as=2.2400e-12 ps=8.5600e-06 nf=1 m=8 par=8
XMpar5 a_1746_1249.t0 a_4437_6576.t2 vdd.t2 vdd.t1 pfet_03v3 w=0.53u l=6.25u ad=1.4840e-13 pd=1.0900e-06 as=2.7560e-13 ps=1.9675e-06 nf=1 m=8 par=8
XMpar6 a_7464_11247.t0 a_3852_12769.t0 out.t0 vss.t0 nfet_03v3 w=0.4u l=2.1u ad=2.4000e-13 pd=2.0000e-06 as=1.1200e-13 ps=9.6000e-07 nf=1 m=2 par=2
XMpar7 a_4437_6576.t0 ib.t0 vss.t2 vss.t1 nfet_03v3 w=0.4u l=6.25u ad=2.4000e-13 pd=2.0000e-06 as=1.1200e-13 ps=9.6000e-07 nf=1 m=2 par=2
XMpar8 a_3732_12977.t2 a_3852_12769.t8 vss.t10 vss.t9 nfet_03v3 w=0.4u l=9.75u ad=2.4000e-13 pd=2.0000e-06 as=1.1200e-13 ps=9.6000e-07 nf=1 m=2 par=2
XMpar9 a_3732_12977.t0 a_3852_12769.t0 a_3852_12769.t1 vss.t0 nfet_03v3 w=0.4u l=2.1u ad=2.4000e-13 pd=2.0000e-06 as=2.4000e-13 ps=2.0000e-06 nf=1 m=2 par=2
XMpar10 a_3242_1249.t8 vss.t19 a_3852_12769.t4 vdd.t0 pfet_03v3 w=1.56u l=2.1u ad=9.3600e-13 pd=4.3200e-06 as=4.3680e-13 ps=2.1200e-06 nf=1 m=2 par=2
XMpar11 a_8014_9604.t8 vss.t19 out.t2 vdd.t0 pfet_03v3 w=1.56u l=2.1u ad=9.3600e-13 pd=4.3200e-06 as=4.3680e-13 ps=2.1200e-06 nf=1 m=2 par=2
X17 out.t4 vss.t12 cap_mim_2f0fF c_width=7.75u c_length=7.75u
Rpar0 a_1746_1249.t0 a_1746_1249.t3 60.9173
Rpar1 a_3242_1249.t0 a_3242_1249.t8 68.4671
Rpar2 a_3732_12977.t0 a_3732_12977.t2 59.2909
Rpar3 a_3852_12769.t0 a_3852_12769.t1 24.7384
Rpar4 a_3852_12769.t0 a_3852_12769.t8 182.5709
Rpar5 a_3852_12769.t0 a_3852_12769.t4 225.9881
Rpar6 a_3852_12769.t1 a_3852_12769.t8 132.1886
Rpar7 a_3852_12769.t1 a_3852_12769.t4 163.6243
Rpar8 a_3852_12769.t8 a_3852_12769.t4 120.9967
Rpar9 a_4437_6576.t0 a_4437_6576.t2 74.8141
Rpar10 a_4437_6576.t0 a_4437_6576.t3 117.8740
Rpar11 a_4437_6576.t2 a_4437_6576.t3 15.8290
Rpar12 a_7464_11247.t0 a_7464_11247.t2 78.2379
Rpar13 a_8014_9604.t0 a_8014_9604.t8 68.4671
Rpar14 ib ib.t0 9.6148
Rpar15 ib ib.t1 11.8107
Rpar16 ib.t0 ib.t1 43.7886
Rpar17 inn inn.t0 2.6952
Rpar18 inp inp.t0 2.6952
Rpar19 out out.t0 54.8440
Rpar20 out out.t2 8.8834
Rpar21 out out.t4 110.7195
Rpar22 out.t0 out.t4 134.2025
Rpar23 vdd vdd.t0 433.0345
Rpar24 vdd vdd.t1 70.5039
Rpar25 vdd vdd.t9 325.3542
Rpar26 vdd vdd.t2 741.3769
Rpar27 vdd.t0 vdd.t1 67.4843
Rpar28 vdd.t0 vdd.t9 365.5236
Rpar29 vdd.t0 vdd.t2 709.6253
Rpar30 vdd.t1 vdd.t9 59.5122
Rpar31 vdd.t1 vdd.t2 12.9698
Rpar32 vdd.t9 vdd.t2 625.7949
Rpar33 vss vss.t0 576.7290
Rpar34 vss vss.t1 508.2821
Rpar35 vss vss.t10 1975.0670
Rpar36 vss vss.t12 834.6813
Rpar37 vss vss.t9 505.4933
Rpar38 vss vss.t19 329.3613
Rpar39 vss vss.t2 177.7055
Rpar40 vss.t0 vss.t1 20.2755
Rpar41 vss.t0 vss.t10 33.7278
Rpar42 vss.t0 vss.t12 455.9525
Rpar43 vss.t0 vss.t9 8.3362
Rpar44 vss.t0 vss.t19 144.5668
Rpar45 vss.t0 vss.t2 81.1067
Rpar46 vss.t1 vss.t10 59.6885
Rpar47 vss.t1 vss.t12 580.9473
Rpar48 vss.t1 vss.t9 16.0604
Rpar49 vss.t1 vss.t19 235.0513
Rpar50 vss.t1 vss.t2 49.2686
Rpar51 vss.t10 vss.t12 1620.8039
Rpar52 vss.t10 vss.t9 27.8580
Rpar53 vss.t10 vss.t19 595.3134
Rpar54 vss.t10 vss.t2 247.5009
Rpar55 vss.t12 vss.t9 417.7639
Rpar56 vss.t12 vss.t19 210.5266
Rpar57 vss.t12 vss.t2 385.9925
Rpar58 vss.t9 vss.t19 143.9983
Rpar59 vss.t9 vss.t2 64.8044
Rpar60 vss.t19 vss.t2 153.2695
Cpar0 a_1746_1249.t0 vss 1.07124e-14
Cpar1 a_1746_1249.t3 vss 4.53752e-14
Cpar2 a_3242_1249.t0 vss 1.85983e-14
Cpar3 a_3242_1249.t8 vss 4.59855e-15
Cpar4 a_3732_12977.t0 vss 3.53030e-15
Cpar5 a_3732_12977.t2 vss 5.82169e-15
Cpar6 a_3852_12769.t0 vss 1.53236e-15
Cpar7 a_3852_12769.t1 vss 7.80653e-16
Cpar8 a_3852_12769.t4 vss 6.68974e-16
Cpar9 a_3852_12769.t8 vss 4.98872e-15
Cpar10 a_4437_6576.t0 vss 6.83785e-15
Cpar11 a_4437_6576.t2 vss 4.07987e-14
Cpar12 a_4437_6576.t3 vss 7.10475e-15
Cpar13 a_7464_11247.t0 vss 5.73825e-15
Cpar14 a_7464_11247.t2 vss 6.48535e-15
Cpar15 a_8014_9604.t0 vss 2.03398e-14
Cpar16 a_8014_9604.t8 vss 5.02915e-15
Cpar17 ib inp 1.93900e-17
Cpar18 ib vdd 5.27500e-17
Cpar19 ib vss 2.08041e-14
Cpar20 ib.t0 vss 2.95802e-15
Cpar21 ib.t1 vss 3.30708e-16
Cpar22 inn inp 1.04540e-16
Cpar23 inn vdd 2.23549e-14
Cpar24 inn vss 5.87862e-15
Cpar25 inn.t0 vss 3.16539e-14
Cpar26 inp vdd 2.21319e-14
Cpar27 inp vss 6.18598e-15
Cpar28 inp.t0 vss 3.14361e-14
Cpar29 out vdd 1.51113e-15
Cpar30 out vss 9.54654e-15
Cpar31 out.t0 vss 6.89483e-16
Cpar32 out.t2 vss 3.33695e-17
Cpar33 out.t4 vss 5.95772e-15
Cpar34 vdd vss 3.28360e-13
Cpar35 vdd.t0 vss 6.08564e-15
Cpar36 vdd.t1 vss 2.86417e-14
Cpar37 vdd.t2 vss 4.29582e-15
Cpar38 vdd.t9 vss 7.66021e-14
.ends opamp_dut

Vdd vdd 0 1.800000
Vss vss 0 0
Ibias vdd ib 1.300000e-08
Vinp inp 0 DC 0.805000 AC 1 PWL(0 0.805000 2.053149e-06 0.805000 2.258463e-06 0.815000)
Rfb out inn 1m
Cload out 0 2.000000e-12
Xdut vdd vss inp inn out ib opamp_dut
.end
