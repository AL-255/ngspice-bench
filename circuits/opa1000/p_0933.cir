* opa1000[0933]: 200f/telescopic_pmos_1v8_i20u_weak (telescopic_pmos, VDD=1.8V, CL=0.2pF, Iref=4.6uA)
.include "pdk_opa.inc"
.temp 27
.option gmin=1e-12 rshunt=1e12 reltol=1e-3 abstol=1e-12 vntol=1e-5 method=gear
* Post-PEX R+C extracted netlist for telescopic_pmos_1v8_i20u_weak
.subckt opamp_dut vdd vss inp inn out ib
XMpar0 a_4104_11989.t0 inp.t0 a_4118_9095.t0 vdd.t5 pfet_03v3 w=2.02u l=1.13u ad=6.1532e-13 pd=2.7846e-06 as=6.1532e-13 ps=2.7846e-06 nf=1 m=52 par=52
XMpar1 a_4104_11989.t0 inn.t0 a_8814_11989.t0 vdd.t5 pfet_03v3 w=2.02u l=1.13u ad=6.1532e-13 pd=2.7846e-06 as=6.1532e-13 ps=2.7846e-06 nf=1 m=52 par=52
XMpar2 a_8814_11989.t52 vss.t41 out.t0 vdd.t4 pfet_03v3 w=2.03u l=0.9u ad=6.1171e-13 pd=2.7680e-06 as=6.1171e-13 ps=2.7680e-06 nf=1 m=30 par=30
XMpar3 a_4118_9095.t52 vss.t41 a_4418_9095.t16 vdd.t4 pfet_03v3 w=2.03u l=0.9u ad=6.1171e-13 pd=2.7680e-06 as=6.1171e-13 ps=2.7680e-06 nf=1 m=30 par=30
XMpar4 a_4418_9095.t1 a_4418_9095.t0 a_6184_6973.t0 vss.t0 nfet_03v3 w=1.69u l=0.9u ad=4.7320e-13 pd=2.2500e-06 as=7.4360e-13 ps=3.4150e-06 nf=1 m=8 par=8
XMpar5 a_6184_6973.t2 a_4418_9095.t46 vss.t2 vss.t1 nfet_03v3 w=1.92u l=1.69u ad=5.3760e-13 pd=2.4800e-06 as=8.4480e-13 ps=3.7600e-06 nf=1 m=4 par=4
XMpar6 a_7628_6973.t2 a_4418_9095.t0 out.t1 vss.t0 nfet_03v3 w=1.69u l=0.9u ad=6.0840e-13 pd=2.8325e-06 as=4.7320e-13 ps=2.2500e-06 nf=1 m=8 par=8
XMpar7 a_4104_11989.t104 a_1757_3168.t2 vdd.t1 vdd.t0 pfet_03v3 w=10u l=1.2u ad=2.8000e-12 pd=1.0560e-05 as=3.6000e-12 ps=1.3220e-05 nf=1 m=8 par=8
XMpar8 ib.t1 ib.t0 vss.t16 vss.t15 nfet_03v3 w=2.29u l=1.2u ad=1.3740e-12 pd=5.7800e-06 as=6.4120e-13 ps=2.8500e-06 nf=1 m=2 par=2
XMpar9 a_7628_6973.t0 a_4418_9095.t46 vss.t2 vss.t1 nfet_03v3 w=1.92u l=1.69u ad=5.3760e-13 pd=2.4800e-06 as=5.3760e-13 ps=2.4800e-06 nf=1 m=4 par=4
XMpar10 a_1757_3168.t0 ib.t0 vss.t16 vss.t15 nfet_03v3 w=2.29u l=1.2u ad=6.4120e-13 pd=2.8500e-06 as=6.4120e-13 ps=2.8500e-06 nf=1 m=2 par=2
XMpar11 a_1757_3168.t3 a_1757_3168.t2 vdd.t1 vdd.t0 pfet_03v3 w=10u l=1.2u ad=2.8000e-12 pd=1.0560e-05 as=2.8000e-12 ps=1.0560e-05 nf=1 m=2 par=2
X130 out.t38 vss.t8 cap_mim_2f0fF c_width=19.27u c_length=19.27u
Rpar0 a_1757_3168.t0 a_1757_3168.t2 158.5943
Rpar1 a_1757_3168.t0 a_1757_3168.t3 80.0351
Rpar2 a_1757_3168.t2 a_1757_3168.t3 26.1617
Rpar3 a_4104_11989.t0 a_4104_11989.t104 59.8939
Rpar4 a_4118_9095.t0 a_4118_9095.t52 45.8306
Rpar5 a_4418_9095.t0 a_4418_9095.t1 16.5095
Rpar6 a_4418_9095.t0 a_4418_9095.t16 332.0605
Rpar7 a_4418_9095.t0 a_4418_9095.t46 365.8439
Rpar8 a_4418_9095.t1 a_4418_9095.t16 101.3266
Rpar9 a_4418_9095.t1 a_4418_9095.t46 111.6354
Rpar10 a_4418_9095.t16 a_4418_9095.t46 174.6233
Rpar11 a_6184_6973.t0 a_6184_6973.t2 55.6182
Rpar12 a_7628_6973.t0 a_7628_6973.t2 80.6136
Rpar13 a_8814_11989.t0 a_8814_11989.t52 45.8306
Rpar14 ib ib.t0 14.7795
Rpar15 ib ib.t1 4.2404
Rpar16 inn inn.t0 1.5379
Rpar17 inp inp.t0 1.5379
Rpar18 out out.t0 111.9728
Rpar19 out out.t1 52.0476
Rpar20 out out.t38 16.1557
Rpar21 out.t0 out.t1 98.2056
Rpar22 out.t0 out.t38 862.4247
Rpar23 out.t1 out.t38 400.8753
Rpar24 vdd vdd.t0 662.9281
Rpar25 vdd vdd.t1 2411.9364
Rpar26 vdd vdd.t5 22.2302
Rpar27 vdd vdd.t4 139.9197
Rpar28 vdd.t0 vdd.t1 5.6585
Rpar29 vdd.t0 vdd.t5 254.8888
Rpar30 vdd.t0 vdd.t4 153.6194
Rpar31 vdd.t1 vdd.t5 927.3638
Rpar32 vdd.t1 vdd.t4 558.9148
Rpar33 vdd.t5 vdd.t4 53.7976
Rpar34 vss vss.t0 127.9319
Rpar35 vss vss.t1 183.7743
Rpar36 vss vss.t2 582.1940
Rpar37 vss vss.t41 124.4619
Rpar38 vss vss.t15 93.4055
Rpar39 vss vss.t16 198.6186
Rpar40 vss vss.t8 989.0997
Rpar41 vss.t0 vss.t1 1.8050
Rpar42 vss.t0 vss.t2 7.8304
Rpar43 vss.t0 vss.t41 693.1982
Rpar44 vss.t0 vss.t15 477.5433
Rpar45 vss.t0 vss.t16 1020.2378
Rpar46 vss.t0 vss.t8 143.3709
Rpar47 vss.t1 vss.t2 11.0673
Rpar48 vss.t1 vss.t41 996.1627
Rpar49 vss.t1 vss.t15 692.6841
Rpar50 vss.t1 vss.t16 1478.6029
Rpar51 vss.t1 vss.t8 215.1495
Rpar52 vss.t2 vss.t41 3154.0453
Rpar53 vss.t2 vss.t8 702.7587
Rpar54 vss.t41 vss.t15 205.1531
Rpar55 vss.t41 vss.t16 436.2377
Rpar56 vss.t41 vss.t8 5376.7476
Rpar57 vss.t15 vss.t16 8.6855
Rpar58 vss.t15 vss.t8 4001.5843
Rpar59 vss.t16 vss.t8 8512.3796
Cpar0 a_1757_3168.t0 vss 1.86876e-15
Cpar1 a_1757_3168.t2 vss 1.75973e-14
Cpar2 a_1757_3168.t3 vss 4.49701e-15
Cpar3 a_4104_11989.t0 vss 6.81880e-14
Cpar4 a_4104_11989.t104 vss 1.87778e-14
Cpar5 a_4118_9095.t0 vss 3.91762e-14
Cpar6 a_4118_9095.t52 vss 2.06818e-14
Cpar7 a_4418_9095.t0 vss 8.38996e-15
Cpar8 a_4418_9095.t1 vss 4.85611e-15
Cpar9 a_4418_9095.t16 vss 1.32663e-14
Cpar10 a_4418_9095.t46 vss 9.58744e-15
Cpar11 a_6184_6973.t0 vss 7.63724e-15
Cpar12 a_6184_6973.t2 vss 6.61957e-15
Cpar13 a_7628_6973.t0 vss 6.94900e-15
Cpar14 a_7628_6973.t2 vss 6.74913e-15
Cpar15 a_8814_11989.t0 vss 3.88171e-14
Cpar16 a_8814_11989.t52 vss 2.04920e-14
Cpar17 ib vss 7.03509e-15
Cpar18 ib.t0 vss 5.99155e-16
Cpar19 ib.t1 vss 1.86680e-16
Cpar20 inn inp 2.07500e-16
Cpar21 inn vdd 2.93615e-14
Cpar22 inn vss 5.44539e-15
Cpar23 inn.t0 vss 4.50214e-14
Cpar24 inp vdd 2.90536e-14
Cpar25 inp vss 5.41613e-15
Cpar26 inp.t0 vss 4.47611e-14
Cpar27 out vdd 7.94495e-15
Cpar28 out vss 2.04221e-14
Cpar29 out.t0 vss 2.75493e-15
Cpar30 out.t1 vss 8.34429e-16
Cpar31 out.t38 vss 2.29136e-14
Cpar32 vdd vss 3.55313e-13
Cpar33 vdd.t0 vss 1.54780e-14
Cpar34 vdd.t1 vss 6.90214e-15
Cpar35 vdd.t4 vss 3.59101e-14
Cpar36 vdd.t5 vss 6.03064e-14
.ends opamp_dut

Vdd vdd 0 1.800000
Vss vss 0 0
Ibias vdd ib 4.600000e-06
Vinp inp 0 DC 0.805000 AC 1 PWL(0 0.805000 4.867513e-09 0.805000 5.354265e-09 0.815000)
Rfb out inn 1m
Cload out 0 2.000000e-13
Xdut vdd vss inp inn out ib opamp_dut
.end
