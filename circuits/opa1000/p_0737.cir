* opa1000[0737]: 2p/rail_to_rail_3v3_i2u_subth (rail_to_rail, VDD=3.3V, CL=2.0pF, Iref=0.25uA)
.include "pdk_opa.inc"
.temp 27
.option gmin=1e-12 rshunt=1e12 reltol=1e-3 abstol=1e-12 vntol=1e-5 method=gear
* Post-PEX R+C extracted netlist for rail_to_rail_3v3_i2u_subth
.subckt opamp_dut vdd vss inp inn out ib
XMpar0 out.t1 a_954_9642.t7 vdd.t7 vdd.t6 pfet_03v3 w=6.18u l=1.69u ad=1.7304e-12 pd=6.7400e-06 as=2.2248e-12 ps=8.4450e-06 nf=1 m=8 par=8
XMpar1 out.t10 ib.t0 vss.t20 vss.t19 nfet_03v3 w=1.19u l=3.25u ad=3.3320e-13 pd=1.7500e-06 as=4.2840e-13 ps=2.2075e-06 nf=1 m=8 par=8
XMpar2 a_4170_13318.t0 inp.t2 a_4766_13318.t0 vdd.t0 pfet_03v3 w=1.94u l=2.38u ad=7.5013e-13 pd=3.3600e-06 as=5.4320e-13 ps=2.5000e-06 nf=1 m=12 par=12
XMpar3 a_4766_13318.t13 a_4766_13318.t12 vss.t2 vss.t1 nfet_03v3 w=0.55u l=3.4u ad=3.3000e-13 pd=2.3000e-06 as=1.5400e-13 ps=1.1100e-06 nf=1 m=2 par=2
XMpar4 a_3529_7712.t0 inn.t0 a_7216_16012.t0 vss.t5 nfet_03v3 w=2.01u l=2.38u ad=1.2060e-12 pd=5.2200e-06 as=5.6280e-13 ps=2.5700e-06 nf=1 m=2 par=2
XMpar5 a_6532_5813.t13 a_6532_5813.t12 vss.t2 vss.t1 nfet_03v3 w=0.55u l=3.4u ad=1.5400e-13 pd=1.1100e-06 as=1.5400e-13 ps=1.1100e-06 nf=1 m=2 par=2
XMpar6 a_954_9642.t5 a_6532_5813.t12 vss.t2 vss.t1 nfet_03v3 w=0.55u l=3.4u ad=3.3000e-13 pd=2.3000e-06 as=1.5400e-13 ps=1.1100e-06 nf=1 m=2 par=2
XMpar7 a_4170_13318.t0 inn.t2 a_6532_5813.t0 vdd.t0 pfet_03v3 w=1.94u l=2.38u ad=7.5013e-13 pd=3.3600e-06 as=5.4320e-13 ps=2.5000e-06 nf=1 m=12 par=12
XMpar8 ib.t1 ib.t0 vss.t20 vss.t19 nfet_03v3 w=1.19u l=3.25u ad=7.1400e-13 pd=3.5800e-06 as=3.3320e-13 ps=1.7500e-06 nf=1 m=2 par=2
XMpar9 a_3529_7712.t0 inp.t0 a_954_9642.t1 vss.t5 nfet_03v3 w=2.01u l=2.38u ad=1.2060e-12 pd=5.2200e-06 as=5.6280e-13 ps=2.5700e-06 nf=1 m=2 par=2
XMpar10 a_6853_7712.t1 a_6853_7712.t0 vdd.t15 vdd.t14 pfet_03v3 w=5.22u l=3.25u ad=1.4616e-12 pd=5.7800e-06 as=1.4616e-12 ps=5.7800e-06 nf=1 m=2 par=2
XMpar11 a_954_9642.t0 a_7216_16012.t4 vdd.t7 vdd.t6 pfet_03v3 w=6.18u l=1.69u ad=3.7080e-12 pd=1.3560e-05 as=1.7304e-12 ps=6.7400e-06 nf=1 m=2 par=2
XMpar12 a_4170_13318.t12 a_6853_7712.t0 vdd.t15 vdd.t14 pfet_03v3 w=5.22u l=3.25u ad=3.1320e-12 pd=1.1640e-05 as=1.4616e-12 ps=5.7800e-06 nf=1 m=2 par=2
XMpar13 a_7216_16012.t5 a_7216_16012.t4 vdd.t7 vdd.t6 pfet_03v3 w=6.18u l=1.69u ad=1.7304e-12 pd=6.7400e-06 as=1.7304e-12 ps=6.7400e-06 nf=1 m=2 par=2
XMpar14 a_6853_7712.t4 ib.t0 vss.t20 vss.t19 nfet_03v3 w=1.19u l=3.25u ad=3.3320e-13 pd=1.7500e-06 as=3.3320e-13 ps=1.7500e-06 nf=1 m=2 par=2
XMpar15 a_7216_16012.t2 a_4766_13318.t12 vss.t2 vss.t1 nfet_03v3 w=0.55u l=3.4u ad=1.5400e-13 pd=1.1100e-06 as=1.5400e-13 ps=1.1100e-06 nf=1 m=2 par=2
XMpar16 a_3529_7712.t4 ib.t0 vss.t20 vss.t19 nfet_03v3 w=1.19u l=3.25u ad=7.1400e-13 pd=3.5800e-06 as=3.3320e-13 ps=1.7500e-06 nf=1 m=2 par=2
X3 a_12128_3370.t1 out.t0 cap_mim_2f0fF c_width=15.62u c_length=15.61u
X10 a_8672_2850.t0 a_12128_3370.t0 vss.t0 ppolyf_u_1k r_width=1u r_length=16.62u
X19 a_8672_2850.t0 a_12128_2330.t0 vss.t0 ppolyf_u_1k r_width=1u r_length=16.62u
X28 a_12128_3370.t1 out.t0 cap_mim_2f0fF c_width=15.62u c_length=15.61u
X32 a_8672_1810.t0 a_12128_2330.t0 vss.t0 ppolyf_u_1k r_width=1u r_length=16.62u
X38 a_8672_1810.t0 a_12128_1290.t0 vss.t0 ppolyf_u_1k r_width=1u r_length=16.62u
X64 a_954_9642.t4 a_12128_1290.t0 vss.t0 ppolyf_u_1k r_width=1u r_length=16.62u
Rpar0 a_12128_3370.t0 a_12128_3370.t1 61.0111
Rpar1 a_3529_7712.t0 a_3529_7712.t4 80.3119
Rpar2 a_4170_13318.t0 a_4170_13318.t12 58.5393
Rpar3 a_4766_13318.t0 a_4766_13318.t12 147.2986
Rpar4 a_4766_13318.t0 a_4766_13318.t13 100.6009
Rpar5 a_4766_13318.t12 a_4766_13318.t13 20.9285
Rpar6 a_6532_5813.t0 a_6532_5813.t12 147.1374
Rpar7 a_6532_5813.t0 a_6532_5813.t13 142.4815
Rpar8 a_6532_5813.t12 a_6532_5813.t13 28.8808
Rpar9 a_6853_7712.t0 a_6853_7712.t1 23.1052
Rpar10 a_6853_7712.t0 a_6853_7712.t4 216.9985
Rpar11 a_6853_7712.t1 a_6853_7712.t4 123.9629
Rpar12 a_7216_16012.t0 a_7216_16012.t2 64.7925
Rpar13 a_7216_16012.t0 a_7216_16012.t4 558.0632
Rpar14 a_7216_16012.t0 a_7216_16012.t5 193.1624
Rpar15 a_7216_16012.t2 a_7216_16012.t4 483.6609
Rpar16 a_7216_16012.t2 a_7216_16012.t5 167.4095
Rpar17 a_7216_16012.t4 a_7216_16012.t5 24.8889
Rpar18 a_954_9642.t0 a_954_9642.t1 223.7598
Rpar19 a_954_9642.t0 a_954_9642.t7 162.5022
Rpar20 a_954_9642.t0 a_954_9642.t4 1020.9218
Rpar21 a_954_9642.t0 a_954_9642.t5 394.1954
Rpar22 a_954_9642.t1 a_954_9642.t7 132.2035
Rpar23 a_954_9642.t1 a_954_9642.t4 830.5700
Rpar24 a_954_9642.t1 a_954_9642.t5 320.6973
Rpar25 a_954_9642.t7 a_954_9642.t4 303.8631
Rpar26 a_954_9642.t7 a_954_9642.t5 117.3267
Rpar27 a_954_9642.t4 a_954_9642.t5 149.6387
Rpar28 ib ib.t0 11.4888
Rpar29 ib ib.t1 10.0577
Rpar30 inn inn.t0 5.0536
Rpar31 inn inn.t2 45.5462
Rpar32 inp inp.t0 5.1022
Rpar33 inp inp.t2 45.4976
Rpar34 out out.t0 20.9990
Rpar35 out out.t1 55.5175
Rpar36 out out.t10 56.2222
Rpar37 out.t1 out.t10 88.4346
Rpar38 vdd vdd.t0 166.3217
Rpar39 vdd vdd.t6 38.6537
Rpar40 vdd vdd.t7 91.9916
Rpar41 vdd vdd.t14 1864.5331
Rpar42 vdd vdd.t15 3882.8763
Rpar43 vdd.t0 vdd.t6 77.9428
Rpar44 vdd.t0 vdd.t7 188.2785
Rpar45 vdd.t0 vdd.t14 364.5053
Rpar46 vdd.t0 vdd.t15 759.0795
Rpar47 vdd.t6 vdd.t7 3.4748
Rpar48 vdd.t6 vdd.t14 174.4892
Rpar49 vdd.t6 vdd.t15 363.3724
Rpar50 vdd.t7 vdd.t14 437.3625
Rpar51 vdd.t7 vdd.t15 910.8042
Rpar52 vdd.t14 vdd.t15 8.7957
Rpar53 vss vss.t0 55.5780
Rpar54 vss vss.t1 180.9900
Rpar55 vss vss.t2 66.8192
Rpar56 vss vss.t5 411.5346
Rpar57 vss vss.t19 1390.5448
Rpar58 vss vss.t20 151.4965
Rpar59 vss.t0 vss.t1 268.1758
Rpar60 vss.t0 vss.t2 98.5444
Rpar61 vss.t0 vss.t5 659.1695
Rpar62 vss.t0 vss.t19 2212.6020
Rpar63 vss.t0 vss.t20 241.1085
Rpar64 vss.t1 vss.t2 23.2921
Rpar65 vss.t1 vss.t5 3.9391
Rpar66 vss.t1 vss.t19 929.1717
Rpar67 vss.t1 vss.t20 107.7514
Rpar68 vss.t2 vss.t5 12.4097
Rpar69 vss.t2 vss.t19 642.7521
Rpar70 vss.t2 vss.t20 71.5916
Rpar71 vss.t5 vss.t19 564.7507
Rpar72 vss.t5 vss.t20 68.2878
Rpar73 vss.t19 vss.t20 56.3728
Cpar0 a_12128_1290.t0 vss 2.64400e-17
Cpar1 a_12128_2330.t0 vss 3.27400e-17
Cpar2 a_12128_3370.t0 vss 8.54784e-17
Cpar3 a_12128_3370.t1 vss 4.54932e-15
Cpar4 a_3529_7712.t0 vss 1.11401e-14
Cpar5 a_3529_7712.t4 vss 1.22892e-14
Cpar6 a_4170_13318.t0 vss 2.40254e-14
Cpar7 a_4170_13318.t12 vss 7.92457e-15
Cpar8 a_4766_13318.t0 vss 8.50249e-15
Cpar9 a_4766_13318.t12 vss 6.00026e-15
Cpar10 a_4766_13318.t13 vss 2.24388e-15
Cpar11 a_6532_5813.t0 vss 8.93999e-15
Cpar12 a_6532_5813.t12 vss 6.52524e-15
Cpar13 a_6532_5813.t13 vss 2.45892e-15
Cpar14 a_6853_7712.t0 vss 1.45209e-14
Cpar15 a_6853_7712.t1 vss 5.03203e-15
Cpar16 a_6853_7712.t4 vss 5.87314e-15
Cpar17 a_7216_16012.t0 vss 3.10671e-15
Cpar18 a_7216_16012.t2 vss 3.11946e-15
Cpar19 a_7216_16012.t4 vss 8.74083e-15
Cpar20 a_7216_16012.t5 vss 4.99358e-15
Cpar21 a_8672_1810.t0 vss 3.80400e-17
Cpar22 a_8672_2850.t0 vss 3.23000e-17
Cpar23 a_954_9642.t0 vss 5.30717e-15
Cpar24 a_954_9642.t1 vss 2.97461e-15
Cpar25 a_954_9642.t4 vss 3.55274e-15
Cpar26 a_954_9642.t5 vss 4.59116e-15
Cpar27 a_954_9642.t7 vss 1.46053e-14
Cpar28 ib out 1.24048e-15
Cpar29 ib vss 3.05671e-14
Cpar30 ib.t0 vss 9.59637e-15
Cpar31 ib.t1 vss 8.47397e-16
Cpar32 inn inp 1.57060e-16
Cpar33 inn vdd 1.48432e-14
Cpar34 inn vss 7.61450e-15
Cpar35 inn.t0 vss 1.90063e-15
Cpar36 inn.t2 vss 2.15439e-14
Cpar37 inp out 2.98200e-17
Cpar38 inp vdd 1.39480e-14
Cpar39 inp vss 7.33042e-15
Cpar40 inp.t0 vss 1.70895e-15
Cpar41 inp.t2 vss 1.92464e-14
Cpar42 out vdd 7.32042e-15
Cpar43 out vss 1.86797e-14
Cpar44 out.t0 vss 1.28968e-14
Cpar45 out.t1 vss 5.51334e-15
Cpar46 out.t10 vss 3.70066e-15
Cpar47 vdd vss 1.79689e-13
Cpar48 vdd.t0 vss 3.61169e-14
Cpar49 vdd.t14 vss 1.10164e-14
Cpar50 vdd.t15 vss 5.28104e-15
Cpar51 vdd.t6 vss 2.11707e-14
Cpar52 vdd.t7 vss 1.06473e-14
.ends opamp_dut

Vdd vdd 0 3.300000
Vss vss 0 0
Ibias vdd ib 2.500000e-07
Vinp inp 0 DC 1.645000 AC 1 PWL(0 1.645000 1.241751e-07 1.645000 1.365926e-07 1.655000)
Rfb out inn 1m
Cload out 0 2.000000e-12
Xdut vdd vss inp inn out ib opamp_dut
.end
