* opa1000[0128]: 2p/current_reuse_1v8_i200n_weak (current_reuse, VDD=1.8V, CL=2.0pF, Iref=0.0286uA)
.include "pdk_opa.inc"
.temp 27
.option gmin=1e-12 rshunt=1e12 reltol=1e-3 abstol=1e-12 vntol=1e-5 method=gear
* Post-PEX R+C extracted netlist for current_reuse_1v8_i200n_weak
.subckt opamp_dut vdd vss inp inn out ib
XMpar0 a_1095_1290.t0 a_8292_14597.t4 vdd.t1 vdd.t0 pfet_03v3 w=0.4u l=2.56u ad=2.4000e-13 pd=2.0000e-06 as=1.1200e-13 ps=9.6000e-07 nf=1 m=1
XMpar1 out.t11 ib.t0 vss.t13 vss.t1 nfet_03v3 w=0.4u l=4u ad=1.8880e-13 pd=1.5840e-06 as=1.6320e-13 ps=1.3760e-06 nf=1 m=5 par=5
XMpar2 out.t0 a_1095_1290.t6 vdd.t1 vdd.t0 pfet_03v3 w=0.4u l=2.56u ad=1.1200e-13 pd=9.6000e-07 as=1.3760e-13 ps=1.1680e-06 nf=1 m=10 par=10
XMpar3 a_5022_9980.t4 ib.t0 vss.t13 vss.t1 nfet_03v3 w=0.4u l=4u ad=2.4000e-13 pd=2.0000e-06 as=1.1200e-13 ps=9.6000e-07 nf=1 m=2 par=2
XMpar4 a_8292_14597.t5 a_8292_14597.t4 vdd.t1 vdd.t0 pfet_03v3 w=0.4u l=2.56u ad=2.4000e-13 pd=2.0000e-06 as=1.1200e-13 ps=9.6000e-07 nf=1 m=1
XMpar5 a_5022_11578.t0 inn.t2 a_8292_14597.t2 vdd.t6 pfet_03v3 w=0.86u l=8.13u ad=5.1600e-13 pd=2.9200e-06 as=2.4080e-13 ps=1.4200e-06 nf=1 m=2 par=2
XMpar6 out.t11 ib.t0 vss.t13 vss.t12 nfet_03v3 w=0.4u l=4u ad=1.8880e-13 pd=1.5840e-06 as=1.6320e-13 ps=1.3760e-06 nf=1 m=5 par=5
XMpar7 a_1095_1290.t3 inp.t2 a_5022_11578.t0 vdd.t6 pfet_03v3 w=0.86u l=8.13u ad=2.4080e-13 pd=1.4200e-06 as=5.1600e-13 ps=2.9200e-06 nf=1 m=2 par=2
XMpar8 a_1095_1290.t1 inp.t0 a_5022_9980.t0 vss.t3 nfet_03v3 w=0.44u l=8.13u ad=1.2320e-13 pd=1.0000e-06 as=2.6400e-13 ps=2.0800e-06 nf=1 m=2 par=2
XMpar9 a_5022_9980.t4 ib.t0 vss.t13 vss.t12 nfet_03v3 w=0.4u l=4u ad=2.4000e-13 pd=2.0000e-06 as=1.1200e-13 ps=9.6000e-07 nf=1 m=2 par=2
XMpar10 ib.t1 ib.t0 vss.t13 vss.t1 nfet_03v3 w=0.4u l=4u ad=2.4000e-13 pd=2.0000e-06 as=1.1200e-13 ps=9.6000e-07 nf=1 m=1
XMpar11 ib.t1 ib.t0 vss.t13 vss.t12 nfet_03v3 w=0.4u l=4u ad=2.4000e-13 pd=2.0000e-06 as=1.1200e-13 ps=9.6000e-07 nf=1 m=1
XMpar12 a_5022_9980.t0 inn.t0 a_8292_14597.t0 vss.t3 nfet_03v3 w=0.44u l=8.13u ad=2.6400e-13 pd=2.0800e-06 as=1.2320e-13 ps=1.0000e-06 nf=1 m=2 par=2
XMpar13 a_5022_11578.t2 a_8292_14597.t4 vdd.t1 vdd.t0 pfet_03v3 w=0.4u l=2.56u ad=1.1200e-13 pd=9.6000e-07 as=2.4000e-13 ps=2.0000e-06 nf=1 m=2 par=2
X5 a_1095_4930.t0 a_5073_5450.t0 vss.t0 ppolyf_u_1k r_width=1u r_length=19.23u
X6 a_1095_1810.t0 a_5073_2330.t0 vss.t0 ppolyf_u_1k r_width=1u r_length=19.23u
X10 a_1095_4930.t0 a_5073_4410.t0 vss.t0 ppolyf_u_1k r_width=1u r_length=19.23u
X14 a_1095_1810.t0 a_5073_1290.t0 vss.t0 ppolyf_u_1k r_width=1u r_length=19.23u
X21 a_1095_7010.t0 a_5073_7530.t0 vss.t0 ppolyf_u_1k r_width=1u r_length=19.23u
X23 a_1095_3890.t0 a_5073_4410.t0 vss.t0 ppolyf_u_1k r_width=1u r_length=19.23u
X28 a_1095_7010.t0 a_5073_6490.t0 vss.t0 ppolyf_u_1k r_width=1u r_length=19.23u
X34 a_5073_7530.t1 out.t2 cap_mim_2f0fF c_width=18.03u c_length=18.03u
X38 a_1095_1290.t5 a_5073_1290.t0 vss.t0 ppolyf_u_1k r_width=1u r_length=19.23u
X39 a_5073_7530.t1 out.t2 cap_mim_2f0fF c_width=18.03u c_length=18.03u
X40 a_1095_3890.t0 a_5073_3370.t0 vss.t0 ppolyf_u_1k r_width=1u r_length=19.23u
X45 a_1095_5970.t0 a_5073_6490.t0 vss.t1 ppolyf_u_1k r_width=1u r_length=19.23u
X48 a_1095_2850.t0 a_5073_3370.t0 vss.t0 ppolyf_u_1k r_width=1u r_length=19.23u
X51 a_1095_5970.t0 a_5073_5450.t0 vss.t0 ppolyf_u_1k r_width=1u r_length=19.23u
X52 a_1095_2850.t0 a_5073_2330.t0 vss.t0 ppolyf_u_1k r_width=1u r_length=19.23u
Rpar0 a_1095_1290.t0 a_1095_1290.t1 799.1548
Rpar1 a_1095_1290.t0 a_1095_1290.t6 110.3821
Rpar2 a_1095_1290.t0 a_1095_1290.t3 502.1950
Rpar3 a_1095_1290.t0 a_1095_1290.t5 1867.4438
Rpar4 a_1095_1290.t1 a_1095_1290.t6 180.7905
Rpar5 a_1095_1290.t1 a_1095_1290.t3 117.0669
Rpar6 a_1095_1290.t1 a_1095_1290.t5 176.4104
Rpar7 a_1095_1290.t6 a_1095_1290.t3 113.6101
Rpar8 a_1095_1290.t6 a_1095_1290.t5 422.4664
Rpar9 a_1095_1290.t3 a_1095_1290.t5 273.5588
Rpar10 a_5022_11578.t0 a_5022_11578.t2 68.6454
Rpar11 a_5022_9980.t0 a_5022_9980.t4 63.1622
Rpar12 a_5073_7530.t0 a_5073_7530.t1 59.1448
Rpar13 a_8292_14597.t0 a_8292_14597.t2 123.3952
Rpar14 a_8292_14597.t0 a_8292_14597.t4 162.5405
Rpar15 a_8292_14597.t0 a_8292_14597.t5 632.8555
Rpar16 a_8292_14597.t2 a_8292_14597.t4 89.8467
Rpar17 a_8292_14597.t2 a_8292_14597.t5 349.8203
Rpar18 a_8292_14597.t4 a_8292_14597.t5 30.2547
Rpar19 ib ib.t0 15.0825
Rpar20 ib ib.t1 14.9091
Rpar21 ib.t0 ib.t1 34.1143
Rpar22 inn inn.t0 3.3596
Rpar23 inn inn.t2 42.3180
Rpar24 inp inp.t0 3.4082
Rpar25 inp inp.t2 42.2694
Rpar26 out out.t0 4.3529
Rpar27 out out.t11 274.5996
Rpar28 out out.t2 475.7779
Rpar29 out.t0 out.t11 196.8746
Rpar30 out.t0 out.t2 341.1097
Rpar31 out.t11 out.t2 147.0899
Rpar32 vdd vdd.t0 75.1478
Rpar33 vdd vdd.t1 79.0647
Rpar34 vdd vdd.t6 192.8480
Rpar35 vdd.t0 vdd.t1 4.2746
Rpar36 vdd.t0 vdd.t6 47.3086
Rpar37 vdd.t1 vdd.t6 68.6716
Rpar38 vss vss.t0 26.0834
Rpar39 vss vss.t1 2456.6106
Rpar40 vss vss.t13 96.6029
Rpar41 vss vss.t3 238.2853
Rpar42 vss.t0 vss.t1 54.6391
Rpar43 vss.t0 vss.t12 17.4282
Rpar44 vss.t0 vss.t13 23.3273
Rpar45 vss.t0 vss.t3 163.9664
Rpar46 vss.t1 vss.t12 525.4922
Rpar47 vss.t1 vss.t13 97.1551
Rpar48 vss.t1 vss.t3 1158.9783
Rpar49 vss.t12 vss.t13 261.8300
Rpar50 vss.t12 vss.t3 1654.3722
Rpar51 vss.t13 vss.t3 76.4365
Cpar0 a_1095_1290.t0 vss 3.45882e-15
Cpar1 a_1095_1290.t1 vss 3.94016e-15
Cpar2 a_1095_1290.t3 vss 3.92206e-15
Cpar3 a_1095_1290.t5 vss 5.34268e-15
Cpar4 a_1095_1290.t6 vss 1.35845e-14
Cpar5 a_1095_1810.t0 vss 4.03800e-17
Cpar6 a_1095_2850.t0 vss 3.64800e-17
Cpar7 a_1095_3890.t0 vss 3.64800e-17
Cpar8 a_1095_4930.t0 vss 3.64800e-17
Cpar9 a_1095_5970.t0 vss 3.72200e-17
Cpar10 a_1095_7010.t0 vss 3.78400e-17
Cpar11 a_5022_11578.t0 vss 7.60020e-15
Cpar12 a_5022_11578.t2 vss 2.92185e-15
Cpar13 a_5022_9980.t0 vss 8.22838e-15
Cpar14 a_5022_9980.t4 vss 1.55008e-14
Cpar15 a_5073_1290.t0 vss 4.15600e-17
Cpar16 a_5073_2330.t0 vss 4.26000e-17
Cpar17 a_5073_3370.t0 vss 4.18600e-17
Cpar18 a_5073_4410.t0 vss 4.18600e-17
Cpar19 a_5073_5450.t0 vss 3.88200e-17
Cpar20 a_5073_6490.t0 vss 4.35600e-17
Cpar21 a_5073_7530.t0 vss 9.17988e-17
Cpar22 a_5073_7530.t1 vss 5.53667e-15
Cpar23 a_8292_14597.t0 vss 3.55051e-15
Cpar24 a_8292_14597.t2 vss 3.94092e-15
Cpar25 a_8292_14597.t4 vss 9.59929e-15
Cpar26 a_8292_14597.t5 vss 1.98882e-15
Cpar27 ib inn 3.12800e-17
Cpar28 ib out 2.26972e-15
Cpar29 ib vss 4.83626e-14
Cpar30 ib.t0 vss 8.18390e-15
Cpar31 ib.t1 vss 6.55628e-16
Cpar32 inn inp 1.03000e-16
Cpar33 inn vdd 7.39621e-15
Cpar34 inn vss 1.15333e-14
Cpar35 inn.t0 vss 2.17062e-15
Cpar36 inn.t2 vss 5.50831e-15
Cpar37 inp out 1.62690e-16
Cpar38 inp vdd 7.41281e-15
Cpar39 inp vss 1.15602e-14
Cpar40 inp.t0 vss 2.31167e-15
Cpar41 inp.t2 vss 5.78517e-15
Cpar42 out vdd 1.01458e-14
Cpar43 out vss 3.16429e-14
Cpar44 out.t0 vss 2.31438e-15
Cpar45 out.t11 vss 7.92949e-15
Cpar46 out.t2 vss 1.76195e-14
Cpar47 vdd vss 9.94822e-14
Cpar48 vdd.t0 vss 1.94894e-14
Cpar49 vdd.t1 vss 1.14457e-14
Cpar50 vdd.t6 vss 1.76213e-14
.ends opamp_dut

Vdd vdd 0 1.800000
Vss vss 0 0
Ibias vdd ib 2.860000e-08
Vinp inp 0 DC 0.895000 AC 1 PWL(0 0.895000 1.231805e-06 0.895000 1.354985e-06 0.905000)
Rfb out inn 1m
Cload out 0 2.000000e-12
Xdut vdd vss inp inn out ib opamp_dut
.end
