* opa1000[0736]: 2p/rail_to_rail_3v3_i1u_subth (rail_to_rail, VDD=3.3V, CL=2.0pF, Iref=0.1312uA)
.include "pdk_opa.inc"
.temp 27
.option gmin=1e-12 rshunt=1e12 reltol=1e-3 abstol=1e-12 vntol=1e-5 method=gear
* Post-PEX R+C extracted netlist for rail_to_rail_3v3_i1u_subth
.subckt opamp_dut vdd vss inp inn out ib
XMpar0 out.t2 ib.t0 vss.t11 vss.t10 nfet_03v3 w=0.67u l=3.5u ad=1.8760e-13 pd=1.2300e-06 as=3.4840e-13 ps=2.2125e-06 nf=1 m=8 par=8
XMpar1 a_4754_8359.t0 inp.t0 a_5290_8359.t0 vdd.t13 pfet_03v3 w=6.09u l=2.08u ad=2.1924e-12 pd=8.3325e-06 as=1.7052e-12 ps=6.6500e-06 nf=1 m=8 par=8
XMpar2 a_4754_8359.t0 inn.t0 a_8804_996.t4 vdd.t13 pfet_03v3 w=6.09u l=2.08u ad=2.1924e-12 pd=8.3325e-06 as=1.7052e-12 ps=6.6500e-06 nf=1 m=8 par=8
XMpar3 a_8452_3970.t8 a_5290_8359.t8 vss.t1 vss.t0 nfet_03v3 w=0.4u l=2.93u ad=1.1200e-13 pd=9.6000e-07 as=1.1200e-13 ps=9.6000e-07 nf=1 m=2 par=2
XMpar4 a_6355_12703.t4 ib.t0 vss.t11 vss.t10 nfet_03v3 w=0.67u l=3.5u ad=4.0200e-13 pd=2.5400e-06 as=1.8760e-13 ps=1.2300e-06 nf=1 m=2 par=2
XMpar5 out.t0 a_836_3740.t9 vdd.t1 vdd.t0 pfet_03v3 w=4.25u l=1.8u ad=1.1900e-12 pd=4.8100e-06 as=1.5300e-12 ps=6.0325e-06 nf=1 m=8 par=8
XMpar6 a_836_3740.t0 a_8804_996.t0 vss.t1 vss.t0 nfet_03v3 w=0.4u l=2.93u ad=2.4000e-13 pd=2.0000e-06 as=1.1200e-13 ps=9.6000e-07 nf=1 m=2 par=2
XMpar7 a_4454_12703.t0 inn.t8 a_8452_3970.t4 vss.t4 nfet_03v3 w=1.42u l=2.08u ad=6.2480e-13 pd=3.0100e-06 as=3.9760e-13 ps=1.9800e-06 nf=1 m=4 par=4
XMpar8 ib.t1 ib.t0 vss.t11 vss.t10 nfet_03v3 w=0.67u l=3.5u ad=4.0200e-13 pd=2.5400e-06 as=1.8760e-13 ps=1.2300e-06 nf=1 m=2 par=2
XMpar9 a_5290_8359.t9 a_5290_8359.t8 vss.t1 vss.t0 nfet_03v3 w=0.4u l=2.93u ad=2.4000e-13 pd=2.0000e-06 as=1.1200e-13 ps=9.6000e-07 nf=1 m=2 par=2
XMpar10 a_4454_12703.t0 inp.t8 a_836_3740.t2 vss.t4 nfet_03v3 w=1.42u l=2.08u ad=6.2480e-13 pd=3.0100e-06 as=3.9760e-13 ps=1.9800e-06 nf=1 m=4 par=4
XMpar11 a_8804_996.t1 a_8804_996.t0 vss.t1 vss.t0 nfet_03v3 w=0.4u l=2.93u ad=2.4000e-13 pd=2.0000e-06 as=1.1200e-13 ps=9.6000e-07 nf=1 m=2 par=2
XMpar12 a_4754_8359.t8 a_6355_12703.t0 vdd.t11 vdd.t10 pfet_03v3 w=2.93u l=3.5u ad=1.7580e-12 pd=7.0600e-06 as=8.2040e-13 ps=3.4900e-06 nf=1 m=2 par=2
XMpar13 a_6355_12703.t1 a_6355_12703.t0 vdd.t11 vdd.t10 pfet_03v3 w=2.93u l=3.5u ad=1.7580e-12 pd=7.0600e-06 as=8.2040e-13 ps=3.4900e-06 nf=1 m=2 par=2
XMpar14 a_4454_12703.t4 ib.t0 vss.t11 vss.t10 nfet_03v3 w=0.67u l=3.5u ad=4.0200e-13 pd=2.5400e-06 as=1.8760e-13 ps=1.2300e-06 nf=1 m=2 par=2
XMpar15 a_8452_3970.t1 a_8452_3970.t0 vdd.t1 vdd.t0 pfet_03v3 w=4.25u l=1.8u ad=1.1900e-12 pd=4.8100e-06 as=1.1900e-12 ps=4.8100e-06 nf=1 m=2 par=2
XMpar16 a_836_3740.t6 a_8452_3970.t0 vdd.t1 vdd.t0 pfet_03v3 w=4.25u l=1.8u ad=2.5500e-12 pd=9.7000e-06 as=1.1900e-12 ps=4.8100e-06 nf=1 m=2 par=2
X4 a_4642_6860.t1 out.t7 cap_mim_2f0fF c_width=16.62u c_length=16.62u
X5 a_836_5300.t0 a_4642_5820.t0 vss.t8 ppolyf_u_1k r_width=1u r_length=18.37u
X17 a_836_5300.t0 a_4642_4780.t0 vss.t8 ppolyf_u_1k r_width=1u r_length=18.37u
X27 a_4642_6860.t1 out.t7 cap_mim_2f0fF c_width=16.62u c_length=16.62u
X41 a_836_4260.t0 a_4642_4780.t0 vss.t8 ppolyf_u_1k r_width=1u r_length=18.37u
X50 a_836_4260.t0 a_4642_3740.t0 vss.t8 ppolyf_u_1k r_width=1u r_length=18.37u
X59 a_836_6340.t0 a_4642_6860.t0 vss.t8 ppolyf_u_1k r_width=1u r_length=18.37u
X62 a_836_3740.t8 a_4642_3740.t0 vss.t8 ppolyf_u_1k r_width=1u r_length=18.37u
X70 a_836_6340.t0 a_4642_5820.t0 vss.t8 ppolyf_u_1k r_width=1u r_length=18.37u
Rpar0 a_4454_12703.t0 a_4454_12703.t4 57.8578
Rpar1 a_4642_6860.t0 a_4642_6860.t1 85.5168
Rpar2 a_4754_8359.t0 a_4754_8359.t8 59.6957
Rpar3 a_5290_8359.t0 a_5290_8359.t8 139.1190
Rpar4 a_5290_8359.t0 a_5290_8359.t9 102.1291
Rpar5 a_5290_8359.t8 a_5290_8359.t9 21.5047
Rpar6 a_6355_12703.t0 a_6355_12703.t1 12.3362
Rpar7 a_6355_12703.t0 a_6355_12703.t4 231.6748
Rpar8 a_6355_12703.t1 a_6355_12703.t4 139.4619
Rpar9 a_836_3740.t0 a_836_3740.t9 210.4146
Rpar10 a_836_3740.t0 a_836_3740.t2 933.1427
Rpar11 a_836_3740.t0 a_836_3740.t6 57.2012
Rpar12 a_836_3740.t0 a_836_3740.t8 177.1827
Rpar13 a_836_3740.t9 a_836_3740.t2 122.7384
Rpar14 a_836_3740.t9 a_836_3740.t6 254.5614
Rpar15 a_836_3740.t9 a_836_3740.t8 133.8915
Rpar16 a_836_3740.t2 a_836_3740.t6 1128.9240
Rpar17 a_836_3740.t2 a_836_3740.t8 593.7793
Rpar18 a_836_3740.t6 a_836_3740.t8 214.3571
Rpar19 a_8452_3970.t0 a_8452_3970.t1 24.7275
Rpar20 a_8452_3970.t0 a_8452_3970.t4 468.7444
Rpar21 a_8452_3970.t0 a_8452_3970.t8 215.8991
Rpar22 a_8452_3970.t1 a_8452_3970.t4 187.7242
Rpar23 a_8452_3970.t1 a_8452_3970.t8 86.4640
Rpar24 a_8452_3970.t4 a_8452_3970.t8 127.9564
Rpar25 a_8804_996.t0 a_8804_996.t1 16.0285
Rpar26 a_8804_996.t0 a_8804_996.t4 163.0984
Rpar27 a_8804_996.t1 a_8804_996.t4 172.1857
Rpar28 ib ib.t0 14.3037
Rpar29 ib ib.t1 14.2429
Rpar30 ib.t0 ib.t1 28.0466
Rpar31 inn inn.t0 71.5100
Rpar32 inn inn.t8 2.1027
Rpar33 inp inp.t0 53.7494
Rpar34 inp inp.t8 2.4875
Rpar35 out out.t0 873.5356
Rpar36 out out.t2 8.2342
Rpar37 out out.t7 291.3463
Rpar38 out.t0 out.t2 227.9482
Rpar39 out.t0 out.t7 468.3870
Rpar40 out.t2 out.t7 76.0265
Rpar41 vdd vdd.t0 240.3195
Rpar42 vdd vdd.t1 551.8236
Rpar43 vdd vdd.t10 2409.5453
Rpar44 vdd vdd.t11 602.1067
Rpar45 vdd vdd.t13 146.2594
Rpar46 vdd.t0 vdd.t1 3.2377
Rpar47 vdd.t0 vdd.t10 654.4968
Rpar48 vdd.t0 vdd.t11 163.5482
Rpar49 vdd.t0 vdd.t13 49.4141
Rpar50 vdd.t1 vdd.t10 1502.8609
Rpar51 vdd.t1 vdd.t11 375.5408
Rpar52 vdd.t1 vdd.t13 113.4651
Rpar53 vdd.t10 vdd.t11 20.7657
Rpar54 vdd.t10 vdd.t13 495.4469
Rpar55 vdd.t11 vdd.t13 123.8042
Rpar56 vss vss.t0 118.6601
Rpar57 vss vss.t1 61.4216
Rpar58 vss vss.t10 979.5451
Rpar59 vss vss.t8 78.7178
Rpar60 vss vss.t4 819.0705
Rpar61 vss.t0 vss.t1 10.9222
Rpar62 vss.t0 vss.t10 1287.6179
Rpar63 vss.t0 vss.t8 153.0474
Rpar64 vss.t0 vss.t4 1070.6017
Rpar65 vss.t1 vss.t10 1049.1404
Rpar66 vss.t1 vss.t8 114.3707
Rpar67 vss.t1 vss.t4 874.7037
Rpar68 vss.t10 vss.t11 17.7845
Rpar69 vss.t10 vss.t8 440.9121
Rpar70 vss.t10 vss.t4 2.2725
Rpar71 vss.t11 vss.t8 5891.0554
Rpar72 vss.t11 vss.t4 32.5647
Rpar73 vss.t8 vss.t4 402.1585
Cpar0 a_4454_12703.t0 vss 8.47625e-15
Cpar1 a_4454_12703.t4 vss 1.23127e-14
Cpar2 a_4642_3740.t0 vss 3.35400e-17
Cpar3 a_4642_4780.t0 vss 3.00800e-17
Cpar4 a_4642_5820.t0 vss 3.33400e-17
Cpar5 a_4642_6860.t0 vss 2.87100e-16
Cpar6 a_4642_6860.t1 vss 8.13396e-15
Cpar7 a_4754_8359.t0 vss 2.40516e-14
Cpar8 a_4754_8359.t8 vss 7.20128e-15
Cpar9 a_5290_8359.t0 vss 7.41349e-15
Cpar10 a_5290_8359.t8 vss 4.15964e-15
Cpar11 a_5290_8359.t9 vss 1.63180e-15
Cpar12 a_6355_12703.t0 vss 1.33604e-14
Cpar13 a_6355_12703.t1 vss 7.64156e-15
Cpar14 a_6355_12703.t4 vss 1.03908e-14
Cpar15 a_836_3740.t0 vss 4.01103e-15
Cpar16 a_836_3740.t2 vss 4.46851e-15
Cpar17 a_836_3740.t6 vss 4.84803e-15
Cpar18 a_836_3740.t8 vss 3.51047e-15
Cpar19 a_836_3740.t9 vss 1.76544e-14
Cpar20 a_836_4260.t0 vss 3.93800e-17
Cpar21 a_836_5300.t0 vss 3.74600e-17
Cpar22 a_836_6340.t0 vss 3.80400e-17
Cpar23 a_8452_3970.t0 vss 7.33223e-15
Cpar24 a_8452_3970.t1 vss 3.60842e-15
Cpar25 a_8452_3970.t4 vss 3.83413e-15
Cpar26 a_8452_3970.t8 vss 2.59605e-15
Cpar27 a_8804_996.t0 vss 5.63081e-15
Cpar28 a_8804_996.t1 vss 2.44432e-15
Cpar29 a_8804_996.t4 vss 8.77172e-15
Cpar30 ib inp 1.01900e-17
Cpar31 ib out 2.00909e-15
Cpar32 ib vss 3.42420e-14
Cpar33 ib.t0 vss 1.17886e-14
Cpar34 ib.t1 vss 1.05543e-15
Cpar35 inn inp 1.04240e-16
Cpar36 inn out 2.26400e-17
Cpar37 inn vdd 9.10517e-15
Cpar38 inn vss 1.05380e-14
Cpar39 inn.t0 vss 1.52998e-14
Cpar40 inn.t8 vss 1.58077e-15
Cpar41 inp out 9.28950e-16
Cpar42 inp vdd 8.97512e-15
Cpar43 inp vss 9.51734e-15
Cpar44 inp.t0 vss 1.42176e-14
Cpar45 inp.t8 vss 1.68552e-15
Cpar46 out vdd 8.35624e-15
Cpar47 out vss 2.45903e-14
Cpar48 out.t0 vss 9.05281e-15
Cpar49 out.t2 vss 6.04842e-15
Cpar50 out.t7 vss 1.89067e-14
Cpar51 vdd vss 1.79367e-13
Cpar52 vdd.t0 vss 1.82272e-14
Cpar53 vdd.t1 vss 8.51557e-15
Cpar54 vdd.t10 vss 1.10129e-14
Cpar55 vdd.t11 vss 5.79663e-15
Cpar56 vdd.t13 vss 3.16896e-14
.ends opamp_dut

Vdd vdd 0 3.300000
Vss vss 0 0
Ibias vdd ib 1.312000e-07
Vinp inp 0 DC 1.645000 AC 1 PWL(0 1.645000 2.353131e-07 1.645000 2.588444e-07 1.655000)
Rfb out inn 1m
Cload out 0 2.000000e-12
Xdut vdd vss inp inn out ib opamp_dut
.end
