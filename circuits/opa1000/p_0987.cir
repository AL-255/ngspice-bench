* opa1000[0987]: 2p/telescopic_pmos_3v3_i1u_weak (telescopic_pmos, VDD=3.3V, CL=2.0pF, Iref=0.23uA)
.include "pdk_opa.inc"
.temp 27
.option gmin=1e-12 rshunt=1e12 reltol=1e-3 abstol=1e-12 vntol=1e-5 method=gear
* Post-PEX R+C extracted netlist for telescopic_pmos_3v3_i1u_weak
.subckt opamp_dut vdd vss inp inn out ib
XMpar0 a_3027_8595.t6 inp.t0 a_3090_10651.t0 vdd.t8 pfet_03v3 w=2u l=4u ad=6.8800e-13 pd=3.0880e-06 as=8.1600e-13 ps=3.6160e-06 nf=1 m=10 par=10
XMpar1 a_3027_8595.t0 a_3147_8387.t0 a_3147_8387.t1 vdd.t19 pfet_03v3 w=1.58u l=2.55u ad=6.1093e-13 pd=2.8800e-06 as=6.1093e-13 ps=2.8800e-06 nf=1 m=6 par=6
XMpar2 a_3090_10651.t20 a_4693_6441.t0 vdd.t1 vdd.t0 pfet_03v3 w=1.6u l=3.5u ad=4.4800e-13 pd=2.1600e-06 as=5.7600e-13 ps=2.7200e-06 nf=1 m=8 par=8
XMpar3 a_3090_10651.t0 inn.t0 a_5170_8595.t0 vdd.t8 pfet_03v3 w=2u l=4u ad=8.1600e-13 pd=3.6160e-06 as=6.8800e-13 ps=3.0880e-06 nf=1 m=10 par=10
XMpar4 a_6414_4675.t0 a_3147_8387.t10 out.t0 vss.t0 nfet_03v3 w=1.17u l=2.55u ad=7.0200e-13 pd=3.5400e-06 as=3.2760e-13 ps=1.7300e-06 nf=1 m=2 par=2
XMpar5 a_4693_6441.t4 ib.t0 vss.t13 vss.t12 nfet_03v3 w=0.4u l=3.5u ad=1.1200e-13 pd=9.6000e-07 as=1.1200e-13 ps=9.6000e-07 nf=1 m=2 par=2
XMpar6 a_6414_4675.t1 a_3147_8387.t16 vss.t4 vss.t3 nfet_03v3 w=1.15u l=5.63u ad=3.2200e-13 pd=1.7100e-06 as=3.2200e-13 ps=1.7100e-06 nf=1 m=2 par=2
XMpar7 ib.t1 ib.t0 vss.t13 vss.t12 nfet_03v3 w=0.4u l=3.5u ad=2.4000e-13 pd=2.0000e-06 as=1.1200e-13 ps=9.6000e-07 nf=1 m=2 par=2
XMpar8 a_4693_6441.t1 a_4693_6441.t0 vdd.t1 vdd.t0 pfet_03v3 w=1.6u l=3.5u ad=4.4800e-13 pd=2.1600e-06 as=4.4800e-13 ps=2.1600e-06 nf=1 m=2 par=2
XMpar9 a_3147_8387.t11 a_3147_8387.t10 a_4420_1249.t0 vss.t0 nfet_03v3 w=1.17u l=2.55u ad=7.0200e-13 pd=3.5400e-06 as=7.0200e-13 ps=3.5400e-06 nf=1 m=2 par=2
XMpar10 a_5170_8595.t10 a_3147_8387.t0 out.t1 vdd.t19 pfet_03v3 w=1.58u l=2.55u ad=6.1093e-13 pd=2.8800e-06 as=4.4240e-13 ps=2.1400e-06 nf=1 m=6 par=6
XMpar11 a_4420_1249.t2 a_3147_8387.t16 vss.t4 vss.t3 nfet_03v3 w=1.15u l=5.63u ad=6.9000e-13 pd=3.5000e-06 as=3.2200e-13 ps=1.7100e-06 nf=1 m=2 par=2
X35 out.t8 vss.t1 cap_mim_2f0fF c_width=10.25u c_length=10.25u
Rpar0 a_3027_8595.t0 a_3027_8595.t6 38.9178
Rpar1 a_3090_10651.t0 a_3090_10651.t20 49.3920
Rpar2 a_3147_8387.t0 a_3147_8387.t1 16.3648
Rpar3 a_3147_8387.t0 a_3147_8387.t10 1005.3307
Rpar4 a_3147_8387.t0 a_3147_8387.t11 607.5541
Rpar5 a_3147_8387.t0 a_3147_8387.t16 551.5987
Rpar6 a_3147_8387.t1 a_3147_8387.t10 374.5261
Rpar7 a_3147_8387.t1 a_3147_8387.t11 226.3383
Rpar8 a_3147_8387.t1 a_3147_8387.t16 205.4927
Rpar9 a_3147_8387.t10 a_3147_8387.t11 23.3471
Rpar10 a_3147_8387.t10 a_3147_8387.t16 200.3483
Rpar11 a_3147_8387.t11 a_3147_8387.t16 121.0770
Rpar12 a_4420_1249.t0 a_4420_1249.t2 65.4420
Rpar13 a_4693_6441.t0 a_4693_6441.t1 27.0276
Rpar14 a_4693_6441.t0 a_4693_6441.t4 82.6018
Rpar15 a_4693_6441.t1 a_4693_6441.t4 91.4555
Rpar16 a_5170_8595.t0 a_5170_8595.t10 59.1201
Rpar17 a_6414_4675.t0 a_6414_4675.t1 63.6030
Rpar18 ib ib.t0 16.8673
Rpar19 ib ib.t1 9.1722
Rpar20 ib.t0 ib.t1 89.7381
Rpar21 inn inn.t0 2.5319
Rpar22 inp inp.t0 2.5319
Rpar23 out out.t0 82.8764
Rpar24 out out.t1 139.6991
Rpar25 out out.t8 15.0032
Rpar26 out.t0 out.t1 119.8415
Rpar27 out.t0 out.t8 1051.7476
Rpar28 out.t1 out.t8 1772.8587
Rpar29 vdd vdd.t0 693.4857
Rpar30 vdd vdd.t1 1476.7958
Rpar31 vdd vdd.t8 32.7566
Rpar32 vdd vdd.t19 374.0114
Rpar33 vdd.t0 vdd.t1 6.5892
Rpar34 vdd.t0 vdd.t8 168.7262
Rpar35 vdd.t0 vdd.t19 22.2352
Rpar36 vdd.t1 vdd.t8 359.3068
Rpar37 vdd.t1 vdd.t19 47.3505
Rpar38 vdd.t8 vdd.t19 90.9976
Rpar39 vss vss.t0 77.4144
Rpar40 vss vss.t1 72.2724
Rpar41 vss vss.t3 91.1817
Rpar42 vss vss.t4 445.8883
Rpar43 vss vss.t12 148.8266
Rpar44 vss vss.t13 366.3352
Rpar45 vss.t0 vss.t1 181.3548
Rpar46 vss.t0 vss.t3 5.5148
Rpar47 vss.t0 vss.t4 26.1329
Rpar48 vss.t0 vss.t12 7.5114
Rpar49 vss.t0 vss.t13 22.8676
Rpar50 vss.t1 vss.t3 213.3383
Rpar51 vss.t1 vss.t4 1109.2671
Rpar52 vss.t1 vss.t12 355.1828
Rpar53 vss.t1 vss.t13 838.9258
Rpar54 vss.t3 vss.t4 30.2572
Rpar55 vss.t3 vss.t12 10.0600
Rpar56 vss.t3 vss.t13 31.9898
Rpar57 vss.t4 vss.t12 39.3991
Rpar58 vss.t4 vss.t13 193.2340
Rpar59 vss.t12 vss.t13 50.1681
Cpar0 a_3027_8595.t0 vss 8.65837e-15
Cpar1 a_3027_8595.t6 vss 1.82614e-14
Cpar2 a_3090_10651.t0 vss 3.17473e-14
Cpar3 a_3090_10651.t20 vss 8.51652e-15
Cpar4 a_3147_8387.t0 vss 1.51838e-14
Cpar5 a_3147_8387.t1 vss 5.21046e-15
Cpar6 a_3147_8387.t10 vss 5.30516e-15
Cpar7 a_3147_8387.t11 vss 2.60907e-15
Cpar8 a_3147_8387.t16 vss 1.05895e-14
Cpar9 a_4420_1249.t0 vss 2.98001e-15
Cpar10 a_4420_1249.t2 vss 3.63848e-15
Cpar11 a_4693_6441.t0 vss 2.57041e-14
Cpar12 a_4693_6441.t1 vss 3.95312e-15
Cpar13 a_4693_6441.t4 vss 2.94574e-15
Cpar14 a_5170_8595.t0 vss 1.96521e-14
Cpar15 a_5170_8595.t10 vss 9.68470e-15
Cpar16 a_6414_4675.t0 vss 4.22876e-15
Cpar17 a_6414_4675.t1 vss 4.25471e-15
Cpar18 ib vss 1.14038e-14
Cpar19 ib.t0 vss 1.32463e-15
Cpar20 ib.t1 vss 8.74487e-17
Cpar21 inn inp 7.17900e-17
Cpar22 inn vdd 1.71089e-14
Cpar23 inn vss 3.97543e-15
Cpar24 inn.t0 vss 2.18580e-14
Cpar25 inp vdd 1.71715e-14
Cpar26 inp vss 3.98464e-15
Cpar27 inp.t0 vss 2.19131e-14
Cpar28 out vdd 5.75777e-15
Cpar29 out vss 1.23672e-14
Cpar30 out.t0 vss 1.23652e-15
Cpar31 out.t1 vss 2.35613e-15
Cpar32 out.t8 vss 1.13675e-14
Cpar33 vdd vss 2.19863e-13
Cpar34 vdd.t0 vss 1.63865e-14
Cpar35 vdd.t1 vss 8.15980e-15
Cpar36 vdd.t19 vss 2.53923e-14
Cpar37 vdd.t8 vss 5.04888e-14
.ends opamp_dut

Vdd vdd 0 3.300000
Vss vss 0 0
Ibias vdd ib 2.300000e-07
Vinp inp 0 DC 1.480000 AC 1 PWL(0 1.480000 1.763275e-07 1.480000 1.939603e-07 1.490000)
Rfb out inn 1m
Cload out 0 2.000000e-12
Xdut vdd vss inp inn out ib opamp_dut
.end
