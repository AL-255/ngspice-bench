* opa1000[0939]: 200f/telescopic_pmos_3v3_i50n_subth (telescopic_pmos, VDD=3.3V, CL=0.2pF, Iref=0.01uA)
.include "pdk_opa.inc"
.temp 27
.option gmin=1e-12 rshunt=1e12 reltol=1e-3 abstol=1e-12 vntol=1e-5 method=gear
* Post-PEX R+C extracted netlist for telescopic_pmos_3v3_i50n_subth
.subckt opamp_dut vdd vss inp inn out ib
XMpar0 a_2384_12049.t0 a_1471_3918.t10 vss.t1 vss.t0 nfet_03v3 w=0.4u l=9.75u ad=2.4000e-13 pd=2.0000e-06 as=1.1200e-13 ps=9.6000e-07 nf=1 m=2 par=2
XMpar1 a_3954_1294.t0 a_6466_3963.t2 vdd.t1 vdd.t0 pfet_03v3 w=0.4u l=3u ad=1.1200e-13 pd=9.6000e-07 as=2.0800e-13 ps=1.7400e-06 nf=1 m=8 par=8
XMpar2 a_2160_4126.t1 inn.t0 a_3954_1294.t6 vdd.t16 pfet_03v3 w=1.65u l=4.4u ad=4.6200e-13 pd=2.2100e-06 as=9.9000e-13 ps=4.5000e-06 nf=1 m=4 par=4
XMpar3 a_6466_3963.t0 ib.t0 vss.t3 vss.t2 nfet_03v3 w=0.4u l=3u ad=1.1200e-13 pd=9.6000e-07 as=1.1200e-13 ps=9.6000e-07 nf=1 m=2 par=2
XMpar4 a_2384_12049.t1 a_1471_3918.t0 out.t1 vss.t10 nfet_03v3 w=0.4u l=2.1u ad=2.4000e-13 pd=2.0000e-06 as=1.1200e-13 ps=9.6000e-07 nf=1 m=2 par=2
XMpar5 a_2160_4126.t0 a_1471_3918.t4 out.t0 vdd.t3 pfet_03v3 w=1.19u l=2.1u ad=7.1400e-13 pd=3.5800e-06 as=3.3320e-13 ps=1.7500e-06 nf=1 m=2 par=2
XMpar6 a_1351_4126.t2 inp.t0 a_3954_1294.t6 vdd.t16 pfet_03v3 w=1.65u l=4.4u ad=4.6200e-13 pd=2.2100e-06 as=9.9000e-13 ps=4.5000e-06 nf=1 m=4 par=4
XMpar7 a_1471_3918.t1 a_1471_3918.t0 a_1576_12049.t0 vss.t10 nfet_03v3 w=0.4u l=2.1u ad=2.4000e-13 pd=2.0000e-06 as=2.4000e-13 ps=2.0000e-06 nf=1 m=2 par=2
XMpar8 ib.t1 ib.t0 vss.t3 vss.t2 nfet_03v3 w=0.4u l=3u ad=2.4000e-13 pd=2.0000e-06 as=1.1200e-13 ps=9.6000e-07 nf=1 m=2 par=2
XMpar9 a_6466_3963.t3 a_6466_3963.t2 vdd.t1 vdd.t0 pfet_03v3 w=0.4u l=3u ad=2.4000e-13 pd=2.0000e-06 as=1.1200e-13 ps=9.6000e-07 nf=1 m=2 par=2
XMpar10 a_1576_12049.t2 a_1471_3918.t10 vss.t1 vss.t0 nfet_03v3 w=0.4u l=9.75u ad=2.4000e-13 pd=2.0000e-06 as=1.1200e-13 ps=9.6000e-07 nf=1 m=2 par=2
XMpar11 a_1351_4126.t0 a_1471_3918.t4 a_1471_3918.t5 vdd.t3 pfet_03v3 w=1.19u l=2.1u ad=7.1400e-13 pd=3.5800e-06 as=7.1400e-13 ps=3.5800e-06 nf=1 m=2 par=2
X7 out.t4 vss.t14 cap_mim_2f0fF c_width=18.88u c_length=18.88u
Rpar0 a_1351_4126.t0 a_1351_4126.t2 53.7343
Rpar1 a_1471_3918.t0 a_1471_3918.t1 24.1064
Rpar2 a_1471_3918.t0 a_1471_3918.t10 191.1122
Rpar3 a_1471_3918.t0 a_1471_3918.t4 989.8759
Rpar4 a_1471_3918.t0 a_1471_3918.t5 545.6921
Rpar5 a_1471_3918.t1 a_1471_3918.t10 138.3728
Rpar6 a_1471_3918.t1 a_1471_3918.t4 716.7093
Rpar7 a_1471_3918.t1 a_1471_3918.t5 395.1027
Rpar8 a_1471_3918.t10 a_1471_3918.t4 179.1158
Rpar9 a_1471_3918.t10 a_1471_3918.t5 98.7417
Rpar10 a_1471_3918.t4 a_1471_3918.t5 22.6047
Rpar11 a_1576_12049.t0 a_1576_12049.t2 57.7625
Rpar12 a_2160_4126.t0 a_2160_4126.t1 71.1004
Rpar13 a_2384_12049.t0 a_2384_12049.t1 63.2261
Rpar14 a_3954_1294.t0 a_3954_1294.t6 59.1638
Rpar15 a_6466_3963.t0 a_6466_3963.t2 83.9336
Rpar16 a_6466_3963.t0 a_6466_3963.t3 127.1974
Rpar17 a_6466_3963.t2 a_6466_3963.t3 15.4347
Rpar18 ib ib.t0 16.2559
Rpar19 ib ib.t1 9.0272
Rpar20 ib.t0 ib.t1 98.6297
Rpar21 inn inn.t0 3.2012
Rpar22 inp inp.t0 3.2012
Rpar23 out out.t0 12.7905
Rpar24 out out.t1 127.2941
Rpar25 out out.t4 178.0500
Rpar26 out.t0 out.t1 1097.0618
Rpar27 out.t0 out.t4 1534.4928
Rpar28 out.t1 out.t4 94.4093
Rpar29 vdd vdd.t0 405.9013
Rpar30 vdd vdd.t1 96.0810
Rpar31 vdd vdd.t3 379.4512
Rpar32 vdd vdd.t16 184.3454
Rpar33 vdd.t0 vdd.t1 14.3189
Rpar34 vdd.t0 vdd.t3 641.5791
Rpar35 vdd.t0 vdd.t16 311.6926
Rpar36 vdd.t1 vdd.t3 151.8683
Rpar37 vdd.t1 vdd.t16 73.7808
Rpar38 vdd.t3 vdd.t16 70.8296
Rpar39 vss vss.t0 1624.0213
Rpar40 vss vss.t1 839.1848
Rpar41 vss vss.t10 523.5842
Rpar42 vss vss.t14 659.7170
Rpar43 vss vss.t2 220.1366
Rpar44 vss vss.t3 749.5845
Rpar45 vss.t0 vss.t1 115.8435
Rpar46 vss.t0 vss.t10 10.7999
Rpar47 vss.t0 vss.t14 643.1593
Rpar48 vss.t0 vss.t2 44.1890
Rpar49 vss.t0 vss.t3 156.8002
Rpar50 vss.t1 vss.t10 37.9204
Rpar51 vss.t1 vss.t14 332.3414
Rpar52 vss.t1 vss.t2 48.9035
Rpar53 vss.t1 vss.t3 171.9001
Rpar54 vss.t10 vss.t14 207.3545
Rpar55 vss.t10 vss.t2 14.5291
Rpar56 vss.t10 vss.t3 51.5650
Rpar57 vss.t14 vss.t2 87.1805
Rpar58 vss.t14 vss.t3 296.8571
Rpar59 vss.t2 vss.t3 16.6480
Cpar0 a_1351_4126.t0 vss 4.79030e-15
Cpar1 a_1351_4126.t2 vss 6.86872e-15
Cpar2 a_1471_3918.t0 vss 2.87791e-15
Cpar3 a_1471_3918.t1 vss 1.46448e-15
Cpar4 a_1471_3918.t10 vss 1.02940e-14
Cpar5 a_1471_3918.t4 vss 3.43383e-15
Cpar6 a_1471_3918.t5 vss 1.81187e-15
Cpar7 a_1576_12049.t0 vss 3.31726e-15
Cpar8 a_1576_12049.t2 vss 6.13840e-15
Cpar9 a_2160_4126.t0 vss 6.25858e-15
Cpar10 a_2160_4126.t1 vss 8.51947e-15
Cpar11 a_2384_12049.t0 vss 7.73785e-15
Cpar12 a_2384_12049.t1 vss 4.41100e-15
Cpar13 a_3954_1294.t0 vss 1.19619e-14
Cpar14 a_3954_1294.t6 vss 1.48285e-14
Cpar15 a_6466_3963.t0 vss 3.37459e-15
Cpar16 a_6466_3963.t2 vss 2.31911e-14
Cpar17 a_6466_3963.t3 vss 5.04704e-15
Cpar18 ib vdd 5.26300e-17
Cpar19 ib vss 1.02502e-14
Cpar20 ib.t0 vss 1.25790e-15
Cpar21 ib.t1 vss 8.60304e-17
Cpar22 inn inp 1.03960e-16
Cpar23 inn vdd 8.10671e-15
Cpar24 inn vss 3.31862e-15
Cpar25 inn.t0 vss 8.36175e-15
Cpar26 inp vdd 8.13336e-15
Cpar27 inp vss 3.19560e-15
Cpar28 inp.t0 vss 8.39133e-15
Cpar29 out vdd 3.47554e-15
Cpar30 out vss 1.55857e-14
Cpar31 out.t0 vss 6.37818e-17
Cpar32 out.t1 vss 4.25533e-16
Cpar33 out.t4 vss 1.15484e-14
Cpar34 vdd vss 1.34151e-13
Cpar35 vdd.t0 vss 2.11340e-14
Cpar36 vdd.t1 vss 6.85395e-15
Cpar37 vdd.t16 vss 2.28413e-14
Cpar38 vdd.t3 vss 1.07274e-14
.ends opamp_dut

Vdd vdd 0 3.300000
Vss vss 0 0
Ibias vdd ib 1.000000e-08
Vinp inp 0 DC 1.480000 AC 1 PWL(0 1.480000 1.213689e-06 1.480000 1.335058e-06 1.490000)
Rfb out inn 1m
Cload out 0 2.000000e-13
Xdut vdd vss inp inn out ib opamp_dut
.end
