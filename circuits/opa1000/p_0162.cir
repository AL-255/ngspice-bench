* opa1000[0162]: 2p/current_reuse_3v3_10u_100u_weak (current_reuse, VDD=3.3V, CL=2.0pF, Iref=8.2143uA)
.include "pdk_opa.inc"
.temp 27
.option gmin=1e-12 rshunt=1e12 reltol=1e-3 abstol=1e-12 vntol=1e-5 method=gear
* Post-PEX R+C extracted netlist for current_reuse_3v3_10u_100u_weak
.subckt opamp_dut vdd vss inp inn out ib
XMpar0 out.t12 ib.t0 vss.t14 vss.t13 nfet_03v3 w=3.4u l=1u ad=1.1696e-12 pd=4.7680e-06 as=9.5200e-13 ps=3.9600e-06 nf=1 m=10 par=10
XMpar1 a_4114_10758.t0 inp.t6 a_991_6062.t2 vdd.t4 pfet_03v3 w=1.94u l=0.8u ad=6.4667e-13 pd=2.9300e-06 as=5.4320e-13 ps=2.5000e-06 nf=1 m=12 par=12
XMpar2 a_5746_6021.t0 inp.t0 a_991_6062.t14 vss.t0 nfet_03v3 w=1.78u l=0.8u ad=6.8827e-13 pd=3.1467e-06 as=4.9840e-13 ps=2.3400e-06 nf=1 m=6 par=6
XMpar3 a_5746_6021.t12 ib.t0 vss.t14 vss.t13 nfet_03v3 w=3.4u l=1u ad=9.5200e-13 pd=3.9600e-06 as=9.5200e-13 ps=3.9600e-06 nf=1 m=4 par=4
XMpar4 a_4114_10758.t0 inn.t6 a_7584_12268.t0 vdd.t4 pfet_03v3 w=1.94u l=0.8u ad=6.4667e-13 pd=2.9300e-06 as=5.4320e-13 ps=2.5000e-06 nf=1 m=12 par=12
XMpar5 a_4114_10758.t12 a_7584_12268.t18 vdd.t1 vdd.t0 pfet_03v3 w=8.37u l=0.5u ad=2.3436e-12 pd=8.9300e-06 as=5.0220e-12 ps=1.7940e-05 nf=1 m=2 par=2
XMpar6 out.t0 a_991_6062.t20 vdd.t1 vdd.t0 pfet_03v3 w=8.37u l=0.5u ad=2.3436e-12 pd=8.9300e-06 as=2.8793e-12 ps=1.0732e-05 nf=1 m=10 par=10
XMpar7 a_5746_6021.t0 inn.t0 a_7584_12268.t12 vss.t0 nfet_03v3 w=1.78u l=0.8u ad=6.8827e-13 pd=3.1467e-06 as=4.9840e-13 ps=2.3400e-06 nf=1 m=6 par=6
XMpar8 ib.t1 ib.t0 vss.t14 vss.t13 nfet_03v3 w=3.4u l=1u ad=9.5200e-13 pd=3.9600e-06 as=9.5200e-13 ps=3.9600e-06 nf=1 m=2 par=2
XMpar9 a_7584_12268.t19 a_7584_12268.t18 vdd.t1 vdd.t0 pfet_03v3 w=8.37u l=0.5u ad=5.0220e-12 pd=1.7940e-05 as=2.3436e-12 ps=8.9300e-06 nf=1 m=1
XMpar10 a_991_6062.t1 a_7584_12268.t18 vdd.t1 vdd.t0 pfet_03v3 w=8.37u l=0.5u ad=5.0220e-12 pd=1.7940e-05 as=2.3436e-12 ps=8.9300e-06 nf=1 m=1
X1 a_1803_6062.t1 out.t6 cap_mim_2f0fF c_width=15.62u c_length=15.61u
X44 a_1803_6062.t1 out.t6 cap_mim_2f0fF c_width=15.62u c_length=15.61u
X63 a_991_6062.t0 a_1803_6062.t0 vss.t6 ppolyf_u_1k r_width=1u r_length=3.4u
Rpar0 a_1803_6062.t0 a_1803_6062.t1 58.4157
Rpar1 a_4114_10758.t0 a_4114_10758.t12 48.3014
Rpar2 a_5746_6021.t0 a_5746_6021.t12 61.5154
Rpar3 a_7584_12268.t0 a_7584_12268.t12 98.1069
Rpar4 a_7584_12268.t0 a_7584_12268.t18 295.3965
Rpar5 a_7584_12268.t0 a_7584_12268.t19 64.9584
Rpar6 a_7584_12268.t12 a_7584_12268.t18 99.0384
Rpar7 a_7584_12268.t12 a_7584_12268.t19 345.7837
Rpar8 a_7584_12268.t18 a_7584_12268.t19 75.4409
Rpar9 a_991_6062.t0 a_991_6062.t1 328.1477
Rpar10 a_991_6062.t0 a_991_6062.t2 127.1908
Rpar11 a_991_6062.t0 a_991_6062.t14 130.7822
Rpar12 a_991_6062.t0 a_991_6062.t20 74.7232
Rpar13 a_991_6062.t1 a_991_6062.t2 58.7294
Rpar14 a_991_6062.t1 a_991_6062.t14 478.8363
Rpar15 a_991_6062.t1 a_991_6062.t20 236.7232
Rpar16 a_991_6062.t2 a_991_6062.t14 185.5980
Rpar17 a_991_6062.t2 a_991_6062.t20 91.7544
Rpar18 a_991_6062.t14 a_991_6062.t20 109.0368
Rpar19 ib ib.t0 21.8223
Rpar20 ib ib.t1 10.3616
Rpar21 ib.t0 ib.t1 65.7817
Rpar22 inn inn.t0 3.1963
Rpar23 inn inn.t6 54.4723
Rpar24 inp inp.t0 3.5811
Rpar25 inp inp.t6 54.4237
Rpar26 out out.t0 1.5762
Rpar27 out out.t12 221.1835
Rpar28 out out.t6 769.8721
Rpar29 out.t0 out.t12 307.1010
Rpar30 out.t0 out.t6 1068.9244
Rpar31 out.t12 out.t6 57.6695
Rpar32 vdd vdd.t0 49.0173
Rpar33 vdd vdd.t1 64.3530
Rpar34 vdd vdd.t4 94.8793
Rpar35 vdd.t0 vdd.t1 3.4620
Rpar36 vdd.t0 vdd.t4 64.7874
Rpar37 vdd.t1 vdd.t4 82.2301
Rpar38 vss vss.t0 110.8860
Rpar39 vss vss.t13 104.8475
Rpar40 vss vss.t14 373.2058
Rpar41 vss vss.t6 125.8561
Rpar42 vss.t0 vss.t13 3.6302
Rpar43 vss.t0 vss.t14 21.5527
Rpar44 vss.t0 vss.t6 394.7614
Rpar45 vss.t13 vss.t14 5.2368
Rpar46 vss.t13 vss.t6 432.7373
Rpar47 vss.t14 vss.t6 1576.8624
Cpar0 a_1803_6062.t0 vss 5.54011e-17
Cpar1 a_1803_6062.t1 vss 4.19598e-15
Cpar2 a_4114_10758.t0 vss 1.63265e-14
Cpar3 a_4114_10758.t12 vss 4.89569e-15
Cpar4 a_5746_6021.t0 vss 6.01704e-15
Cpar5 a_5746_6021.t12 vss 6.78573e-15
Cpar6 a_7584_12268.t0 vss 1.02060e-14
Cpar7 a_7584_12268.t12 vss 5.60787e-15
Cpar8 a_7584_12268.t18 vss 4.89562e-15
Cpar9 a_7584_12268.t19 vss 6.91631e-15
Cpar10 a_991_6062.t0 vss 2.18650e-15
Cpar11 a_991_6062.t1 vss 4.21504e-15
Cpar12 a_991_6062.t14 vss 2.86942e-15
Cpar13 a_991_6062.t2 vss 7.06258e-15
Cpar14 a_991_6062.t20 vss 9.35706e-15
Cpar15 ib out 1.81405e-15
Cpar16 ib vss 1.84772e-14
Cpar17 ib.t0 vss 3.82567e-15
Cpar18 ib.t1 vss 3.60890e-16
Cpar19 inn inp 1.04240e-16
Cpar20 inn out 1.02150e-16
Cpar21 inn vdd 7.57009e-15
Cpar22 inn vss 9.61626e-15
Cpar23 inn.t0 vss 1.62191e-15
Cpar24 inn.t6 vss 8.99521e-15
Cpar25 inp out 8.59260e-16
Cpar26 inp vdd 7.81682e-15
Cpar27 inp vss 8.92942e-15
Cpar28 inp.t0 vss 1.72584e-15
Cpar29 inp.t6 vss 8.59378e-15
Cpar30 out vdd 1.72993e-14
Cpar31 out vss 2.36216e-14
Cpar32 out.t0 vss 6.77891e-15
Cpar33 out.t12 vss 7.00120e-15
Cpar34 out.t6 vss 1.41426e-14
Cpar35 vdd vss 1.06498e-13
Cpar36 vdd.t0 vss 1.91085e-14
Cpar37 vdd.t1 vss 1.56180e-14
Cpar38 vdd.t4 vss 2.13868e-14
.ends opamp_dut

Vdd vdd 0 3.300000
Vss vss 0 0
Ibias vdd ib 8.214300e-06
Vinp inp 0 DC 1.645000 AC 1 PWL(0 1.645000 3.726258e-09 1.645000 4.098884e-09 1.655000)
Rfb out inn 1m
Cload out 0 2.000000e-12
Xdut vdd vss inp inn out ib opamp_dut
.end
