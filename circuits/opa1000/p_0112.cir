* opa1000[0112]: 200f/current_reuse_3v3_i1u_weak (current_reuse, VDD=3.3V, CL=0.2pF, Iref=0.15uA)
.include "pdk_opa.inc"
.temp 27
.option gmin=1e-12 rshunt=1e12 reltol=1e-3 abstol=1e-12 vntol=1e-5 method=gear
* Post-PEX R+C extracted netlist for current_reuse_3v3_i1u_weak
.subckt opamp_dut vdd vss inp inn out ib
XMpar0 a_6354_6494.t4 ib.t0 vss.t11 vss.t10 nfet_03v3 w=0.4u l=3.5u ad=2.4000e-13 pd=2.0000e-06 as=1.1200e-13 ps=9.6000e-07 nf=1 m=4 par=4
XMpar1 out.t0 a_1004_1290.t6 vdd.t1 vdd.t0 pfet_03v3 w=0.85u l=1.8u ad=2.3800e-13 pd=1.4100e-06 as=2.9240e-13 ps=1.7080e-06 nf=1 m=10 par=10
XMpar2 a_6354_8128.t0 a_7804_10207.t0 vdd.t1 vdd.t0 pfet_03v3 w=0.85u l=1.8u ad=2.3800e-13 pd=1.4100e-06 as=5.1000e-13 ps=2.9000e-06 nf=1 m=2 par=2
XMpar3 a_1004_1290.t1 inp.t0 a_6354_6494.t0 vss.t0 nfet_03v3 w=0.62u l=3.2u ad=1.7360e-13 pd=1.1800e-06 as=3.7200e-13 ps=2.4400e-06 nf=1 m=2 par=2
XMpar4 a_1004_1290.t3 inp.t2 a_6354_8128.t1 vdd.t6 pfet_03v3 w=1.3u l=3.2u ad=3.6400e-13 pd=1.8600e-06 as=7.8000e-13 ps=3.8000e-06 nf=1 m=2 par=2
XMpar5 a_1004_1290.t0 a_7804_10207.t0 vdd.t1 vdd.t0 pfet_03v3 w=0.85u l=1.8u ad=5.1000e-13 pd=2.9000e-06 as=2.3800e-13 ps=1.4100e-06 nf=1 m=1
XMpar6 out.t10 ib.t0 vss.t11 vss.t10 nfet_03v3 w=0.4u l=3.5u ad=1.8880e-13 pd=1.5840e-06 as=1.6320e-13 ps=1.3760e-06 nf=1 m=10 par=10
XMpar7 a_6354_8128.t1 inn.t2 a_7804_10207.t4 vdd.t6 pfet_03v3 w=1.3u l=3.2u ad=7.8000e-13 pd=3.8000e-06 as=3.6400e-13 ps=1.8600e-06 nf=1 m=2 par=2
XMpar8 ib.t1 ib.t0 vss.t11 vss.t10 nfet_03v3 w=0.4u l=3.5u ad=2.4000e-13 pd=2.0000e-06 as=1.1200e-13 ps=9.6000e-07 nf=1 m=2 par=2
XMpar9 a_7804_10207.t1 a_7804_10207.t0 vdd.t1 vdd.t0 pfet_03v3 w=0.85u l=1.8u ad=5.1000e-13 pd=2.9000e-06 as=2.3800e-13 ps=1.4100e-06 nf=1 m=1
XMpar10 a_6354_6494.t0 inn.t0 a_7804_10207.t2 vss.t0 nfet_03v3 w=0.62u l=3.2u ad=3.7200e-13 pd=2.4400e-06 as=1.7360e-13 ps=1.1800e-06 nf=1 m=2 par=2
X1 a_4684_4410.t1 out.t1 cap_mim_2f0fF c_width=13.83u c_length=13.83u
X2 a_1004_2850.t0 a_4684_3370.t0 vss.t2 ppolyf_u_1k r_width=1u r_length=17.74u
X8 a_1004_2850.t0 a_4684_2330.t0 vss.t2 ppolyf_u_1k r_width=1u r_length=17.74u
X17 a_1004_1810.t0 a_4684_2330.t0 vss.t2 ppolyf_u_1k r_width=1u r_length=17.74u
X21 a_1004_1810.t0 a_4684_1290.t0 vss.t2 ppolyf_u_1k r_width=1u r_length=17.74u
X29 a_1004_3890.t0 a_4684_4410.t0 vss.t2 ppolyf_u_1k r_width=1u r_length=17.74u
X41 a_1004_1290.t5 a_4684_1290.t0 vss.t2 ppolyf_u_1k r_width=1u r_length=17.74u
X45 a_1004_3890.t0 a_4684_3370.t0 vss.t2 ppolyf_u_1k r_width=1u r_length=17.74u
Rpar0 a_1004_1290.t0 a_1004_1290.t1 337.3187
Rpar1 a_1004_1290.t0 a_1004_1290.t6 509.8717
Rpar2 a_1004_1290.t0 a_1004_1290.t3 130.4182
Rpar3 a_1004_1290.t0 a_1004_1290.t5 1168.6880
Rpar4 a_1004_1290.t1 a_1004_1290.t6 114.4239
Rpar5 a_1004_1290.t1 a_1004_1290.t3 150.5841
Rpar6 a_1004_1290.t1 a_1004_1290.t5 262.2734
Rpar7 a_1004_1290.t6 a_1004_1290.t3 227.6144
Rpar8 a_1004_1290.t6 a_1004_1290.t5 94.5737
Rpar9 a_1004_1290.t3 a_1004_1290.t5 521.7199
Rpar10 a_4684_4410.t0 a_4684_4410.t1 52.8110
Rpar11 a_6354_6494.t0 a_6354_6494.t4 53.2349
Rpar12 a_6354_8128.t0 a_6354_8128.t1 44.2348
Rpar13 a_7804_10207.t0 a_7804_10207.t1 30.3913
Rpar14 a_7804_10207.t0 a_7804_10207.t2 77.4854
Rpar15 a_7804_10207.t0 a_7804_10207.t4 70.1154
Rpar16 a_7804_10207.t1 a_7804_10207.t2 435.6645
Rpar17 a_7804_10207.t1 a_7804_10207.t4 163.4515
Rpar18 a_7804_10207.t2 a_7804_10207.t4 137.2636
Rpar19 ib ib.t0 14.4639
Rpar20 ib ib.t1 14.6953
Rpar21 ib.t0 ib.t1 34.2161
Rpar22 inn inn.t0 3.4553
Rpar23 inn inn.t2 42.8960
Rpar24 inp inp.t0 3.5039
Rpar25 inp inp.t2 42.8474
Rpar26 out out.t0 128.8687
Rpar27 out out.t1 479.9562
Rpar28 out out.t10 4.5548
Rpar29 out.t0 out.t1 79.7848
Rpar30 out.t0 out.t10 102.4288
Rpar31 out.t1 out.t10 381.4838
Rpar32 vdd vdd.t0 55.3294
Rpar33 vdd vdd.t1 66.3101
Rpar34 vdd vdd.t6 147.3227
Rpar35 vdd.t0 vdd.t1 3.9327
Rpar36 vdd.t0 vdd.t6 55.1782
Rpar37 vdd.t1 vdd.t6 101.6380
Rpar38 vss vss.t0 237.7237
Rpar39 vss vss.t10 233.6537
Rpar40 vss vss.t11 65.8808
Rpar41 vss vss.t2 66.1064
Rpar42 vss.t0 vss.t10 464.0527
Rpar43 vss.t0 vss.t11 158.6345
Rpar44 vss.t0 vss.t2 307.1961
Rpar45 vss.t10 vss.t11 13.1252
Rpar46 vss.t10 vss.t2 226.1668
Rpar47 vss.t11 vss.t2 111.9264
Cpar0 a_1004_1290.t0 vss 2.57246e-15
Cpar1 a_1004_1290.t1 vss 2.67132e-15
Cpar2 a_1004_1290.t3 vss 2.99320e-15
Cpar3 a_1004_1290.t5 vss 3.07985e-15
Cpar4 a_1004_1290.t6 vss 1.09307e-14
Cpar5 a_1004_1810.t0 vss 3.20200e-17
Cpar6 a_1004_2850.t0 vss 3.00800e-17
Cpar7 a_1004_3890.t0 vss 2.83000e-17
Cpar8 a_4684_1290.t0 vss 3.46000e-17
Cpar9 a_4684_2330.t0 vss 3.86600e-17
Cpar10 a_4684_3370.t0 vss 4.18200e-17
Cpar11 a_4684_4410.t0 vss 1.06900e-16
Cpar12 a_4684_4410.t1 vss 2.16979e-15
Cpar13 a_6354_6494.t0 vss 6.32825e-15
Cpar14 a_6354_6494.t4 vss 1.52599e-14
Cpar15 a_6354_8128.t0 vss 1.98477e-15
Cpar16 a_6354_8128.t1 vss 5.11283e-15
Cpar17 a_7804_10207.t0 vss 7.97415e-15
Cpar18 a_7804_10207.t1 vss 2.03471e-15
Cpar19 a_7804_10207.t2 vss 2.35513e-15
Cpar20 a_7804_10207.t4 vss 2.80661e-15
Cpar21 ib out 2.20235e-15
Cpar22 ib vss 4.42001e-14
Cpar23 ib.t0 vss 7.35489e-15
Cpar24 ib.t1 vss 6.06910e-16
Cpar25 inn inp 1.03960e-16
Cpar26 inn vdd 3.39578e-15
Cpar27 inn vss 6.14395e-15
Cpar28 inn.t0 vss 1.10769e-15
Cpar29 inn.t2 vss 3.21738e-15
Cpar30 inp out 3.63100e-17
Cpar31 inp vdd 3.74192e-15
Cpar32 inp vss 6.04039e-15
Cpar33 inp.t0 vss 1.24827e-15
Cpar34 inp.t2 vss 3.57952e-15
Cpar35 out vdd 7.00780e-15
Cpar36 out vss 2.02232e-14
Cpar37 out.t0 vss 3.89948e-15
Cpar38 out.t1 vss 9.38895e-15
Cpar39 out.t10 vss 4.86024e-15
Cpar40 vdd vss 8.00582e-14
Cpar41 vdd.t0 vss 1.60277e-14
Cpar42 vdd.t1 vss 8.82139e-15
Cpar43 vdd.t6 vss 8.96393e-15
.ends opamp_dut

Vdd vdd 0 3.300000
Vss vss 0 0
Ibias vdd ib 1.500000e-07
Vinp inp 0 DC 1.645000 AC 1 PWL(0 1.645000 6.767359e-08 1.645000 7.444094e-08 1.655000)
Rfb out inn 1m
Cload out 0 2.000000e-13
Xdut vdd vss inp inn out ib opamp_dut
.end
