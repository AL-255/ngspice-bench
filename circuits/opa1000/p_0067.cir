* opa1000[0067]: 2p/cherry_hooper_3v3_0p1u_1u_weak (cherry_hooper, VDD=3.3V, CL=2.0pF, Iref=0.0359uA)
.include "pdk_opa.inc"
.temp 27
.option gmin=1e-12 rshunt=1e12 reltol=1e-3 abstol=1e-12 vntol=1e-5 method=gear
* Post-PEX R+C extracted netlist for cherry_hooper_3v3_0p1u_1u_weak
.subckt opamp_dut vdd vss inp inn out ib
XMpar0 a_9906_16147.t2 ib.t0 vss.t3 vss.t2 nfet_03v3 w=0.4u l=5u ad=1.1200e-13 pd=9.6000e-07 as=1.1200e-13 ps=9.6000e-07 nf=1 m=2 par=2
XMpar1 a_5451_5522.t1 ib.t0 vss.t3 vss.t2 nfet_03v3 w=0.4u l=5u ad=1.1200e-13 pd=9.6000e-07 as=1.4400e-13 ps=1.2200e-06 nf=1 m=8 par=8
XMpar2 a_9906_14700.t1 ib.t0 vss.t3 vss.t2 nfet_03v3 w=0.4u l=5u ad=1.1200e-13 pd=9.6000e-07 as=1.7600e-13 ps=1.4800e-06 nf=1 m=4 par=4
XMpar3 a_10238_1204.t0 a_8822_10088.t6 a_5451_5522.t0 vss.t1 nfet_03v3 w=1.15u l=5.2u ad=6.9000e-13 pd=3.5000e-06 as=6.9000e-13 ps=3.5000e-06 nf=1 m=1
XMpar4 a_6454_12921.t2 ib.t0 vss.t3 vss.t2 nfet_03v3 w=0.4u l=5u ad=2.4000e-13 pd=2.0000e-06 as=1.1200e-13 ps=9.6000e-07 nf=1 m=1
XMpar5 a_8822_10088.t2 a_8822_10088.t1 vdd.t1 vdd.t0 pfet_03v3 w=0.45u l=2.5u ad=1.2600e-13 pd=1.0100e-06 as=2.7000e-13 ps=2.1000e-06 nf=1 m=2 par=2
XMpar6 a_10238_1204.t2 a_10238_1204.t1 vdd.t1 vdd.t0 pfet_03v3 w=0.45u l=2.5u ad=2.7000e-13 pd=2.1000e-06 as=1.2600e-13 ps=1.0100e-06 nf=1 m=4 par=4
XMpar7 a_11374_14700.t3 a_11374_14700.t2 vdd.t1 vdd.t0 pfet_03v3 w=0.45u l=2.5u ad=1.2600e-13 pd=1.0100e-06 as=2.7000e-13 ps=2.1000e-06 nf=1 m=2 par=2
XMpar8 a_11374_6943.t0 a_6454_12921.t0 vdd.t14 vdd.t13 pfet_03v3 w=0.41u l=5u ad=2.4600e-13 pd=2.0200e-06 as=2.4600e-13 ps=2.0200e-06 nf=1 m=1
XMpar9 out.t0 a_10238_1204.t1 vdd.t1 vdd.t0 pfet_03v3 w=0.45u l=2.5u ad=1.9800e-13 pd=1.5550e-06 as=1.2600e-13 ps=1.0100e-06 nf=1 m=4 par=4
XMpar10 a_6454_12921.t1 a_6454_12921.t0 vdd.t14 vdd.t13 pfet_03v3 w=0.41u l=5u ad=2.4600e-13 pd=2.0200e-06 as=2.4600e-13 ps=2.0200e-06 nf=1 m=1
XMpar11 a_10026_14491.t1 a_4842_8466.t3 a_8822_10088.t0 vdd.t4 pfet_03v3 w=0.4u l=6.11u ad=2.4000e-13 pd=2.0000e-06 as=2.4000e-13 ps=2.0000e-06 nf=1 m=1
XMpar12 ib.t1 ib.t0 vss.t3 vss.t2 nfet_03v3 w=0.4u l=5u ad=2.4000e-13 pd=2.0000e-06 as=1.1200e-13 ps=9.6000e-07 nf=1 m=1
XMpar13 a_1106_5314.t0 a_4842_8466.t1 a_4842_8466.t2 vdd.t10 pfet_03v3 w=1.49u l=1u ad=8.9400e-13 pd=4.1800e-06 as=8.9400e-13 ps=4.1800e-06 nf=1 m=1
XMpar14 a_11374_6943.t1 inn.t0 a_9906_16147.t0 vss.t0 nfet_03v3 w=0.4u l=5.2u ad=2.4000e-13 pd=2.0000e-06 as=2.4000e-13 ps=2.0000e-06 nf=1 m=2 par=2
XMpar15 a_10026_14491.t2 inp.t0 a_9906_16147.t0 vss.t0 nfet_03v3 w=0.4u l=5.2u ad=2.4000e-13 pd=2.0000e-06 as=2.4000e-13 ps=2.0000e-06 nf=1 m=2 par=2
XMpar16 a_5451_5522.t0 a_11374_14700.t6 out.t1 vss.t1 nfet_03v3 w=1.15u l=5.2u ad=6.9000e-13 pd=3.5000e-06 as=6.9000e-13 ps=3.5000e-06 nf=1 m=1
XMpar17 a_8822_10088.t5 a_10026_14491.t4 a_9906_14700.t0 vss.t0 nfet_03v3 w=0.58u l=5.2u ad=3.4800e-13 pd=2.3600e-06 as=3.4800e-13 ps=2.3600e-06 nf=1 m=1
XMpar18 a_11374_14700.t1 a_4842_8466.t3 a_11374_6943.t3 vdd.t4 pfet_03v3 w=0.4u l=6.11u ad=2.4000e-13 pd=2.0000e-06 as=2.4000e-13 ps=2.0000e-06 nf=1 m=1
XMpar19 a_10026_14491.t0 a_6454_12921.t0 vdd.t14 vdd.t13 pfet_03v3 w=0.41u l=5u ad=2.4600e-13 pd=2.0200e-06 as=2.4600e-13 ps=2.0200e-06 nf=1 m=1
XMpar20 a_1106_5314.t2 a_1106_5314.t1 vdd.t1 vdd.t0 pfet_03v3 w=0.45u l=2.5u ad=2.7000e-13 pd=2.1000e-06 as=2.7000e-13 ps=2.1000e-06 nf=1 m=1
XMpar21 a_4842_8466.t0 ib.t0 vss.t3 vss.t2 nfet_03v3 w=0.4u l=5u ad=2.4000e-13 pd=2.0000e-06 as=2.4000e-13 ps=2.0000e-06 nf=1 m=1
XMpar22 a_11374_14700.t0 a_11374_6943.t4 a_9906_14700.t0 vss.t0 nfet_03v3 w=0.58u l=5.2u ad=3.4800e-13 pd=2.3600e-06 as=3.4800e-13 ps=2.3600e-06 nf=1 m=1
X6 out.t5 vss.t38 cap_mim_2f0fF c_width=17.8u c_length=17.8u
X36 out.t5 vss.t38 cap_mim_2f0fF c_width=17.8u c_length=17.8u
X40 out.t5 vss.t38 cap_mim_2f0fF c_width=17.8u c_length=17.8u
Rpar0 a_10026_14491.t0 a_10026_14491.t1 219.5965
Rpar1 a_10026_14491.t0 a_10026_14491.t2 244.9278
Rpar2 a_10026_14491.t0 a_10026_14491.t4 259.2058
Rpar3 a_10026_14491.t1 a_10026_14491.t2 151.0148
Rpar4 a_10026_14491.t1 a_10026_14491.t4 159.8181
Rpar5 a_10026_14491.t2 a_10026_14491.t4 101.4571
Rpar6 a_10238_1204.t0 a_10238_1204.t1 223.4895
Rpar7 a_10238_1204.t0 a_10238_1204.t2 215.9656
Rpar8 a_10238_1204.t1 a_10238_1204.t2 8.2471
Rpar9 a_1106_5314.t0 a_1106_5314.t1 164.6491
Rpar10 a_1106_5314.t0 a_1106_5314.t2 123.3678
Rpar11 a_1106_5314.t1 a_1106_5314.t2 38.0770
Rpar12 a_11374_14700.t0 a_11374_14700.t1 185.6885
Rpar13 a_11374_14700.t0 a_11374_14700.t2 714.8194
Rpar14 a_11374_14700.t0 a_11374_14700.t3 606.6917
Rpar15 a_11374_14700.t0 a_11374_14700.t6 463.6282
Rpar16 a_11374_14700.t1 a_11374_14700.t2 217.9510
Rpar17 a_11374_14700.t1 a_11374_14700.t3 184.9825
Rpar18 a_11374_14700.t1 a_11374_14700.t6 141.3619
Rpar19 a_11374_14700.t2 a_11374_14700.t3 31.5589
Rpar20 a_11374_14700.t2 a_11374_14700.t6 206.4853
Rpar21 a_11374_14700.t3 a_11374_14700.t6 175.2512
Rpar22 a_11374_6943.t0 a_11374_6943.t1 217.7097
Rpar23 a_11374_6943.t0 a_11374_6943.t3 1006.1624
Rpar24 a_11374_6943.t0 a_11374_6943.t4 390.5163
Rpar25 a_11374_6943.t1 a_11374_6943.t3 231.8575
Rpar26 a_11374_6943.t1 a_11374_6943.t4 89.9896
Rpar27 a_11374_6943.t3 a_11374_6943.t4 254.2946
Rpar28 a_4842_8466.t0 a_4842_8466.t1 493.1392
Rpar29 a_4842_8466.t0 a_4842_8466.t2 164.2036
Rpar30 a_4842_8466.t0 a_4842_8466.t3 156.8180
Rpar31 a_4842_8466.t1 a_4842_8466.t2 57.2965
Rpar32 a_4842_8466.t1 a_4842_8466.t3 266.9743
Rpar33 a_4842_8466.t2 a_4842_8466.t3 88.8961
Rpar34 a_5451_5522.t0 a_5451_5522.t1 53.0578
Rpar35 a_6454_12921.t0 a_6454_12921.t1 31.2993
Rpar36 a_6454_12921.t0 a_6454_12921.t2 57.6659
Rpar37 a_6454_12921.t1 a_6454_12921.t2 331.8058
Rpar38 a_8822_10088.t0 a_8822_10088.t1 463.1251
Rpar39 a_8822_10088.t0 a_8822_10088.t2 393.0702
Rpar40 a_8822_10088.t0 a_8822_10088.t5 161.7645
Rpar41 a_8822_10088.t0 a_8822_10088.t6 192.3145
Rpar42 a_8822_10088.t1 a_8822_10088.t2 30.5692
Rpar43 a_8822_10088.t1 a_8822_10088.t5 730.0199
Rpar44 a_8822_10088.t1 a_8822_10088.t6 185.0293
Rpar45 a_8822_10088.t2 a_8822_10088.t5 619.5929
Rpar46 a_8822_10088.t2 a_8822_10088.t6 157.0407
Rpar47 a_8822_10088.t5 a_8822_10088.t6 303.1435
Rpar48 a_9906_14700.t0 a_9906_14700.t1 65.5835
Rpar49 a_9906_16147.t0 a_9906_16147.t2 53.3664
Rpar50 ib ib.t0 7.2779
Rpar51 ib ib.t1 15.6637
Rpar52 inn inn.t0 4.3032
Rpar53 inp inp.t0 4.3027
Rpar54 out out.t0 242.9939
Rpar55 out out.t1 77.6076
Rpar56 out out.t5 17.7232
Rpar57 out.t0 out.t1 545.4158
Rpar58 out.t0 out.t5 1014.1119
Rpar59 out.t1 out.t5 323.8879
Rpar60 vdd vdd.t0 243.2894
Rpar61 vdd vdd.t1 121.2582
Rpar62 vdd vdd.t10 728.9328
Rpar63 vdd vdd.t13 199.9946
Rpar64 vdd vdd.t14 148.2593
Rpar65 vdd vdd.t4 188.2513
Rpar66 vdd.t0 vdd.t1 6.6064
Rpar67 vdd.t0 vdd.t10 342.6582
Rpar68 vdd.t0 vdd.t13 398.9453
Rpar69 vdd.t0 vdd.t14 231.3649
Rpar70 vdd.t0 vdd.t4 107.9823
Rpar71 vdd.t1 vdd.t10 152.3592
Rpar72 vdd.t1 vdd.t13 195.1437
Rpar73 vdd.t1 vdd.t14 111.4861
Rpar74 vdd.t1 vdd.t4 53.9182
Rpar75 vdd.t10 vdd.t13 705.8256
Rpar76 vdd.t10 vdd.t14 307.0359
Rpar77 vdd.t10 vdd.t4 442.6618
Rpar78 vdd.t13 vdd.t14 19.9759
Rpar79 vdd.t13 vdd.t4 329.3771
Rpar80 vdd.t14 vdd.t4 202.0334
Rpar81 vss vss.t0 3508.4616
Rpar82 vss vss.t1 873.7728
Rpar83 vss vss.t2 69.8870
Rpar84 vss vss.t3 500.6226
Rpar85 vss vss.t38 66.5972
Rpar86 vss.t0 vss.t1 3528.0652
Rpar87 vss.t0 vss.t2 3.4754
Rpar88 vss.t0 vss.t3 26.6301
Rpar89 vss.t1 vss.t2 56.0696
Rpar90 vss.t1 vss.t3 431.0311
Rpar91 vss.t1 vss.t38 10438.4786
Rpar92 vss.t2 vss.t3 2.7863
Rpar93 vss.t2 vss.t38 834.9006
Rpar94 vss.t3 vss.t38 5980.6604
Cpar0 a_10026_14491.t0 vss 4.27024e-15
Cpar1 a_10026_14491.t1 vss 3.68583e-15
Cpar2 a_10026_14491.t2 vss 5.77400e-15
Cpar3 a_10026_14491.t4 vss 5.78107e-15
Cpar4 a_10238_1204.t0 vss 7.06730e-15
Cpar5 a_10238_1204.t1 vss 2.07121e-14
Cpar6 a_10238_1204.t2 vss 1.08133e-14
Cpar7 a_1106_5314.t0 vss 2.11502e-15
Cpar8 a_1106_5314.t1 vss 2.11100e-15
Cpar9 a_1106_5314.t2 vss 1.63624e-15
Cpar10 a_11374_14700.t0 vss 3.29716e-15
Cpar11 a_11374_14700.t1 vss 2.65032e-15
Cpar12 a_11374_14700.t2 vss 2.75132e-15
Cpar13 a_11374_14700.t3 vss 1.52942e-15
Cpar14 a_11374_14700.t6 vss 3.53451e-15
Cpar15 a_11374_6943.t0 vss 4.73548e-15
Cpar16 a_11374_6943.t1 vss 6.85592e-15
Cpar17 a_11374_6943.t3 vss 4.07248e-15
Cpar18 a_11374_6943.t4 vss 5.50115e-15
Cpar19 a_4842_8466.t0 vss 4.37165e-15
Cpar20 a_4842_8466.t1 vss 1.88495e-15
Cpar21 a_4842_8466.t2 vss 3.70630e-15
Cpar22 a_4842_8466.t3 vss 9.63750e-15
Cpar23 a_5451_5522.t0 vss 1.33567e-15
Cpar24 a_5451_5522.t1 vss 2.66993e-15
Cpar25 a_6454_12921.t0 vss 1.34699e-14
Cpar26 a_6454_12921.t1 vss 2.95446e-15
Cpar27 a_6454_12921.t2 vss 4.62217e-15
Cpar28 a_8822_10088.t0 vss 3.11221e-15
Cpar29 a_8822_10088.t1 vss 3.86419e-15
Cpar30 a_8822_10088.t2 vss 2.15816e-15
Cpar31 a_8822_10088.t5 vss 3.18637e-15
Cpar32 a_8822_10088.t6 vss 5.35272e-15
Cpar33 a_9906_14700.t0 vss 3.27891e-15
Cpar34 a_9906_14700.t1 vss 4.93068e-15
Cpar35 a_9906_16147.t0 vss 7.39985e-15
Cpar36 a_9906_16147.t2 vss 4.13923e-15
Cpar37 ib out 7.87670e-16
Cpar38 ib vdd 5.31610e-16
Cpar39 ib vss 5.44016e-14
Cpar40 ib.t0 vss 7.91784e-15
Cpar41 ib.t1 vss 1.94900e-17
Cpar42 inn inp 1.04540e-16
Cpar43 inn vss 6.23199e-15
Cpar44 inn.t0 vss 1.03159e-15
Cpar45 inp vss 6.16204e-15
Cpar46 inp.t0 vss 1.05065e-15
Cpar47 out vdd 9.09461e-15
Cpar48 out vss 3.24232e-14
Cpar49 out.t0 vss 1.02482e-15
Cpar50 out.t1 vss 2.52575e-16
Cpar51 out.t5 vss 2.68386e-14
Cpar52 vdd vss 1.46787e-13
Cpar53 vdd.t0 vss 2.82245e-14
Cpar54 vdd.t1 vss 1.83006e-14
Cpar55 vdd.t10 vss 2.89264e-15
Cpar56 vdd.t13 vss 5.59193e-15
Cpar57 vdd.t14 vss 8.43973e-15
Cpar58 vdd.t4 vss 6.30531e-15
.ends opamp_dut

Vdd vdd 0 3.300000
Vss vss 0 0
Ibias vdd ib 3.590000e-08
Vinp inp 0 DC 2.091400 AC 1 PWL(0 2.091400 2.508760e-07 2.091400 2.759636e-07 2.101400)
Rfb out inn 1m
Cload out 0 2.000000e-12
Xdut vdd vss inp inn out ib opamp_dut
.end
