* opa1000[0469]: 2p/nmos_miller_1v8_1u_10u_subth (nmos_miller, VDD=1.8V, CL=2.0pF, Iref=0.9286uA)
.include "pdk_opa.inc"
.temp 27
.option gmin=1e-12 rshunt=1e12 reltol=1e-3 abstol=1e-12 vntol=1e-5 method=gear
* Post-PEX R+C extracted netlist for nmos_miller_1v8_1u_10u_subth
.subckt opamp_dut vdd vss inp inn out ib
XMpar0 a_2866_12518.t0 inn.t0 a_7012_6545.t0 vss.t0 nfet_03v3 w=2u l=0.8u ad=6.4000e-13 pd=2.8900e-06 as=5.6000e-13 ps=2.5600e-06 nf=1 m=64 par=64
XMpar1 a_2866_12518.t0 inp.t0 a_966_6545.t0 vss.t0 nfet_03v3 w=2u l=0.8u ad=6.4000e-13 pd=2.8900e-06 as=5.6000e-13 ps=2.5600e-06 nf=1 m=64 par=64
XMpar2 out.t2 ib.t0 vss.t17 vss.t0 nfet_03v3 w=2u l=1.6u ad=6.8800e-13 pd=3.0880e-06 as=5.6000e-13 ps=2.5600e-06 nf=1 m=10 par=10
XMpar3 ib.t1 ib.t0 vss.t17 vss.t0 nfet_03v3 w=2u l=1.6u ad=5.6000e-13 pd=2.5600e-06 as=5.6000e-13 ps=2.5600e-06 nf=1 m=2 par=2
XMpar4 a_2866_12518.t64 ib.t0 vss.t17 vss.t0 nfet_03v3 w=2u l=1.6u ad=5.6000e-13 pd=2.5600e-06 as=5.6000e-13 ps=2.5600e-06 nf=1 m=4 par=4
XMpar5 out.t0 a_966_6545.t67 vdd.t1 vdd.t0 pfet_03v3 w=10u l=1u ad=2.8000e-12 pd=1.0560e-05 as=3.4400e-12 ps=1.2688e-05 nf=1 m=10 par=10
XMpar6 a_966_6545.t65 a_7012_6545.t64 vdd.t1 vdd.t0 pfet_03v3 w=10u l=1u ad=6.0000e-12 pd=2.1200e-05 as=2.8000e-12 ps=1.0560e-05 nf=1 m=2 par=2
XMpar7 a_7012_6545.t65 a_7012_6545.t64 vdd.t1 vdd.t0 pfet_03v3 w=10u l=1u ad=2.8000e-12 pd=1.0560e-05 as=2.8000e-12 ps=1.0560e-05 nf=1 m=2 par=2
X1 a_5100_10374.t1 out.t18 cap_mim_2f0fF c_width=19.27u c_length=19.27u
X85 a_966_6545.t64 a_5100_10374.t0 vss.t64 ppolyf_u_1k r_width=1u r_length=19.7u
X145 a_5100_10374.t1 out.t18 cap_mim_2f0fF c_width=19.27u c_length=19.27u
Rpar0 a_2866_12518.t0 a_2866_12518.t64 40.5955
Rpar1 a_5100_10374.t0 a_5100_10374.t1 75.1504
Rpar2 a_7012_6545.t0 a_7012_6545.t64 343.2290
Rpar3 a_7012_6545.t0 a_7012_6545.t65 82.9379
Rpar4 a_7012_6545.t64 a_7012_6545.t65 33.3395
Rpar5 a_966_6545.t0 a_966_6545.t64 97.3849
Rpar6 a_966_6545.t0 a_966_6545.t65 149.1188
Rpar7 a_966_6545.t0 a_966_6545.t67 438.9892
Rpar8 a_966_6545.t64 a_966_6545.t65 96.6832
Rpar9 a_966_6545.t64 a_966_6545.t67 284.6246
Rpar10 a_966_6545.t65 a_966_6545.t67 103.3113
Rpar11 ib ib.t0 23.7142
Rpar12 ib ib.t1 12.7239
Rpar13 ib.t0 ib.t1 58.6844
Rpar14 inn inn.t0 1.5563
Rpar15 inp inp.t0 1.5563
Rpar16 out out.t0 1.7318
Rpar17 out out.t2 61.1683
Rpar18 out out.t18 209.9960
Rpar19 out.t2 out.t18 163.5890
Rpar20 vdd vdd.t0 90.7169
Rpar21 vdd vdd.t1 194.7910
Rpar22 vdd.t0 vdd.t1 3.8085
Rpar23 vss vss.t0 86.6861
Rpar24 vss vss.t17 2238.7094
Rpar25 vss vss.t64 675.2859
Rpar26 vss.t0 vss.t17 3.9793
Rpar27 vss.t0 vss.t64 3.8411
Rpar28 vss.t17 vss.t64 221.7940
Cpar0 a_2866_12518.t0 vss 7.36750e-14
Cpar1 a_2866_12518.t64 vss 6.40016e-15
Cpar2 a_5100_10374.t0 vss 1.43943e-16
Cpar3 a_5100_10374.t1 vss 8.16787e-15
Cpar4 a_7012_6545.t0 vss 3.42388e-14
Cpar5 a_7012_6545.t64 vss 8.81125e-15
Cpar6 a_7012_6545.t65 vss 8.06074e-15
Cpar7 a_966_6545.t0 vss 3.08261e-14
Cpar8 a_966_6545.t64 vss 3.85510e-15
Cpar9 a_966_6545.t65 vss 9.22741e-15
Cpar10 a_966_6545.t67 vss 2.19109e-14
Cpar11 ib inn 2.87900e-17
Cpar12 ib out 1.71183e-15
Cpar13 ib vdd 2.44500e-17
Cpar14 ib vss 2.29500e-14
Cpar15 ib.t0 vss 4.57718e-15
Cpar16 ib.t1 vss 3.22602e-16
Cpar17 inn inp 2.09090e-16
Cpar18 inn vdd 3.37000e-17
Cpar19 inn vss 3.14370e-14
Cpar20 inn.t0 vss 1.86373e-14
Cpar21 inp vdd 9.55300e-17
Cpar22 inp vss 3.15320e-14
Cpar23 inp.t0 vss 1.86519e-14
Cpar24 out vdd 1.33441e-14
Cpar25 out vss 2.44466e-14
Cpar26 out.t0 vss 6.02176e-15
Cpar27 out.t18 vss 1.55404e-14
Cpar28 out.t2 vss 4.60493e-15
Cpar29 vdd vss 8.14624e-14
Cpar30 vdd.t0 vss 2.09948e-14
Cpar31 vdd.t1 vss 1.26407e-14
.ends opamp_dut

Vdd vdd 0 1.800000
Vss vss 0 0
Ibias vdd ib 9.286000e-07
Vinp inp 0 DC 0.895000 AC 1 PWL(0 0.895000 4.234407e-08 0.895000 4.657847e-08 0.905000)
Rfb out inn 1m
Cload out 0 2.000000e-12
Xdut vdd vss inp inn out ib opamp_dut
.end
