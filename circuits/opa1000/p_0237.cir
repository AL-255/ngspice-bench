* opa1000[0237]: 2p/folded_cascode_nmos_3v3_i2u_subth (folded_cascode_nmos, VDD=3.3V, CL=2.0pF, Iref=0.3778uA)
.include "pdk_opa.inc"
.temp 27
.option gmin=1e-12 rshunt=1e12 reltol=1e-3 abstol=1e-12 vntol=1e-5 method=gear
* Post-PEX R+C extracted netlist for folded_cascode_nmos_3v3_i2u_subth
.subckt opamp_dut vdd vss inp inn out ib
XMpar0 a_11054_1295.t3 ib.t10 out.t0 vdd.t11 pfet_03v3 w=1.92u l=1.95u ad=6.4931e-13 pd=2.9455e-06 as=5.9345e-13 ps=2.7127e-06 nf=1 m=22 par=22
XMpar1 a_11054_1295.t25 inn.t0 a_1872_1295.t0 vss.t0 nfet_03v3 w=3.81u l=2.85u ad=1.1430e-12 pd=4.6481e-06 as=1.1811e-12 ps=4.7872e-06 nf=1 m=64 par=64
XMpar2 a_1872_1295.t0 inp.t0 a_2562_1295.t0 vss.t0 nfet_03v3 w=3.81u l=2.85u ad=1.1811e-12 pd=4.7872e-06 as=1.1430e-12 ps=4.6481e-06 nf=1 m=64 par=64
XMpar3 a_11054_1295.t0 a_1101_9143.t0 vdd.t1 vdd.t0 pfet_03v3 w=4.9u l=2.04u ad=1.3720e-12 pd=5.4600e-06 as=2.9400e-12 ps=1.1000e-05 nf=1 m=4 par=4
XMpar4 a_1872_1295.t64 ib.t0 vss.t26 vss.t0 nfet_03v3 w=1.8u l=3.25u ad=1.0800e-12 pd=4.8000e-06 as=5.0400e-13 ps=2.3600e-06 nf=1 m=4 par=4
XMpar5 a_2562_1295.t65 ib.t10 a_7232_13429.t0 vdd.t11 pfet_03v3 w=1.92u l=1.95u ad=6.4931e-13 pd=2.9455e-06 as=5.9345e-13 ps=2.7127e-06 nf=1 m=22 par=22
XMpar6 a_1101_9143.t1 a_1101_9143.t0 vdd.t1 vdd.t0 pfet_03v3 w=4.9u l=2.04u ad=1.3720e-12 pd=5.4600e-06 as=2.9400e-12 ps=1.1000e-05 nf=1 m=2 par=2
XMpar7 ib.t1 ib.t0 vss.t26 vss.t0 nfet_03v3 w=1.8u l=3.25u ad=1.0800e-12 pd=4.8000e-06 as=5.0400e-13 ps=2.3600e-06 nf=1 m=2 par=2
XMpar8 out.t12 a_7232_13429.t22 vss.t26 vss.t0 nfet_03v3 w=1.8u l=3.25u ad=1.0800e-12 pd=4.8000e-06 as=5.0400e-13 ps=2.3600e-06 nf=1 m=2 par=2
XMpar9 a_1101_9143.t4 ib.t0 vss.t26 vss.t0 nfet_03v3 w=1.8u l=3.25u ad=1.0800e-12 pd=4.8000e-06 as=5.0400e-13 ps=2.3600e-06 nf=1 m=2 par=2
XMpar10 a_2562_1295.t64 a_1101_9143.t0 vdd.t1 vdd.t0 pfet_03v3 w=4.9u l=2.04u ad=1.3720e-12 pd=5.4600e-06 as=2.9400e-12 ps=1.1000e-05 nf=1 m=4 par=4
XMpar11 a_7232_13429.t23 a_7232_13429.t22 vss.t26 vss.t0 nfet_03v3 w=1.8u l=3.25u ad=1.0800e-12 pd=4.8000e-06 as=5.0400e-13 ps=2.3600e-06 nf=1 m=2 par=2
X34 out.t24 vss.t66 cap_mim_2f0fF c_width=7.75u c_length=7.75u
Rpar0 a_1101_9143.t0 a_1101_9143.t1 23.1719
Rpar1 a_1101_9143.t0 a_1101_9143.t4 198.9379
Rpar2 a_1101_9143.t1 a_1101_9143.t4 120.2945
Rpar3 a_11054_1295.t0 a_11054_1295.t3 65.7354
Rpar4 a_11054_1295.t0 a_11054_1295.t25 225.9017
Rpar5 a_11054_1295.t3 a_11054_1295.t25 68.1365
Rpar6 a_1872_1295.t0 a_1872_1295.t64 81.0926
Rpar7 a_2562_1295.t0 a_2562_1295.t64 225.9017
Rpar8 a_2562_1295.t0 a_2562_1295.t65 68.1365
Rpar9 a_2562_1295.t64 a_2562_1295.t65 65.7354
Rpar10 a_7232_13429.t0 a_7232_13429.t22 153.5784
Rpar11 a_7232_13429.t0 a_7232_13429.t23 103.3807
Rpar12 a_7232_13429.t22 a_7232_13429.t23 12.2628
Rpar13 ib ib.t0 505.7134
Rpar14 ib ib.t1 446.0173
Rpar15 ib ib.t10 1.5976
Rpar16 ib.t0 ib.t1 12.4307
Rpar17 ib.t0 ib.t10 128.7222
Rpar18 ib.t1 ib.t10 113.5274
Rpar19 inn inn.t0 1.2902
Rpar20 inp inp.t0 1.2902
Rpar21 out out.t0 73.6442
Rpar22 out out.t12 7.5881
Rpar23 out out.t24 152.1760
Rpar24 out.t0 out.t24 168.2635
Rpar25 vdd vdd.t0 87.7683
Rpar26 vdd vdd.t1 40.3967
Rpar27 vdd vdd.t11 139.8402
Rpar28 vdd.t0 vdd.t1 5.5400
Rpar29 vdd.t0 vdd.t11 243.3392
Rpar30 vdd.t1 vdd.t11 68.9000
Rpar31 vss vss.t0 79.7754
Rpar32 vss vss.t26 437.6554
Rpar33 vss vss.t66 2482.1225
Rpar34 vss.t0 vss.t26 5.8529
Rpar35 vss.t0 vss.t66 162.4226
Rpar36 vss.t26 vss.t66 219.8831
Cpar0 a_1101_9143.t0 vss 2.53502e-14
Cpar1 a_1101_9143.t1 vss 5.98170e-15
Cpar2 a_1101_9143.t4 vss 6.59990e-15
Cpar3 a_11054_1295.t0 vss 8.50590e-15
Cpar4 a_11054_1295.t25 vss 6.72466e-14
Cpar5 a_11054_1295.t3 vss 1.93144e-14
Cpar6 a_1872_1295.t0 vss 1.13954e-13
Cpar7 a_1872_1295.t64 vss 8.21696e-15
Cpar8 a_2562_1295.t0 vss 7.02331e-14
Cpar9 a_2562_1295.t64 vss 8.88362e-15
Cpar10 a_2562_1295.t65 vss 2.01720e-14
Cpar11 a_7232_13429.t0 vss 1.47619e-14
Cpar12 a_7232_13429.t22 vss 9.33329e-15
Cpar13 a_7232_13429.t23 vss 4.19516e-15
Cpar14 ib inp 2.16300e-17
Cpar15 ib out 6.69515e-15
Cpar16 ib vdd 3.96828e-14
Cpar17 ib vss 2.61094e-14
Cpar18 ib.t0 vss 1.63276e-14
Cpar19 ib.t1 vss 4.12717e-15
Cpar20 ib.t10 vss 5.01118e-14
Cpar21 inn inp 2.20580e-16
Cpar22 inn vss 7.15356e-14
Cpar23 inn.t0 vss 5.09813e-14
Cpar24 inp vss 7.11524e-14
Cpar25 inp.t0 vss 5.11530e-14
Cpar26 out vdd 7.74091e-15
Cpar27 out vss 1.94891e-14
Cpar28 out.t0 vss 1.12775e-14
Cpar29 out.t12 vss 8.95130e-16
Cpar30 out.t24 vss 1.62829e-14
Cpar31 vdd vss 2.10340e-13
Cpar32 vdd.t0 vss 1.86486e-14
Cpar33 vdd.t1 vss 1.56555e-14
Cpar34 vdd.t11 vss 4.98622e-14
.ends opamp_dut

Vdd vdd 0 3.300000
Vss vss 0 0
Ibias vdd ib 3.778000e-07
Vinp inp 0 DC 1.810000 AC 1 PWL(0 1.810000 1.305037e-07 1.810000 1.435541e-07 1.820000)
Rfb out inn 1m
Cload out 0 2.000000e-12
Xdut vdd vss inp inn out ib opamp_dut
.end
