* opa1000[0171]: 200f/folded_cascode_nmos_1v8_i200n_subth (folded_cascode_nmos, VDD=1.8V, CL=0.2pF, Iref=0.0578uA)
.include "pdk_opa.inc"
.temp 27
.option gmin=1e-12 rshunt=1e12 reltol=1e-3 abstol=1e-12 vntol=1e-5 method=gear
* Post-PEX R+C extracted netlist for folded_cascode_nmos_1v8_i200n_subth
.subckt opamp_dut vdd vss inp inn out ib
XMpar0 a_3162_6586.t0 a_2902_10654.t0 vdd.t1 vdd.t0 pfet_03v3 w=3.06u l=8.13u ad=8.5680e-13 pd=3.6200e-06 as=1.8360e-12 ps=7.3200e-06 nf=1 m=4 par=4
XMpar1 a_2902_10654.t1 a_2902_10654.t0 vdd.t1 vdd.t0 pfet_03v3 w=3.06u l=8.13u ad=8.5680e-13 pd=3.6200e-06 as=1.8360e-12 ps=7.3200e-06 nf=1 m=2 par=2
XMpar2 out.t0 a_4250_3147.t4 vss.t1 vss.t0 nfet_03v3 w=0.4u l=3u ad=1.1200e-13 pd=9.6000e-07 as=1.1200e-13 ps=9.6000e-07 nf=1 m=2 par=2
XMpar3 a_1602_6586.t0 inn.t0 a_6574_3147.t2 vss.t4 nfet_03v3 w=2.48u l=7.2u ad=1.0912e-12 pd=4.6000e-06 as=8.9280e-13 ps=3.8200e-06 nf=1 m=8 par=8
XMpar4 ib.t1 ib.t0 vss.t1 vss.t0 nfet_03v3 w=0.4u l=3u ad=2.4000e-13 pd=2.0000e-06 as=1.1200e-13 ps=9.6000e-07 nf=1 m=2 par=2
XMpar5 a_1602_6586.t0 inp.t0 a_3162_6586.t1 vss.t4 nfet_03v3 w=2.48u l=7.2u ad=1.0912e-12 pd=4.6000e-06 as=8.9280e-13 ps=3.8200e-06 nf=1 m=8 par=8
XMpar6 a_1602_6586.t16 ib.t0 vss.t1 vss.t0 nfet_03v3 w=0.4u l=3u ad=1.1200e-13 pd=9.6000e-07 as=1.1200e-13 ps=9.6000e-07 nf=1 m=4 par=4
XMpar7 a_6574_3147.t0 a_2902_10654.t0 vdd.t1 vdd.t0 pfet_03v3 w=3.06u l=8.13u ad=8.5680e-13 pd=3.6200e-06 as=1.8360e-12 ps=7.3200e-06 nf=1 m=4 par=4
XMpar8 a_6574_3147.t11 ib.t10 out.t1 vdd.t13 pfet_03v3 w=2.24u l=2.8u ad=9.8560e-13 pd=4.2400e-06 as=6.2720e-13 ps=2.8000e-06 nf=1 m=4 par=4
XMpar9 a_3162_6586.t10 ib.t10 a_4250_3147.t0 vdd.t13 pfet_03v3 w=2.24u l=2.8u ad=9.8560e-13 pd=4.2400e-06 as=6.2720e-13 ps=2.8000e-06 nf=1 m=4 par=4
XMpar10 a_2902_10654.t4 ib.t0 vss.t1 vss.t0 nfet_03v3 w=0.4u l=3u ad=1.1200e-13 pd=9.6000e-07 as=1.1200e-13 ps=9.6000e-07 nf=1 m=2 par=2
XMpar11 a_4250_3147.t5 a_4250_3147.t4 vss.t1 vss.t0 nfet_03v3 w=0.4u l=3u ad=2.4000e-13 pd=2.0000e-06 as=1.1200e-13 ps=9.6000e-07 nf=1 m=2 par=2
Rpar0 a_1602_6586.t0 a_1602_6586.t16 45.8744
Rpar1 a_2902_10654.t0 a_2902_10654.t1 23.6687
Rpar2 a_2902_10654.t0 a_2902_10654.t4 92.9688
Rpar3 a_2902_10654.t1 a_2902_10654.t4 89.0736
Rpar4 a_3162_6586.t0 a_3162_6586.t1 53.9760
Rpar5 a_3162_6586.t0 a_3162_6586.t10 148.7102
Rpar6 a_3162_6586.t1 a_3162_6586.t10 70.5765
Rpar7 a_4250_3147.t0 a_4250_3147.t4 93.8876
Rpar8 a_4250_3147.t0 a_4250_3147.t5 68.6347
Rpar9 a_4250_3147.t4 a_4250_3147.t5 22.5705
Rpar10 a_6574_3147.t0 a_6574_3147.t11 148.7102
Rpar11 a_6574_3147.t0 a_6574_3147.t2 53.9760
Rpar12 a_6574_3147.t11 a_6574_3147.t2 70.5765
Rpar13 ib ib.t0 121.9902
Rpar14 ib ib.t1 101.4268
Rpar15 ib ib.t10 1.6324
Rpar16 ib.t0 ib.t1 21.4311
Rpar17 inn inn.t0 2.3105
Rpar18 inp inp.t0 2.3105
Rpar19 out out.t0 54.4323
Rpar20 out out.t1 4.6566
Rpar21 vdd vdd.t0 37.8374
Rpar22 vdd vdd.t1 53.7950
Rpar23 vdd vdd.t13 212.8318
Rpar24 vdd.t0 vdd.t1 5.6228
Rpar25 vdd.t0 vdd.t13 87.9205
Rpar26 vdd.t1 vdd.t13 92.9087
Rpar27 vss vss.t0 57.8173
Rpar28 vss vss.t1 121.4080
Rpar29 vss vss.t4 275.9339
Rpar30 vss.t0 vss.t1 6.4589
Rpar31 vss.t0 vss.t4 1.9270
Rpar32 vss.t1 vss.t4 17.7901
Cpar0 a_1602_6586.t0 vss 2.90095e-14
Cpar1 a_1602_6586.t16 vss 5.10515e-15
Cpar2 a_2902_10654.t0 vss 5.57342e-14
Cpar3 a_2902_10654.t1 vss 4.50524e-15
Cpar4 a_2902_10654.t4 vss 4.83895e-15
Cpar5 a_3162_6586.t0 vss 1.00552e-14
Cpar6 a_3162_6586.t1 vss 1.80152e-14
Cpar7 a_3162_6586.t10 vss 7.75453e-15
Cpar8 a_4250_3147.t0 vss 2.06530e-15
Cpar9 a_4250_3147.t4 vss 3.30545e-15
Cpar10 a_4250_3147.t5 vss 1.11054e-15
Cpar11 a_6574_3147.t0 vss 9.13435e-15
Cpar12 a_6574_3147.t11 vss 7.04441e-15
Cpar13 a_6574_3147.t2 vss 1.63655e-14
Cpar14 ib out 6.70910e-16
Cpar15 ib vdd 1.16183e-14
Cpar16 ib vss 2.39213e-14
Cpar17 ib.t0 vss 7.46669e-15
Cpar18 ib.t1 vss 1.85370e-15
Cpar19 ib.t10 vss 7.87575e-15
Cpar20 inn inp 1.04860e-16
Cpar21 inn out 3.91200e-17
Cpar22 inn vdd 1.72000e-16
Cpar23 inn vss 2.41092e-14
Cpar24 inn.t0 vss 8.50022e-15
Cpar25 inp vdd 1.39800e-17
Cpar26 inp vss 2.39657e-14
Cpar27 inp.t0 vss 8.37734e-15
Cpar28 out vdd 2.78366e-15
Cpar29 out vss 6.83104e-15
Cpar30 out.t0 vss 2.09490e-15
Cpar31 out.t1 vss 1.55219e-15
Cpar32 vdd vss 1.69437e-13
Cpar33 vdd.t0 vss 3.05857e-14
Cpar34 vdd.t1 vss 2.70662e-14
Cpar35 vdd.t13 vss 1.89240e-14
.ends opamp_dut

Vdd vdd 0 1.800000
Vss vss 0 0
Ibias vdd ib 5.780000e-08
Vinp inp 0 DC 0.985000 AC 1 PWL(0 0.985000 1.018104e-07 0.985000 1.119914e-07 0.995000)
Rfb out inn 1m
Cload out 0 2.000000e-13
Xdut vdd vss inp inn out ib opamp_dut
.end
