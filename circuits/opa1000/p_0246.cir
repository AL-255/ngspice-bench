* opa1000[0246]: 2p/folded_cascode_nmos_3v3_i150u_subth (folded_cascode_nmos, VDD=3.3V, CL=2.0pF, Iref=43.3333uA)
.include "pdk_opa.inc"
.temp 27
.option gmin=1e-12 rshunt=1e12 reltol=1e-3 abstol=1e-12 vntol=1e-5 method=gear
* Post-PEX R+C extracted netlist for folded_cascode_nmos_3v3_i150u_subth
.subckt opamp_dut vdd vss inp inn out ib
XMpar0 a_2898_1249.t0 ib a_3094_1249.t0 vdd.t6 pfet_03v3 w=3.79u l=0.38u ad=1.1218e-12 pd=4.5715e-06 as=1.0612e-12 ps=4.3500e-06 nf=1 m=160 par=160
XMpar1 a_10734_1249.t160 inn.t0 a_1927_11286.t12 vss.t0 nfet_03v3 w=4.27u l=0.53u ad=1.1956e-12 pd=4.8300e-06 as=1.2810e-12 ps=5.1369e-06 nf=1 m=160 par=160
XMpar2 a_1927_11286.t12 inp.t0 a_2898_1249.t160 vss.t0 nfet_03v3 w=4.27u l=0.53u ad=1.2810e-12 pd=5.1369e-06 as=1.1956e-12 ps=4.8300e-06 nf=1 m=160 par=160
XMpar3 a_10734_1249.t320 a_1254_7613.t6 vdd.t1 vdd.t0 pfet_03v3 w=10u l=1.05u ad=2.8000e-12 pd=1.0560e-05 as=3.3333e-12 ps=1.2333e-05 nf=1 m=12 par=12
XMpar4 a_1254_7613.t7 a_1254_7613.t6 vdd.t1 vdd.t0 pfet_03v3 w=10u l=1.05u ad=2.8000e-12 pd=1.0560e-05 as=3.8667e-12 ps=1.4107e-05 nf=1 m=6 par=6
XMpar5 out.t48 a_3094_1249.t160 vss.t1 vss.t0 nfet_03v3 w=10u l=0.65u ad=2.8000e-12 pd=1.0560e-05 as=2.8000e-12 ps=1.0560e-05 nf=1 m=6 par=6
XMpar6 a_10734_1249.t0 ib out vdd.t6 pfet_03v3 w=3.79u l=0.38u ad=1.1218e-12 pd=4.5715e-06 as=1.0612e-12 ps=4.3500e-06 nf=1 m=160 par=160
XMpar7 a_3094_1249.t161 a_3094_1249.t160 vss.t1 vss.t0 nfet_03v3 w=10u l=0.65u ad=3.8667e-12 pd=1.4107e-05 as=2.8000e-12 ps=1.0560e-05 nf=1 m=6 par=6
XMpar8 a_1927_11286.t0 ib.t0 vss.t1 vss.t0 nfet_03v3 w=10u l=0.65u ad=2.8000e-12 pd=1.0560e-05 as=2.8000e-12 ps=1.0560e-05 nf=1 m=12 par=12
XMpar9 a_1254_7613.t0 ib.t0 vss.t1 vss.t0 nfet_03v3 w=10u l=0.65u ad=2.8000e-12 pd=1.0560e-05 as=2.8000e-12 ps=1.0560e-05 nf=1 m=6 par=6
XMpar10 a_2898_1249.t320 a_1254_7613.t6 vdd.t1 vdd.t0 pfet_03v3 w=10u l=1.05u ad=2.8000e-12 pd=1.0560e-05 as=3.3333e-12 ps=1.2333e-05 nf=1 m=12 par=12
XMpar11 ib.t1 ib.t0 vss.t1 vss.t0 nfet_03v3 w=10u l=0.65u ad=3.8667e-12 pd=1.4107e-05 as=2.8000e-12 ps=1.0560e-05 nf=1 m=6 par=6
X678 out.t166 vss.t132 cap_mim_2f0fF c_width=10.25u c_length=10.25u
Rpar0 a_10734_1249.t0 a_10734_1249.t160 314.3586
Rpar1 a_10734_1249.t0 a_10734_1249.t320 67.8241
Rpar2 a_10734_1249.t160 a_10734_1249.t320 78.5946
Rpar3 a_1254_7613.t0 a_1254_7613.t6 95.6160
Rpar4 a_1254_7613.t0 a_1254_7613.t7 147.2252
Rpar5 a_1254_7613.t6 a_1254_7613.t7 18.2567
Rpar6 a_1927_11286.t0 a_1927_11286.t12 47.3671
Rpar7 a_2898_1249.t0 a_2898_1249.t160 314.3586
Rpar8 a_2898_1249.t0 a_2898_1249.t320 67.8241
Rpar9 a_2898_1249.t160 a_2898_1249.t320 78.5946
Rpar10 a_3094_1249.t0 a_3094_1249.t160 629.6527
Rpar11 a_3094_1249.t0 a_3094_1249.t161 75.1005
Rpar12 a_3094_1249.t160 a_3094_1249.t161 20.6057
Rpar13 ib ib.t0 385.9403
Rpar14 ib ib.t1 69.0401
Rpar15 ib.t0 ib.t1 18.1279
Rpar16 inn inn.t0 1.8095
Rpar17 inp inp.t0 1.8095
Rpar18 out out.t166 85.1430
Rpar19 out out.t48 125.2265
Rpar20 out.t166 out.t48 82.9378
Rpar21 vdd vdd.t0 183.1148
Rpar22 vdd vdd.t1 181.3848
Rpar23 vdd vdd.t6 394.1957
Rpar24 vdd.t0 vdd.t1 2.7789
Rpar25 vdd.t0 vdd.t6 129.0069
Rpar26 vdd.t1 vdd.t6 66.3525
Rpar27 vss vss.t0 172.2960
Rpar28 vss vss.t1 6078.8823
Rpar29 vss vss.t132 129.4962
Rpar30 vss.t0 vss.t1 2.3428
Rpar31 vss.t0 vss.t132 105.0673
Rpar32 vss.t1 vss.t132 3706.9454
Cpar0 a_10734_1249.t0 vss 1.45820e-13
Cpar1 a_10734_1249.t160 vss 1.70137e-13
Cpar2 a_10734_1249.t320 vss 3.34522e-14
Cpar3 a_1254_7613.t0 vss 8.96561e-15
Cpar4 a_1254_7613.t6 vss 4.33482e-14
Cpar5 a_1254_7613.t7 vss 8.72152e-15
Cpar6 a_1927_11286.t0 vss 2.57292e-14
Cpar7 a_1927_11286.t12 vss 2.87901e-13
Cpar8 a_2898_1249.t0 vss 1.49296e-13
Cpar9 a_2898_1249.t160 vss 1.74193e-13
Cpar10 a_2898_1249.t320 vss 3.42497e-14
Cpar11 a_3094_1249.t0 vss 1.42719e-13
Cpar12 a_3094_1249.t160 vss 2.19234e-14
Cpar13 a_3094_1249.t161 vss 2.67111e-14
Cpar14 ib inp 1.71200e-17
Cpar15 ib out 2.47104e-14
Cpar16 ib vdd 9.76949e-14
Cpar17 ib vss 1.83897e-13
Cpar18 ib.t0 vss 3.01144e-14
Cpar19 ib.t1 vss 1.71591e-14
Cpar20 inn inp 2.58410e-16
Cpar21 inn out 1.25900e-17
Cpar22 inn vdd 4.46500e-17
Cpar23 inn vss 6.06629e-14
Cpar24 inn.t0 vss 5.10048e-14
Cpar25 inp vdd 7.91700e-17
Cpar26 inp vss 6.06570e-14
Cpar27 inp.t0 vss 5.11403e-14
Cpar28 out vdd 1.37771e-14
Cpar29 out vss 1.45576e-13
Cpar30 out.t166 vss 4.63109e-14
Cpar31 out.t48 vss 1.44329e-14
Cpar32 vdd vss 4.69037e-13
Cpar33 vdd.t0 vss 4.73067e-14
Cpar34 vdd.t1 vss 2.02220e-14
Cpar35 vdd.t6 vss 1.41154e-13
.ends opamp_dut

Vdd vdd 0 3.300000
Vss vss 0 0
Ibias vdd ib 4.333330e-05
Vinp inp 0 DC 1.810000 AC 1 PWL(0 1.810000 3.000000e-09 1.810000 3.300000e-09 1.820000)
Rfb out inn 1m
Cload out 0 2.000000e-12
Xdut vdd vss inp inn out ib opamp_dut
.end
