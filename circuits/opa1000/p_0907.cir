* opa1000[0907]: 2p/telescopic_nmos_3v3_1u_10u_weak (telescopic_nmos, VDD=3.3V, CL=2.0pF, Iref=1.4375uA)
.include "pdk_opa.inc"
.temp 27
.option gmin=1e-12 rshunt=1e12 reltol=1e-3 abstol=1e-12 vntol=1e-5 method=gear
* Post-PEX R+C extracted netlist for telescopic_nmos_3v3_1u_10u_weak
.subckt opamp_dut vdd vss inp inn out ib
XMpar0 a_3664_11850.t4 a_3784_11642.t66 vdd.t3 vdd.t2 pfet_03v3 w=1.84u l=4u ad=7.1147e-13 pd=3.2267e-06 as=5.1520e-13 ps=2.4000e-06 nf=1 m=18 par=18
XMpar1 a_5496_11850.t1 a_3784_11642.t66 vdd.t3 vdd.t2 pfet_03v3 w=1.84u l=4u ad=5.1520e-13 pd=2.4000e-06 as=5.1520e-13 ps=2.4000e-06 nf=1 m=18 par=18
XMpar2 a_8844_4038.t0 a_3784_11642.t0 out.t9 vss.t0 nfet_03v3 w=2.04u l=1.6u ad=1.2240e-12 pd=5.2800e-06 as=5.7120e-13 ps=2.6000e-06 nf=1 m=4 par=4
XMpar3 ib.t1 ib.t0 vss.t2 vss.t1 nfet_03v3 w=1.33u l=2u ad=3.7240e-13 pd=1.8900e-06 as=3.7240e-13 ps=1.8900e-06 nf=1 m=2 par=2
XMpar4 a_1509_4038.t8 inp.t0 a_6426_1205.t2 vss.t21 nfet_03v3 w=1.99u l=2u ad=7.6947e-13 pd=3.4267e-06 as=5.5720e-13 ps=2.5500e-06 nf=1 m=12 par=12
XMpar5 a_1509_4038.t8 inn.t0 a_8844_4038.t3 vss.t21 nfet_03v3 w=1.99u l=2u ad=7.6947e-13 pd=3.4267e-06 as=5.5720e-13 ps=2.5500e-06 nf=1 m=12 par=12
XMpar6 a_5496_11850.t0 a_3784_11642.t8 out.t0 vdd.t0 pfet_03v3 w=2.04u l=1.6u ad=9.3387e-13 pd=4.0889e-06 as=6.4373e-13 ps=2.8978e-06 nf=1 m=18 par=18
XMpar7 a_3664_11850.t0 a_3784_11642.t8 a_3784_11642.t9 vdd.t0 pfet_03v3 w=2.04u l=1.6u ad=9.3387e-13 pd=4.0889e-06 as=6.4373e-13 ps=2.8978e-06 nf=1 m=18 par=18
XMpar8 a_1509_4038.t0 ib.t0 vss.t2 vss.t1 nfet_03v3 w=1.33u l=2u ad=3.7240e-13 pd=1.8900e-06 as=4.7880e-13 ps=2.3825e-06 nf=1 m=8 par=8
XMpar9 a_3784_11642.t1 a_3784_11642.t0 a_6426_1205.t0 vss.t0 nfet_03v3 w=2.04u l=1.6u ad=1.2240e-12 pd=5.2800e-06 as=1.2240e-12 ps=5.2800e-06 nf=1 m=4 par=4
Rpar0 a_1509_4038.t0 a_1509_4038.t8 49.9008
Rpar1 a_3664_11850.t0 a_3664_11850.t4 36.6943
Rpar2 a_3784_11642.t0 a_3784_11642.t1 10.2072
Rpar3 a_3784_11642.t0 a_3784_11642.t66 515.8432
Rpar4 a_3784_11642.t0 a_3784_11642.t9 661.3441
Rpar5 a_3784_11642.t1 a_3784_11642.t66 117.6410
Rpar6 a_3784_11642.t1 a_3784_11642.t9 150.8233
Rpar7 a_3784_11642.t8 a_3784_11642.t66 903.4309
Rpar8 a_3784_11642.t8 a_3784_11642.t9 7.9330
Rpar9 a_3784_11642.t66 a_3784_11642.t9 43.0039
Rpar10 a_5496_11850.t0 a_5496_11850.t1 55.6052
Rpar11 a_6426_1205.t0 a_6426_1205.t2 67.5242
Rpar12 a_8844_4038.t0 a_8844_4038.t3 38.7939
Rpar13 ib ib.t0 11.2657
Rpar14 ib ib.t1 14.4695
Rpar15 inn inn.t0 2.0120
Rpar16 inp inp.t0 2.0120
Rpar17 out out.t0 3.6422
Rpar18 out out.t9 39.0369
Rpar19 vdd vdd.t0 124.7056
Rpar20 vdd vdd.t3 467.0707
Rpar21 vdd vdd.t2 22.7472
Rpar22 vdd.t0 vdd.t3 1029.5601
Rpar23 vdd.t0 vdd.t2 50.1415
Rpar24 vdd.t3 vdd.t2 10.4481
Rpar25 vss vss.t0 232.2293
Rpar26 vss vss.t1 93.5746
Rpar27 vss vss.t2 367.9189
Rpar28 vss vss.t21 107.7455
Rpar29 vss.t0 vss.t1 9.9830
Rpar30 vss.t0 vss.t2 72.9197
Rpar31 vss.t0 vss.t21 3.3268
Rpar32 vss.t1 vss.t2 6.7744
Rpar33 vss.t1 vss.t21 4.4101
Rpar34 vss.t2 vss.t21 30.5902
Cpar0 a_1509_4038.t0 vss 4.78630e-15
Cpar1 a_1509_4038.t8 vss 1.76844e-14
Cpar2 a_3664_11850.t0 vss 3.05625e-14
Cpar3 a_3664_11850.t4 vss 3.99661e-14
Cpar4 a_3784_11642.t0 vss 1.03328e-14
Cpar5 a_3784_11642.t1 vss 8.73500e-15
Cpar6 a_3784_11642.t66 vss 9.35185e-14
Cpar7 a_3784_11642.t8 vss 4.18237e-14
Cpar8 a_3784_11642.t9 vss 1.79979e-14
Cpar9 a_5496_11850.t0 vss 3.38430e-14
Cpar10 a_5496_11850.t1 vss 3.97854e-14
Cpar11 a_6426_1205.t0 vss 8.60603e-15
Cpar12 a_6426_1205.t2 vss 1.01125e-14
Cpar13 a_8844_4038.t0 vss 8.61005e-15
Cpar14 a_8844_4038.t3 vss 9.92974e-15
Cpar15 ib vss 1.72813e-14
Cpar16 ib.t0 vss 2.81899e-15
Cpar17 ib.t1 vss 1.03773e-16
Cpar18 inn inp 1.04570e-16
Cpar19 inn vss 1.34998e-14
Cpar20 inn.t0 vss 4.64099e-15
Cpar21 inp vss 1.34926e-14
Cpar22 inp.t0 vss 4.62672e-15
Cpar23 out vdd 1.28417e-14
Cpar24 out vss 1.44485e-14
Cpar25 out.t0 vss 2.02398e-14
Cpar26 out.t9 vss 8.73755e-15
Cpar27 vdd vss 3.05318e-13
Cpar28 vdd.t0 vss 6.57116e-14
Cpar29 vdd.t2 vss 9.82239e-14
Cpar30 vdd.t3 vss 1.13977e-14
.ends opamp_dut

Vdd vdd 0 3.300000
Vss vss 0 0
Ibias vdd ib 1.437500e-06
Vinp inp 0 DC 1.711000 AC 1 PWL(0 1.711000 3.005442e-08 1.711000 3.305986e-08 1.721000)
Rfb out inn 1m
Cload out 0 2.000000e-12
Xdut vdd vss inp inn out ib opamp_dut
.end
