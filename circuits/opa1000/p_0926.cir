* opa1000[0926]: 200f/telescopic_pmos_1v8_i2u_subth (telescopic_pmos, VDD=1.8V, CL=0.2pF, Iref=0.28uA)
.include "pdk_opa.inc"
.temp 27
.option gmin=1e-12 rshunt=1e12 reltol=1e-3 abstol=1e-12 vntol=1e-5 method=gear
* Post-PEX R+C extracted netlist for telescopic_pmos_1v8_i2u_subth
.subckt opamp_dut vdd vss inp inn out ib
XMpar0 a_11728_6001.t1 a_10366_9908.t0 out.t11 vss.t8 nfet_03v3 w=1.85u l=0.78u ad=1.1100e-12 pd=4.9000e-06 as=5.1800e-13 ps=2.4100e-06 nf=1 m=2 par=2
XMpar1 a_10366_9908.t4 vss.t20 a_5802_12718.t64 vdd.t2 pfet_03v3 w=1.82u l=0.78u ad=5.0960e-13 pd=2.3800e-06 as=7.0373e-13 ps=3.2000e-06 nf=1 m=12 par=12
XMpar2 a_5302_12718.t0 inp.t0 a_5802_12718.t0 vdd.t4 pfet_03v3 w=5.99u l=1.9u ad=1.8569e-12 pd=7.1716e-06 as=1.7970e-12 ps=6.9644e-06 nf=1 m=64 par=64
XMpar3 a_12014_9908.t0 inn.t0 a_5302_12718.t0 vdd.t4 pfet_03v3 w=5.99u l=1.9u ad=1.7970e-12 pd=6.9644e-06 as=1.8569e-12 ps=7.1716e-06 nf=1 m=64 par=64
XMpar4 a_12014_9908.t64 vss.t20 out.t0 vdd.t2 pfet_03v3 w=1.82u l=0.78u ad=7.0373e-13 pd=3.2000e-06 as=5.0960e-13 ps=2.3800e-06 nf=1 m=12 par=12
XMpar5 a_5302_12718.t128 a_16734_8929.t2 vdd.t1 vdd.t0 pfet_03v3 w=4.67u l=2.6u ad=1.3076e-12 pd=5.2300e-06 as=1.6812e-12 ps=6.5575e-06 nf=1 m=8 par=8
XMpar6 a_10816_8111.t1 a_10366_9908.t18 vss.t1 vss.t0 nfet_03v3 w=1.08u l=2.04u ad=6.4800e-13 pd=3.3600e-06 as=3.0240e-13 ps=1.6400e-06 nf=1 m=2 par=2
XMpar7 ib.t1 ib.t0 vss.t3 vss.t2 nfet_03v3 w=1.03u l=2.6u ad=6.1800e-13 pd=3.2600e-06 as=2.8840e-13 ps=1.5900e-06 nf=1 m=2 par=2
XMpar8 a_16734_8929.t3 a_16734_8929.t2 vdd.t1 vdd.t0 pfet_03v3 w=4.67u l=2.6u ad=1.3076e-12 pd=5.2300e-06 as=1.3076e-12 ps=5.2300e-06 nf=1 m=2 par=2
XMpar9 a_10366_9908.t1 a_10366_9908.t0 a_10816_8111.t0 vss.t8 nfet_03v3 w=1.85u l=0.78u ad=1.1100e-12 pd=4.9000e-06 as=1.1100e-12 ps=4.9000e-06 nf=1 m=2 par=2
XMpar10 a_11728_6001.t0 a_10366_9908.t18 vss.t1 vss.t0 nfet_03v3 w=1.08u l=2.04u ad=3.0240e-13 pd=1.6400e-06 as=3.0240e-13 ps=1.6400e-06 nf=1 m=2 par=2
XMpar11 a_16734_8929.t0 ib.t0 vss.t3 vss.t2 nfet_03v3 w=1.03u l=2.6u ad=6.1800e-13 pd=3.2600e-06 as=2.8840e-13 ps=1.5900e-06 nf=1 m=2 par=2
X9 out.t14 vss.t9 cap_mim_2f0fF c_width=15.52u c_length=15.51u
X40 out.t14 vss.t9 cap_mim_2f0fF c_width=15.52u c_length=15.51u
Rpar0 a_10366_9908.t0 a_10366_9908.t1 26.6289
Rpar1 a_10366_9908.t0 a_10366_9908.t4 670.3122
Rpar2 a_10366_9908.t0 a_10366_9908.t18 178.0538
Rpar3 a_10366_9908.t1 a_10366_9908.t4 205.3717
Rpar4 a_10366_9908.t1 a_10366_9908.t18 54.5525
Rpar5 a_10366_9908.t4 a_10366_9908.t18 80.1175
Rpar6 a_10816_8111.t0 a_10816_8111.t1 51.7972
Rpar7 a_11728_6001.t0 a_11728_6001.t1 58.2572
Rpar8 a_12014_9908.t0 a_12014_9908.t64 52.7397
Rpar9 a_16734_8929.t0 a_16734_8929.t2 145.2944
Rpar10 a_16734_8929.t0 a_16734_8929.t3 112.9373
Rpar11 a_16734_8929.t2 a_16734_8929.t3 23.4284
Rpar12 a_5302_12718.t0 a_5302_12718.t128 62.8143
Rpar13 a_5802_12718.t0 a_5802_12718.t64 52.7397
Rpar14 ib ib.t0 13.5547
Rpar15 ib ib.t1 12.4913
Rpar16 ib.t0 ib.t1 28.4157
Rpar17 inn inn.t0 1.6985
Rpar18 inp inp.t0 1.6985
Rpar19 out out.t0 227.9724
Rpar20 out out.t11 107.7451
Rpar21 out out.t14 17.3217
Rpar22 out.t0 out.t11 102.8236
Rpar23 out.t0 out.t14 1077.5735
Rpar24 out.t11 out.t14 509.2864
Rpar25 vdd vdd.t0 429.3936
Rpar26 vdd vdd.t1 839.8123
Rpar27 vdd vdd.t4 20.7646
Rpar28 vdd vdd.t2 106.3540
Rpar29 vdd.t0 vdd.t1 5.8063
Rpar30 vdd.t0 vdd.t4 1231.5332
Rpar31 vdd.t0 vdd.t2 97.1058
Rpar32 vdd.t1 vdd.t4 2408.6452
Rpar33 vdd.t1 vdd.t2 189.9205
Rpar34 vdd.t4 vdd.t2 305.0313
Rpar35 vss vss.t0 126.4159
Rpar36 vss vss.t1 597.0600
Rpar37 vss vss.t8 111.2943
Rpar38 vss vss.t2 1483.3299
Rpar39 vss vss.t20 581.3945
Rpar40 vss vss.t3 499.6428
Rpar41 vss vss.t9 67.3365
Rpar42 vss.t0 vss.t1 19.2002
Rpar43 vss.t0 vss.t8 2.2114
Rpar44 vss.t0 vss.t2 415.0856
Rpar45 vss.t0 vss.t20 86.3360
Rpar46 vss.t0 vss.t3 149.9328
Rpar47 vss.t0 vss.t9 476.9775
Rpar48 vss.t1 vss.t8 21.0893
Rpar49 vss.t1 vss.t2 1892.9606
Rpar50 vss.t1 vss.t20 312.2139
Rpar51 vss.t1 vss.t3 733.7940
Rpar52 vss.t1 vss.t9 2252.7553
Rpar53 vss.t8 vss.t2 363.8851
Rpar54 vss.t8 vss.t20 88.0197
Rpar55 vss.t8 vss.t3 129.5522
Rpar56 vss.t8 vss.t9 419.9223
Rpar57 vss.t2 vss.t20 2568.0353
Rpar58 vss.t2 vss.t3 25.8124
Rpar59 vss.t2 vss.t9 5596.7225
Rpar60 vss.t20 vss.t3 888.9170
Rpar61 vss.t20 vss.t9 2193.6481
Rpar62 vss.t3 vss.t9 1885.1922
Cpar0 a_10366_9908.t0 vss 2.05241e-15
Cpar1 a_10366_9908.t1 vss 2.43402e-15
Cpar2 a_10366_9908.t18 vss 4.30308e-15
Cpar3 a_10366_9908.t4 vss 4.16032e-15
Cpar4 a_10816_8111.t0 vss 3.02558e-15
Cpar5 a_10816_8111.t1 vss 2.49077e-15
Cpar6 a_11728_6001.t0 vss 2.29854e-15
Cpar7 a_11728_6001.t1 vss 3.81414e-15
Cpar8 a_12014_9908.t0 vss 8.95005e-14
Cpar9 a_12014_9908.t64 vss 7.89295e-15
Cpar10 a_16734_8929.t0 vss 3.67543e-15
Cpar11 a_16734_8929.t2 vss 2.48862e-14
Cpar12 a_16734_8929.t3 vss 3.87532e-15
Cpar13 a_5302_12718.t0 vss 1.51212e-13
Cpar14 a_5302_12718.t128 vss 1.08734e-14
Cpar15 a_5802_12718.t0 vss 8.60604e-14
Cpar16 a_5802_12718.t64 vss 7.58960e-15
Cpar17 ib out 1.20000e-17
Cpar18 ib vdd 1.19900e-17
Cpar19 ib vss 1.20359e-14
Cpar20 ib.t0 vss 2.02904e-15
Cpar21 ib.t1 vss 4.47391e-16
Cpar22 inn inp 2.20640e-16
Cpar23 inn out 1.98900e-17
Cpar24 inn vdd 5.15843e-14
Cpar25 inn vss 8.47122e-15
Cpar26 inn.t0 vss 1.02605e-13
Cpar27 inp vdd 5.11709e-14
Cpar28 inp vss 8.45075e-15
Cpar29 inp.t0 vss 1.02248e-13
Cpar30 out vdd 4.08857e-15
Cpar31 out vss 2.18175e-14
Cpar32 out.t0 vss 4.02835e-16
Cpar33 out.t11 vss 3.11971e-16
Cpar34 out.t14 vss 1.27996e-14
Cpar35 vdd vss 5.89801e-13
Cpar36 vdd.t0 vss 1.26738e-14
Cpar37 vdd.t1 vss 7.06899e-15
Cpar38 vdd.t2 vss 1.60682e-14
Cpar39 vdd.t4 vss 1.40149e-13
.ends opamp_dut

Vdd vdd 0 1.800000
Vss vss 0 0
Ibias vdd ib 2.800000e-07
Vinp inp 0 DC 0.805000 AC 1 PWL(0 0.805000 5.619220e-08 0.805000 6.181141e-08 0.815000)
Rfb out inn 1m
Cload out 0 2.000000e-13
Xdut vdd vss inp inn out ib opamp_dut
.end
