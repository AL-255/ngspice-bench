* opa1000[0354]: 200f/nmos_5t_1v8_i500u_weak (nmos_5t, VDD=1.8V, CL=0.2pF, Iref=125.0uA)
.include "pdk_opa.inc"
.temp 27
.option gmin=1e-12 rshunt=1e12 reltol=1e-3 abstol=1e-12 vntol=1e-5 method=gear
* Post-PEX R+C extracted netlist for nmos_5t_1v8_i500u_weak
.subckt opamp_dut vdd vss inp inn out ib
XMpar0 out.t160 a_3998_12052.t160 vdd.t1 vdd.t0 pfet_03v3 w=2.15u l=0.75u ad=6.0200e-13 pd=2.7100e-06 as=6.4500e-13 ps=2.8844e-06 nf=1 m=160 par=160
XMpar1 a_1358_1249.t0 inp.t0 a_3998_12052.t0 vss.t0 nfet_03v3 w=2.45u l=0.45u ad=7.2520e-13 pd=3.1645e-06 as=7.1540e-13 ps=3.1259e-06 nf=1 m=160 par=160
XMpar2 a_3998_12052.t161 a_3998_12052.t160 vdd.t1 vdd.t0 pfet_03v3 w=2.15u l=0.75u ad=6.0200e-13 pd=2.7100e-06 as=6.0200e-13 ps=2.7100e-06 nf=1 m=160 par=160
XMpar3 a_1358_1249.t160 ib.t0 vss.t0 vss.t0 nfet_03v3 w=2.38u l=0.35u ad=6.6640e-13 pd=2.9400e-06 as=6.9020e-13 ps=3.0344e-06 nf=1 m=64 par=64
XMpar4 a_1358_1249.t0 inn.t0 out.t0 vss.t0 nfet_03v3 w=2.45u l=0.45u ad=7.2520e-13 pd=3.1645e-06 as=7.1540e-13 ps=3.1259e-06 nf=1 m=160 par=160
XMpar5 ib.t1 ib.t0 vss.t0 vss.t0 nfet_03v3 w=2.38u l=0.35u ad=6.6640e-13 pd=2.9400e-06 as=6.6640e-13 ps=2.9400e-06 nf=1 m=16 par=16
X441 out.t320 vss.t205 cap_mim_2f0fF c_width=18.88u c_length=18.88u
Rpar0 a_1358_1249.t0 a_1358_1249.t160 36.9934
Rpar1 a_3998_12052.t0 a_3998_12052.t160 225.0387
Rpar2 a_3998_12052.t0 a_3998_12052.t161 63.4219
Rpar3 a_3998_12052.t160 a_3998_12052.t161 2.8168
Rpar4 ib ib.t0 11.2652
Rpar5 ib ib.t1 3.8054
Rpar6 inn inn.t0 1.8524
Rpar7 inp inp.t0 1.8524
Rpar8 out out.t0 212.7648
Rpar9 out out.t160 2.5252
Rpar10 out out.t320 67.8775
Rpar11 out.t0 out.t320 212.5447
Rpar12 vdd vdd.t0 18.9721
Rpar13 vdd.t0 vdd.t1 8.3901
Rpar14 vss vss.t0 90.7018
Rpar15 vss vss.t205 130.1706
Rpar16 vss.t0 vss.t205 63.3116
Cpar0 a_1358_1249.t0 vss 1.99605e-13
Cpar1 a_1358_1249.t160 vss 4.06596e-14
Cpar2 a_3998_12052.t0 vss 1.08539e-13
Cpar3 a_3998_12052.t160 vss 2.64842e-13
Cpar4 a_3998_12052.t161 vss 1.36851e-13
Cpar5 ib inn 1.84100e-17
Cpar6 ib inp 2.25700e-17
Cpar7 ib out 4.24530e-16
Cpar8 ib vss 5.66146e-14
Cpar9 ib.t0 vss 8.06985e-15
Cpar10 ib.t1 vss 2.91152e-15
Cpar11 inn inp 3.41660e-16
Cpar12 inn out 2.62789e-14
Cpar13 inn vdd 1.38800e-17
Cpar14 inn vss 5.50890e-14
Cpar15 inn.t0 vss 3.95768e-14
Cpar16 inp vdd 1.38800e-17
Cpar17 inp vss 5.52784e-14
Cpar18 inp.t0 vss 3.94860e-14
Cpar19 out vdd 1.01370e-13
Cpar20 out vss 5.11784e-14
Cpar21 out.t0 vss 8.00699e-14
Cpar22 out.t160 vss 8.36661e-14
Cpar23 out.t320 vss 1.19434e-13
Cpar24 vdd vss 4.72371e-13
Cpar25 vdd.t0 vss 3.50403e-13
Cpar26 vdd.t1 vss 5.65554e-14
.ends opamp_dut

Vdd vdd 0 1.800000
Vss vss 0 0
Ibias vdd ib 1.250000e-04
Vinp inp 0 DC 0.895000 AC 1 PWL(0 0.895000 3.000000e-09 0.895000 3.300000e-09 0.905000)
Rfb out inn 1m
Cload out 0 2.000000e-13
Xdut vdd vss inp inn out ib opamp_dut
.end
