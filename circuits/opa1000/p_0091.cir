* opa1000[0091]: 200f/current_reuse_1v8_i1u_subth (current_reuse, VDD=1.8V, CL=0.2pF, Iref=0.1429uA)
.include "pdk_opa.inc"
.temp 27
.option gmin=1e-12 rshunt=1e12 reltol=1e-3 abstol=1e-12 vntol=1e-5 method=gear
* Post-PEX R+C extracted netlist for current_reuse_1v8_i1u_subth
.subckt opamp_dut vdd vss inp inn out ib
XMpar0 a_5330_13159.t0 inp.t4 a_935_4851.t0 vdd.t2 pfet_03v3 w=1.81u l=2.6u ad=7.9640e-13 pd=3.5950e-06 as=5.0680e-13 ps=2.3700e-06 nf=1 m=8 par=8
XMpar1 a_3514_1294.t0 inn.t0 a_7804_8678.t8 vss.t1 nfet_03v3 w=1.28u l=2.6u ad=5.6320e-13 pd=2.8000e-06 as=3.5840e-13 ps=1.8400e-06 nf=1 m=4 par=4
XMpar2 out.t0 a_935_4851.t14 vdd.t1 vdd.t0 pfet_03v3 w=3.73u l=1.8u ad=1.2831e-12 pd=5.1640e-06 as=1.2831e-12 ps=5.1640e-06 nf=1 m=10 par=10
XMpar3 a_3514_1294.t0 inp.t0 a_935_4851.t8 vss.t1 nfet_03v3 w=1.28u l=2.6u ad=5.6320e-13 pd=2.8000e-06 as=3.5840e-13 ps=1.8400e-06 nf=1 m=4 par=4
XMpar4 a_3514_1294.t8 ib.t0 vss.t10 vss.t9 nfet_03v3 w=0.73u l=3.5u ad=4.3800e-13 pd=2.6600e-06 as=2.0440e-13 ps=1.2900e-06 nf=1 m=4 par=4
XMpar5 out.t5 ib.t0 vss.t10 vss.t9 nfet_03v3 w=0.73u l=3.5u ad=3.4456e-13 pd=2.1120e-06 as=2.9784e-13 ps=1.8380e-06 nf=1 m=10 par=10
XMpar6 a_7804_8678.t13 a_7804_8678.t12 vdd.t1 vdd.t0 pfet_03v3 w=3.73u l=1.8u ad=2.2380e-12 pd=8.6600e-06 as=1.0444e-12 ps=4.2900e-06 nf=1 m=1
XMpar7 a_5330_13159.t0 inn.t4 a_7804_8678.t0 vdd.t2 pfet_03v3 w=1.81u l=2.6u ad=7.9640e-13 pd=3.5950e-06 as=5.0680e-13 ps=2.3700e-06 nf=1 m=8 par=8
XMpar8 a_5330_13159.t16 a_7804_8678.t12 vdd.t1 vdd.t0 pfet_03v3 w=3.73u l=1.8u ad=1.0444e-12 pd=4.2900e-06 as=2.2380e-12 ps=8.6600e-06 nf=1 m=2 par=2
XMpar9 ib.t1 ib.t0 vss.t10 vss.t9 nfet_03v3 w=0.73u l=3.5u ad=4.3800e-13 pd=2.6600e-06 as=2.0440e-13 ps=1.2900e-06 nf=1 m=2 par=2
XMpar10 a_935_4851.t12 a_7804_8678.t12 vdd.t1 vdd.t0 pfet_03v3 w=3.73u l=1.8u ad=2.2380e-12 pd=8.6600e-06 as=1.0444e-12 ps=4.2900e-06 nf=1 m=1
X13 a_935_5371.t0 a_4703_5891.t0 vss.t0 ppolyf_u_1k r_width=1u r_length=18.18u
X19 a_935_8491.t0 a_4703_7971.t0 vss.t0 ppolyf_u_1k r_width=1u r_length=18.18u
X23 a_935_5371.t0 a_4703_4851.t0 vss.t0 ppolyf_u_1k r_width=1u r_length=18.18u
X28 a_935_7451.t0 a_4703_7971.t0 vss.t0 ppolyf_u_1k r_width=1u r_length=18.18u
X29 a_935_4851.t13 a_4703_4851.t0 vss.t0 ppolyf_u_1k r_width=1u r_length=18.18u
X39 a_935_7451.t0 a_4703_6931.t0 vss.t0 ppolyf_u_1k r_width=1u r_length=18.18u
X42 a_935_6411.t0 a_4703_6931.t0 vss.t0 ppolyf_u_1k r_width=1u r_length=18.18u
X56 a_935_6411.t0 a_4703_5891.t0 vss.t0 ppolyf_u_1k r_width=1u r_length=18.18u
X58 a_935_8491.t1 out.t16 cap_mim_2f0fF c_width=12.99u c_length=12.99u
Rpar0 a_3514_1294.t0 a_3514_1294.t8 67.9418
Rpar1 a_5330_13159.t0 a_5330_13159.t16 55.6374
Rpar2 a_7804_8678.t0 a_7804_8678.t8 114.0961
Rpar3 a_7804_8678.t0 a_7804_8678.t12 105.4083
Rpar4 a_7804_8678.t0 a_7804_8678.t13 213.4337
Rpar5 a_7804_8678.t8 a_7804_8678.t12 107.3253
Rpar6 a_7804_8678.t8 a_7804_8678.t13 137.8046
Rpar7 a_7804_8678.t12 a_7804_8678.t13 26.4557
Rpar8 a_935_4851.t0 a_935_4851.t8 109.1967
Rpar9 a_935_4851.t0 a_935_4851.t12 149.4403
Rpar10 a_935_4851.t0 a_935_4851.t13 708.9876
Rpar11 a_935_4851.t0 a_935_4851.t14 244.8117
Rpar12 a_935_4851.t8 a_935_4851.t12 107.9560
Rpar13 a_935_4851.t8 a_935_4851.t13 512.1743
Rpar14 a_935_4851.t8 a_935_4851.t14 176.8526
Rpar15 a_935_4851.t12 a_935_4851.t13 285.8763
Rpar16 a_935_4851.t12 a_935_4851.t14 98.7124
Rpar17 a_935_4851.t13 a_935_4851.t14 63.5720
Rpar18 a_935_8491.t0 a_935_8491.t1 80.8185
Rpar19 ib ib.t0 14.9680
Rpar20 ib ib.t1 13.2371
Rpar21 ib.t0 ib.t1 31.2101
Rpar22 inn inn.t0 2.2550
Rpar23 inn inn.t4 33.2158
Rpar24 inp inp.t0 2.3036
Rpar25 inp inp.t4 33.1672
Rpar26 out out.t0 2.7840
Rpar27 out out.t5 997.4836
Rpar28 out out.t16 856.0065
Rpar29 out.t0 out.t5 144.9241
Rpar30 out.t0 out.t16 124.3689
Rpar31 out.t5 out.t16 84.2529
Rpar32 vdd vdd.t0 334.3305
Rpar33 vdd vdd.t1 276.1467
Rpar34 vdd vdd.t2 22.4491
Rpar35 vdd.t0 vdd.t1 4.8476
Rpar36 vdd.t0 vdd.t2 150.5211
Rpar37 vdd.t1 vdd.t2 124.3258
Rpar38 vss vss.t0 417.9524
Rpar39 vss vss.t1 150.4886
Rpar40 vss vss.t10 1724.1239
Rpar41 vss vss.t9 79.0722
Rpar42 vss.t0 vss.t1 16.5081
Rpar43 vss.t0 vss.t10 110.5884
Rpar44 vss.t0 vss.t9 4.9919
Rpar45 vss.t1 vss.t10 47.5783
Rpar46 vss.t1 vss.t9 2.2832
Rpar47 vss.t10 vss.t9 17.6462
Cpar0 a_3514_1294.t0 vss 7.86870e-15
Cpar1 a_3514_1294.t8 vss 1.31111e-14
Cpar2 a_4703_4851.t0 vss 3.49000e-17
Cpar3 a_4703_5891.t0 vss 3.87800e-17
Cpar4 a_4703_6931.t0 vss 3.72200e-17
Cpar5 a_4703_7971.t0 vss 3.35200e-17
Cpar6 a_5330_13159.t0 vss 1.68775e-14
Cpar7 a_5330_13159.t16 vss 6.42361e-15
Cpar8 a_7804_8678.t0 vss 7.91848e-15
Cpar9 a_7804_8678.t12 vss 1.23936e-14
Cpar10 a_7804_8678.t13 vss 4.66334e-15
Cpar11 a_7804_8678.t8 vss 4.41847e-15
Cpar12 a_935_4851.t0 vss 5.37646e-15
Cpar13 a_935_4851.t12 vss 3.25292e-15
Cpar14 a_935_4851.t13 vss 2.54826e-15
Cpar15 a_935_4851.t14 vss 1.89529e-14
Cpar16 a_935_4851.t8 vss 2.88948e-15
Cpar17 a_935_5371.t0 vss 3.91400e-17
Cpar18 a_935_6411.t0 vss 3.64800e-17
Cpar19 a_935_7451.t0 vss 4.05600e-17
Cpar20 a_935_8491.t0 vss 2.15900e-16
Cpar21 a_935_8491.t1 vss 3.42548e-15
Cpar22 ib out 2.43457e-15
Cpar23 ib vss 4.42922e-14
Cpar24 ib.t0 vss 7.73554e-15
Cpar25 ib.t1 vss 6.43688e-16
Cpar26 inn inp 1.54210e-16
Cpar27 inn vdd 1.05501e-14
Cpar28 inn vss 9.21884e-15
Cpar29 inn.t0 vss 2.80412e-15
Cpar30 inn.t4 vss 1.25018e-14
Cpar31 inp vdd 1.00501e-14
Cpar32 inp vss 9.30624e-15
Cpar33 inp.t0 vss 2.70182e-15
Cpar34 inp.t4 vss 1.18751e-14
Cpar35 out vdd 1.23594e-14
Cpar36 out vss 1.91381e-14
Cpar37 out.t0 vss 7.40294e-15
Cpar38 out.t16 vss 8.74945e-15
Cpar39 out.t5 vss 8.47875e-15
Cpar40 vdd vss 1.40245e-13
Cpar41 vdd.t0 vss 2.42161e-14
Cpar42 vdd.t1 vss 1.21305e-14
Cpar43 vdd.t2 vss 2.72912e-14
.ends opamp_dut

Vdd vdd 0 1.800000
Vss vss 0 0
Ibias vdd ib 1.429000e-07
Vinp inp 0 DC 0.895000 AC 1 PWL(0 0.895000 5.081650e-08 0.895000 5.589815e-08 0.905000)
Rfb out inn 1m
Cload out 0 2.000000e-13
Xdut vdd vss inp inn out ib opamp_dut
.end
