* opa1000[0068]: 2p/cherry_hooper_3v3_i1u_subth (cherry_hooper, VDD=3.3V, CL=2.0pF, Iref=0.065uA)
.include "pdk_opa.inc"
.temp 27
.option gmin=1e-12 rshunt=1e12 reltol=1e-3 abstol=1e-12 vntol=1e-5 method=gear
* Post-PEX R+C extracted netlist for cherry_hooper_3v3_i1u_subth
.subckt opamp_dut vdd vss inp inn out ib
XMpar0 a_7714_6307.t0 a_1264_11348.t1 vdd.t11 vdd.t10 pfet_03v3 w=1.93u l=2.8u ad=5.4040e-13 pd=2.4900e-06 as=1.1580e-12 ps=5.0600e-06 nf=1 m=2 par=2
XMpar1 a_2258_8675.t8 a_1043_6352.t9 out.t2 vss.t33 nfet_03v3 w=7.5u l=1.56u ad=4.5000e-12 pd=1.6200e-05 as=2.1000e-12 ps=8.0600e-06 nf=1 m=2 par=2
XMpar2 a_7282_6307.t4 inn.t0 a_9294_14702.t3 vss.t34 nfet_03v3 w=1.88u l=1.56u ad=8.2720e-13 pd=3.7000e-06 as=5.2640e-13 ps=2.4400e-06 nf=1 m=4 par=4
XMpar3 out.t0 a_7508_18552.t2 vdd.t1 vdd.t0 pfet_03v3 w=3.39u l=1.8u ad=9.4920e-13 pd=3.9500e-06 as=9.4920e-13 ps=3.9500e-06 nf=1 m=4 par=4
XMpar4 a_9294_14702.t0 a_1264_11348.t1 vdd.t11 vdd.t10 pfet_03v3 w=1.93u l=2.8u ad=5.4040e-13 pd=2.4900e-06 as=1.1580e-12 ps=5.0600e-06 nf=1 m=2 par=2
XMpar5 a_1264_11348.t0 ib.t0 vss.t1 vss.t0 nfet_03v3 w=0.52u l=2.8u ad=3.1200e-13 pd=2.2400e-06 as=1.4560e-13 ps=1.0800e-06 nf=1 m=1
XMpar6 a_2258_8675.t0 ib.t0 vss.t1 vss.t0 nfet_03v3 w=0.52u l=2.8u ad=1.4560e-13 pd=1.0800e-06 as=2.2880e-13 ps=1.6600e-06 nf=1 m=8 par=8
XMpar7 a_1043_6352.t0 a_9294_14702.t7 a_8130_8630.t6 vss.t38 nfet_03v3 w=5.63u l=1.56u ad=1.5764e-12 pd=6.1900e-06 as=3.3780e-12 ps=1.2460e-05 nf=1 m=2 par=2
XMpar8 a_1043_6352.t4 a_1043_6352.t3 vdd.t1 vdd.t0 pfet_03v3 w=3.39u l=1.8u ad=1.3108e-12 pd=5.2933e-06 as=1.3108e-12 ps=5.2933e-06 nf=1 m=3 par=3
XMpar9 a_1264_11348.t2 a_1264_11348.t1 vdd.t11 vdd.t10 pfet_03v3 w=1.93u l=2.8u ad=1.1580e-12 pd=5.0600e-06 as=1.1580e-12 ps=5.0600e-06 nf=1 m=1
XMpar10 a_3564_16679.t2 a_3684_16471.t1 a_3684_16471.t2 vdd.t39 pfet_03v3 w=2.85u l=1u ad=1.7100e-12 pd=6.9000e-06 as=1.7100e-12 ps=6.9000e-06 nf=1 m=1
XMpar11 a_7282_6307.t4 inp.t0 a_7714_6307.t2 vss.t34 nfet_03v3 w=1.88u l=1.56u ad=8.2720e-13 pd=3.7000e-06 as=5.2640e-13 ps=2.4400e-06 nf=1 m=4 par=4
XMpar12 a_7508_18552.t3 a_7508_18552.t2 vdd.t1 vdd.t0 pfet_03v3 w=3.39u l=1.8u ad=9.4920e-13 pd=3.9500e-06 as=1.4916e-12 ps=5.9650e-06 nf=1 m=4 par=4
XMpar13 a_8130_8630.t0 ib.t0 vss.t1 vss.t0 nfet_03v3 w=0.52u l=2.8u ad=2.0107e-13 pd=1.4667e-06 as=1.4560e-13 ps=1.0800e-06 nf=1 m=6 par=6
XMpar14 a_2258_8675.t8 a_8250_11438.t9 a_7508_18552.t0 vss.t33 nfet_03v3 w=7.5u l=1.56u ad=4.5000e-12 pd=1.6200e-05 as=2.1000e-12 ps=8.0600e-06 nf=1 m=2 par=2
XMpar15 a_8250_11438.t1 a_8250_11438.t0 vdd.t1 vdd.t0 pfet_03v3 w=3.39u l=1.8u ad=1.3108e-12 pd=5.2933e-06 as=1.3108e-12 ps=5.2933e-06 nf=1 m=3 par=3
XMpar16 a_7282_6307.t0 ib.t0 vss.t1 vss.t0 nfet_03v3 w=0.52u l=2.8u ad=3.1200e-13 pd=2.2400e-06 as=2.2880e-13 ps=1.6600e-06 nf=1 m=4 par=4
XMpar17 a_1043_6352.t2 a_3684_16471.t3 a_9294_14702.t2 vdd.t38 pfet_03v3 w=0.77u l=1u ad=4.6200e-13 pd=2.7400e-06 as=4.6200e-13 ps=2.7400e-06 nf=1 m=1
XMpar18 a_8130_8630.t6 a_7714_6307.t7 a_8250_11438.t6 vss.t38 nfet_03v3 w=5.63u l=1.56u ad=3.3780e-12 pd=1.2460e-05 as=1.5764e-12 ps=6.1900e-06 nf=1 m=2 par=2
XMpar19 ib.t1 ib.t0 vss.t1 vss.t0 nfet_03v3 w=0.52u l=2.8u ad=3.1200e-13 pd=2.2400e-06 as=1.4560e-13 ps=1.0800e-06 nf=1 m=1
XMpar20 a_3684_16471.t0 ib.t0 vss.t1 vss.t0 nfet_03v3 w=0.52u l=2.8u ad=3.1200e-13 pd=2.2400e-06 as=3.1200e-13 ps=2.2400e-06 nf=1 m=1
XMpar21 a_7714_6307.t6 a_3684_16471.t3 a_8250_11438.t8 vdd.t38 pfet_03v3 w=0.77u l=1u ad=4.6200e-13 pd=2.7400e-06 as=4.6200e-13 ps=2.7400e-06 nf=1 m=1
XMpar22 a_3564_16679.t1 a_3564_16679.t0 vdd.t1 vdd.t0 pfet_03v3 w=3.39u l=1.8u ad=2.0340e-12 pd=7.9800e-06 as=2.0340e-12 ps=7.9800e-06 nf=1 m=1
X19 out.t6 vss.t40 cap_mim_2f0fF c_width=16.58u c_length=16.59u
X35 out.t6 vss.t40 cap_mim_2f0fF c_width=16.58u c_length=16.59u
Rpar0 a_1043_6352.t0 a_1043_6352.t9 54.3525
Rpar1 a_1043_6352.t0 a_1043_6352.t2 130.0551
Rpar2 a_1043_6352.t0 a_1043_6352.t3 513.2756
Rpar3 a_1043_6352.t0 a_1043_6352.t4 143.0802
Rpar4 a_1043_6352.t9 a_1043_6352.t2 165.9610
Rpar5 a_1043_6352.t9 a_1043_6352.t3 782.5993
Rpar6 a_1043_6352.t9 a_1043_6352.t4 218.1566
Rpar7 a_1043_6352.t2 a_1043_6352.t3 1872.6089
Rpar8 a_1043_6352.t2 a_1043_6352.t4 522.0065
Rpar9 a_1043_6352.t3 a_1043_6352.t4 20.5242
Rpar10 a_1264_11348.t0 a_1264_11348.t1 67.2168
Rpar11 a_1264_11348.t0 a_1264_11348.t2 108.8325
Rpar12 a_1264_11348.t1 a_1264_11348.t2 26.2726
Rpar13 a_2258_8675.t0 a_2258_8675.t8 68.5143
Rpar14 a_3564_16679.t0 a_3564_16679.t1 43.9346
Rpar15 a_3564_16679.t0 a_3564_16679.t2 437.9456
Rpar16 a_3564_16679.t1 a_3564_16679.t2 98.7618
Rpar17 a_3684_16471.t0 a_3684_16471.t1 556.6821
Rpar18 a_3684_16471.t0 a_3684_16471.t2 99.1137
Rpar19 a_3684_16471.t0 a_3684_16471.t3 91.8721
Rpar20 a_3684_16471.t1 a_3684_16471.t2 52.6717
Rpar21 a_3684_16471.t1 a_3684_16471.t3 942.6687
Rpar22 a_3684_16471.t2 a_3684_16471.t3 167.8362
Rpar23 a_7282_6307.t0 a_7282_6307.t4 69.0534
Rpar24 a_7508_18552.t0 a_7508_18552.t2 229.6599
Rpar25 a_7508_18552.t0 a_7508_18552.t3 84.9778
Rpar26 a_7508_18552.t2 a_7508_18552.t3 17.5522
Rpar27 a_7714_6307.t0 a_7714_6307.t2 82.0451
Rpar28 a_7714_6307.t0 a_7714_6307.t6 144.7243
Rpar29 a_7714_6307.t0 a_7714_6307.t7 206.2527
Rpar30 a_7714_6307.t2 a_7714_6307.t6 118.0489
Rpar31 a_7714_6307.t2 a_7714_6307.t7 81.0006
Rpar32 a_7714_6307.t6 a_7714_6307.t7 296.7627
Rpar33 a_8130_8630.t0 a_8130_8630.t6 106.5865
Rpar34 a_8250_11438.t0 a_8250_11438.t1 20.4306
Rpar35 a_8250_11438.t0 a_8250_11438.t9 1140.2218
Rpar36 a_8250_11438.t0 a_8250_11438.t6 872.8626
Rpar37 a_8250_11438.t0 a_8250_11438.t8 688.6862
Rpar38 a_8250_11438.t1 a_8250_11438.t9 317.8471
Rpar39 a_8250_11438.t1 a_8250_11438.t6 243.3183
Rpar40 a_8250_11438.t1 a_8250_11438.t8 191.9775
Rpar41 a_8250_11438.t9 a_8250_11438.t6 49.8163
Rpar42 a_8250_11438.t9 a_8250_11438.t8 190.8521
Rpar43 a_8250_11438.t6 a_8250_11438.t8 146.1011
Rpar44 a_9294_14702.t0 a_9294_14702.t2 99.8219
Rpar45 a_9294_14702.t0 a_9294_14702.t3 94.1822
Rpar46 a_9294_14702.t0 a_9294_14702.t7 123.9236
Rpar47 a_9294_14702.t2 a_9294_14702.t3 195.0747
Rpar48 a_9294_14702.t2 a_9294_14702.t7 256.6764
Rpar49 a_9294_14702.t3 a_9294_14702.t7 66.0501
Rpar50 ib ib.t0 2.2178
Rpar51 ib ib.t1 287.0349
Rpar52 ib.t0 ib.t1 26.9343
Rpar53 inn inn.t0 3.2307
Rpar54 inp inp.t0 3.2793
Rpar55 out out.t0 60.6300
Rpar56 out out.t2 6.4406
Rpar57 out out.t6 123.9189
Rpar58 out.t0 out.t6 125.2841
Rpar59 vdd vdd.t0 49.6590
Rpar60 vdd vdd.t1 85.0614
Rpar61 vdd vdd.t10 309.3556
Rpar62 vdd vdd.t11 270.0481
Rpar63 vdd vdd.t38 405.7094
Rpar64 vdd vdd.t39 1857.6134
Rpar65 vdd.t0 vdd.t1 2.3698
Rpar66 vdd.t0 vdd.t10 103.9283
Rpar67 vdd.t0 vdd.t11 84.9458
Rpar68 vdd.t0 vdd.t38 155.7440
Rpar69 vdd.t0 vdd.t39 377.6461
Rpar70 vdd.t1 vdd.t10 137.3728
Rpar71 vdd.t1 vdd.t11 111.4301
Rpar72 vdd.t1 vdd.t38 209.4489
Rpar73 vdd.t1 vdd.t39 476.5910
Rpar74 vdd.t10 vdd.t11 10.2009
Rpar75 vdd.t10 vdd.t38 86.9510
Rpar76 vdd.t10 vdd.t39 213.2482
Rpar77 vdd.t11 vdd.t38 74.0064
Rpar78 vdd.t11 vdd.t39 157.5947
Rpar79 vdd.t38 vdd.t39 202.3819
Rpar80 vss vss.t0 325.1058
Rpar81 vss vss.t1 91.2937
Rpar82 vss vss.t33 1323.5995
Rpar83 vss vss.t34 131.3130
Rpar84 vss vss.t38 639.5654
Rpar85 vss vss.t40 50.4906
Rpar86 vss.t0 vss.t1 5.9444
Rpar87 vss.t0 vss.t33 136.7144
Rpar88 vss.t0 vss.t34 3.7605
Rpar89 vss.t0 vss.t38 111.5709
Rpar90 vss.t0 vss.t40 1652.9318
Rpar91 vss.t1 vss.t33 70.7490
Rpar92 vss.t1 vss.t34 22.0957
Rpar93 vss.t1 vss.t38 202.7264
Rpar94 vss.t1 vss.t40 464.1638
Rpar95 vss.t33 vss.t34 189.2421
Rpar96 vss.t33 vss.t38 65.9246
Rpar97 vss.t33 vss.t40 6729.5633
Rpar98 vss.t34 vss.t38 33.7776
Rpar99 vss.t34 vss.t40 667.6335
Rpar100 vss.t38 vss.t40 3251.7355
Cpar0 a_1043_6352.t0 vss 3.81483e-15
Cpar1 a_1043_6352.t2 vss 1.46740e-15
Cpar2 a_1043_6352.t3 vss 4.15364e-15
Cpar3 a_1043_6352.t4 vss 4.03072e-15
Cpar4 a_1043_6352.t9 vss 4.79936e-15
Cpar5 a_1264_11348.t0 vss 2.70090e-15
Cpar6 a_1264_11348.t1 vss 1.34481e-14
Cpar7 a_1264_11348.t2 vss 3.07165e-15
Cpar8 a_2258_8675.t0 vss 2.55596e-15
Cpar9 a_2258_8675.t8 vss 5.08785e-15
Cpar10 a_3564_16679.t0 vss 2.52578e-15
Cpar11 a_3564_16679.t1 vss 5.31665e-15
Cpar12 a_3564_16679.t2 vss 4.86956e-15
Cpar13 a_3684_16471.t0 vss 2.74495e-15
Cpar14 a_3684_16471.t1 vss 1.20156e-15
Cpar15 a_3684_16471.t2 vss 3.30859e-15
Cpar16 a_3684_16471.t3 vss 2.76753e-15
Cpar17 a_7282_6307.t0 vss 5.50227e-15
Cpar18 a_7282_6307.t4 vss 5.54112e-15
Cpar19 a_7508_18552.t0 vss 3.98650e-15
Cpar20 a_7508_18552.t2 vss 1.28101e-14
Cpar21 a_7508_18552.t3 vss 5.03406e-15
Cpar22 a_7714_6307.t0 vss 2.63795e-15
Cpar23 a_7714_6307.t2 vss 4.14224e-15
Cpar24 a_7714_6307.t6 vss 1.73526e-15
Cpar25 a_7714_6307.t7 vss 4.47383e-15
Cpar26 a_8130_8630.t0 vss 7.88506e-15
Cpar27 a_8130_8630.t6 vss 8.84311e-15
Cpar28 a_8250_11438.t0 vss 4.05372e-15
Cpar29 a_8250_11438.t1 vss 4.22718e-15
Cpar30 a_8250_11438.t6 vss 3.25949e-15
Cpar31 a_8250_11438.t8 vss 1.93427e-15
Cpar32 a_8250_11438.t9 vss 4.37355e-15
Cpar33 a_9294_14702.t0 vss 3.26529e-15
Cpar34 a_9294_14702.t2 vss 1.77979e-15
Cpar35 a_9294_14702.t3 vss 3.73879e-15
Cpar36 a_9294_14702.t7 vss 4.84803e-15
Cpar37 ib out 1.28652e-15
Cpar38 ib vdd 1.87028e-15
Cpar39 ib vss 5.15970e-14
Cpar40 ib.t0 vss 9.61728e-15
Cpar41 ib.t1 vss 6.39333e-16
Cpar42 inn inp 5.16800e-17
Cpar43 inn out 5.57300e-17
Cpar44 inn vss 4.39177e-15
Cpar45 inn.t0 vss 7.91931e-16
Cpar46 inp out 3.03700e-17
Cpar47 inp vss 4.39111e-15
Cpar48 inp.t0 vss 8.35641e-16
Cpar49 out vdd 5.33841e-15
Cpar50 out vss 1.97380e-14
Cpar51 out.t0 vss 6.18668e-16
Cpar52 out.t2 vss 1.66740e-16
Cpar53 out.t6 vss 1.66130e-14
Cpar54 vdd vss 1.32628e-13
Cpar55 vdd.t0 vss 2.31765e-14
Cpar56 vdd.t1 vss 1.53215e-14
Cpar57 vdd.t10 vss 7.04608e-15
Cpar58 vdd.t11 vss 8.79582e-15
Cpar59 vdd.t38 vss 4.67206e-15
Cpar60 vdd.t39 vss 2.65074e-15
.ends opamp_dut

Vdd vdd 0 3.300000
Vss vss 0 0
Ibias vdd ib 6.500000e-08
Vinp inp 0 DC 2.046300 AC 1 PWL(0 2.046300 1.228691e-07 2.046300 1.351560e-07 2.056300)
Rfb out inn 1m
Cload out 0 2.000000e-12
Xdut vdd vss inp inn out ib opamp_dut
.end
