* opa1000[0273]: 200f/folded_cascode_pmos_3v3_i200n_subth (folded_cascode_pmos, VDD=3.3V, CL=0.2pF, Iref=0.0444uA)
.include "pdk_opa.inc"
.temp 27
.option gmin=1e-12 rshunt=1e12 reltol=1e-3 abstol=1e-12 vntol=1e-5 method=gear
* Post-PEX R+C extracted netlist for folded_cascode_pmos_3v3_i200n_subth
.subckt opamp_dut vdd vss inp inn out ib
XMpar0 a_978_8598.t6 a_1596_10198.t0 vdd.t1 vdd.t0 pfet_03v3 w=2.82u l=9.75u ad=1.6920e-12 pd=6.8400e-06 as=1.2408e-12 ps=5.1100e-06 nf=1 m=4 par=4
XMpar1 a_1596_10198.t4 ib.t0 vss.t5 vss.t4 nfet_03v3 w=0.43u l=6.25u ad=1.2040e-13 pd=9.9000e-07 as=1.2040e-13 ps=9.9000e-07 nf=1 m=2 par=2
XMpar2 a_6574_4991.t8 ib.t0 vss.t5 vss.t4 nfet_03v3 w=0.43u l=6.25u ad=1.2040e-13 pd=9.9000e-07 as=2.5800e-13 ps=2.0600e-06 nf=1 m=4 par=4
XMpar3 a_6574_4991.t2 inn.t0 a_978_8598.t0 vdd.t3 pfet_03v3 w=2.16u l=3.84u ad=6.0480e-13 pd=2.7200e-06 as=8.3520e-13 ps=3.6533e-06 nf=1 m=6 par=6
XMpar4 a_6574_4991.t0 a_1596_10198.t6 out.t0 vss.t0 nfet_03v3 w=0.89u l=3.5u ad=5.3400e-13 pd=2.9800e-06 as=2.4920e-13 ps=1.4500e-06 nf=1 m=2 par=2
XMpar5 a_1866_8598.t8 ib.t0 vss.t5 vss.t4 nfet_03v3 w=0.43u l=6.25u ad=1.2040e-13 pd=9.9000e-07 as=2.5800e-13 ps=2.0600e-06 nf=1 m=4 par=4
XMpar6 a_1866_8598.t0 inp.t0 a_978_8598.t0 vdd.t3 pfet_03v3 w=2.16u l=3.84u ad=6.0480e-13 pd=2.7200e-06 as=8.3520e-13 ps=3.6533e-06 nf=1 m=6 par=6
XMpar7 a_1866_8598.t6 a_1596_10198.t6 a_2432_6499.t0 vss.t0 nfet_03v3 w=0.89u l=3.5u ad=5.3400e-13 pd=2.9800e-06 as=2.4920e-13 ps=1.4500e-06 nf=1 m=2 par=2
XMpar8 out.t2 a_2432_6499.t2 vdd.t1 vdd.t0 pfet_03v3 w=2.82u l=9.75u ad=7.8960e-13 pd=3.3800e-06 as=7.8960e-13 ps=3.3800e-06 nf=1 m=2 par=2
XMpar9 ib.t1 ib.t0 vss.t5 vss.t4 nfet_03v3 w=0.43u l=6.25u ad=2.5800e-13 pd=2.0600e-06 as=1.2040e-13 ps=9.9000e-07 nf=1 m=2 par=2
XMpar10 a_1596_10198.t1 a_1596_10198.t0 vdd.t1 vdd.t0 pfet_03v3 w=2.82u l=9.75u ad=1.6920e-12 pd=6.8400e-06 as=7.8960e-13 ps=3.3800e-06 nf=1 m=2 par=2
XMpar11 a_2432_6499.t3 a_2432_6499.t2 vdd.t1 vdd.t0 pfet_03v3 w=2.82u l=9.75u ad=1.6920e-12 pd=6.8400e-06 as=7.8960e-13 ps=3.3800e-06 nf=1 m=2 par=2
Rpar0 a_1596_10198.t0 a_1596_10198.t1 12.6587
Rpar1 a_1596_10198.t0 a_1596_10198.t4 643.7158
Rpar2 a_1596_10198.t0 a_1596_10198.t6 293.9299
Rpar3 a_1596_10198.t1 a_1596_10198.t4 272.9279
Rpar4 a_1596_10198.t1 a_1596_10198.t6 124.6228
Rpar5 a_1596_10198.t4 a_1596_10198.t6 96.3510
Rpar6 a_1866_8598.t0 a_1866_8598.t8 83.5250
Rpar7 a_1866_8598.t0 a_1866_8598.t6 122.0380
Rpar8 a_1866_8598.t8 a_1866_8598.t6 60.7309
Rpar9 a_2432_6499.t0 a_2432_6499.t2 173.6304
Rpar10 a_2432_6499.t0 a_2432_6499.t3 66.7111
Rpar11 a_2432_6499.t2 a_2432_6499.t3 18.4170
Rpar12 a_6574_4991.t0 a_6574_4991.t8 60.7309
Rpar13 a_6574_4991.t0 a_6574_4991.t2 122.0380
Rpar14 a_6574_4991.t8 a_6574_4991.t2 83.5250
Rpar15 a_978_8598.t0 a_978_8598.t6 37.2446
Rpar16 ib ib.t0 1.9540
Rpar17 ib ib.t1 63.6534
Rpar18 ib.t0 ib.t1 23.2560
Rpar19 inn inn.t0 1.5418
Rpar20 inp inp.t0 1.5904
Rpar21 out out.t0 13.0922
Rpar22 out out.t2 61.1326
Rpar23 vdd vdd.t0 27.6370
Rpar24 vdd vdd.t1 189.1751
Rpar25 vdd vdd.t3 112.6123
Rpar26 vdd.t0 vdd.t1 6.2212
Rpar27 vdd.t0 vdd.t3 35.2663
Rpar28 vdd.t1 vdd.t3 142.1678
Rpar29 vss vss.t0 100.7860
Rpar30 vss vss.t4 32.7094
Rpar31 vss vss.t5 100.4815
Rpar32 vss.t0 vss.t4 6.0874
Rpar33 vss.t0 vss.t5 20.1039
Rpar34 vss.t4 vss.t5 6.5117
Cpar0 a_1596_10198.t0 vss 3.69533e-14
Cpar1 a_1596_10198.t1 vss 8.39630e-15
Cpar2 a_1596_10198.t4 vss 3.57846e-15
Cpar3 a_1596_10198.t6 vss 8.55558e-15
Cpar4 a_1866_8598.t0 vss 5.44546e-15
Cpar5 a_1866_8598.t6 vss 2.45457e-15
Cpar6 a_1866_8598.t8 vss 4.12052e-15
Cpar7 a_2432_6499.t0 vss 1.63124e-15
Cpar8 a_2432_6499.t2 vss 2.45837e-14
Cpar9 a_2432_6499.t3 vss 5.44069e-15
Cpar10 a_6574_4991.t0 vss 2.92184e-15
Cpar11 a_6574_4991.t2 vss 6.48208e-15
Cpar12 a_6574_4991.t8 vss 4.94513e-15
Cpar13 a_978_8598.t0 vss 1.53768e-14
Cpar14 a_978_8598.t6 vss 1.67713e-14
Cpar15 ib vss 4.56973e-14
Cpar16 ib.t0 vss 4.46497e-15
Cpar17 ib.t1 vss 4.44121e-16
Cpar18 inn inp 5.25900e-17
Cpar19 inn out 2.53000e-17
Cpar20 inn vdd 1.13311e-14
Cpar21 inn vss 4.98503e-15
Cpar22 inn.t0 vss 9.75336e-15
Cpar23 inp vdd 1.11889e-14
Cpar24 inp vss 4.78673e-15
Cpar25 inp.t0 vss 9.79691e-15
Cpar26 out vdd 5.26374e-15
Cpar27 out vss 6.79798e-15
Cpar28 out.t0 vss 2.29384e-16
Cpar29 out.t2 vss 6.86287e-15
Cpar30 vdd vss 2.06740e-13
Cpar31 vdd.t0 vss 6.00483e-14
Cpar32 vdd.t1 vss 1.72355e-14
Cpar33 vdd.t3 vss 3.14048e-14
.ends opamp_dut

Vdd vdd 0 3.300000
Vss vss 0 0
Ibias vdd ib 4.440000e-08
Vinp inp 0 DC 1.381000 AC 1 PWL(0 1.381000 2.055287e-07 1.381000 2.260816e-07 1.391000)
Rfb out inn 1m
Cload out 0 2.000000e-13
Xdut vdd vss inp inn out ib opamp_dut
.end
