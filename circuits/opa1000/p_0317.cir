* opa1000[0317]: 2p/folded_cascode_pmos_3v3_0p1u_1u_weak (folded_cascode_pmos, VDD=3.3V, CL=2.0pF, Iref=0.1444uA)
.include "pdk_opa.inc"
.temp 27
.option gmin=1e-12 rshunt=1e12 reltol=1e-3 abstol=1e-12 vntol=1e-5 method=gear
* Post-PEX R+C extracted netlist for folded_cascode_pmos_3v3_0p1u_1u_weak
.subckt opamp_dut vdd vss inp inn out ib
XMpar0 a_2034_9440.t0 inn.t0 a_6574_6104.t4 vdd.t16 pfet_03v3 w=1.79u l=10u ad=1.0740e-12 pd=4.7800e-06 as=5.0120e-13 ps=2.3500e-06 nf=1 m=12 par=12
XMpar1 a_2034_9440.t24 a_1193_7350.t2 vdd.t1 vdd.t0 pfet_03v3 w=1.95u l=8.13u ad=5.4600e-13 pd=2.5100e-06 as=8.5800e-13 ps=3.8050e-06 nf=1 m=4 par=4
XMpar2 a_2034_9440.t0 inp.t0 a_2180_2794.t4 vdd.t16 pfet_03v3 w=1.79u l=10u ad=1.0740e-12 pd=4.7800e-06 as=5.0120e-13 ps=2.3500e-06 nf=1 m=12 par=12
XMpar3 a_1193_7350.t3 a_1193_7350.t2 vdd.t1 vdd.t0 pfet_03v3 w=1.95u l=8.13u ad=5.4600e-13 pd=2.5100e-06 as=5.4600e-13 ps=2.5100e-06 nf=1 m=2 par=2
XMpar4 out.t0 a_3080_4222.t2 vdd.t1 vdd.t0 pfet_03v3 w=1.95u l=8.13u ad=5.4600e-13 pd=2.5100e-06 as=5.4600e-13 ps=2.5100e-06 nf=1 m=2 par=2
XMpar5 ib.t1 ib vss.t3 vss.t2 nfet_03v3 w=0.49u l=6.25u ad=2.9400e-13 pd=2.1800e-06 as=1.3720e-13 ps=1.0500e-06 nf=1 m=2 par=2
XMpar6 a_2180_2794.t16 a_1193_7350.t6 a_3080_4222.t0 vss.t0 nfet_03v3 w=0.62u l=4u ad=3.7200e-13 pd=2.4400e-06 as=1.7360e-13 ps=1.1800e-06 nf=1 m=2 par=2
XMpar7 a_2180_2794.t0 ib vss.t3 vss.t2 nfet_03v3 w=0.49u l=6.25u ad=1.3720e-13 pd=1.0500e-06 as=2.1560e-13 ps=1.6150e-06 nf=1 m=4 par=4
XMpar8 a_6574_6104.t16 a_1193_7350.t6 out.t1 vss.t0 nfet_03v3 w=0.62u l=4u ad=3.7200e-13 pd=2.4400e-06 as=1.7360e-13 ps=1.1800e-06 nf=1 m=2 par=2
XMpar9 a_6574_6104.t0 ib vss.t3 vss.t2 nfet_03v3 w=0.49u l=6.25u ad=1.3720e-13 pd=1.0500e-06 as=2.1560e-13 ps=1.6150e-06 nf=1 m=4 par=4
XMpar10 a_1193_7350.t0 ib vss.t3 vss.t2 nfet_03v3 w=0.49u l=6.25u ad=1.3720e-13 pd=1.0500e-06 as=1.3720e-13 ps=1.0500e-06 nf=1 m=2 par=2
XMpar11 a_3080_4222.t3 a_3080_4222.t2 vdd.t1 vdd.t0 pfet_03v3 w=1.95u l=8.13u ad=1.1700e-12 pd=5.1000e-06 as=5.4600e-13 ps=2.5100e-06 nf=1 m=2 par=2
Rpar0 a_1193_7350.t0 a_1193_7350.t2 214.2034
Rpar1 a_1193_7350.t0 a_1193_7350.t3 242.5465
Rpar2 a_1193_7350.t0 a_1193_7350.t6 154.4720
Rpar3 a_1193_7350.t2 a_1193_7350.t3 29.4837
Rpar4 a_1193_7350.t2 a_1193_7350.t6 117.9727
Rpar5 a_1193_7350.t3 a_1193_7350.t6 133.5826
Rpar6 a_2034_9440.t0 a_2034_9440.t24 32.8295
Rpar7 a_2180_2794.t0 a_2180_2794.t4 102.5172
Rpar8 a_2180_2794.t0 a_2180_2794.t16 77.8032
Rpar9 a_2180_2794.t4 a_2180_2794.t16 138.8923
Rpar10 a_3080_4222.t0 a_3080_4222.t2 213.1945
Rpar11 a_3080_4222.t0 a_3080_4222.t3 96.5641
Rpar12 a_3080_4222.t2 a_3080_4222.t3 18.5092
Rpar13 a_6574_6104.t0 a_6574_6104.t4 147.4008
Rpar14 a_6574_6104.t0 a_6574_6104.t16 76.6824
Rpar15 a_6574_6104.t4 a_6574_6104.t16 100.2417
Rpar16 ib ib.t1 17.3018
Rpar17 inn inn.t0 2.7170
Rpar18 inp inp.t0 2.7170
Rpar19 out out.t0 51.4150
Rpar20 out out.t1 13.5873
Rpar21 vdd vdd.t0 164.6698
Rpar22 vdd vdd.t1 313.5252
Rpar23 vdd vdd.t16 23.2981
Rpar24 vdd.t0 vdd.t1 4.6373
Rpar25 vdd.t0 vdd.t16 76.5306
Rpar26 vdd.t1 vdd.t16 145.7115
Rpar27 vss vss.t0 523.8880
Rpar28 vss vss.t2 31.8374
Rpar29 vss vss.t3 107.3119
Rpar30 vss.t0 vss.t2 62.7320
Rpar31 vss.t0 vss.t3 197.4460
Rpar32 vss.t2 vss.t3 5.1613
Cpar0 a_1193_7350.t0 vss 3.78288e-15
Cpar1 a_1193_7350.t2 vss 2.91157e-14
Cpar2 a_1193_7350.t3 vss 4.46903e-15
Cpar3 a_1193_7350.t6 vss 8.26913e-15
Cpar4 a_2034_9440.t0 vss 5.74329e-14
Cpar5 a_2034_9440.t24 vss 1.08753e-14
Cpar6 a_2180_2794.t0 vss 8.21351e-15
Cpar7 a_2180_2794.t16 vss 5.49088e-15
Cpar8 a_2180_2794.t4 vss 2.69394e-14
Cpar9 a_3080_4222.t0 vss 2.03927e-15
Cpar10 a_3080_4222.t2 vss 2.06257e-14
Cpar11 a_3080_4222.t3 vss 5.22520e-15
Cpar12 a_6574_6104.t0 vss 6.96735e-15
Cpar13 a_6574_6104.t16 vss 5.84404e-15
Cpar14 a_6574_6104.t4 vss 2.63058e-14
Cpar15 ib vdd 4.37300e-17
Cpar16 ib vss 4.88477e-14
Cpar17 ib.t1 vss 3.64067e-16
Cpar18 inn inp 3.11840e-16
Cpar19 inn vdd 4.05375e-14
Cpar20 inn vss 5.77732e-15
Cpar21 inn.t0 vss 5.42744e-14
Cpar22 inp vdd 4.09732e-14
Cpar23 inp vss 5.80646e-15
Cpar24 inp.t0 vss 5.45739e-14
Cpar25 out vdd 3.99462e-15
Cpar26 out vss 6.16686e-15
Cpar27 out.t0 vss 5.66209e-15
Cpar28 out.t1 vss 2.22696e-16
Cpar29 vdd vss 3.47340e-13
Cpar30 vdd.t0 vss 3.91695e-14
Cpar31 vdd.t1 vss 2.10642e-14
Cpar32 vdd.t16 vss 9.72008e-14
.ends opamp_dut

Vdd vdd 0 3.300000
Vss vss 0 0
Ibias vdd ib 1.444000e-07
Vinp inp 0 DC 1.381000 AC 1 PWL(0 1.381000 4.722514e-07 1.381000 5.194766e-07 1.391000)
Rfb out inn 1m
Cload out 0 2.000000e-12
Xdut vdd vss inp inn out ib opamp_dut
.end
