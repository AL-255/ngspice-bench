* opa1000[0520]: 200f/pmos_5t_1v8_i500u_subth (pmos_5t, VDD=1.8V, CL=0.2pF, Iref=70.0uA)
.include "pdk_opa.inc"
.temp 27
.option gmin=1e-12 rshunt=1e12 reltol=1e-3 abstol=1e-12 vntol=1e-5 method=gear
* Post-PEX R+C extracted netlist for pmos_5t_1v8_i500u_subth
.subckt opamp_dut vdd vss inp inn out ib
XMpar0 a_2435_6486.t0 ib.t0 vss.t8 vss.t7 nfet_03v3 w=6.6u l=0.68u ad=1.8480e-12 pd=7.1600e-06 as=2.1120e-12 ps=8.0650e-06 nf=1 m=16 par=16
XMpar1 a_2186_16579.t320 a_2435_6486.t16 vdd.t1 vdd.t0 pfet_03v3 w=10u l=0.68u ad=3.0000e-12 pd=1.1225e-05 as=3.0000e-12 ps=1.1225e-05 nf=1 m=64 par=64
XMpar2 a_2186_16579.t0 inp.t0 a_2382_16579.t0 vdd.t47 pfet_03v3 w=14u l=0.38u ad=4.0320e-12 pd=1.4926e-05 as=3.9760e-12 ps=1.4743e-05 nf=1 m=160 par=160
XMpar3 a_2186_16579.t0 inn.t0 out.t0 vdd.t47 pfet_03v3 w=14u l=0.38u ad=4.0320e-12 pd=1.4926e-05 as=3.9760e-12 ps=1.4743e-05 nf=1 m=160 par=160
XMpar4 out.t108 a_2382_16579.t160 vss.t4 vss.t3 nfet_03v3 w=1.98u l=0.63u ad=6.0314e-13 pd=2.7415e-06 as=5.5440e-13 ps=2.5400e-06 nf=1 m=78 par=78
XMpar5 a_2382_16579.t161 a_2382_16579.t160 vss.t4 vss.t3 nfet_03v3 w=1.98u l=0.63u ad=5.5440e-13 pd=2.5400e-06 as=5.5440e-13 ps=2.5400e-06 nf=1 m=78 par=78
XMpar6 a_2435_6486.t17 a_2435_6486.t16 vdd.t1 vdd.t0 pfet_03v3 w=10u l=0.68u ad=4.0000e-12 pd=1.4550e-05 as=2.8000e-12 ps=1.0560e-05 nf=1 m=16 par=16
XMpar7 ib.t1 ib.t0 vss.t8 vss.t7 nfet_03v3 w=6.6u l=0.68u ad=1.8480e-12 pd=7.1600e-06 as=2.1120e-12 ps=8.0650e-06 nf=1 m=16 par=16
X171 out.t238 vss.t0 cap_mim_2f0fF c_width=18.66u c_length=18.67u
X396 out.t238 vss.t0 cap_mim_2f0fF c_width=18.66u c_length=18.67u
X441 out.t238 vss.t0 cap_mim_2f0fF c_width=18.66u c_length=18.67u
Rpar0 a_2186_16579.t0 a_2186_16579.t320 42.8936
Rpar1 a_2382_16579.t0 a_2382_16579.t160 338.4212
Rpar2 a_2382_16579.t0 a_2382_16579.t161 89.4613
Rpar3 a_2382_16579.t160 a_2382_16579.t161 4.6767
Rpar4 a_2435_6486.t0 a_2435_6486.t16 182.0657
Rpar5 a_2435_6486.t0 a_2435_6486.t17 44.7432
Rpar6 a_2435_6486.t16 a_2435_6486.t17 6.4817
Rpar7 ib ib.t0 14.3089
Rpar8 ib ib.t1 2.7792
Rpar9 ib.t0 ib.t1 17.4554
Rpar10 inn inn.t0 2.8181
Rpar11 inp inp.t0 2.8181
Rpar12 out out.t108 2.5859
Rpar13 out.t0 out.t108 101.6383
Rpar14 out.t0 out.t238 73.1792
Rpar15 out.t108 out.t238 96.6092
Rpar16 vdd vdd.t0 108.1256
Rpar17 vdd vdd.t47 85.9352
Rpar18 vdd.t0 vdd.t1 11.2401
Rpar19 vdd.t0 vdd.t47 11.7241
Rpar20 vdd.t1 vdd.t47 1825.7695
Rpar21 vss vss.t0 495.6545
Rpar22 vss vss.t8 169.7455
Rpar23 vss vss.t3 65.5852
Rpar24 vss vss.t4 4241.0826
Rpar25 vss vss.t7 1361.3794
Rpar26 vss.t0 vss.t8 423.0631
Rpar27 vss.t0 vss.t3 53.7437
Rpar28 vss.t0 vss.t4 3475.6279
Rpar29 vss.t0 vss.t7 2814.8158
Rpar30 vss.t8 vss.t3 52.8204
Rpar31 vss.t8 vss.t7 11.3395
Rpar32 vss.t3 vss.t4 8.9985
Rpar33 vss.t3 vss.t7 32.5647
Rpar34 vss.t4 vss.t7 1748.4416
Cpar0 a_2186_16579.t0 vss 9.26301e-13
Cpar1 a_2186_16579.t320 vss 1.55910e-13
Cpar2 a_2382_16579.t0 vss 3.71815e-13
Cpar3 a_2382_16579.t160 vss 9.20144e-14
Cpar4 a_2382_16579.t161 vss 5.75087e-14
Cpar5 a_2435_6486.t0 vss 1.67163e-14
Cpar6 a_2435_6486.t16 vss 8.92497e-14
Cpar7 a_2435_6486.t17 vss 3.99043e-14
Cpar8 ib vss 4.64082e-14
Cpar9 ib.t0 vss 5.50597e-15
Cpar10 ib.t1 vss 3.25074e-15
Cpar11 inn inp 1.07080e-16
Cpar12 inn out 4.74774e-14
Cpar13 inn vdd 5.21655e-14
Cpar14 inn vss 2.18900e-14
Cpar15 inn.t0 vss 1.20825e-13
Cpar16 inp vdd 5.18189e-14
Cpar17 inp vss 2.18372e-14
Cpar18 inp.t0 vss 1.20661e-13
Cpar19 out vdd 2.13942e-14
Cpar20 out vss 8.66618e-14
Cpar21 out.t0 vss 2.29665e-13
Cpar22 out.t108 vss 3.24109e-14
Cpar23 out.t238 vss 2.60286e-13
Cpar24 vdd vss 1.00498e-12
Cpar25 vdd.t0 vss 8.62709e-14
Cpar26 vdd.t1 vss 2.73291e-14
Cpar27 vdd.t47 vss 2.40514e-13
.ends opamp_dut

Vdd vdd 0 1.800000
Vss vss 0 0
Ibias vdd ib 7.000000e-05
Vinp inp 0 DC 0.805000 AC 1 PWL(0 0.805000 3.000000e-09 0.805000 3.300000e-09 0.815000)
Rfb out inn 1m
Cload out 0 2.000000e-13
Xdut vdd vss inp inn out ib opamp_dut
.end
