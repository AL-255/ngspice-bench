* opa1000[0735]: 2p/rail_to_rail_3v3_i1u_weak (rail_to_rail, VDD=3.3V, CL=2.0pF, Iref=0.125uA)
.include "pdk_opa.inc"
.temp 27
.option gmin=1e-12 rshunt=1e12 reltol=1e-3 abstol=1e-12 vntol=1e-5 method=gear
* Post-PEX R+C extracted netlist for rail_to_rail_3v3_i1u_weak
.subckt opamp_dut vdd vss inp inn out ib
XMpar0 a_6514_1294.t1 inn.t0 a_7452_4540.t4 vdd.t15 pfet_03v3 w=1.36u l=4u ad=8.1600e-13 pd=3.9200e-06 as=3.8080e-13 ps=1.9200e-06 nf=1 m=2 par=2
XMpar1 a_12416_2824.t4 ib.t0 vss.t2 vss.t1 nfet_03v3 w=0.4u l=4.38u ad=2.4000e-13 pd=2.0000e-06 as=1.1200e-13 ps=9.6000e-07 nf=1 m=2 par=2
XMpar2 a_6514_6364.t2 inp.t2 a_828_1290.t3 vss.t22 nfet_03v3 w=0.4u l=4u ad=2.4000e-13 pd=2.0000e-06 as=1.1200e-13 ps=9.6000e-07 nf=1 m=2 par=2
XMpar3 a_6514_6364.t2 inn.t2 a_7452_2779.t6 vss.t22 nfet_03v3 w=0.4u l=4u ad=2.4000e-13 pd=2.0000e-06 as=1.1200e-13 ps=9.6000e-07 nf=1 m=2 par=2
XMpar4 out.t10 a_828_1290.t7 vdd.t1 vdd.t0 pfet_03v3 w=1.35u l=2.7u ad=4.8600e-13 pd=2.4075e-06 as=5.9400e-13 ps=2.9050e-06 nf=1 m=8 par=8
XMpar5 out.t1 ib.t0 vss.t2 vss.t1 nfet_03v3 w=0.4u l=4.38u ad=1.1200e-13 pd=9.6000e-07 as=2.0800e-13 ps=1.7400e-06 nf=1 m=8 par=8
XMpar6 a_6514_6364.t0 ib.t0 vss.t2 vss.t1 nfet_03v3 w=0.4u l=4.38u ad=2.4000e-13 pd=2.0000e-06 as=1.1200e-13 ps=9.6000e-07 nf=1 m=2 par=2
XMpar7 a_7452_2779.t0 a_7332_7819.t2 vss.t18 vss.t17 nfet_03v3 w=0.4u l=2.7u ad=1.1200e-13 pd=9.6000e-07 as=1.1200e-13 ps=9.6000e-07 nf=1 m=2 par=2
XMpar8 a_6514_1294.t1 inp.t0 a_7332_7819.t0 vdd.t15 pfet_03v3 w=1.36u l=4u ad=8.1600e-13 pd=3.9200e-06 as=3.8080e-13 ps=1.9200e-06 nf=1 m=2 par=2
XMpar9 ib.t1 ib.t0 vss.t2 vss.t1 nfet_03v3 w=0.4u l=4.38u ad=2.4000e-13 pd=2.0000e-06 as=1.1200e-13 ps=9.6000e-07 nf=1 m=2 par=2
XMpar10 a_7452_2779.t3 a_7452_2779.t2 vdd.t1 vdd.t0 pfet_03v3 w=1.35u l=2.7u ad=3.7800e-13 pd=1.9100e-06 as=3.7800e-13 ps=1.9100e-06 nf=1 m=2 par=2
XMpar11 a_7332_7819.t3 a_7332_7819.t2 vss.t18 vss.t17 nfet_03v3 w=0.4u l=2.7u ad=2.4000e-13 pd=2.0000e-06 as=1.1200e-13 ps=9.6000e-07 nf=1 m=2 par=2
XMpar12 a_7452_4540.t1 a_7452_4540.t0 vss.t18 vss.t17 nfet_03v3 w=0.4u l=2.7u ad=1.1200e-13 pd=9.6000e-07 as=1.1200e-13 ps=9.6000e-07 nf=1 m=2 par=2
XMpar13 a_828_1290.t5 a_7452_2779.t2 vdd.t1 vdd.t0 pfet_03v3 w=1.35u l=2.7u ad=8.1000e-13 pd=3.9000e-06 as=3.7800e-13 ps=1.9100e-06 nf=1 m=2 par=2
XMpar14 a_12416_2824.t1 a_12416_2824.t0 vdd.t5 vdd.t4 pfet_03v3 w=1.09u l=4.38u ad=6.5400e-13 pd=3.3800e-06 as=3.0520e-13 ps=1.6500e-06 nf=1 m=2 par=2
XMpar15 a_828_1290.t0 a_7452_4540.t0 vss.t18 vss.t17 nfet_03v3 w=0.4u l=2.7u ad=2.4000e-13 pd=2.0000e-06 as=1.1200e-13 ps=9.6000e-07 nf=1 m=2 par=2
XMpar16 a_6514_1294.t0 a_12416_2824.t0 vdd.t5 vdd.t4 pfet_03v3 w=1.09u l=4.38u ad=6.5400e-13 pd=3.3800e-06 as=3.0520e-13 ps=1.6500e-06 nf=1 m=2 par=2
X2 a_828_3890.t0 a_4806_3370.t0 vss.t0 ppolyf_u_1k r_width=1u r_length=19.23u
X9 a_828_5970.t0 a_4806_6490.t0 vss.t0 ppolyf_u_1k r_width=1u r_length=19.23u
X10 a_828_2850.t0 a_4806_3370.t0 vss.t0 ppolyf_u_1k r_width=1u r_length=19.23u
X12 a_828_5970.t0 a_4806_5450.t0 vss.t0 ppolyf_u_1k r_width=1u r_length=19.23u
X17 a_828_2850.t0 a_4806_2330.t0 vss.t0 ppolyf_u_1k r_width=1u r_length=19.23u
X24 a_828_4930.t0 a_4806_5450.t0 vss.t0 ppolyf_u_1k r_width=1u r_length=19.23u
X28 a_828_1810.t0 a_4806_2330.t0 vss.t0 ppolyf_u_1k r_width=1u r_length=19.23u
X32 a_828_4930.t0 a_4806_4410.t0 vss.t0 ppolyf_u_1k r_width=1u r_length=19.23u
X33 a_828_1810.t0 a_4806_1290.t0 vss.t0 ppolyf_u_1k r_width=1u r_length=19.23u
X38 a_4806_7530.t1 out.t0 cap_mim_2f0fF c_width=15.62u c_length=15.61u
X40 a_828_7010.t0 a_4806_7530.t0 vss.t0 ppolyf_u_1k r_width=1u r_length=19.23u
X45 a_828_3890.t0 a_4806_4410.t0 vss.t0 ppolyf_u_1k r_width=1u r_length=19.23u
X49 a_828_7010.t0 a_4806_6490.t0 vss.t0 ppolyf_u_1k r_width=1u r_length=19.23u
X55 a_4806_7530.t1 out.t0 cap_mim_2f0fF c_width=15.62u c_length=15.61u
X59 a_828_1290.t2 a_4806_1290.t0 vss.t0 ppolyf_u_1k r_width=1u r_length=19.23u
Rpar0 a_12416_2824.t0 a_12416_2824.t1 14.6609
Rpar1 a_12416_2824.t0 a_12416_2824.t4 121.9857
Rpar2 a_12416_2824.t1 a_12416_2824.t4 95.5694
Rpar3 a_4806_7530.t0 a_4806_7530.t1 68.3381
Rpar4 a_6514_1294.t0 a_6514_1294.t1 60.7176
Rpar5 a_6514_6364.t0 a_6514_6364.t2 57.4975
Rpar6 a_7332_7819.t0 a_7332_7819.t2 165.1053
Rpar7 a_7332_7819.t0 a_7332_7819.t3 120.9407
Rpar8 a_7332_7819.t2 a_7332_7819.t3 21.1403
Rpar9 a_7452_2779.t0 a_7452_2779.t2 390.1134
Rpar10 a_7452_2779.t0 a_7452_2779.t3 318.9435
Rpar11 a_7452_2779.t0 a_7452_2779.t6 73.4696
Rpar12 a_7452_2779.t2 a_7452_2779.t3 26.7837
Rpar13 a_7452_2779.t2 a_7452_2779.t6 266.3062
Rpar14 a_7452_2779.t3 a_7452_2779.t6 217.7230
Rpar15 a_7452_4540.t0 a_7452_4540.t1 29.2774
Rpar16 a_7452_4540.t0 a_7452_4540.t4 136.6279
Rpar17 a_7452_4540.t1 a_7452_4540.t4 142.1053
Rpar18 a_828_1290.t0 a_828_1290.t7 212.4867
Rpar19 a_828_1290.t0 a_828_1290.t2 171.2357
Rpar20 a_828_1290.t0 a_828_1290.t3 151.3097
Rpar21 a_828_1290.t0 a_828_1290.t5 108.9972
Rpar22 a_828_1290.t7 a_828_1290.t2 372.8964
Rpar23 a_828_1290.t7 a_828_1290.t3 93.6855
Rpar24 a_828_1290.t7 a_828_1290.t5 237.3609
Rpar25 a_828_1290.t2 a_828_1290.t3 265.5358
Rpar26 a_828_1290.t2 a_828_1290.t5 89.4788
Rpar27 a_828_1290.t3 a_828_1290.t5 169.0223
Rpar28 ib ib.t0 14.8040
Rpar29 ib ib.t1 16.2598
Rpar30 ib.t0 ib.t1 29.6017
Rpar31 inn inn.t0 55.5980
Rpar32 inn inn.t2 3.2967
Rpar33 inp inp.t0 45.5126
Rpar34 inp inp.t2 3.3453
Rpar35 out out.t0 668.3522
Rpar36 out out.t1 281.5011
Rpar37 out out.t10 6.1396
Rpar38 out.t0 out.t1 82.0214
Rpar39 out.t0 out.t10 208.8913
Rpar40 out.t1 out.t10 87.9823
Rpar41 vdd vdd.t0 225.9047
Rpar42 vdd vdd.t1 78.2914
Rpar43 vdd vdd.t15 275.7765
Rpar44 vdd vdd.t5 1634.0636
Rpar45 vdd vdd.t4 3254.1460
Rpar46 vdd.t0 vdd.t1 5.6739
Rpar47 vdd.t0 vdd.t15 63.2139
Rpar48 vdd.t0 vdd.t5 374.5622
Rpar49 vdd.t0 vdd.t4 745.9196
Rpar50 vdd.t1 vdd.t15 99.1755
Rpar51 vdd.t1 vdd.t5 587.6466
Rpar52 vdd.t1 vdd.t4 1170.2652
Rpar53 vdd.t15 vdd.t5 84.0393
Rpar54 vdd.t15 vdd.t4 167.3596
Rpar55 vdd.t5 vdd.t4 20.3361
Rpar56 vss vss.t0 73.0963
Rpar57 vss vss.t1 6501.5703
Rpar58 vss vss.t2 729.9208
Rpar59 vss vss.t17 734.1210
Rpar60 vss vss.t18 122.1850
Rpar61 vss vss.t22 1337.4221
Rpar62 vss.t0 vss.t1 451.5128
Rpar63 vss.t0 vss.t2 62.4868
Rpar64 vss.t0 vss.t17 19.2298
Rpar65 vss.t0 vss.t18 9.0182
Rpar66 vss.t0 vss.t22 25.5523
Rpar67 vss.t1 vss.t2 38.2228
Rpar68 vss.t1 vss.t17 4615.7736
Rpar69 vss.t1 vss.t18 1498.1634
Rpar70 vss.t1 vss.t22 5624.3807
Rpar71 vss.t2 vss.t17 1326.5115
Rpar72 vss.t2 vss.t18 364.0122
Rpar73 vss.t2 vss.t22 1412.8544
Rpar74 vss.t17 vss.t18 80.7243
Rpar75 vss.t17 vss.t22 530.5321
Rpar76 vss.t18 vss.t22 91.8381
Cpar0 a_12416_2824.t0 vss 1.17847e-14
Cpar1 a_12416_2824.t1 vss 4.76626e-15
Cpar2 a_12416_2824.t4 vss 9.59002e-15
Cpar3 a_4806_1290.t0 vss 3.71400e-17
Cpar4 a_4806_2330.t0 vss 3.95400e-17
Cpar5 a_4806_3370.t0 vss 3.98400e-17
Cpar6 a_4806_4410.t0 vss 3.76800e-17
Cpar7 a_4806_5450.t0 vss 3.85600e-17
Cpar8 a_4806_6490.t0 vss 4.24000e-17
Cpar9 a_4806_7530.t0 vss 1.57816e-16
Cpar10 a_4806_7530.t1 vss 5.69096e-15
Cpar11 a_6514_1294.t0 vss 8.62864e-15
Cpar12 a_6514_1294.t1 vss 7.14401e-15
Cpar13 a_6514_6364.t0 vss 1.28093e-14
Cpar14 a_6514_6364.t2 vss 7.48721e-15
Cpar15 a_7332_7819.t0 vss 1.87575e-15
Cpar16 a_7332_7819.t2 vss 3.91083e-15
Cpar17 a_7332_7819.t3 vss 1.82776e-15
Cpar18 a_7452_2779.t0 vss 2.50552e-15
Cpar19 a_7452_2779.t2 vss 7.79092e-15
Cpar20 a_7452_2779.t3 vss 2.26821e-15
Cpar21 a_7452_2779.t6 vss 2.56114e-15
Cpar22 a_7452_4540.t0 vss 5.02456e-15
Cpar23 a_7452_4540.t1 vss 1.43138e-15
Cpar24 a_7452_4540.t4 vss 2.10284e-15
Cpar25 a_828_1290.t0 vss 3.09593e-15
Cpar26 a_828_1290.t2 vss 3.23504e-15
Cpar27 a_828_1290.t3 vss 2.47182e-15
Cpar28 a_828_1290.t5 vss 3.62441e-15
Cpar29 a_828_1290.t7 vss 1.63220e-14
Cpar30 a_828_1810.t0 vss 3.20200e-17
Cpar31 a_828_2850.t0 vss 2.93600e-17
Cpar32 a_828_3890.t0 vss 2.93600e-17
Cpar33 a_828_4930.t0 vss 2.93600e-17
Cpar34 a_828_5970.t0 vss 3.00800e-17
Cpar35 a_828_7010.t0 vss 2.66000e-17
Cpar36 ib out 1.87518e-15
Cpar37 ib vdd 2.97600e-17
Cpar38 ib vss 4.04944e-14
Cpar39 ib.t0 vss 1.31681e-14
Cpar40 ib.t1 vss 1.08513e-15
Cpar41 inn inp 1.03940e-16
Cpar42 inn vdd 4.67587e-15
Cpar43 inn vss 8.90811e-15
Cpar44 inn.t0 vss 4.88811e-15
Cpar45 inn.t2 vss 1.22575e-15
Cpar46 inp vdd 4.53089e-15
Cpar47 inp vss 9.59756e-15
Cpar48 inp.t0 vss 4.21640e-15
Cpar49 inp.t2 vss 1.16869e-15
Cpar50 out vdd 1.35435e-14
Cpar51 out vss 2.05637e-14
Cpar52 out.t0 vss 1.70982e-14
Cpar53 out.t1 vss 6.65080e-15
Cpar54 out.t10 vss 3.24215e-15
Cpar55 vdd vss 1.27955e-13
Cpar56 vdd.t0 vss 3.02386e-14
Cpar57 vdd.t1 vss 6.85959e-15
Cpar58 vdd.t15 vss 1.25462e-14
Cpar59 vdd.t4 vss 1.54771e-14
Cpar60 vdd.t5 vss 4.11664e-15
.ends opamp_dut

Vdd vdd 0 3.300000
Vss vss 0 0
Ibias vdd ib 1.250000e-07
Vinp inp 0 DC 1.645000 AC 1 PWL(0 1.645000 3.151537e-07 1.645000 3.466691e-07 1.655000)
Rfb out inn 1m
Cload out 0 2.000000e-12
Xdut vdd vss inp inn out ib opamp_dut
.end
