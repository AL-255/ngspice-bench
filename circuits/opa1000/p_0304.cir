* opa1000[0304]: 2p/folded_cascode_pmos_1v8_i10u_subth (folded_cascode_pmos, VDD=1.8V, CL=2.0pF, Iref=2.5556uA)
.include "pdk_opa.inc"
.temp 27
.option gmin=1e-12 rshunt=1e12 reltol=1e-3 abstol=1e-12 vntol=1e-5 method=gear
* Post-PEX R+C extracted netlist for folded_cascode_pmos_1v8_i10u_subth
.subckt opamp_dut vdd vss inp inn out ib
XMpar0 a_1754_1249.t1 inp.t0 a_2054_1249.t1 vdd.t4 pfet_03v3 w=8u l=0.9u ad=2.4000e-12 pd=9.1000e-06 as=2.3200e-12 ps=8.8300e-06 nf=1 m=64 par=64
XMpar1 a_1754_1249.t1 inn.t0 a_8494_15473.t14 vdd.t4 pfet_03v3 w=8u l=0.9u ad=2.4000e-12 pd=9.1000e-06 as=2.3200e-12 ps=8.8300e-06 nf=1 m=64 par=64
XMpar2 a_8494_15473.t0 a_2370_11893.t6 out.t0 vss.t0 nfet_03v3 w=2.02u l=0.94u ad=6.9488e-13 pd=3.1120e-06 as=5.6560e-13 ps=2.5800e-06 nf=1 m=10 par=10
XMpar3 a_5486_15473.t5 a_5486_15473.t4 vdd.t1 vdd.t0 pfet_03v3 w=10u l=2.7u ad=6.0000e-12 pd=2.1200e-05 as=2.8000e-12 ps=1.0560e-05 nf=1 m=2 par=2
XMpar4 a_2054_1249.t0 a_2370_11893.t6 a_5486_15473.t0 vss.t0 nfet_03v3 w=2.02u l=0.94u ad=6.9488e-13 pd=3.1120e-06 as=5.6560e-13 ps=2.5800e-06 nf=1 m=10 par=10
XMpar5 a_1754_1249.t0 a_2370_11893.t2 vdd.t1 vdd.t0 pfet_03v3 w=10u l=2.7u ad=2.8000e-12 pd=1.0560e-05 as=4.4000e-12 ps=1.5880e-05 nf=1 m=4 par=4
XMpar6 out.t1 a_5486_15473.t4 vdd.t1 vdd.t0 pfet_03v3 w=10u l=2.7u ad=2.8000e-12 pd=1.0560e-05 as=2.8000e-12 ps=1.0560e-05 nf=1 m=2 par=2
XMpar7 a_2054_1249.t68 ib.t0 vss.t9 vss.t8 nfet_03v3 w=7.96u l=2.25u ad=2.2288e-12 pd=8.5200e-06 as=3.5024e-12 ps=1.2820e-05 nf=1 m=4 par=4
XMpar8 a_2370_11893.t0 ib.t0 vss.t9 vss.t8 nfet_03v3 w=7.96u l=2.25u ad=2.2288e-12 pd=8.5200e-06 as=2.2288e-12 ps=8.5200e-06 nf=1 m=2 par=2
XMpar9 a_8494_15473.t3 ib.t0 vss.t9 vss.t8 nfet_03v3 w=7.96u l=2.25u ad=2.2288e-12 pd=8.5200e-06 as=3.5024e-12 ps=1.2820e-05 nf=1 m=4 par=4
XMpar10 ib.t1 ib.t0 vss.t9 vss.t8 nfet_03v3 w=7.96u l=2.25u ad=4.7760e-12 pd=1.7120e-05 as=2.2288e-12 ps=8.5200e-06 nf=1 m=2 par=2
XMpar11 a_2370_11893.t3 a_2370_11893.t2 vdd.t1 vdd.t0 pfet_03v3 w=10u l=2.7u ad=2.8000e-12 pd=1.0560e-05 as=2.8000e-12 ps=1.0560e-05 nf=1 m=2 par=2
X143 out.t12 vss.t4 cap_mim_2f0fF c_width=15u c_length=15u
Rpar0 a_1754_1249.t0 a_1754_1249.t1 61.0537
Rpar1 a_2054_1249.t0 a_2054_1249.t1 93.2564
Rpar2 a_2054_1249.t0 a_2054_1249.t68 70.7450
Rpar3 a_2054_1249.t1 a_2054_1249.t68 58.6850
Rpar4 a_2370_11893.t0 a_2370_11893.t6 64.0962
Rpar5 a_2370_11893.t0 a_2370_11893.t2 868.1690
Rpar6 a_2370_11893.t0 a_2370_11893.t3 469.5663
Rpar7 a_2370_11893.t6 a_2370_11893.t2 511.8281
Rpar8 a_2370_11893.t6 a_2370_11893.t3 276.8323
Rpar9 a_2370_11893.t2 a_2370_11893.t3 24.1543
Rpar10 a_5486_15473.t0 a_5486_15473.t4 720.1351
Rpar11 a_5486_15473.t0 a_5486_15473.t5 155.1222
Rpar12 a_5486_15473.t4 a_5486_15473.t5 20.3228
Rpar13 a_8494_15473.t0 a_8494_15473.t14 93.2564
Rpar14 a_8494_15473.t0 a_8494_15473.t3 70.7450
Rpar15 a_8494_15473.t14 a_8494_15473.t3 58.6850
Rpar16 ib ib.t0 2.8084
Rpar17 ib ib.t1 63.7874
Rpar18 ib.t0 ib.t1 20.6483
Rpar19 inn inn.t0 2.2184
Rpar20 inp inp.t0 2.2184
Rpar21 out out.t0 470.7696
Rpar22 out out.t1 7.3247
Rpar23 out out.t12 171.9700
Rpar24 out.t0 out.t1 2293.2802
Rpar25 out.t0 out.t12 113.7252
Rpar26 out.t1 out.t12 837.7247
Rpar27 vdd vdd.t0 24.8431
Rpar28 vdd vdd.t1 103.2750
Rpar29 vdd vdd.t4 243.6047
Rpar30 vdd.t0 vdd.t1 3.7813
Rpar31 vdd.t0 vdd.t4 77.9643
Rpar32 vdd.t1 vdd.t4 247.8373
Rpar33 vss vss.t0 298.5476
Rpar34 vss vss.t8 492.3052
Rpar35 vss vss.t9 157.5459
Rpar36 vss vss.t4 706.5523
Rpar37 vss.t0 vss.t8 1.5075
Rpar38 vss.t0 vss.t9 6.0969
Rpar39 vss.t0 vss.t4 121.6662
Rpar40 vss.t8 vss.t9 6.9618
Rpar41 vss.t8 vss.t4 151.4740
Rpar42 vss.t9 vss.t4 147.5435
Cpar0 a_1754_1249.t0 vss 1.19644e-14
Cpar1 a_1754_1249.t1 vss 1.71898e-13
Cpar2 a_2054_1249.t0 vss 7.35816e-15
Cpar3 a_2054_1249.t1 vss 8.98572e-14
Cpar4 a_2054_1249.t68 vss 8.16044e-15
Cpar5 a_2370_11893.t0 vss 3.57935e-15
Cpar6 a_2370_11893.t2 vss 2.02472e-14
Cpar7 a_2370_11893.t3 vss 5.60903e-15
Cpar8 a_2370_11893.t6 vss 1.09433e-14
Cpar9 a_5486_15473.t0 vss 5.80606e-15
Cpar10 a_5486_15473.t4 vss 1.26989e-14
Cpar11 a_5486_15473.t5 vss 7.99413e-15
Cpar12 a_8494_15473.t0 vss 7.29337e-15
Cpar13 a_8494_15473.t14 vss 8.90661e-14
Cpar14 a_8494_15473.t3 vss 8.08855e-15
Cpar15 ib inn 1.22700e-17
Cpar16 ib inp 1.39000e-17
Cpar17 ib out 5.71200e-16
Cpar18 ib vdd 3.17130e-16
Cpar19 ib vss 3.05030e-14
Cpar20 ib.t0 vss 5.65512e-15
Cpar21 ib.t1 vss 1.26843e-15
Cpar22 inn inp 9.65700e-17
Cpar23 inn vdd 3.27726e-14
Cpar24 inn vss 1.09327e-14
Cpar25 inn.t0 vss 6.70007e-14
Cpar26 inp vdd 3.26945e-14
Cpar27 inp vss 1.10695e-14
Cpar28 inp.t0 vss 6.69382e-14
Cpar29 out vdd 7.46797e-15
Cpar30 out vss 1.86126e-14
Cpar31 out.t0 vss 2.36735e-15
Cpar32 out.t1 vss 9.39139e-16
Cpar33 out.t12 vss 2.05951e-14
Cpar34 vdd vss 4.46936e-13
Cpar35 vdd.t0 vss 2.28732e-14
Cpar36 vdd.t1 vss 9.06160e-15
Cpar37 vdd.t4 vss 1.02577e-13
.ends opamp_dut

Vdd vdd 0 1.800000
Vss vss 0 0
Ibias vdd ib 2.555600e-06
Vinp inp 0 DC 0.751000 AC 1 PWL(0 0.751000 2.614821e-08 0.751000 2.876304e-08 0.761000)
Rfb out inn 1m
Cload out 0 2.000000e-12
Xdut vdd vss inp inn out ib opamp_dut
.end
