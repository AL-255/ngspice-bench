* opa1000[0954]: 200f/telescopic_pmos_3v3_10u_100u_subth (telescopic_pmos, VDD=3.3V, CL=0.2pF, Iref=8.5uA)
.include "pdk_opa.inc"
.temp 27
.option gmin=1e-12 rshunt=1e12 reltol=1e-3 abstol=1e-12 vntol=1e-5 method=gear
* Post-PEX R+C extracted netlist for telescopic_pmos_3v3_10u_100u_subth
.subckt opamp_dut vdd vss inp inn out ib
XMpar0 a_7968_1205.t5 a_5767_11550.t172 vss.t7 vss.t0 nfet_03v3 w=1.8u l=1u ad=5.8629e-13 pd=2.7086e-06 as=5.0400e-13 ps=2.3600e-06 nf=1 m=14 par=14
XMpar1 a_5767_11550.t33 a_5767_11550.t32 a_7968_1205.t0 vss.t0 nfet_03v3 w=2.02u l=0.28u ad=9.2736e-13 pd=3.1218e-06 as=1.1624e-12 ps=4.0891e-06 nf=1 m=22 par=22
XMpar2 a_5617_11758.t64 a_5767_11550.t0 a_5767_11550.t1 vdd.t0 pfet_03v3 w=2.56u l=0.28u ad=1.3568e-12 pd=4.4200e-06 as=1.2800e-12 ps=4.1200e-06 nf=1 m=64 par=64
XMpar3 a_1400_8870.t0 inp.t0 a_5617_11758.t0 vdd.t8 pfet_03v3 w=8u l=0.45u ad=2.4000e-12 pd=9.1000e-06 as=2.2400e-12 ps=8.5600e-06 nf=1 m=64 par=64
XMpar4 a_1400_8870.t0 inn.t0 a_6350_11758.t0 vdd.t8 pfet_03v3 w=8u l=0.45u ad=2.4000e-12 pd=9.1000e-06 as=2.2400e-12 ps=8.5600e-06 nf=1 m=64 par=64
XMpar5 a_6350_11758.t64 a_5767_11550.t0 out.t0 vdd.t0 pfet_03v3 w=2.56u l=0.28u ad=1.3568e-12 pd=4.4200e-06 as=1.3056e-12 ps=4.2200e-06 nf=1 m=64 par=64
XMpar6 a_8600_1205.t0 a_5767_11550.t172 vss.t7 vss.t0 nfet_03v3 w=1.8u l=1u ad=5.0400e-13 pd=2.3600e-06 as=5.0400e-13 ps=2.3600e-06 nf=1 m=14 par=14
XMpar7 a_1280_8662.t3 a_1280_8662.t2 vdd.t4 vdd.t3 pfet_03v3 w=10u l=0.6u ad=2.8000e-12 pd=1.0560e-05 as=2.8000e-12 ps=1.0560e-05 nf=1 m=2 par=2
XMpar8 a_1280_8662.t0 ib.t0 vss.t36 vss.t35 nfet_03v3 w=5.74u l=0.6u ad=1.6072e-12 pd=6.3000e-06 as=1.6072e-12 ps=6.3000e-06 nf=1 m=2 par=2
XMpar9 a_8600_1205.t6 a_5767_11550.t32 out.t62 vss.t0 nfet_03v3 w=2.02u l=0.28u ad=1.1037e-12 pd=3.8473e-06 as=9.2736e-13 ps=3.1218e-06 nf=1 m=22 par=22
XMpar10 ib.t1 ib.t0 vss.t36 vss.t35 nfet_03v3 w=5.74u l=0.6u ad=3.4440e-12 pd=1.2680e-05 as=1.6072e-12 ps=6.3000e-06 nf=1 m=2 par=2
XMpar11 a_1400_8870.t128 a_1280_8662.t2 vdd.t4 vdd.t3 pfet_03v3 w=10u l=0.6u ad=2.8000e-12 pd=1.0560e-05 as=3.6000e-12 ps=1.3220e-05 nf=1 m=8 par=8
X121 out.t86 vss.t2 cap_mim_2f0fF c_width=16.2u c_length=16.21u
X274 out.t86 vss.t2 cap_mim_2f0fF c_width=16.2u c_length=16.21u
Rpar0 a_1280_8662.t0 a_1280_8662.t2 211.3292
Rpar1 a_1280_8662.t0 a_1280_8662.t3 78.0391
Rpar2 a_1280_8662.t2 a_1280_8662.t3 30.1669
Rpar3 a_1400_8870.t0 a_1400_8870.t128 48.8781
Rpar4 a_5617_11758.t0 a_5617_11758.t64 69.5100
Rpar5 a_5767_11550.t0 a_5767_11550.t1 5.7019
Rpar6 a_5767_11550.t0 a_5767_11550.t172 1034.8411
Rpar7 a_5767_11550.t0 a_5767_11550.t33 704.8111
Rpar8 a_5767_11550.t1 a_5767_11550.t172 217.6753
Rpar9 a_5767_11550.t1 a_5767_11550.t32 656.1907
Rpar10 a_5767_11550.t1 a_5767_11550.t33 148.2546
Rpar11 a_5767_11550.t172 a_5767_11550.t32 308.3356
Rpar12 a_5767_11550.t172 a_5767_11550.t33 69.6629
Rpar13 a_5767_11550.t32 a_5767_11550.t33 6.3293
Rpar14 a_6350_11758.t0 a_6350_11758.t64 36.9601
Rpar15 a_7968_1205.t0 a_7968_1205.t5 55.5800
Rpar16 a_8600_1205.t0 a_8600_1205.t6 47.3193
Rpar17 ib ib.t0 30.3298
Rpar18 ib ib.t1 3.3671
Rpar19 ib.t0 ib.t1 227.0291
Rpar20 inn inn.t0 2.8414
Rpar21 inp inp.t0 2.8414
Rpar22 out out.t0 64.9647
Rpar23 out out.t62 108.8047
Rpar24 out out.t86 18.0904
Rpar25 out.t0 out.t62 102.0136
Rpar26 out.t0 out.t86 296.0842
Rpar27 out.t62 out.t86 495.8904
Rpar28 vdd vdd.t0 105.1471
Rpar29 vdd vdd.t8 45.0739
Rpar30 vdd vdd.t3 398.4542
Rpar31 vdd vdd.t4 1301.8374
Rpar32 vdd.t0 vdd.t8 128.6105
Rpar33 vdd.t0 vdd.t3 126.0715
Rpar34 vdd.t0 vdd.t4 411.9033
Rpar35 vdd.t8 vdd.t3 487.3686
Rpar36 vdd.t8 vdd.t4 1592.3403
Rpar37 vdd.t3 vdd.t4 5.6538
Rpar38 vss vss.t0 120.4898
Rpar39 vss vss.t7 3094.5008
Rpar40 vss vss.t2 287.0853
Rpar41 vss vss.t35 89.4439
Rpar42 vss vss.t36 132.7095
Rpar43 vss.t0 vss.t7 3.5353
Rpar44 vss.t0 vss.t2 54.6533
Rpar45 vss.t0 vss.t35 252.6496
Rpar46 vss.t0 vss.t36 374.8560
Rpar47 vss.t7 vss.t2 1412.4892
Rpar48 vss.t2 vss.t35 639.3150
Rpar49 vss.t2 vss.t36 948.5625
Rpar50 vss.t35 vss.t36 9.6423
Cpar0 a_1280_8662.t0 vss 3.06458e-15
Cpar1 a_1280_8662.t2 vss 8.95807e-15
Cpar2 a_1280_8662.t3 vss 4.96860e-15
Cpar3 a_1400_8870.t0 vss 2.17227e-13
Cpar4 a_1400_8870.t128 vss 1.96243e-14
Cpar5 a_5617_11758.t0 vss 1.18031e-13
Cpar6 a_5617_11758.t64 vss 8.15650e-14
Cpar7 a_5767_11550.t0 vss 5.81090e-14
Cpar8 a_5767_11550.t1 vss 7.09572e-14
Cpar9 a_5767_11550.t172 vss 2.68791e-14
Cpar10 a_5767_11550.t32 vss 1.86033e-14
Cpar11 a_5767_11550.t33 vss 2.67444e-14
Cpar12 a_6350_11758.t0 vss 1.17177e-13
Cpar13 a_6350_11758.t64 vss 8.36861e-14
Cpar14 a_7968_1205.t0 vss 2.18226e-14
Cpar15 a_7968_1205.t5 vss 7.63313e-15
Cpar16 a_8600_1205.t0 vss 9.47342e-15
Cpar17 a_8600_1205.t6 vss 2.58168e-14
Cpar18 ib vss 7.69125e-15
Cpar19 ib.t0 vss 3.71907e-16
Cpar20 ib.t1 vss 3.81878e-16
Cpar21 inn inp 1.03940e-16
Cpar22 inn out 1.21100e-17
Cpar23 inn vdd 2.38331e-14
Cpar24 inn vss 1.15262e-14
Cpar25 inn.t0 vss 3.92290e-14
Cpar26 inp out 1.29000e-17
Cpar27 inp vdd 2.41677e-14
Cpar28 inp vss 1.15933e-14
Cpar29 inp.t0 vss 3.94845e-14
Cpar30 out vdd 2.61760e-14
Cpar31 out vss 3.09936e-14
Cpar32 out.t0 vss 2.63955e-14
Cpar33 out.t62 vss 8.95583e-15
Cpar34 out.t86 vss 8.09719e-14
Cpar35 vdd vss 5.50640e-13
Cpar36 vdd.t0 vss 1.08736e-13
Cpar37 vdd.t3 vss 1.16655e-14
Cpar38 vdd.t4 vss 6.10980e-15
Cpar39 vdd.t8 vss 8.51139e-14
.ends opamp_dut

Vdd vdd 0 3.300000
Vss vss 0 0
Ibias vdd ib 8.500000e-06
Vinp inp 0 DC 1.480000 AC 1 PWL(0 1.480000 3.000000e-09 1.480000 3.300000e-09 1.490000)
Rfb out inn 1m
Cload out 0 2.000000e-13
Xdut vdd vss inp inn out ib opamp_dut
.end
