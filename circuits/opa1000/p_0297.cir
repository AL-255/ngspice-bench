* opa1000[0297]: 2p/folded_cascode_pmos_1v8_0p1u_1u_subth (folded_cascode_pmos, VDD=1.8V, CL=2.0pF, Iref=0.1278uA)
.include "pdk_opa.inc"
.temp 27
.option gmin=1e-12 rshunt=1e12 reltol=1e-3 abstol=1e-12 vntol=1e-5 method=gear
* Post-PEX R+C extracted netlist for folded_cascode_pmos_1v8_0p1u_1u_subth
.subckt opamp_dut vdd vss inp inn out ib
XMpar0 a_11854_1249.t0 inn.t0 a_1762_9353.t0 vdd.t2 pfet_03v3 w=6.37u l=3.2u ad=1.9110e-12 pd=7.3681e-06 as=1.9747e-12 ps=7.5872e-06 nf=1 m=64 par=64
XMpar1 a_1762_9353.t0 inp.t0 a_2522_9353.t0 vdd.t2 pfet_03v3 w=6.37u l=3.2u ad=1.9747e-12 pd=7.5872e-06 as=1.9110e-12 ps=7.3681e-06 nf=1 m=64 par=64
XMpar2 ib.t1 ib vss.t4 vss.t3 nfet_03v3 w=0.6u l=3.25u ad=3.6000e-13 pd=2.4000e-06 as=1.6800e-13 ps=1.1600e-06 nf=1 m=2 par=2
XMpar3 a_1232_2666.t0 ib vss.t4 vss.t3 nfet_03v3 w=0.6u l=3.25u ad=1.6800e-13 pd=1.1600e-06 as=1.6800e-13 ps=1.1600e-06 nf=1 m=2 par=2
XMpar4 a_11854_1249.t64 ib vss.t4 vss.t3 nfet_03v3 w=0.6u l=3.25u ad=1.6800e-13 pd=1.1600e-06 as=2.6400e-13 ps=1.7800e-06 nf=1 m=4 par=4
XMpar5 a_2522_9353.t64 ib vss.t4 vss.t3 nfet_03v3 w=0.6u l=3.25u ad=1.6800e-13 pd=1.1600e-06 as=2.6400e-13 ps=1.7800e-06 nf=1 m=4 par=4
XMpar6 a_11854_1249.t68 a_1232_2666.t6 out.t0 vss.t0 nfet_03v3 w=1.25u l=2u ad=7.5000e-13 pd=3.7000e-06 as=3.5000e-13 ps=1.8100e-06 nf=1 m=2 par=2
XMpar7 a_2522_9353.t68 a_1232_2666.t6 a_7712_5366.t4 vss.t0 nfet_03v3 w=1.25u l=2u ad=7.5000e-13 pd=3.7000e-06 as=3.5000e-13 ps=1.8100e-06 nf=1 m=2 par=2
XMpar8 a_7712_5366.t1 a_7712_5366.t0 vdd.t1 vdd.t0 pfet_03v3 w=4.78u l=9.75u ad=2.8680e-12 pd=1.0760e-05 as=1.3384e-12 ps=5.3400e-06 nf=1 m=2 par=2
XMpar9 a_1762_9353.t128 a_1232_2666.t2 vdd.t1 vdd.t0 pfet_03v3 w=4.78u l=9.75u ad=1.3384e-12 pd=5.3400e-06 as=2.1032e-12 ps=8.0500e-06 nf=1 m=4 par=4
XMpar10 a_1232_2666.t3 a_1232_2666.t2 vdd.t1 vdd.t0 pfet_03v3 w=4.78u l=9.75u ad=1.3384e-12 pd=5.3400e-06 as=1.3384e-12 ps=5.3400e-06 nf=1 m=2 par=2
XMpar11 out.t2 a_7712_5366.t0 vdd.t1 vdd.t0 pfet_03v3 w=4.78u l=9.75u ad=1.3384e-12 pd=5.3400e-06 as=1.3384e-12 ps=5.3400e-06 nf=1 m=2 par=2
Rpar0 a_11854_1249.t0 a_11854_1249.t64 71.2688
Rpar1 a_11854_1249.t0 a_11854_1249.t68 277.9110
Rpar2 a_11854_1249.t64 a_11854_1249.t68 107.3255
Rpar3 a_1232_2666.t0 a_1232_2666.t2 1160.6189
Rpar4 a_1232_2666.t0 a_1232_2666.t3 394.7829
Rpar5 a_1232_2666.t0 a_1232_2666.t6 65.7398
Rpar6 a_1232_2666.t2 a_1232_2666.t3 26.5332
Rpar7 a_1232_2666.t2 a_1232_2666.t6 327.4634
Rpar8 a_1232_2666.t3 a_1232_2666.t6 111.3862
Rpar9 a_1762_9353.t0 a_1762_9353.t128 45.9960
Rpar10 a_2522_9353.t0 a_2522_9353.t64 71.2688
Rpar11 a_2522_9353.t0 a_2522_9353.t68 277.9110
Rpar12 a_2522_9353.t64 a_2522_9353.t68 107.3255
Rpar13 a_7712_5366.t0 a_7712_5366.t1 17.6910
Rpar14 a_7712_5366.t0 a_7712_5366.t4 477.0740
Rpar15 a_7712_5366.t1 a_7712_5366.t4 159.6693
Rpar16 ib ib.t1 18.0826
Rpar17 inn inn.t0 1.4550
Rpar18 inp inp.t0 1.4550
Rpar19 out out.t0 66.1328
Rpar20 out out.t2 10.0218
Rpar21 vdd vdd.t0 361.8348
Rpar22 vdd vdd.t1 900.4644
Rpar23 vdd vdd.t2 19.9006
Rpar24 vdd.t0 vdd.t1 4.0921
Rpar25 vdd.t0 vdd.t2 125.8588
Rpar26 vdd.t1 vdd.t2 313.2131
Rpar27 vss vss.t0 69.9950
Rpar28 vss vss.t4 127.7068
Rpar29 vss vss.t3 66.9021
Rpar30 vss.t0 vss.t4 195.4638
Rpar31 vss.t0 vss.t3 136.3791
Rpar32 vss.t4 vss.t3 6.2841
Cpar0 a_11854_1249.t0 vss 9.36692e-14
Cpar1 a_11854_1249.t64 vss 9.45860e-15
Cpar2 a_11854_1249.t68 vss 6.81939e-15
Cpar3 a_1232_2666.t0 vss 1.69217e-15
Cpar4 a_1232_2666.t2 vss 4.15282e-14
Cpar5 a_1232_2666.t3 vss 4.60373e-15
Cpar6 a_1232_2666.t6 vss 5.01756e-15
Cpar7 a_1762_9353.t0 vss 1.76601e-13
Cpar8 a_1762_9353.t128 vss 1.03843e-14
Cpar9 a_2522_9353.t0 vss 9.52988e-14
Cpar10 a_2522_9353.t64 vss 9.62312e-15
Cpar11 a_2522_9353.t68 vss 6.93803e-15
Cpar12 a_7712_5366.t0 vss 2.59623e-14
Cpar13 a_7712_5366.t1 vss 6.86694e-15
Cpar14 a_7712_5366.t4 vss 3.63031e-15
Cpar15 ib inn 2.78420e-16
Cpar16 ib inp 2.64440e-16
Cpar17 ib out 1.00705e-15
Cpar18 ib vdd 1.66033e-15
Cpar19 ib vss 4.41288e-14
Cpar20 ib.t1 vss 2.31324e-15
Cpar21 inn inp 2.21580e-16
Cpar22 inn vdd 7.51714e-14
Cpar23 inn vss 9.46583e-15
Cpar24 inn.t0 vss 1.44686e-13
Cpar25 inp vdd 7.49027e-14
Cpar26 inp vss 9.49829e-15
Cpar27 inp.t0 vss 1.44458e-13
Cpar28 out vdd 5.77924e-15
Cpar29 out vss 1.10783e-14
Cpar30 out.t0 vss 3.11676e-15
Cpar31 out.t2 vss 3.01886e-15
Cpar32 vdd vss 8.69880e-13
Cpar33 vdd.t0 vss 4.19046e-14
Cpar34 vdd.t1 vss 1.83955e-14
Cpar35 vdd.t2 vss 2.14787e-13
.ends opamp_dut

Vdd vdd 0 1.800000
Vss vss 0 0
Ibias vdd ib 1.278000e-07
Vinp inp 0 DC 0.751000 AC 1 PWL(0 0.751000 3.928344e-07 0.751000 4.321178e-07 0.761000)
Rfb out inn 1m
Cload out 0 2.000000e-12
Xdut vdd vss inp inn out ib opamp_dut
.end
