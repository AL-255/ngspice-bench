* opa1000[0699]: 200f/rail_to_rail_3v3_i10u_subth (rail_to_rail, VDD=3.3V, CL=0.2pF, Iref=0.875uA)
.include "pdk_opa.inc"
.temp 27
.option gmin=1e-12 rshunt=1e12 reltol=1e-3 abstol=1e-12 vntol=1e-5 method=gear
* Post-PEX R+C extracted netlist for rail_to_rail_3v3_i10u_subth
.subckt opamp_dut vdd vss inp inn out ib
XMpar0 a_4018_1294.t1 inp.t0 a_4246_1294.t0 vdd.t8 pfet_03v3 w=1.93u l=0.54u ad=6.1760e-13 pd=2.8112e-06 as=5.4040e-13 ps=2.4900e-06 nf=1 m=32 par=32
XMpar1 a_4018_1294.t1 inn.t0 a_7156_13947.t4 vdd.t8 pfet_03v3 w=1.93u l=0.54u ad=6.1760e-13 pd=2.8112e-06 as=5.4040e-13 ps=2.4900e-06 nf=1 m=32 par=32
XMpar2 out.t3 a_1203_5887.t9 vdd.t1 vdd.t0 pfet_03v3 w=10u l=0.75u ad=2.8000e-12 pd=1.0560e-05 as=3.6000e-12 ps=1.3220e-05 nf=1 m=8 par=8
XMpar3 a_4246_1294.t33 a_4246_1294.t32 vss.t1 vss.t0 nfet_03v3 w=0.71u l=1.44u ad=4.2600e-13 pd=2.6200e-06 as=1.9880e-13 ps=1.2700e-06 nf=1 m=2 par=2
XMpar4 a_7432_5796.t8 a_4246_1294.t32 vss.t1 vss.t0 nfet_03v3 w=0.71u l=1.44u ad=1.9880e-13 pd=1.2700e-06 as=1.9880e-13 ps=1.2700e-06 nf=1 m=2 par=2
XMpar5 a_7156_13947.t1 a_7156_13947.t0 vss.t1 vss.t0 nfet_03v3 w=0.71u l=1.44u ad=1.9880e-13 pd=1.2700e-06 as=1.9880e-13 ps=1.2700e-06 nf=1 m=2 par=2
XMpar6 a_5793_9604.t3 a_5793_9604.t2 vdd.t7 vdd.t6 pfet_03v3 w=10u l=2.25u ad=2.8000e-12 pd=1.0560e-05 as=2.8000e-12 ps=1.0560e-05 nf=1 m=2 par=2
XMpar7 a_5793_9604.t0 ib.t0 vss.t21 vss.t20 nfet_03v3 w=2.72u l=2.25u ad=7.6160e-13 pd=3.2800e-06 as=7.6160e-13 ps=3.2800e-06 nf=1 m=2 par=2
XMpar8 out.t1 ib.t0 vss.t21 vss.t20 nfet_03v3 w=2.72u l=2.25u ad=7.6160e-13 pd=3.2800e-06 as=9.7920e-13 ps=4.1200e-06 nf=1 m=8 par=8
XMpar9 a_1203_5887.t0 a_7156_13947.t0 vss.t1 vss.t0 nfet_03v3 w=0.71u l=1.44u ad=4.2600e-13 pd=2.6200e-06 as=1.9880e-13 ps=1.2700e-06 nf=1 m=2 par=2
XMpar10 a_1203_5887.t2 a_7432_5796.t4 vdd.t1 vdd.t0 pfet_03v3 w=10u l=0.75u ad=6.0000e-12 pd=2.1200e-05 as=2.8000e-12 ps=1.0560e-05 nf=1 m=2 par=2
XMpar11 ib.t1 ib.t0 vss.t21 vss.t20 nfet_03v3 w=2.72u l=2.25u ad=1.6320e-12 pd=6.6400e-06 as=7.6160e-13 ps=3.2800e-06 nf=1 m=2 par=2
XMpar12 a_4018_1294.t0 a_5793_9604.t2 vdd.t7 vdd.t6 pfet_03v3 w=10u l=2.25u ad=6.0000e-12 pd=2.1200e-05 as=2.8000e-12 ps=1.0560e-05 nf=1 m=2 par=2
XMpar13 a_3269_9604.t0 inn.t32 a_7432_5796.t0 vss.t4 nfet_03v3 w=1.78u l=0.54u ad=7.8320e-13 pd=3.5500e-06 as=4.9840e-13 ps=2.3400e-06 nf=1 m=4 par=4
XMpar14 a_1203_5887.t4 inp.t32 a_3269_9604.t0 vss.t4 nfet_03v3 w=1.78u l=0.54u ad=4.9840e-13 pd=2.3400e-06 as=7.8320e-13 ps=3.5500e-06 nf=1 m=4 par=4
XMpar15 a_7432_5796.t5 a_7432_5796.t4 vdd.t1 vdd.t0 pfet_03v3 w=10u l=0.75u ad=2.8000e-12 pd=1.0560e-05 as=2.8000e-12 ps=1.0560e-05 nf=1 m=2 par=2
XMpar16 a_3269_9604.t4 ib.t0 vss.t21 vss.t20 nfet_03v3 w=2.72u l=2.25u ad=1.6320e-12 pd=6.6400e-06 as=7.6160e-13 ps=3.2800e-06 nf=1 m=2 par=2
X18 a_1266_12655.t0 a_3602_12135.t0 vss.t52 ppolyf_u_1k r_width=1u r_length=11.02u
X39 a_1203_5887.t8 a_3602_12135.t0 vss.t52 ppolyf_u_1k r_width=1u r_length=11.02u
X67 a_1266_12655.t1 out.t0 cap_mim_2f0fF c_width=15u c_length=15u
Rpar0 a_1203_5887.t0 a_1203_5887.t9 283.4418
Rpar1 a_1203_5887.t0 a_1203_5887.t2 915.3886
Rpar2 a_1203_5887.t0 a_1203_5887.t4 56.5883
Rpar3 a_1203_5887.t0 a_1203_5887.t8 216.9121
Rpar4 a_1203_5887.t9 a_1203_5887.t2 106.9096
Rpar5 a_1203_5887.t9 a_1203_5887.t4 146.1487
Rpar6 a_1203_5887.t9 a_1203_5887.t8 162.1711
Rpar7 a_1203_5887.t2 a_1203_5887.t4 471.9942
Rpar8 a_1203_5887.t2 a_1203_5887.t8 523.7393
Rpar9 a_1203_5887.t4 a_1203_5887.t8 111.8446
Rpar10 a_1266_12655.t0 a_1266_12655.t1 73.1290
Rpar11 a_3269_9604.t0 a_3269_9604.t4 48.0394
Rpar12 a_4018_1294.t0 a_4018_1294.t1 58.5451
Rpar13 a_4246_1294.t0 a_4246_1294.t32 105.3910
Rpar14 a_4246_1294.t0 a_4246_1294.t33 61.8175
Rpar15 a_4246_1294.t32 a_4246_1294.t33 21.9448
Rpar16 a_5793_9604.t0 a_5793_9604.t2 158.1538
Rpar17 a_5793_9604.t0 a_5793_9604.t3 66.9924
Rpar18 a_5793_9604.t2 a_5793_9604.t3 27.6871
Rpar19 a_7156_13947.t0 a_7156_13947.t1 28.6657
Rpar20 a_7156_13947.t0 a_7156_13947.t4 142.6405
Rpar21 a_7156_13947.t1 a_7156_13947.t4 133.8812
Rpar22 a_7432_5796.t0 a_7432_5796.t4 1121.9465
Rpar23 a_7432_5796.t0 a_7432_5796.t5 230.0072
Rpar24 a_7432_5796.t0 a_7432_5796.t8 167.6885
Rpar25 a_7432_5796.t4 a_7432_5796.t5 39.1636
Rpar26 a_7432_5796.t4 a_7432_5796.t8 416.2031
Rpar27 a_7432_5796.t5 a_7432_5796.t8 85.3247
Rpar28 ib ib.t0 11.9888
Rpar29 ib ib.t1 6.4319
Rpar30 inn inn.t0 67.6724
Rpar31 inn inn.t32 9.5176
Rpar32 inp inp.t0 67.6238
Rpar33 inp inp.t32 9.5662
Rpar34 out out.t0 197.0840
Rpar35 out out.t1 162.1897
Rpar36 out out.t3 1.8472
Rpar37 out.t0 out.t1 66.9410
Rpar38 out.t0 out.t3 381.7569
Rpar39 out.t1 out.t3 314.1656
Rpar40 vdd vdd.t0 87.7769
Rpar41 vdd vdd.t1 239.7737
Rpar42 vdd vdd.t8 218.9843
Rpar43 vdd vdd.t6 1026.7612
Rpar44 vdd vdd.t7 2205.1683
Rpar45 vdd.t0 vdd.t1 3.8281
Rpar46 vdd.t0 vdd.t8 59.1047
Rpar47 vdd.t0 vdd.t6 106.3959
Rpar48 vdd.t0 vdd.t7 228.5059
Rpar49 vdd.t1 vdd.t8 158.2701
Rpar50 vdd.t1 vdd.t6 280.1812
Rpar51 vdd.t1 vdd.t7 601.7434
Rpar52 vdd.t8 vdd.t6 446.4313
Rpar53 vdd.t8 vdd.t7 958.7975
Rpar54 vdd.t6 vdd.t7 9.7784
Rpar55 vss vss.t0 222.5750
Rpar56 vss vss.t1 253.2638
Rpar57 vss vss.t20 265.3054
Rpar58 vss vss.t21 721.3193
Rpar59 vss vss.t4 435.2216
Rpar60 vss vss.t52 2223.9496
Rpar61 vss.t0 vss.t1 13.9583
Rpar62 vss.t0 vss.t20 5.6440
Rpar63 vss.t0 vss.t21 24.5184
Rpar64 vss.t0 vss.t4 3.6075
Rpar65 vss.t0 vss.t52 58.1033
Rpar66 vss.t1 vss.t20 23.3273
Rpar67 vss.t1 vss.t21 148.1246
Rpar68 vss.t1 vss.t4 20.4004
Rpar69 vss.t1 vss.t52 366.9304
Rpar70 vss.t20 vss.t21 8.4249
Rpar71 vss.t20 vss.t4 1.9795
Rpar72 vss.t20 vss.t52 5.6805
Rpar73 vss.t21 vss.t4 14.8860
Rpar74 vss.t21 vss.t52 65.0133
Rpar75 vss.t4 vss.t52 34.8849
Cpar0 a_1203_5887.t0 vss 2.44322e-15
Cpar1 a_1203_5887.t2 vss 8.30146e-15
Cpar2 a_1203_5887.t4 vss 3.38024e-15
Cpar3 a_1203_5887.t8 vss 2.90578e-15
Cpar4 a_1203_5887.t9 vss 1.38518e-14
Cpar5 a_1266_12655.t0 vss 2.39060e-16
Cpar6 a_1266_12655.t1 vss 4.93482e-15
Cpar7 a_3269_9604.t0 vss 5.26681e-15
Cpar8 a_3269_9604.t4 vss 9.78605e-15
Cpar9 a_3602_12135.t0 vss 3.54200e-17
Cpar10 a_4018_1294.t0 vss 1.24465e-14
Cpar11 a_4018_1294.t1 vss 4.16582e-14
Cpar12 a_4246_1294.t0 vss 1.92802e-14
Cpar13 a_4246_1294.t32 vss 4.72704e-15
Cpar14 a_4246_1294.t33 vss 2.50816e-15
Cpar15 a_5793_9604.t0 vss 3.48040e-15
Cpar16 a_5793_9604.t2 vss 1.20206e-14
Cpar17 a_5793_9604.t3 vss 4.17450e-15
Cpar18 a_7156_13947.t0 vss 6.58556e-15
Cpar19 a_7156_13947.t1 vss 3.27326e-15
Cpar20 a_7156_13947.t4 vss 2.34076e-14
Cpar21 a_7432_5796.t0 vss 4.72994e-15
Cpar22 a_7432_5796.t4 vss 5.57987e-15
Cpar23 a_7432_5796.t5 vss 7.02330e-15
Cpar24 a_7432_5796.t8 vss 4.16288e-15
Cpar25 ib out 1.84872e-15
Cpar26 ib vdd 8.92200e-17
Cpar27 ib vss 2.45193e-14
Cpar28 ib.t0 vss 8.69220e-15
Cpar29 ib.t1 vss 1.05905e-15
Cpar30 inn inp 1.57040e-16
Cpar31 inn out 7.00850e-16
Cpar32 inn vdd 1.32222e-14
Cpar33 inn vss 1.32398e-14
Cpar34 inn.t0 vss 2.26335e-14
Cpar35 inn.t32 vss 8.92910e-16
Cpar36 inp vdd 1.35064e-14
Cpar37 inp vss 1.38837e-14
Cpar38 inp.t0 vss 2.11740e-14
Cpar39 inp.t32 vss 8.40561e-16
Cpar40 out vdd 1.41501e-14
Cpar41 out vss 1.45442e-14
Cpar42 out.t0 vss 9.47395e-15
Cpar43 out.t1 vss 6.66739e-15
Cpar44 out.t3 vss 8.55980e-15
Cpar45 vdd vss 1.84842e-13
Cpar46 vdd.t0 vss 2.03995e-14
Cpar47 vdd.t1 vss 1.13500e-14
Cpar48 vdd.t6 vss 1.21081e-14
Cpar49 vdd.t7 vss 6.12493e-15
Cpar50 vdd.t8 vss 3.71475e-14
.ends opamp_dut

Vdd vdd 0 3.300000
Vss vss 0 0
Ibias vdd ib 8.750000e-07
Vinp inp 0 DC 1.645000 AC 1 PWL(0 1.645000 1.435216e-08 1.645000 1.578737e-08 1.655000)
Rfb out inn 1m
Cload out 0 2.000000e-13
Xdut vdd vss inp inn out ib opamp_dut
.end
