* opa1000[0731]: 2p/rail_to_rail_3v3_i50n_weak (rail_to_rail, VDD=3.3V, CL=2.0pF, Iref=0.0081uA)
.include "pdk_opa.inc"
.temp 27
.option gmin=1e-12 rshunt=1e12 reltol=1e-3 abstol=1e-12 vntol=1e-5 method=gear
* Post-PEX R+C extracted netlist for rail_to_rail_3v3_i50n_weak
.subckt opamp_dut vdd vss inp inn out ib
XMpar0 ib.t1 ib.t0 vss.t1 vss.t0 nfet_03v3 w=0.4u l=7.5u ad=2.4000e-13 pd=2.0000e-06 as=1.1200e-13 ps=9.6000e-07 nf=1 m=2 par=2
XMpar1 a_1012_3577.t5 a_11290_4989.t2 vss.t22 vss.t21 nfet_03v3 w=0.4u l=6.5u ad=2.4000e-13 pd=2.0000e-06 as=1.1200e-13 ps=9.6000e-07 nf=1 m=2 par=2
XMpar2 a_11026_1250.t2 inn.t0 a_11950_11109.t6 vss.t26 nfet_03v3 w=0.4u l=5.2u ad=2.4000e-13 pd=2.0000e-06 as=2.4000e-13 ps=2.0000e-06 nf=1 m=2 par=2
XMpar3 a_11290_4989.t0 inn.t2 a_9874_8216.t0 vdd.t11 pfet_03v3 w=0.4u l=5.2u ad=1.1200e-13 pd=9.6000e-07 as=2.4000e-13 ps=2.0000e-06 nf=1 m=2 par=2
XMpar4 a_9874_8216.t2 a_18601_14336.t2 vdd.t5 vdd.t4 pfet_03v3 w=0.4u l=7.5u ad=2.4000e-13 pd=2.0000e-06 as=1.1200e-13 ps=9.6000e-07 nf=1 m=2 par=2
XMpar5 out.t2 ib.t0 vss.t1 vss.t0 nfet_03v3 w=0.4u l=7.5u ad=1.1200e-13 pd=9.6000e-07 as=2.0800e-13 ps=1.7400e-06 nf=1 m=8 par=8
XMpar6 a_1012_3577.t2 a_11950_11109.t2 vdd.t1 vdd.t0 pfet_03v3 w=0.4u l=3.2u ad=2.4000e-13 pd=2.0000e-06 as=1.1200e-13 ps=9.6000e-07 nf=1 m=2 par=2
XMpar7 a_1012_3577.t0 inp.t0 a_11026_1250.t2 vss.t26 nfet_03v3 w=0.4u l=5.2u ad=2.4000e-13 pd=2.0000e-06 as=2.4000e-13 ps=2.0000e-06 nf=1 m=2 par=2
XMpar8 out.t0 a_1012_3577.t7 vdd.t1 vdd.t0 pfet_03v3 w=0.4u l=3.2u ad=1.1200e-13 pd=9.6000e-07 as=1.7600e-13 ps=1.4800e-06 nf=1 m=8 par=8
XMpar9 a_9652_3536.t3 a_9652_3536.t2 vss.t22 vss.t21 nfet_03v3 w=0.4u l=6.5u ad=2.4000e-13 pd=2.0000e-06 as=1.1200e-13 ps=9.6000e-07 nf=1 m=2 par=2
XMpar10 a_11026_1250.t0 ib.t0 vss.t1 vss.t0 nfet_03v3 w=0.4u l=7.5u ad=2.4000e-13 pd=2.0000e-06 as=1.1200e-13 ps=9.6000e-07 nf=1 m=2 par=2
XMpar11 a_18601_14336.t0 ib.t0 vss.t1 vss.t0 nfet_03v3 w=0.4u l=7.5u ad=2.4000e-13 pd=2.0000e-06 as=1.1200e-13 ps=9.6000e-07 nf=1 m=2 par=2
XMpar12 a_9652_3536.t0 inp.t2 a_9874_8216.t0 vdd.t11 pfet_03v3 w=0.4u l=5.2u ad=1.1200e-13 pd=9.6000e-07 as=2.4000e-13 ps=2.0000e-06 nf=1 m=2 par=2
XMpar13 a_11950_11109.t3 a_11950_11109.t2 vdd.t1 vdd.t0 pfet_03v3 w=0.4u l=3.2u ad=2.4000e-13 pd=2.0000e-06 as=1.1200e-13 ps=9.6000e-07 nf=1 m=2 par=2
XMpar14 a_11290_4989.t3 a_11290_4989.t2 vss.t22 vss.t21 nfet_03v3 w=0.4u l=6.5u ad=2.4000e-13 pd=2.0000e-06 as=1.1200e-13 ps=9.6000e-07 nf=1 m=2 par=2
XMpar15 a_18601_14336.t3 a_18601_14336.t2 vdd.t5 vdd.t4 pfet_03v3 w=0.4u l=7.5u ad=2.4000e-13 pd=2.0000e-06 as=1.1200e-13 ps=9.6000e-07 nf=1 m=2 par=2
XMpar16 a_11950_11109.t0 a_9652_3536.t2 vss.t22 vss.t21 nfet_03v3 w=0.4u l=6.5u ad=1.1200e-13 pd=9.6000e-07 as=1.1200e-13 ps=9.6000e-07 nf=1 m=2 par=2
X1 a_1012_6177.t0 a_4990_6697.t0 vss.t25 ppolyf_u_1k r_width=1u r_length=19.23u
X4 a_1012_3577.t4 a_4990_3577.t0 vss.t25 ppolyf_u_1k r_width=1u r_length=19.23u
X9 a_1012_9297.t0 a_4990_8777.t0 vss.t25 ppolyf_u_1k r_width=1u r_length=19.23u
X11 a_1012_6177.t0 a_4990_5657.t0 vss.t25 ppolyf_u_1k r_width=1u r_length=19.23u
X16 a_1012_8257.t0 a_4990_8777.t0 vss.t25 ppolyf_u_1k r_width=1u r_length=19.23u
X20 a_1012_5137.t0 a_4990_5657.t0 vss.t25 ppolyf_u_1k r_width=1u r_length=19.23u
X22 a_4990_9817.t1 out.t10 cap_mim_2f0fF c_width=17.1u c_length=17.11u
X27 a_1012_8257.t0 a_4990_7737.t0 vss.t25 ppolyf_u_1k r_width=1u r_length=19.23u
X29 a_1012_5137.t0 a_4990_4617.t0 vss.t25 ppolyf_u_1k r_width=1u r_length=19.23u
X34 a_1012_7217.t0 a_4990_7737.t0 vss.t25 ppolyf_u_1k r_width=1u r_length=19.23u
X35 a_4990_9817.t1 out.t10 cap_mim_2f0fF c_width=17.1u c_length=17.11u
X36 a_1012_4097.t0 a_4990_4617.t0 vss.t25 ppolyf_u_1k r_width=1u r_length=19.23u
X42 a_1012_7217.t0 a_4990_6697.t0 vss.t25 ppolyf_u_1k r_width=1u r_length=19.23u
X49 a_1012_9297.t0 a_4990_9817.t0 vss.t25 ppolyf_u_1k r_width=1u r_length=19.23u
X58 a_1012_4097.t0 a_4990_3577.t0 vss.t25 ppolyf_u_1k r_width=1u r_length=19.23u
X59 a_4990_9817.t1 out.t10 cap_mim_2f0fF c_width=17.1u c_length=17.11u
Rpar0 a_1012_3577.t0 a_1012_3577.t7 319.4990
Rpar1 a_1012_3577.t0 a_1012_3577.t2 414.2411
Rpar2 a_1012_3577.t0 a_1012_3577.t4 154.6653
Rpar3 a_1012_3577.t0 a_1012_3577.t5 260.1854
Rpar4 a_1012_3577.t7 a_1012_3577.t2 761.7236
Rpar5 a_1012_3577.t7 a_1012_3577.t4 265.2069
Rpar6 a_1012_3577.t7 a_1012_3577.t5 478.4396
Rpar7 a_1012_3577.t2 a_1012_3577.t4 368.7406
Rpar8 a_1012_3577.t2 a_1012_3577.t5 176.1413
Rpar9 a_1012_3577.t4 a_1012_3577.t5 231.6064
Rpar10 a_11026_1250.t0 a_11026_1250.t2 106.9852
Rpar11 a_11290_4989.t0 a_11290_4989.t2 138.2592
Rpar12 a_11290_4989.t0 a_11290_4989.t3 137.1390
Rpar13 a_11290_4989.t2 a_11290_4989.t3 16.7341
Rpar14 a_11950_11109.t0 a_11950_11109.t2 213.3576
Rpar15 a_11950_11109.t0 a_11950_11109.t3 218.1790
Rpar16 a_11950_11109.t0 a_11950_11109.t6 87.1121
Rpar17 a_11950_11109.t2 a_11950_11109.t3 15.8245
Rpar18 a_11950_11109.t2 a_11950_11109.t6 341.7936
Rpar19 a_11950_11109.t3 a_11950_11109.t6 349.5174
Rpar20 a_18601_14336.t0 a_18601_14336.t2 124.4458
Rpar21 a_18601_14336.t0 a_18601_14336.t3 115.7116
Rpar22 a_18601_14336.t2 a_18601_14336.t3 16.7659
Rpar23 a_4990_9817.t0 a_4990_9817.t1 67.8618
Rpar24 a_9652_3536.t0 a_9652_3536.t2 139.7689
Rpar25 a_9652_3536.t0 a_9652_3536.t3 108.8101
Rpar26 a_9652_3536.t2 a_9652_3536.t3 22.0614
Rpar27 a_9874_8216.t0 a_9874_8216.t2 57.8939
Rpar28 ib ib.t0 18.7340
Rpar29 ib ib.t1 18.1851
Rpar30 ib.t0 ib.t1 28.5738
Rpar31 inn inn.t0 4.3026
Rpar32 inn inn.t2 47.4692
Rpar33 inp inp.t0 4.3033
Rpar34 inp inp.t2 47.4205
Rpar35 out out.t0 314.0790
Rpar36 out out.t10 22.1766
Rpar37 out out.t2 97.7966
Rpar38 out.t0 out.t10 1797.7204
Rpar39 out.t0 out.t2 104.1386
Rpar40 out.t10 out.t2 559.7664
Rpar41 vdd vdd.t0 443.8490
Rpar42 vdd vdd.t1 71.7121
Rpar43 vdd vdd.t5 848.8064
Rpar44 vdd vdd.t11 495.7803
Rpar45 vdd vdd.t4 1530.2425
Rpar46 vdd.t0 vdd.t1 8.7388
Rpar47 vdd.t0 vdd.t5 1676.0505
Rpar48 vdd.t0 vdd.t11 201.9169
Rpar49 vdd.t0 vdd.t4 3021.6120
Rpar50 vdd.t1 vdd.t5 643.7142
Rpar51 vdd.t1 vdd.t11 103.5535
Rpar52 vdd.t1 vdd.t4 1160.4988
Rpar53 vdd.t5 vdd.t11 225.0163
Rpar54 vdd.t5 vdd.t4 21.1657
Rpar55 vdd.t11 vdd.t4 405.6631
Rpar56 vss vss.t0 6643.4336
Rpar57 vss vss.t1 2791.5643
Rpar58 vss vss.t21 64.5075
Rpar59 vss vss.t22 300.2343
Rpar60 vss vss.t25 1895.5437
Rpar61 vss vss.t26 175.0555
Rpar62 vss.t0 vss.t1 13.4068
Rpar63 vss.t0 vss.t21 434.8992
Rpar64 vss.t0 vss.t22 820.3217
Rpar65 vss.t0 vss.t25 466.6013
Rpar66 vss.t0 vss.t26 1208.6597
Rpar67 vss.t1 vss.t21 229.1556
Rpar68 vss.t1 vss.t22 337.2908
Rpar69 vss.t1 vss.t25 317.7828
Rpar70 vss.t1 vss.t26 647.0883
Rpar71 vss.t21 vss.t22 9.3684
Rpar72 vss.t21 vss.t25 145.8495
Rpar73 vss.t21 vss.t26 4.6852
Rpar74 vss.t22 vss.t25 230.3733
Rpar75 vss.t22 vss.t26 26.5253
Rpar76 vss.t25 vss.t26 409.7844
Cpar0 a_1012_3577.t0 vss 6.41242e-15
Cpar1 a_1012_3577.t2 vss 6.16649e-15
Cpar2 a_1012_3577.t4 vss 6.51147e-15
Cpar3 a_1012_3577.t5 vss 7.75336e-15
Cpar4 a_1012_3577.t7 vss 1.62030e-14
Cpar5 a_1012_4097.t0 vss 3.92600e-17
Cpar6 a_1012_5137.t0 vss 3.59600e-17
Cpar7 a_1012_6177.t0 vss 3.59600e-17
Cpar8 a_1012_7217.t0 vss 3.59600e-17
Cpar9 a_1012_8257.t0 vss 3.66800e-17
Cpar10 a_1012_9297.t0 vss 3.49000e-17
Cpar11 a_11026_1250.t0 vss 2.22969e-14
Cpar12 a_11026_1250.t2 vss 1.39698e-14
Cpar13 a_11290_4989.t0 vss 1.31318e-15
Cpar14 a_11290_4989.t2 vss 6.44856e-15
Cpar15 a_11290_4989.t3 vss 1.82359e-15
Cpar16 a_11950_11109.t0 vss 5.58369e-15
Cpar17 a_11950_11109.t2 vss 9.94896e-15
Cpar18 a_11950_11109.t3 vss 4.23431e-15
Cpar19 a_11950_11109.t6 vss 5.32640e-15
Cpar20 a_18601_14336.t0 vss 1.61242e-14
Cpar21 a_18601_14336.t2 vss 1.74123e-14
Cpar22 a_18601_14336.t3 vss 6.18889e-15
Cpar23 a_4990_3577.t0 vss 3.14600e-17
Cpar24 a_4990_4617.t0 vss 3.00800e-17
Cpar25 a_4990_5657.t0 vss 2.93600e-17
Cpar26 a_4990_6697.t0 vss 2.93600e-17
Cpar27 a_4990_7737.t0 vss 2.93600e-17
Cpar28 a_4990_8777.t0 vss 3.20200e-17
Cpar29 a_4990_9817.t0 vss 1.92200e-16
Cpar30 a_4990_9817.t1 vss 1.26600e-14
Cpar31 a_9652_3536.t0 vss 1.34802e-15
Cpar32 a_9652_3536.t2 vss 5.60511e-15
Cpar33 a_9652_3536.t3 vss 1.71726e-15
Cpar34 a_9874_8216.t0 vss 7.46772e-15
Cpar35 a_9874_8216.t2 vss 9.60788e-15
Cpar36 ib out 1.98270e-15
Cpar37 ib vdd 2.99340e-16
Cpar38 ib vss 6.21721e-14
Cpar39 ib.t0 vss 1.99340e-14
Cpar40 ib.t1 vss 1.54628e-15
Cpar41 inn inp 1.56510e-16
Cpar42 inn vdd 5.67181e-15
Cpar43 inn vss 1.17784e-14
Cpar44 inn.t0 vss 2.06084e-15
Cpar45 inn.t2 vss 4.66948e-15
Cpar46 inp vdd 4.98687e-15
Cpar47 inp vss 1.08235e-14
Cpar48 inp.t0 vss 1.99374e-15
Cpar49 inp.t2 vss 4.51549e-15
Cpar50 out vdd 1.06425e-14
Cpar51 out vss 3.12480e-14
Cpar52 out.t0 vss 4.31152e-15
Cpar53 out.t10 vss 1.95978e-14
Cpar54 out.t2 vss 8.56297e-15
Cpar55 vdd vss 1.54873e-13
Cpar56 vdd.t0 vss 2.78420e-14
Cpar57 vdd.t1 vss 1.04757e-14
Cpar58 vdd.t11 vss 1.48400e-14
Cpar59 vdd.t4 vss 1.98073e-14
Cpar60 vdd.t5 vss 7.05615e-15
.ends opamp_dut

Vdd vdd 0 3.300000
Vss vss 0 0
Ibias vdd ib 8.100000e-09
Vinp inp 0 DC 1.645000 AC 1 PWL(0 1.645000 5.933968e-06 1.645000 6.527364e-06 1.655000)
Rfb out inn 1m
Cload out 0 2.000000e-12
Xdut vdd vss inp inn out ib opamp_dut
.end
