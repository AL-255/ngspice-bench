* opa1000[0856]: 200f/telescopic_nmos_3v3_i50n_weak (telescopic_nmos, VDD=3.3V, CL=0.2pF, Iref=0.0144uA)
.include "pdk_opa.inc"
.temp 27
.option gmin=1e-12 rshunt=1e12 reltol=1e-3 abstol=1e-12 vntol=1e-5 method=gear
* Post-PEX R+C extracted netlist for telescopic_nmos_3v3_i50n_weak
.subckt opamp_dut vdd vss inp inn out ib
XMpar0 a_1715_6388.t0 inp.t0 a_1956_4134.t0 vss.t0 nfet_03v3 w=0.54u l=9.75u ad=3.2400e-13 pd=2.2800e-06 as=3.2400e-13 ps=2.2800e-06 nf=1 m=2 par=2
XMpar1 a_1715_8163.t0 a_1835_6180.t12 vdd.t2 vdd.t1 pfet_03v3 w=0.4u l=5.2u ad=2.4000e-13 pd=2.0000e-06 as=1.1200e-13 ps=9.6000e-07 nf=1 m=2 par=2
XMpar2 a_3154_8163.t0 a_1835_6180.t4 out.t0 vdd.t0 pfet_03v3 w=0.62u l=5.25u ad=3.7200e-13 pd=2.4400e-06 as=1.7360e-13 ps=1.1800e-06 nf=1 m=2 par=2
XMpar3 a_1715_8163.t2 a_1835_6180.t4 a_1835_6180.t5 vdd.t0 pfet_03v3 w=0.62u l=5.25u ad=3.7200e-13 pd=2.4400e-06 as=3.7200e-13 ps=2.4400e-06 nf=1 m=2 par=2
XMpar4 a_1715_6388.t2 a_1835_6180.t0 a_1835_6180.t1 vss.t1 nfet_03v3 w=0.4u l=5.25u ad=2.4000e-13 pd=2.0000e-06 as=2.4000e-13 ps=2.0000e-06 nf=1 m=2 par=2
XMpar5 a_1956_4134.t4 ib.t0 vss.t5 vss.t4 nfet_03v3 w=0.4u l=5u ad=1.1200e-13 pd=9.6000e-07 as=2.0800e-13 ps=1.7400e-06 nf=1 m=8 par=8
XMpar6 ib.t1 ib.t0 vss.t5 vss.t4 nfet_03v3 w=0.4u l=5u ad=2.4000e-13 pd=2.0000e-06 as=1.1200e-13 ps=9.6000e-07 nf=1 m=2 par=2
XMpar7 a_1956_4134.t0 inn.t0 a_3154_6388.t0 vss.t0 nfet_03v3 w=0.54u l=9.75u ad=3.2400e-13 pd=2.2800e-06 as=3.2400e-13 ps=2.2800e-06 nf=1 m=2 par=2
XMpar8 a_3154_6388.t2 a_1835_6180.t0 out.t1 vss.t1 nfet_03v3 w=0.4u l=5.25u ad=2.4000e-13 pd=2.0000e-06 as=1.1200e-13 ps=9.6000e-07 nf=1 m=2 par=2
XMpar9 a_3154_8163.t1 a_1835_6180.t12 vdd.t2 vdd.t1 pfet_03v3 w=0.4u l=5.2u ad=1.1200e-13 pd=9.6000e-07 as=1.1200e-13 ps=9.6000e-07 nf=1 m=2 par=2
Rpar0 a_1715_6388.t0 a_1715_6388.t2 48.2639
Rpar1 a_1715_8163.t0 a_1715_8163.t2 73.9190
Rpar2 a_1835_6180.t0 a_1835_6180.t1 26.2154
Rpar3 a_1835_6180.t0 a_1835_6180.t4 264.0732
Rpar4 a_1835_6180.t0 a_1835_6180.t12 301.4833
Rpar5 a_1835_6180.t0 a_1835_6180.t5 189.3724
Rpar6 a_1835_6180.t1 a_1835_6180.t4 216.5192
Rpar7 a_1835_6180.t1 a_1835_6180.t12 247.1925
Rpar8 a_1835_6180.t1 a_1835_6180.t5 155.2704
Rpar9 a_1835_6180.t4 a_1835_6180.t12 185.8245
Rpar10 a_1835_6180.t4 a_1835_6180.t5 25.5191
Rpar11 a_1835_6180.t12 a_1835_6180.t5 133.2587
Rpar12 a_1956_4134.t0 a_1956_4134.t4 42.2699
Rpar13 a_3154_6388.t0 a_3154_6388.t2 49.2062
Rpar14 a_3154_8163.t0 a_3154_8163.t1 54.0437
Rpar15 ib ib.t0 13.2767
Rpar16 ib ib.t1 14.2348
Rpar17 ib.t0 ib.t1 33.8818
Rpar18 inn inn.t0 4.1120
Rpar19 inp inp.t0 4.1118
Rpar20 out out.t0 14.3624
Rpar21 out out.t1 36.4061
Rpar22 vdd vdd.t0 86.2613
Rpar23 vdd vdd.t1 41.3254
Rpar24 vdd vdd.t2 73.9355
Rpar25 vdd.t0 vdd.t1 81.4683
Rpar26 vdd.t0 vdd.t2 145.7555
Rpar27 vdd.t1 vdd.t2 16.7111
Rpar28 vss vss.t0 134.2731
Rpar29 vss vss.t1 81.5398
Rpar30 vss vss.t4 33.7710
Rpar31 vss vss.t5 247.0192
Rpar32 vss.t0 vss.t1 18.7626
Rpar33 vss.t0 vss.t4 7.6863
Rpar34 vss.t0 vss.t5 82.8086
Rpar35 vss.t1 vss.t4 4.7131
Rpar36 vss.t1 vss.t5 51.2140
Rpar37 vss.t4 vss.t5 20.8013
Cpar0 a_1715_6388.t0 vss 4.63480e-15
Cpar1 a_1715_6388.t2 vss 4.26192e-15
Cpar2 a_1715_8163.t0 vss 6.45764e-15
Cpar3 a_1715_8163.t2 vss 7.01152e-15
Cpar4 a_1835_6180.t0 vss 1.05986e-14
Cpar5 a_1835_6180.t1 vss 3.19551e-15
Cpar6 a_1835_6180.t12 vss 1.02698e-14
Cpar7 a_1835_6180.t4 vss 1.14026e-14
Cpar8 a_1835_6180.t5 vss 3.56833e-15
Cpar9 a_1956_4134.t0 vss 7.25761e-15
Cpar10 a_1956_4134.t4 vss 8.18870e-15
Cpar11 a_3154_6388.t0 vss 5.26354e-15
Cpar12 a_3154_6388.t2 vss 4.76786e-15
Cpar13 a_3154_8163.t0 vss 8.00090e-15
Cpar14 a_3154_8163.t1 vss 5.58006e-15
Cpar15 ib inn 1.86100e-17
Cpar16 ib inp 2.23600e-17
Cpar17 ib vss 3.75703e-14
Cpar18 ib.t0 vss 5.27886e-15
Cpar19 ib.t1 vss 4.37688e-16
Cpar20 inn inp 1.02550e-16
Cpar21 inn vss 9.49294e-15
Cpar22 inn.t0 vss 1.45445e-15
Cpar23 inp vss 9.44745e-15
Cpar24 inp.t0 vss 1.47885e-15
Cpar25 out vdd 3.11002e-15
Cpar26 out vss 9.23463e-15
Cpar27 out.t0 vss 6.46283e-16
Cpar28 out.t1 vss 2.70691e-15
Cpar29 vdd vss 6.51265e-14
Cpar30 vdd.t0 vss 1.38384e-14
Cpar31 vdd.t1 vss 8.28799e-15
Cpar32 vdd.t2 vss 4.65561e-15
.ends opamp_dut

Vdd vdd 0 3.300000
Vss vss 0 0
Ibias vdd ib 1.440000e-08
Vinp inp 0 DC 1.711000 AC 1 PWL(0 1.711000 2.984296e-07 1.711000 3.282726e-07 1.721000)
Rfb out inn 1m
Cload out 0 2.000000e-13
Xdut vdd vss inp inn out ib opamp_dut
.end
