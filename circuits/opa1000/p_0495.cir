* opa1000[0495]: 2p/nmos_miller_3v3_10u_100u_weak (nmos_miller, VDD=3.3V, CL=2.0pF, Iref=9.2857uA)
.include "pdk_opa.inc"
.temp 27
.option gmin=1e-12 rshunt=1e12 reltol=1e-3 abstol=1e-12 vntol=1e-5 method=gear
* Post-PEX R+C extracted netlist for nmos_miller_3v3_10u_100u_weak
.subckt opamp_dut vdd vss inp inn out ib
XMpar0 a_982_6653.t9 a_5720_1041.t8 vdd.t1 vdd.t0 pfet_03v3 w=10u l=0.63u ad=6.0000e-12 pd=2.1200e-05 as=2.8000e-12 ps=1.0560e-05 nf=1 m=2 par=2
XMpar1 a_3922_4830.t0 inp.t0 a_982_6653.t0 vss.t0 nfet_03v3 w=1.81u l=0.6u ad=6.5160e-13 pd=2.9825e-06 as=5.0680e-13 ps=2.3700e-06 nf=1 m=8 par=8
XMpar2 ib.t1 ib.t0 vss.t9 vss.t0 nfet_03v3 w=3.04u l=0.8u ad=8.5120e-13 pd=3.6000e-06 as=8.5120e-13 ps=3.6000e-06 nf=1 m=2 par=2
XMpar3 a_3922_4830.t0 inn.t0 a_5720_1041.t0 vss.t0 nfet_03v3 w=1.81u l=0.6u ad=6.7229e-13 pd=3.0700e-06 as=5.0680e-13 ps=2.3700e-06 nf=1 m=7 par=7
XMpar4 out.t0 ib.t0 vss.t9 vss.t38 nfet_03v3 w=3.04u l=0.8u ad=1.8240e-12 pd=7.2800e-06 as=8.5120e-13 ps=3.6000e-06 nf=1 m=1
XMpar5 out.t0 ib.t0 vss.t9 vss.t0 nfet_03v3 w=3.04u l=0.8u ad=9.5929e-13 pd=4.0089e-06 as=8.5120e-13 ps=3.6000e-06 nf=1 m=9 par=9
XMpar6 a_3922_4830.t0 inn.t0 a_5720_1041.t0 vss.t38 nfet_03v3 w=1.81u l=0.6u ad=5.0680e-13 pd=2.3700e-06 as=5.0680e-13 ps=2.3700e-06 nf=1 m=1
XMpar7 out.t7 a_982_6653.t11 vdd.t1 vdd.t0 pfet_03v3 w=10u l=0.63u ad=2.8000e-12 pd=1.0560e-05 as=3.4400e-12 ps=1.2688e-05 nf=1 m=10 par=10
XMpar8 a_5720_1041.t9 a_5720_1041.t8 vdd.t1 vdd.t0 pfet_03v3 w=10u l=0.63u ad=2.8000e-12 pd=1.0560e-05 as=2.8000e-12 ps=1.0560e-05 nf=1 m=2 par=2
XMpar9 a_3922_4830.t8 ib.t0 vss.t9 vss.t0 nfet_03v3 w=3.04u l=0.8u ad=8.5120e-13 pd=3.6000e-06 as=8.5120e-13 ps=3.6000e-06 nf=1 m=4 par=4
X33 a_1636_6653.t1 out.t5 cap_mim_2f0fF c_width=19.27u c_length=19.27u
X39 a_982_6653.t8 a_1636_6653.t0 vss.t47 ppolyf_u_1k r_width=1u r_length=2.61u
X46 a_1636_6653.t1 out.t5 cap_mim_2f0fF c_width=19.27u c_length=19.27u
Rpar0 a_1636_6653.t0 a_1636_6653.t1 63.0233
Rpar1 a_3922_4830.t0 a_3922_4830.t8 56.4030
Rpar2 a_5720_1041.t0 a_5720_1041.t8 377.7175
Rpar3 a_5720_1041.t0 a_5720_1041.t9 68.7744
Rpar4 a_5720_1041.t8 a_5720_1041.t9 42.8128
Rpar5 a_982_6653.t0 a_982_6653.t9 88.8257
Rpar6 a_982_6653.t0 a_982_6653.t11 355.3969
Rpar7 a_982_6653.t0 a_982_6653.t8 72.7538
Rpar8 a_982_6653.t9 a_982_6653.t11 82.2253
Rpar9 a_982_6653.t9 a_982_6653.t8 191.1252
Rpar10 a_982_6653.t11 a_982_6653.t8 764.7030
Rpar11 ib ib.t0 12.3860
Rpar12 ib ib.t1 9.0213
Rpar13 inn inn.t0 4.3153
Rpar14 inp inp.t0 4.3639
Rpar15 out out.t0 38.2550
Rpar16 out out.t7 153.5150
Rpar17 out out.t5 24.3097
Rpar18 out.t0 out.t7 96.0363
Rpar19 out.t0 out.t5 199.1067
Rpar20 out.t7 out.t5 799.0025
Rpar21 vdd vdd.t0 165.7529
Rpar22 vdd vdd.t1 380.6277
Rpar23 vdd.t0 vdd.t1 3.6192
Rpar24 vss vss.t0 39.9217
Rpar25 vss vss.t9 296.5093
Rpar26 vss vss.t38 1193.2740
Rpar27 vss vss.t47 191.7745
Rpar28 vss.t0 vss.t9 3.8712
Rpar29 vss.t0 vss.t38 8.5087
Rpar30 vss.t0 vss.t47 46.0710
Rpar31 vss.t9 vss.t38 93.7243
Rpar32 vss.t9 vss.t47 338.0047
Rpar33 vss.t38 vss.t47 1350.1587
Cpar0 a_1636_6653.t0 vss 1.20064e-16
Cpar1 a_1636_6653.t1 vss 8.45999e-15
Cpar2 a_3922_4830.t0 vss 7.80097e-15
Cpar3 a_3922_4830.t8 vss 7.59305e-15
Cpar4 a_5720_1041.t0 vss 3.35298e-15
Cpar5 a_5720_1041.t8 vss 5.15501e-15
Cpar6 a_5720_1041.t9 vss 6.00059e-15
Cpar7 a_982_6653.t0 vss 3.13771e-15
Cpar8 a_982_6653.t11 vss 1.24564e-14
Cpar9 a_982_6653.t8 vss 1.55230e-15
Cpar10 a_982_6653.t9 vss 7.68190e-15
Cpar11 ib out 1.56402e-15
Cpar12 ib vdd 1.88870e-16
Cpar13 ib vss 1.65079e-14
Cpar14 ib.t0 vss 3.28220e-15
Cpar15 ib.t1 vss 3.29470e-16
Cpar16 inn inp 5.16800e-17
Cpar17 inn vdd 1.37000e-17
Cpar18 inn vss 4.84495e-15
Cpar19 inn.t0 vss 7.40486e-16
Cpar20 inp vdd 1.25000e-17
Cpar21 inp vss 4.86768e-15
Cpar22 inp.t0 vss 7.49382e-16
Cpar23 out vdd 1.70564e-14
Cpar24 out vss 2.19410e-14
Cpar25 out.t0 vss 4.88164e-15
Cpar26 out.t5 vss 1.46196e-14
Cpar27 out.t7 vss 8.62785e-15
Cpar28 vdd vss 7.24994e-14
Cpar29 vdd.t0 vss 2.25303e-14
Cpar30 vdd.t1 vss 1.31319e-14
.ends opamp_dut

Vdd vdd 0 3.300000
Vss vss 0 0
Ibias vdd ib 9.285700e-06
Vinp inp 0 DC 1.645000 AC 1 PWL(0 1.645000 6.109381e-09 1.645000 6.720320e-09 1.655000)
Rfb out inn 1m
Cload out 0 2.000000e-12
Xdut vdd vss inp inn out ib opamp_dut
.end
