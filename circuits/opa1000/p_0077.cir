* opa1000[0077]: 2p/cherry_hooper_3v3_10u_100u_weak (cherry_hooper, VDD=3.3V, CL=2.0pF, Iref=2.3611uA)
.include "pdk_opa.inc"
.temp 27
.option gmin=1e-12 rshunt=1e12 reltol=1e-3 abstol=1e-12 vntol=1e-5 method=gear
* Post-PEX R+C extracted netlist for cherry_hooper_3v3_10u_100u_weak
.subckt opamp_dut vdd vss inp inn out ib
XMpar0 a_10432_13467.t0 a_11534_10834.t10 out.t0 vss.t0 nfet_03v3 w=7.87u l=0.75u ad=3.0431e-12 pd=1.1267e-05 as=3.0431e-12 ps=1.1267e-05 nf=1 m=3 par=3
XMpar1 a_10031_8894.t0 ib.t0 vss.t3 vss.t2 nfet_03v3 w=1.57u l=0.8u ad=6.0707e-13 pd=2.8667e-06 as=4.3960e-13 ps=2.1300e-06 nf=1 m=6 par=6
XMpar2 a_10432_13467.t2 ib.t0 vss.t3 vss.t2 nfet_03v3 w=1.57u l=0.8u ad=4.3960e-13 pd=2.1300e-06 as=5.6520e-13 ps=2.6825e-06 nf=1 m=8 par=8
XMpar3 a_7027_6322.t0 ib.t0 vss.t3 vss.t2 nfet_03v3 w=1.57u l=0.8u ad=9.4200e-13 pd=4.3400e-06 as=4.3960e-13 ps=2.1300e-06 nf=1 m=1
XMpar4 a_10031_8894.t6 a_10440_1294.t7 a_6470_2892.t2 vss.t40 nfet_03v3 w=8.86u l=0.75u ad=5.3160e-12 pd=1.8920e-05 as=2.4808e-12 ps=9.4200e-06 nf=1 m=2 par=2
XMpar5 out.t1 a_10588_16298.t0 vdd.t3 vdd.t2 pfet_03v3 w=9.6u l=0.75u ad=2.6880e-12 pd=1.0160e-05 as=2.6880e-12 ps=1.0160e-05 nf=1 m=4 par=4
XMpar6 a_10170_1294.t2 inn.t0 a_11534_6486.t1 vss.t40 nfet_03v3 w=1.48u l=0.75u ad=6.5120e-13 pd=3.1000e-06 as=4.1440e-13 ps=2.0400e-06 nf=1 m=2 par=2
XMpar7 a_10432_13467.t0 a_6470_2892.t10 a_10588_16298.t8 vss.t0 nfet_03v3 w=7.87u l=0.75u ad=3.0431e-12 pd=1.1267e-05 as=3.0431e-12 ps=1.1267e-05 nf=1 m=3 par=3
XMpar8 a_11534_10834.t6 a_10714_10626.t15 a_11534_6486.t0 vdd.t1 pfet_03v3 w=5.62u l=1u ad=3.3720e-12 pd=1.2440e-05 as=1.5736e-12 ps=6.1800e-06 nf=1 m=2 par=2
XMpar9 ib.t1 ib.t0 vss.t3 vss.t2 nfet_03v3 w=1.57u l=0.8u ad=9.4200e-13 pd=4.3400e-06 as=4.3960e-13 ps=2.1300e-06 nf=1 m=1
XMpar10 a_10714_10626.t2 a_10714_10626.t1 a_18289_8584.t2 vdd.t0 pfet_03v3 w=8.98u l=0.75u ad=2.9249e-12 pd=1.0914e-05 as=2.9249e-12 ps=1.0914e-05 nf=1 m=7 par=7
XMpar11 a_11534_10834.t1 a_11534_10834.t0 vdd.t3 vdd.t2 pfet_03v3 w=9.6u l=0.75u ad=3.7120e-12 pd=1.3573e-05 as=3.7120e-12 ps=1.3573e-05 nf=1 m=3 par=3
XMpar12 a_6470_2892.t5 a_6470_2892.t4 vdd.t3 vdd.t2 pfet_03v3 w=9.6u l=0.75u ad=3.7120e-12 pd=1.3573e-05 as=3.7120e-12 ps=1.3573e-05 nf=1 m=3 par=3
XMpar13 a_10170_1294.t0 ib.t0 vss.t3 vss.t2 nfet_03v3 w=1.57u l=0.8u ad=4.3960e-13 pd=2.1300e-06 as=4.3960e-13 ps=2.1300e-06 nf=1 m=2 par=2
XMpar14 a_11534_6486.t6 a_7027_6322.t1 vdd.t16 vdd.t15 pfet_03v3 w=4.5u l=0.8u ad=2.7000e-12 pd=1.0200e-05 as=2.7000e-12 ps=1.0200e-05 nf=1 m=1
XMpar15 a_10170_1294.t2 inp.t0 a_10440_1294.t2 vss.t40 nfet_03v3 w=1.48u l=0.75u ad=6.5120e-13 pd=3.1000e-06 as=4.1440e-13 ps=2.0400e-06 nf=1 m=2 par=2
XMpar16 a_10588_16298.t1 a_10588_16298.t0 vdd.t3 vdd.t2 pfet_03v3 w=9.6u l=0.75u ad=2.6880e-12 pd=1.0160e-05 as=4.2240e-12 ps=1.5280e-05 nf=1 m=4 par=4
XMpar17 a_10170_1294.t2 inn.t0 a_11534_6486.t1 vss.t43 nfet_03v3 w=1.48u l=0.75u ad=6.5120e-13 pd=3.1000e-06 as=4.1440e-13 ps=2.0400e-06 nf=1 m=2 par=2
XMpar18 a_7027_6322.t2 a_7027_6322.t1 vdd.t16 vdd.t15 pfet_03v3 w=4.5u l=0.8u ad=2.7000e-12 pd=1.0200e-05 as=2.7000e-12 ps=1.0200e-05 nf=1 m=1
XMpar19 a_10031_8894.t6 a_11534_6486.t7 a_11534_10834.t8 vss.t40 nfet_03v3 w=8.86u l=0.75u ad=5.3160e-12 pd=1.8920e-05 as=2.4808e-12 ps=9.4200e-06 nf=1 m=2 par=2
XMpar20 a_18289_8584.t1 a_18289_8584.t0 vdd.t3 vdd.t2 pfet_03v3 w=9.6u l=0.75u ad=5.7600e-12 pd=2.0400e-05 as=5.7600e-12 ps=2.0400e-05 nf=1 m=1
XMpar21 a_10440_1294.t0 a_10714_10626.t15 a_6470_2892.t0 vdd.t1 pfet_03v3 w=5.62u l=1u ad=1.5736e-12 pd=6.1800e-06 as=3.3720e-12 ps=1.2440e-05 nf=1 m=2 par=2
XMpar22 a_10440_1294.t6 a_7027_6322.t1 vdd.t16 vdd.t15 pfet_03v3 w=4.5u l=0.8u ad=2.7000e-12 pd=1.0200e-05 as=2.7000e-12 ps=1.0200e-05 nf=1 m=1
XMpar23 a_10714_10626.t0 ib.t0 vss.t3 vss.t2 nfet_03v3 w=1.57u l=0.8u ad=9.4200e-13 pd=4.3400e-06 as=9.4200e-13 ps=4.3400e-06 nf=1 m=1
XMpar24 a_10170_1294.t2 inp.t0 a_10440_1294.t2 vss.t43 nfet_03v3 w=1.48u l=0.75u ad=6.5120e-13 pd=3.1000e-06 as=4.1440e-13 ps=2.0400e-06 nf=1 m=2 par=2
X13 out.t7 vss.t50 cap_mim_2f0fF c_width=17.8u c_length=17.8u
X15 out.t7 vss.t50 cap_mim_2f0fF c_width=17.8u c_length=17.8u
X44 out.t7 vss.t50 cap_mim_2f0fF c_width=17.8u c_length=17.8u
Rpar0 a_10031_8894.t0 a_10031_8894.t6 46.6286
Rpar1 a_10170_1294.t0 a_10170_1294.t2 114.6114
Rpar2 a_10432_13467.t0 a_10432_13467.t2 47.3470
Rpar3 a_10440_1294.t0 a_10440_1294.t2 186.0272
Rpar4 a_10440_1294.t0 a_10440_1294.t6 99.6715
Rpar5 a_10440_1294.t0 a_10440_1294.t7 294.6391
Rpar6 a_10440_1294.t2 a_10440_1294.t6 121.6699
Rpar7 a_10440_1294.t2 a_10440_1294.t7 104.7413
Rpar8 a_10440_1294.t6 a_10440_1294.t7 192.7068
Rpar9 a_10588_16298.t0 a_10588_16298.t1 25.4187
Rpar10 a_10588_16298.t0 a_10588_16298.t8 235.0132
Rpar11 a_10588_16298.t1 a_10588_16298.t8 45.6262
Rpar12 a_10714_10626.t0 a_10714_10626.t1 643.5513
Rpar13 a_10714_10626.t0 a_10714_10626.t2 76.1681
Rpar14 a_10714_10626.t0 a_10714_10626.t15 190.9743
Rpar15 a_10714_10626.t1 a_10714_10626.t2 24.3092
Rpar16 a_10714_10626.t1 a_10714_10626.t15 511.9619
Rpar17 a_10714_10626.t2 a_10714_10626.t15 60.5937
Rpar18 a_11534_10834.t0 a_11534_10834.t1 41.7069
Rpar19 a_11534_10834.t0 a_11534_10834.t10 3008.1126
Rpar20 a_11534_10834.t0 a_11534_10834.t6 1479.1290
Rpar21 a_11534_10834.t0 a_11534_10834.t8 674.7211
Rpar22 a_11534_10834.t1 a_11534_10834.t10 316.8923
Rpar23 a_11534_10834.t1 a_11534_10834.t6 155.8202
Rpar24 a_11534_10834.t1 a_11534_10834.t8 71.0791
Rpar25 a_11534_10834.t10 a_11534_10834.t6 62.8781
Rpar26 a_11534_10834.t10 a_11534_10834.t8 976.4782
Rpar27 a_11534_10834.t6 a_11534_10834.t8 480.1474
Rpar28 a_11534_6486.t0 a_11534_6486.t1 186.0272
Rpar29 a_11534_6486.t0 a_11534_6486.t6 99.6715
Rpar30 a_11534_6486.t0 a_11534_6486.t7 294.6391
Rpar31 a_11534_6486.t1 a_11534_6486.t6 121.6699
Rpar32 a_11534_6486.t1 a_11534_6486.t7 104.7413
Rpar33 a_11534_6486.t6 a_11534_6486.t7 192.7068
Rpar34 a_18289_8584.t0 a_18289_8584.t1 101.9858
Rpar35 a_18289_8584.t0 a_18289_8584.t2 474.0914
Rpar36 a_18289_8584.t1 a_18289_8584.t2 39.9172
Rpar37 a_6470_2892.t0 a_6470_2892.t10 62.8781
Rpar38 a_6470_2892.t0 a_6470_2892.t2 480.1474
Rpar39 a_6470_2892.t0 a_6470_2892.t4 1479.1290
Rpar40 a_6470_2892.t0 a_6470_2892.t5 155.8202
Rpar41 a_6470_2892.t10 a_6470_2892.t2 976.4782
Rpar42 a_6470_2892.t10 a_6470_2892.t4 3008.1126
Rpar43 a_6470_2892.t10 a_6470_2892.t5 316.8923
Rpar44 a_6470_2892.t2 a_6470_2892.t4 674.7211
Rpar45 a_6470_2892.t2 a_6470_2892.t5 71.0791
Rpar46 a_6470_2892.t4 a_6470_2892.t5 41.7069
Rpar47 a_7027_6322.t0 a_7027_6322.t1 97.2528
Rpar48 a_7027_6322.t0 a_7027_6322.t2 146.3364
Rpar49 a_7027_6322.t1 a_7027_6322.t2 39.8951
Rpar50 ib ib.t0 2.1331
Rpar51 ib ib.t1 80.0082
Rpar52 ib.t0 ib.t1 30.0969
Rpar53 inn inn.t0 6.7075
Rpar54 inp inp.t0 6.7561
Rpar55 out out.t0 72.0522
Rpar56 out out.t1 67.4848
Rpar57 out out.t7 18.5200
Rpar58 out.t0 out.t1 95.8596
Rpar59 out.t0 out.t7 297.6003
Rpar60 out.t1 out.t7 278.7357
Rpar61 vdd vdd.t0 96.6524
Rpar62 vdd vdd.t1 380.2939
Rpar63 vdd vdd.t3 88.0720
Rpar64 vdd vdd.t2 51.7713
Rpar65 vdd vdd.t16 3037.8507
Rpar66 vdd.t0 vdd.t1 934.3718
Rpar67 vdd.t0 vdd.t3 82.7523
Rpar68 vdd.t0 vdd.t2 77.6367
Rpar69 vdd.t1 vdd.t3 161.3126
Rpar70 vdd.t1 vdd.t2 89.0559
Rpar71 vdd.t1 vdd.t15 382.3795
Rpar72 vdd.t1 vdd.t16 82.7458
Rpar73 vdd.t3 vdd.t2 2.7323
Rpar74 vdd.t3 vdd.t15 336.6207
Rpar75 vdd.t3 vdd.t16 110.8461
Rpar76 vdd.t2 vdd.t15 193.3311
Rpar77 vdd.t2 vdd.t16 63.5820
Rpar78 vdd.t15 vdd.t16 12.4937
Rpar79 vss vss.t0 1684.6976
Rpar80 vss vss.t2 216.2347
Rpar81 vss vss.t3 293.1263
Rpar82 vss vss.t40 76.6145
Rpar83 vss vss.t43 168.2494
Rpar84 vss vss.t50 1285.0228
Rpar85 vss.t0 vss.t2 103.6826
Rpar86 vss.t0 vss.t3 219.6936
Rpar87 vss.t0 vss.t40 257.3964
Rpar88 vss.t0 vss.t43 719.1718
Rpar89 vss.t0 vss.t50 6229.2714
Rpar90 vss.t2 vss.t3 2.4005
Rpar91 vss.t2 vss.t40 36.4918
Rpar92 vss.t2 vss.t43 31.5257
Rpar93 vss.t2 vss.t50 137.1549
Rpar94 vss.t3 vss.t40 65.8591
Rpar95 vss.t3 vss.t43 77.5163
Rpar96 vss.t3 vss.t50 130.5555
Rpar97 vss.t40 vss.t43 8.6178
Rpar98 vss.t40 vss.t50 441.1866
Rpar99 vss.t43 vss.t50 775.3226
Cpar0 a_10031_8894.t0 vss 2.63526e-15
Cpar1 a_10031_8894.t6 vss 8.36874e-15
Cpar2 a_10170_1294.t0 vss 9.53312e-15
Cpar3 a_10170_1294.t2 vss 1.18327e-14
Cpar4 a_10432_13467.t0 vss 8.60240e-15
Cpar5 a_10432_13467.t2 vss 2.94355e-15
Cpar6 a_10440_1294.t0 vss 3.75088e-15
Cpar7 a_10440_1294.t2 vss 2.51989e-15
Cpar8 a_10440_1294.t6 vss 3.32361e-15
Cpar9 a_10440_1294.t7 vss 2.84760e-15
Cpar10 a_10588_16298.t0 vss 9.83880e-15
Cpar11 a_10588_16298.t1 vss 7.71353e-15
Cpar12 a_10588_16298.t8 vss 5.03713e-15
Cpar13 a_10714_10626.t0 vss 1.54923e-15
Cpar14 a_10714_10626.t1 vss 6.89891e-15
Cpar15 a_10714_10626.t15 vss 4.73321e-15
Cpar16 a_10714_10626.t2 vss 1.08430e-14
Cpar17 a_11534_10834.t0 vss 2.74074e-15
Cpar18 a_11534_10834.t1 vss 8.38154e-15
Cpar19 a_11534_10834.t10 vss 3.56311e-15
Cpar20 a_11534_10834.t6 vss 5.34096e-15
Cpar21 a_11534_10834.t8 vss 3.76542e-15
Cpar22 a_11534_6486.t0 vss 4.54080e-15
Cpar23 a_11534_6486.t1 vss 3.05059e-15
Cpar24 a_11534_6486.t6 vss 4.02355e-15
Cpar25 a_11534_6486.t7 vss 3.44730e-15
Cpar26 a_18289_8584.t0 vss 1.28787e-15
Cpar27 a_18289_8584.t1 vss 4.29809e-15
Cpar28 a_18289_8584.t2 vss 1.05536e-14
Cpar29 a_6470_2892.t0 vss 7.82299e-15
Cpar30 a_6470_2892.t10 vss 5.21892e-15
Cpar31 a_6470_2892.t2 vss 5.51528e-15
Cpar32 a_6470_2892.t4 vss 4.01441e-15
Cpar33 a_6470_2892.t5 vss 1.22766e-14
Cpar34 a_7027_6322.t0 vss 2.43587e-15
Cpar35 a_7027_6322.t1 vss 3.85434e-15
Cpar36 a_7027_6322.t2 vss 3.71984e-15
Cpar37 ib out 3.03200e-17
Cpar38 ib vdd 2.27046e-15
Cpar39 ib vss 2.41466e-14
Cpar40 ib.t0 vss 6.62314e-15
Cpar41 ib.t1 vss 1.34774e-15
Cpar42 inn inp 5.17500e-17
Cpar43 inn vdd 3.24700e-17
Cpar44 inn vss 2.83643e-15
Cpar45 inn.t0 vss 3.89098e-16
Cpar46 inp vdd 3.14200e-17
Cpar47 inp vss 2.87214e-15
Cpar48 inp.t0 vss 3.95417e-16
Cpar49 out vdd 7.75665e-15
Cpar50 out vss 2.57297e-14
Cpar51 out.t0 vss 3.19127e-16
Cpar52 out.t1 vss 4.02374e-16
Cpar53 out.t7 vss 1.74406e-14
Cpar54 vdd vss 1.82526e-13
Cpar55 vdd.t0 vss 1.11736e-14
Cpar56 vdd.t1 vss 7.66884e-15
Cpar57 vdd.t15 vss 3.47691e-15
Cpar58 vdd.t16 vss 7.19794e-15
Cpar59 vdd.t2 vss 2.39476e-14
Cpar60 vdd.t3 vss 1.79761e-14
.ends opamp_dut

Vdd vdd 0 3.300000
Vss vss 0 0
Ibias vdd ib 2.361100e-06
Vinp inp 0 DC 2.108100 AC 1 PWL(0 2.108100 6.285975e-09 2.108100 6.914573e-09 2.118100)
Rfb out inn 1m
Cload out 0 2.000000e-12
Xdut vdd vss inp inn out ib opamp_dut
.end
