* opa1000[0443]: 200f/nmos_miller_3v3_i1u_subth (nmos_miller, VDD=3.3V, CL=0.2pF, Iref=0.1857uA)
.include "pdk_opa.inc"
.temp 27
.option gmin=1e-12 rshunt=1e12 reltol=1e-3 abstol=1e-12 vntol=1e-5 method=gear
* Post-PEX R+C extracted netlist for nmos_miller_3v3_i1u_subth
.subckt opamp_dut vdd vss inp inn out ib
XMpar0 out.t2 ib.t0 vss.t2 vss.t1 nfet_03v3 w=0.54u l=2.1u ad=2.5488e-13 pd=1.8080e-06 as=2.2032e-13 ps=1.5720e-06 nf=1 m=10 par=10
XMpar1 out.t0 a_4626_1294.t9 vdd.t1 vdd.t0 pfet_03v3 w=3.52u l=1.08u ad=9.8560e-13 pd=4.0800e-06 as=1.2109e-12 ps=4.9120e-06 nf=1 m=10 par=10
XMpar2 a_3046_3148.t4 inn.t0 a_6500_6516.t4 vss.t25 nfet_03v3 w=1.72u l=1.56u ad=6.6507e-13 pd=3.0667e-06 as=4.8160e-13 ps=2.2800e-06 nf=1 m=6 par=6
XMpar3 a_3046_3148.t4 inp.t0 a_4626_1294.t1 vss.t25 nfet_03v3 w=1.72u l=1.56u ad=6.6507e-13 pd=3.0667e-06 as=4.8160e-13 ps=2.2800e-06 nf=1 m=6 par=6
XMpar4 a_3046_3148.t0 ib.t0 vss.t2 vss.t1 nfet_03v3 w=0.54u l=2.1u ad=3.2400e-13 pd=2.2800e-06 as=1.5120e-13 ps=1.1000e-06 nf=1 m=4 par=4
XMpar5 a_6500_6516.t1 a_6500_6516.t0 vdd.t1 vdd.t0 pfet_03v3 w=3.52u l=1.08u ad=9.8560e-13 pd=4.0800e-06 as=9.8560e-13 ps=4.0800e-06 nf=1 m=2 par=2
XMpar6 a_4626_1294.t0 a_6500_6516.t0 vdd.t1 vdd.t0 pfet_03v3 w=3.52u l=1.08u ad=2.1120e-12 pd=8.2400e-06 as=9.8560e-13 ps=4.0800e-06 nf=1 m=2 par=2
XMpar7 ib.t1 ib.t0 vss.t2 vss.t1 nfet_03v3 w=0.54u l=2.1u ad=3.2400e-13 pd=2.2800e-06 as=1.5120e-13 ps=1.1000e-06 nf=1 m=2 par=2
X6 a_9262_3664.t0 a_12626_4184.t0 vss.t0 ppolyf_u_1k r_width=1u r_length=16.16u
X14 a_9262_3664.t0 a_12626_3144.t0 vss.t0 ppolyf_u_1k r_width=1u r_length=16.16u
X23 a_4626_1294.t8 a_12626_3144.t0 vss.t0 ppolyf_u_1k r_width=1u r_length=16.16u
X26 a_12626_5224.t1 out.t17 cap_mim_2f0fF c_width=13.23u c_length=13.23u
X34 a_9262_4704.t0 a_12626_5224.t0 vss.t0 ppolyf_u_1k r_width=1u r_length=16.16u
X41 a_9262_4704.t0 a_12626_4184.t0 vss.t0 ppolyf_u_1k r_width=1u r_length=16.16u
Rpar0 a_12626_5224.t0 a_12626_5224.t1 87.5460
Rpar1 a_3046_3148.t0 a_3046_3148.t4 50.6011
Rpar2 a_4626_1294.t0 a_4626_1294.t1 267.7711
Rpar3 a_4626_1294.t0 a_4626_1294.t9 92.4780
Rpar4 a_4626_1294.t0 a_4626_1294.t8 206.6370
Rpar5 a_4626_1294.t1 a_4626_1294.t9 153.9432
Rpar6 a_4626_1294.t1 a_4626_1294.t8 343.9775
Rpar7 a_4626_1294.t9 a_4626_1294.t8 78.1291
Rpar8 a_6500_6516.t0 a_6500_6516.t1 24.9964
Rpar9 a_6500_6516.t0 a_6500_6516.t4 284.4424
Rpar10 a_6500_6516.t1 a_6500_6516.t4 107.1165
Rpar11 ib ib.t0 13.0947
Rpar12 ib ib.t1 13.2075
Rpar13 ib.t0 ib.t1 33.1987
Rpar14 inn inn.t0 2.3141
Rpar15 inp inp.t0 2.3627
Rpar16 out out.t0 2.2415
Rpar17 out out.t2 137.3806
Rpar18 out out.t17 155.2243
Rpar19 out.t0 out.t2 92.5663
Rpar20 out.t0 out.t17 104.5893
Rpar21 out.t2 out.t17 187.8107
Rpar22 vdd vdd.t0 50.7701
Rpar23 vdd vdd.t1 109.4298
Rpar24 vdd.t0 vdd.t1 3.0266
Rpar25 vss vss.t0 180.5548
Rpar26 vss vss.t1 123.6450
Rpar27 vss vss.t2 136.8630
Rpar28 vss vss.t25 52.9863
Rpar29 vss.t0 vss.t1 37.4722
Rpar30 vss.t0 vss.t2 150.1844
Rpar31 vss.t0 vss.t25 8.8307
Rpar32 vss.t1 vss.t2 25.3635
Rpar33 vss.t1 vss.t25 2.2513
Rpar34 vss.t2 vss.t25 15.0203
Cpar0 a_12626_3144.t0 vss 3.55000e-17
Cpar1 a_12626_4184.t0 vss 3.75000e-17
Cpar2 a_12626_5224.t0 vss 5.72910e-16
Cpar3 a_12626_5224.t1 vss 6.68279e-15
Cpar4 a_3046_3148.t0 vss 1.07275e-14
Cpar5 a_3046_3148.t4 vss 7.53006e-15
Cpar6 a_4626_1294.t0 vss 4.29762e-15
Cpar7 a_4626_1294.t1 vss 4.03132e-15
Cpar8 a_4626_1294.t8 vss 3.03823e-15
Cpar9 a_4626_1294.t9 vss 1.12792e-14
Cpar10 a_6500_6516.t0 vss 4.15286e-15
Cpar11 a_6500_6516.t1 vss 3.82448e-15
Cpar12 a_6500_6516.t4 vss 4.05674e-15
Cpar13 a_9262_3664.t0 vss 4.03600e-17
Cpar14 a_9262_4704.t0 vss 3.51600e-17
Cpar15 ib inp 1.00400e-17
Cpar16 ib out 2.12924e-15
Cpar17 ib vdd 4.11200e-17
Cpar18 ib vss 3.09489e-14
Cpar19 ib.t0 vss 5.74229e-15
Cpar20 ib.t1 vss 5.82512e-16
Cpar21 inn inp 5.12600e-17
Cpar22 inn vss 6.43712e-15
Cpar23 inn.t0 vss 1.05391e-15
Cpar24 inp vss 6.32296e-15
Cpar25 inp.t0 vss 1.08133e-15
Cpar26 out vdd 8.64662e-15
Cpar27 out vss 1.54783e-14
Cpar28 out.t0 vss 4.80030e-15
Cpar29 out.t17 vss 8.14404e-15
Cpar30 out.t2 vss 6.33193e-15
Cpar31 vdd vss 5.58509e-14
Cpar32 vdd.t0 vss 1.59909e-14
Cpar33 vdd.t1 vss 7.86146e-15
.ends opamp_dut

Vdd vdd 0 3.300000
Vss vss 0 0
Ibias vdd ib 1.857000e-07
Vinp inp 0 DC 1.645000 AC 1 PWL(0 1.645000 5.047739e-08 1.645000 5.552513e-08 1.655000)
Rfb out inn 1m
Cload out 0 2.000000e-13
Xdut vdd vss inp inn out ib opamp_dut
.end
