* opa1000[0560]: 2p/pmos_5t_1v8_i150u_subth (pmos_5t, VDD=1.8V, CL=2.0pF, Iref=34.5uA)
.include "pdk_opa.inc"
.temp 27
.option gmin=1e-12 rshunt=1e12 reltol=1e-3 abstol=1e-12 vntol=1e-5 method=gear
* Post-PEX R+C extracted netlist for pmos_5t_1v8_i150u_subth
.subckt opamp_dut vdd vss inp inn out ib
XMpar0 out.t160 a_1764_1204.t160 vss.t1 vss.t0 nfet_03v3 w=1.97u l=0.88u ad=6.1261e-13 pd=2.7826e-06 as=5.5160e-13 ps=2.5300e-06 nf=1 m=62 par=62
XMpar1 a_1764_1204.t161 a_1764_1204.t160 vss.t1 vss.t0 nfet_03v3 w=1.97u l=0.88u ad=6.1261e-13 pd=2.7826e-06 as=6.3294e-13 ps=2.8668e-06 nf=1 m=62 par=62
XMpar2 a_1538_1204.t2 inp.t0 a_1764_1204.t0 vdd.t6 pfet_03v3 w=14u l=0.53u ad=4.1440e-12 pd=1.5292e-05 as=3.9200e-12 ps=1.4560e-05 nf=1 m=160 par=160
XMpar3 a_1538_1204.t2 inn.t0 out.t0 vdd.t6 pfet_03v3 w=14u l=0.53u ad=4.1440e-12 pd=1.5292e-05 as=3.9200e-12 ps=1.4560e-05 nf=1 m=160 par=160
XMpar4 a_1538_1204.t0 a_1500_15854.t6 vdd.t1 vdd.t0 pfet_03v3 w=10u l=0.39u ad=2.8000e-12 pd=1.0560e-05 as=3.0667e-12 ps=1.1447e-05 nf=1 m=24 par=24
XMpar5 a_1500_15854.t7 a_1500_15854.t6 vdd.t1 vdd.t0 pfet_03v3 w=10u l=0.39u ad=2.8000e-12 pd=1.0560e-05 as=2.8000e-12 ps=1.0560e-05 nf=1 m=6 par=6
XMpar6 a_1500_15854.t0 ib.t0 vss.t36 vss.t35 nfet_03v3 w=5.63u l=0.39u ad=1.5764e-12 pd=6.1900e-06 as=1.5764e-12 ps=6.1900e-06 nf=1 m=6 par=6
XMpar7 ib.t1 ib.t0 vss.t36 vss.t35 nfet_03v3 w=5.63u l=0.39u ad=2.1769e-12 pd=8.2800e-06 as=1.5764e-12 ps=6.1900e-06 nf=1 m=6 par=6
X50 out.t222 vss.t14 cap_mim_2f0fF c_width=11.18u c_length=11.18u
Rpar0 a_1500_15854.t0 a_1500_15854.t6 238.8211
Rpar1 a_1500_15854.t0 a_1500_15854.t7 59.3298
Rpar2 a_1500_15854.t6 a_1500_15854.t7 21.0933
Rpar3 a_1538_1204.t0 a_1538_1204.t2 59.5929
Rpar4 a_1764_1204.t0 a_1764_1204.t160 352.4829
Rpar5 a_1764_1204.t0 a_1764_1204.t161 103.4510
Rpar6 a_1764_1204.t160 a_1764_1204.t161 3.5148
Rpar7 ib ib.t0 17.5390
Rpar8 ib ib.t1 2.0418
Rpar9 inn inn.t0 2.6764
Rpar10 inp inp.t0 2.6764
Rpar11 out out.t0 97.1555
Rpar12 out out.t160 2.9006
Rpar13 out out.t222 67.2478
Rpar14 out.t0 out.t222 186.6751
Rpar15 vdd vdd.t0 154.5374
Rpar16 vdd vdd.t1 956.4880
Rpar17 vdd vdd.t6 85.7332
Rpar18 vdd.t0 vdd.t1 3.4637
Rpar19 vdd.t0 vdd.t6 37.7326
Rpar20 vdd.t1 vdd.t6 233.5407
Rpar21 vss vss.t1 393.5162
Rpar22 vss vss.t14 424.0146
Rpar23 vss vss.t35 190.7042
Rpar24 vss vss.t36 270.6797
Rpar25 vss.t0 vss.t1 8.7932
Rpar26 vss.t0 vss.t35 1642.3833
Rpar27 vss.t1 vss.t14 98.8965
Rpar28 vss.t1 vss.t35 193.7332
Rpar29 vss.t1 vss.t36 275.3580
Rpar30 vss.t14 vss.t35 209.0992
Rpar31 vss.t14 vss.t36 296.7891
Rpar32 vss.t35 vss.t36 5.4162
Cpar0 a_1500_15854.t0 vss 7.66030e-15
Cpar1 a_1500_15854.t6 vss 2.51955e-14
Cpar2 a_1500_15854.t7 vss 1.39455e-14
Cpar3 a_1538_1204.t0 vss 4.59689e-14
Cpar4 a_1538_1204.t2 vss 8.08927e-13
Cpar5 a_1764_1204.t0 vss 3.22644e-13
Cpar6 a_1764_1204.t160 vss 8.30310e-14
Cpar7 a_1764_1204.t161 vss 4.26924e-14
Cpar8 ib vdd 5.14600e-17
Cpar9 ib vss 1.73986e-14
Cpar10 ib.t0 vss 9.19761e-16
Cpar11 ib.t1 vss 9.39520e-16
Cpar12 inn inp 2.07280e-16
Cpar13 inn out 6.23258e-14
Cpar14 inn vdd 5.91007e-14
Cpar15 inn vss 2.06459e-14
Cpar16 inn.t0 vss 1.56508e-13
Cpar17 inp vdd 5.91011e-14
Cpar18 inp vss 2.09355e-14
Cpar19 inp.t0 vss 1.56405e-13
Cpar20 out vdd 1.83485e-14
Cpar21 out vss 6.70747e-14
Cpar22 out.t0 vss 3.46475e-13
Cpar23 out.t160 vss 4.18280e-14
Cpar24 out.t222 vss 4.91293e-14
Cpar25 vdd vss 9.59331e-13
Cpar26 vdd.t0 vss 1.74761e-14
Cpar27 vdd.t1 vss 9.18861e-15
Cpar28 vdd.t6 vss 2.20363e-13
.ends opamp_dut

Vdd vdd 0 1.800000
Vss vss 0 0
Ibias vdd ib 3.450000e-05
Vinp inp 0 DC 0.805000 AC 1 PWL(0 0.805000 3.000000e-09 0.805000 3.300000e-09 0.815000)
Rfb out inn 1m
Cload out 0 2.000000e-12
Xdut vdd vss inp inn out ib opamp_dut
.end
