* opa1000[0592]: 200f/pmos_miller_1v8_i1u_subth (pmos_miller, VDD=1.8V, CL=0.2pF, Iref=0.1437uA)
.include "pdk_opa.inc"
.temp 27
.option gmin=1e-12 rshunt=1e12 reltol=1e-3 abstol=1e-12 vntol=1e-5 method=gear
* Post-PEX R+C extracted netlist for pmos_miller_1v8_i1u_subth
.subckt opamp_dut vdd vss inp inn out ib
XMpar0 a_1676_1086.t0 inp.t0 a_3245_7347.t0 vdd.t4 pfet_03v3 w=1.99u l=2.08u ad=5.5720e-13 pd=2.5500e-06 as=7.6947e-13 ps=3.4267e-06 nf=1 m=12 par=12
XMpar1 out.t1 a_1676_1086.t15 vss.t1 vss.t0 nfet_03v3 w=1.33u l=2.25u ad=4.5752e-13 pd=2.2840e-06 as=5.4264e-13 ps=2.6780e-06 nf=1 m=10 par=10
XMpar2 a_3245_7347.t0 inn.t0 a_6352_5337.t0 vdd.t4 pfet_03v3 w=1.99u l=2.08u ad=7.6947e-13 pd=3.4267e-06 as=5.5720e-13 ps=2.5500e-06 nf=1 m=12 par=12
XMpar3 out.t0 a_1229_7139.t0 vdd.t1 vdd.t0 pfet_03v3 w=1.92u l=2.1u ad=6.6048e-13 pd=2.9920e-06 as=5.3760e-13 ps=2.4800e-06 nf=1 m=10 par=10
XMpar4 a_3245_7347.t24 a_1229_7139.t0 vdd.t1 vdd.t0 pfet_03v3 w=1.92u l=2.1u ad=5.3760e-13 pd=2.4800e-06 as=5.3760e-13 ps=2.4800e-06 nf=1 m=4 par=4
XMpar5 a_1229_7139.t4 ib.t0 vss.t23 vss.t22 nfet_03v3 w=0.42u l=2.1u ad=1.1760e-13 pd=9.8000e-07 as=1.1760e-13 ps=9.8000e-07 nf=1 m=2 par=2
XMpar6 a_1229_7139.t1 a_1229_7139.t0 vdd.t1 vdd.t0 pfet_03v3 w=1.92u l=2.1u ad=5.3760e-13 pd=2.4800e-06 as=5.3760e-13 ps=2.4800e-06 nf=1 m=2 par=2
XMpar7 ib.t1 ib.t0 vss.t23 vss.t22 nfet_03v3 w=0.42u l=2.1u ad=2.5200e-13 pd=2.0400e-06 as=1.1760e-13 ps=9.8000e-07 nf=1 m=2 par=2
XMpar8 a_1676_1086.t12 a_6352_5337.t12 vss.t1 vss.t0 nfet_03v3 w=1.33u l=2.25u ad=7.9800e-13 pd=3.8600e-06 as=3.7240e-13 ps=1.8900e-06 nf=1 m=2 par=2
XMpar9 a_6352_5337.t13 a_6352_5337.t12 vss.t1 vss.t0 nfet_03v3 w=1.33u l=2.25u ad=3.7240e-13 pd=1.8900e-06 as=3.7240e-13 ps=1.8900e-06 nf=1 m=2 par=2
X2 a_1676_1086.t14 a_9079_1290.t0 vss.t16 ppolyf_u_1k r_width=1u r_length=16.97u
X17 a_5553_2850.t0 a_9079_3370.t0 vss.t16 ppolyf_u_1k r_width=1u r_length=16.97u
X27 a_5553_2850.t0 a_9079_2330.t0 vss.t16 ppolyf_u_1k r_width=1u r_length=16.97u
X28 a_9079_3370.t1 out.t16 cap_mim_2f0fF c_width=13.23u c_length=13.23u
X36 a_5553_1810.t0 a_9079_2330.t0 vss.t16 ppolyf_u_1k r_width=1u r_length=16.97u
X42 a_5553_1810.t0 a_9079_1290.t0 vss.t16 ppolyf_u_1k r_width=1u r_length=16.97u
Rpar0 a_1229_7139.t0 a_1229_7139.t1 25.2671
Rpar1 a_1229_7139.t0 a_1229_7139.t4 171.0200
Rpar2 a_1229_7139.t1 a_1229_7139.t4 193.6429
Rpar3 a_1676_1086.t0 a_1676_1086.t12 148.7683
Rpar4 a_1676_1086.t0 a_1676_1086.t14 166.6883
Rpar5 a_1676_1086.t0 a_1676_1086.t15 156.4610
Rpar6 a_1676_1086.t12 a_1676_1086.t14 101.0384
Rpar7 a_1676_1086.t12 a_1676_1086.t15 94.8390
Rpar8 a_1676_1086.t14 a_1676_1086.t15 69.0750
Rpar9 a_3245_7347.t0 a_3245_7347.t24 41.0234
Rpar10 a_6352_5337.t0 a_6352_5337.t12 144.7335
Rpar11 a_6352_5337.t0 a_6352_5337.t13 128.7193
Rpar12 a_6352_5337.t12 a_6352_5337.t13 28.2579
Rpar13 a_9079_3370.t0 a_9079_3370.t1 56.0195
Rpar14 ib ib.t0 15.3581
Rpar15 ib ib.t1 8.6309
Rpar16 ib.t0 ib.t1 123.0346
Rpar17 inn inn.t0 2.0406
Rpar18 inp inp.t0 2.0406
Rpar19 out out.t0 360.1666
Rpar20 out out.t1 4.7304
Rpar21 out out.t16 442.0155
Rpar22 out.t0 out.t1 121.8937
Rpar23 out.t0 out.t16 98.2526
Rpar24 out.t1 out.t16 149.5944
Rpar25 vdd vdd.t0 70.3226
Rpar26 vdd vdd.t1 363.7776
Rpar27 vdd vdd.t4 24.4580
Rpar28 vdd.t0 vdd.t1 4.8646
Rpar29 vdd.t0 vdd.t4 219.2586
Rpar30 vdd.t1 vdd.t4 1134.2207
Rpar31 vss vss.t0 450.7224
Rpar32 vss vss.t1 72.7023
Rpar33 vss vss.t16 44.7524
Rpar34 vss vss.t22 605.2752
Rpar35 vss vss.t23 647.0582
Rpar36 vss.t0 vss.t1 23.2958
Rpar37 vss.t0 vss.t16 3.9757
Rpar38 vss.t0 vss.t22 332.6145
Rpar39 vss.t0 vss.t23 358.0039
Rpar40 vss.t1 vss.t16 17.6155
Rpar41 vss.t1 vss.t22 105.8574
Rpar42 vss.t1 vss.t23 113.8147
Rpar43 vss.t16 vss.t22 522.7372
Rpar44 vss.t16 vss.t23 559.5656
Rpar45 vss.t22 vss.t23 18.2957
Cpar0 a_1229_7139.t0 vss 2.77377e-14
Cpar1 a_1229_7139.t1 vss 5.83236e-15
Cpar2 a_1229_7139.t4 vss 4.91249e-15
Cpar3 a_1676_1086.t0 vss 5.59488e-15
Cpar4 a_1676_1086.t12 vss 1.96355e-15
Cpar5 a_1676_1086.t14 vss 1.85181e-15
Cpar6 a_1676_1086.t15 vss 8.80561e-15
Cpar7 a_3245_7347.t0 vss 2.39623e-14
Cpar8 a_3245_7347.t24 vss 7.51874e-15
Cpar9 a_5553_1810.t0 vss 4.30600e-17
Cpar10 a_5553_2850.t0 vss 3.69000e-17
Cpar11 a_6352_5337.t0 vss 7.94168e-15
Cpar12 a_6352_5337.t12 vss 5.49474e-15
Cpar13 a_6352_5337.t13 vss 2.10617e-15
Cpar14 a_9079_1290.t0 vss 3.68800e-17
Cpar15 a_9079_2330.t0 vss 4.59600e-17
Cpar16 a_9079_3370.t0 vss 1.02370e-16
Cpar17 a_9079_3370.t1 vss 2.26322e-15
Cpar18 ib vdd 2.40000e-17
Cpar19 ib vss 8.12095e-15
Cpar20 ib.t0 vss 9.47569e-16
Cpar21 ib.t1 vss 7.46446e-17
Cpar22 inn inp 1.02790e-16
Cpar23 inn vdd 1.21167e-14
Cpar24 inn vss 3.87994e-15
Cpar25 inn.t0 vss 1.45630e-14
Cpar26 inp vdd 1.23003e-14
Cpar27 inp vss 3.87922e-15
Cpar28 inp.t0 vss 1.46318e-14
Cpar29 out vdd 7.32550e-15
Cpar30 out vss 2.30334e-14
Cpar31 out.t0 vss 6.24520e-15
Cpar32 out.t1 vss 3.59755e-15
Cpar33 out.t16 vss 7.50107e-15
Cpar34 vdd vss 1.41433e-13
Cpar35 vdd.t0 vss 2.41755e-14
Cpar36 vdd.t1 vss 6.41467e-15
Cpar37 vdd.t4 vss 3.35393e-14
.ends opamp_dut

Vdd vdd 0 1.800000
Vss vss 0 0
Ibias vdd ib 1.437000e-07
Vinp inp 0 DC 0.805000 AC 1 PWL(0 0.805000 7.298254e-08 0.805000 8.028080e-08 0.815000)
Rfb out inn 1m
Cload out 0 2.000000e-13
Xdut vdd vss inp inn out ib opamp_dut
.end
