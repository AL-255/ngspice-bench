* opa1000[0931]: 200f/telescopic_pmos_1v8_i10u_weak (telescopic_pmos, VDD=1.8V, CL=0.2pF, Iref=2.6uA)
.include "pdk_opa.inc"
.temp 27
.option gmin=1e-12 rshunt=1e12 reltol=1e-3 abstol=1e-12 vntol=1e-5 method=gear
* Post-PEX R+C extracted netlist for telescopic_pmos_1v8_i10u_weak
.subckt opamp_dut vdd vss inp inn out ib
XMpar0 a_1832_8247.t0 ib.t0 vss.t5 vss.t4 nfet_03v3 w=1.3u l=1.2u ad=3.6400e-13 pd=1.8600e-06 as=3.6400e-13 ps=1.8600e-06 nf=1 m=2 par=2
XMpar1 a_2336_1249.t0 inn.t0 a_8174_1249.t0 vdd.t1 pfet_03v3 w=1.95u l=1.95u ad=6.3514e-13 pd=2.8800e-06 as=5.7571e-13 ps=2.6333e-06 nf=1 m=42 par=42
XMpar2 a_2766_10388.t1 a_2766_10388.t0 a_4644_6349.t4 vss.t2 nfet_03v3 w=2u l=0.94u ad=5.6000e-13 pd=2.5600e-06 as=1.2000e-12 ps=5.2000e-06 nf=1 m=4 par=4
XMpar3 a_4644_6349.t0 a_2766_10388.t26 vss.t1 vss.t0 nfet_03v3 w=1.59u l=2.25u ad=6.1480e-13 pd=2.8933e-06 as=4.4520e-13 ps=2.1500e-06 nf=1 m=6 par=6
XMpar4 a_8174_1249.t42 vss.t41 out.t0 vdd.t0 pfet_03v3 w=2.02u l=0.94u ad=6.3742e-13 pd=2.8756e-06 as=5.6560e-13 ps=2.5800e-06 nf=1 m=18 par=18
XMpar5 a_5776_6349.t0 a_2766_10388.t0 out.t2 vss.t2 nfet_03v3 w=2u l=0.94u ad=8.8000e-13 pd=3.8800e-06 as=5.6000e-13 ps=2.5600e-06 nf=1 m=4 par=4
XMpar6 a_2336_1249.t0 inp.t0 a_2458_10388.t0 vdd.t1 pfet_03v3 w=1.95u l=1.95u ad=6.3514e-13 pd=2.8800e-06 as=5.7571e-13 ps=2.6333e-06 nf=1 m=42 par=42
XMpar7 a_2458_10388.t42 vss.t41 a_2766_10388.t8 vdd.t0 pfet_03v3 w=2.02u l=0.94u ad=6.3742e-13 pd=2.8756e-06 as=5.6560e-13 ps=2.5800e-06 nf=1 m=18 par=18
XMpar8 a_5776_6349.t2 a_2766_10388.t26 vss.t1 vss.t0 nfet_03v3 w=1.59u l=2.25u ad=4.4520e-13 pd=2.1500e-06 as=4.4520e-13 ps=2.1500e-06 nf=1 m=6 par=6
XMpar9 a_1832_8247.t3 a_1832_8247.t2 vdd.t24 vdd.t23 pfet_03v3 w=5.79u l=1.2u ad=1.6212e-12 pd=6.3500e-06 as=1.6212e-12 ps=6.3500e-06 nf=1 m=2 par=2
XMpar10 a_2336_1249.t42 a_1832_8247.t2 vdd.t24 vdd.t23 pfet_03v3 w=5.79u l=1.2u ad=1.6212e-12 pd=6.3500e-06 as=2.0844e-12 ps=7.9575e-06 nf=1 m=8 par=8
XMpar11 ib.t1 ib.t0 vss.t5 vss.t4 nfet_03v3 w=1.3u l=1.2u ad=7.8000e-13 pd=3.8000e-06 as=3.6400e-13 ps=1.8600e-06 nf=1 m=2 par=2
X76 out.t22 vss.t37 cap_mim_2f0fF c_width=16.58u c_length=16.59u
Rpar0 a_1832_8247.t0 a_1832_8247.t2 244.4315
Rpar1 a_1832_8247.t0 a_1832_8247.t3 141.5313
Rpar2 a_1832_8247.t2 a_1832_8247.t3 22.7885
Rpar3 a_2336_1249.t0 a_2336_1249.t42 73.3247
Rpar4 a_2458_10388.t0 a_2458_10388.t42 49.5858
Rpar5 a_2766_10388.t0 a_2766_10388.t1 20.5841
Rpar6 a_2766_10388.t0 a_2766_10388.t8 391.3787
Rpar7 a_2766_10388.t0 a_2766_10388.t26 209.5217
Rpar8 a_2766_10388.t1 a_2766_10388.t8 140.2976
Rpar9 a_2766_10388.t1 a_2766_10388.t26 75.1073
Rpar10 a_2766_10388.t8 a_2766_10388.t26 151.6561
Rpar11 a_4644_6349.t0 a_4644_6349.t4 56.1228
Rpar12 a_5776_6349.t0 a_5776_6349.t2 50.1936
Rpar13 a_8174_1249.t0 a_8174_1249.t42 49.5858
Rpar14 ib ib.t0 16.5827
Rpar15 ib ib.t1 6.8458
Rpar16 ib.t0 ib.t1 164.6862
Rpar17 inn inn.t0 1.5717
Rpar18 inp inp.t0 1.5717
Rpar19 out out.t0 2.2419
Rpar20 out out.t2 68.6656
Rpar21 out out.t22 56.2746
Rpar22 out.t2 out.t22 286.0150
Rpar23 vdd vdd.t0 49.8723
Rpar24 vdd vdd.t1 703.9843
Rpar25 vdd vdd.t23 107.6280
Rpar26 vdd vdd.t24 265.8334
Rpar27 vdd.t0 vdd.t1 109.0931
Rpar28 vdd.t0 vdd.t23 55.4737
Rpar29 vdd.t0 vdd.t24 137.0161
Rpar30 vdd.t1 vdd.t23 783.0528
Rpar31 vdd.t1 vdd.t24 1934.0838
Rpar32 vdd.t23 vdd.t24 5.3095
Rpar33 vss vss.t0 343.8539
Rpar34 vss vss.t1 648.9690
Rpar35 vss vss.t4 188.6650
Rpar36 vss vss.t5 371.1132
Rpar37 vss vss.t2 329.3122
Rpar38 vss vss.t37 2532.8876
Rpar39 vss vss.t41 143.1610
Rpar40 vss.t0 vss.t1 11.1639
Rpar41 vss.t0 vss.t4 213.5716
Rpar42 vss.t0 vss.t5 420.2461
Rpar43 vss.t0 vss.t2 2.5183
Rpar44 vss.t0 vss.t37 267.3353
Rpar45 vss.t0 vss.t41 398.2637
Rpar46 vss.t1 vss.t4 400.5444
Rpar47 vss.t1 vss.t5 788.2012
Rpar48 vss.t1 vss.t2 11.1225
Rpar49 vss.t1 vss.t37 503.7970
Rpar50 vss.t1 vss.t41 751.6588
Rpar51 vss.t4 vss.t5 12.5881
Rpar52 vss.t4 vss.t2 204.8272
Rpar53 vss.t4 vss.t37 1618.8923
Rpar54 vss.t4 vss.t41 218.5184
Rpar55 vss.t5 vss.t2 403.0345
Rpar56 vss.t5 vss.t37 3184.6340
Rpar57 vss.t5 vss.t41 429.8364
Rpar58 vss.t2 vss.t37 264.2900
Rpar59 vss.t2 vss.t41 381.4209
Rpar60 vss.t37 vss.t41 2933.6795
Cpar0 a_1832_8247.t0 vss 2.86408e-15
Cpar1 a_1832_8247.t2 vss 1.53492e-14
Cpar2 a_1832_8247.t3 vss 4.70272e-15
Cpar3 a_2336_1249.t0 vss 6.29316e-14
Cpar4 a_2336_1249.t42 vss 1.40474e-14
Cpar5 a_2458_10388.t0 vss 3.64370e-14
Cpar6 a_2458_10388.t42 vss 1.39317e-14
Cpar7 a_2766_10388.t0 vss 3.66181e-15
Cpar8 a_2766_10388.t1 vss 2.59797e-15
Cpar9 a_2766_10388.t26 vss 1.04709e-14
Cpar10 a_2766_10388.t8 vss 5.96191e-15
Cpar11 a_4644_6349.t0 vss 4.53495e-15
Cpar12 a_4644_6349.t4 vss 4.54855e-15
Cpar13 a_5776_6349.t0 vss 5.14385e-15
Cpar14 a_5776_6349.t2 vss 5.69302e-15
Cpar15 a_8174_1249.t0 vss 3.48222e-14
Cpar16 a_8174_1249.t42 vss 1.33141e-14
Cpar17 ib vss 6.49508e-15
Cpar18 ib.t0 vss 6.61097e-16
Cpar19 ib.t1 vss 9.30344e-17
Cpar20 inn inp 1.35280e-16
Cpar21 inn vdd 3.44144e-14
Cpar22 inn vss 5.13742e-15
Cpar23 inn.t0 vss 5.19192e-14
Cpar24 inp vdd 3.45147e-14
Cpar25 inp vss 5.21752e-15
Cpar26 inp.t0 vss 5.20192e-14
Cpar27 out vdd 4.91376e-15
Cpar28 out vss 1.81711e-14
Cpar29 out.t0 vss 8.14211e-16
Cpar30 out.t2 vss 6.64447e-16
Cpar31 out.t22 vss 1.37084e-14
Cpar32 vdd vss 3.35612e-13
Cpar33 vdd.t0 vss 2.68517e-14
Cpar34 vdd.t1 vss 8.01135e-14
Cpar35 vdd.t23 vss 1.20069e-14
Cpar36 vdd.t24 vss 5.90191e-15
.ends opamp_dut

Vdd vdd 0 1.800000
Vss vss 0 0
Ibias vdd ib 2.600000e-06
Vinp inp 0 DC 0.805000 AC 1 PWL(0 0.805000 7.121499e-09 0.805000 7.833649e-09 0.815000)
Rfb out inn 1m
Cload out 0 2.000000e-13
Xdut vdd vss inp inn out ib opamp_dut
.end
