* opa1000[0436]: 200f/nmos_miller_1v8_i150u_weak (nmos_miller, VDD=1.8V, CL=0.2pF, Iref=27.8571uA)
.include "pdk_opa.inc"
.temp 27
.option gmin=1e-12 rshunt=1e12 reltol=1e-3 abstol=1e-12 vntol=1e-5 method=gear
* Post-PEX R+C extracted netlist for nmos_miller_1v8_i150u_weak
.subckt opamp_dut vdd vss inp inn out ib
XMpar0 a_1938_13702.t0 inp.t0 a_995_8077.t0 vss.t0 nfet_03v3 w=2.01u l=0.56u ad=6.2712e-13 pd=2.8350e-06 as=5.6280e-13 ps=2.5700e-06 nf=1 m=20 par=20
XMpar1 a_1938_13702.t0 inn.t0 a_5444_7848.t0 vss.t0 nfet_03v3 w=2.01u l=0.56u ad=6.3051e-13 pd=2.8489e-06 as=5.6280e-13 ps=2.5700e-06 nf=1 m=19 par=19
XMpar2 a_995_8077.t21 a_5444_7848.t20 vdd.t1 vdd.t0 pfet_03v3 w=10u l=0.6u ad=3.8667e-12 pd=1.4107e-05 as=2.8000e-12 ps=1.0560e-05 nf=1 m=6 par=6
XMpar3 out.t3 a_995_8077.t27 vdd.t1 vdd.t0 pfet_03v3 w=10u l=0.6u ad=3.0133e-12 pd=1.1269e-05 as=3.0133e-12 ps=1.1269e-05 nf=1 m=30 par=30
XMpar4 ib.t1 ib.t0 vss.t0 vss.t0 nfet_03v3 w=1.53u l=0.39u ad=4.2840e-13 pd=2.0900e-06 as=5.9160e-13 ps=2.8133e-06 nf=1 m=6 par=6
XMpar5 out.t0 ib.t0 vss.t0 vss.t0 nfet_03v3 w=1.53u l=0.39u ad=4.6104e-13 pd=2.2347e-06 as=4.2840e-13 ps=2.0900e-06 nf=1 m=30 par=30
XMpar6 a_5444_7848.t21 a_5444_7848.t20 vdd.t1 vdd.t0 pfet_03v3 w=10u l=0.6u ad=2.8000e-12 pd=1.0560e-05 as=2.8000e-12 ps=1.0560e-05 nf=1 m=6 par=6
XMpar7 a_1938_13702.t20 ib.t0 vss.t0 vss.t0 nfet_03v3 w=1.53u l=0.39u ad=4.2840e-13 pd=2.0900e-06 as=4.2840e-13 ps=2.0900e-06 nf=1 m=11 par=11
XMpar8 a_1938_13702.t20 ib.t0 vss.t0 vss.t16 nfet_03v3 w=1.53u l=0.39u ad=4.2840e-13 pd=2.0900e-06 as=4.2840e-13 ps=2.0900e-06 nf=1 m=1
XMpar9 a_1938_13702.t0 inn.t0 a_5444_7848.t0 vss.t16 nfet_03v3 w=2.01u l=0.56u ad=5.6280e-13 pd=2.5700e-06 as=5.6280e-13 ps=2.5700e-06 nf=1 m=1
X26 a_995_8077.t20 a_1327_8077.t0 vss.t135 ppolyf_u_1k r_width=1u r_length=1u
X128 a_1327_8077.t1 out.t50 cap_mim_2f0fF c_width=17.5u c_length=17.5u
Rpar0 a_1327_8077.t0 a_1327_8077.t1 58.1088
Rpar1 a_1938_13702.t0 a_1938_13702.t20 34.5309
Rpar2 a_5444_7848.t0 a_5444_7848.t20 755.3847
Rpar3 a_5444_7848.t0 a_5444_7848.t21 63.5132
Rpar4 a_5444_7848.t20 a_5444_7848.t21 22.2962
Rpar5 a_995_8077.t0 a_995_8077.t20 67.6014
Rpar6 a_995_8077.t0 a_995_8077.t21 129.2069
Rpar7 a_995_8077.t0 a_995_8077.t27 337.1383
Rpar8 a_995_8077.t20 a_995_8077.t21 108.5597
Rpar9 a_995_8077.t20 a_995_8077.t27 283.2638
Rpar10 a_995_8077.t21 a_995_8077.t27 66.6009
Rpar11 ib ib.t0 11.3042
Rpar12 ib ib.t1 2.8940
Rpar13 inn inn.t0 1.6585
Rpar14 inp inp.t0 2.0289
Rpar15 out out.t0 441.2232
Rpar16 out out.t3 1.8859
Rpar17 out out.t50 418.8992
Rpar18 out.t0 out.t3 95.4491
Rpar19 out.t0 out.t50 367.9846
Rpar20 out.t3 out.t50 90.6198
Rpar21 vdd vdd.t0 51.6975
Rpar22 vdd vdd.t1 492.7741
Rpar23 vdd.t0 vdd.t1 3.7666
Rpar24 vss vss.t0 68.3177
Rpar25 vss vss.t135 957.2766
Rpar26 vss vss.t16 8303.6400
Rpar27 vss.t0 vss.t135 31.2599
Rpar28 vss.t0 vss.t16 3.7815
Rpar29 vss.t135 vss.t16 3160.3239
Cpar0 a_1327_8077.t0 vss 4.25200e-17
Cpar1 a_1327_8077.t1 vss 2.25703e-15
Cpar2 a_1938_13702.t0 vss 2.12409e-14
Cpar3 a_1938_13702.t20 vss 6.92804e-15
Cpar4 a_5444_7848.t0 vss 9.61360e-15
Cpar5 a_5444_7848.t20 vss 1.35263e-14
Cpar6 a_5444_7848.t21 vss 1.29123e-14
Cpar7 a_995_8077.t0 vss 9.04459e-15
Cpar8 a_995_8077.t20 vss 2.18024e-15
Cpar9 a_995_8077.t21 vss 1.38559e-14
Cpar10 a_995_8077.t27 vss 3.62395e-14
Cpar11 ib inn 1.39600e-17
Cpar12 ib out 2.48833e-15
Cpar13 ib vdd 5.47600e-17
Cpar14 ib vss 3.00946e-14
Cpar15 ib.t0 vss 2.85463e-15
Cpar16 ib.t1 vss 5.24575e-17
Cpar17 inn inp 5.25900e-17
Cpar18 inn vdd 5.55500e-17
Cpar19 inn vss 1.16704e-14
Cpar20 inn.t0 vss 1.61736e-15
Cpar21 inp vdd 3.36500e-17
Cpar22 inp vss 1.14477e-14
Cpar23 inp.t0 vss 1.97005e-15
Cpar24 out vdd 5.31279e-14
Cpar25 out vss 3.12909e-14
Cpar26 out.t0 vss 8.61621e-15
Cpar27 out.t3 vss 4.74565e-14
Cpar28 out.t50 vss 1.38886e-14
Cpar29 vdd vss 1.36040e-13
Cpar30 vdd.t0 vss 7.28607e-14
Cpar31 vdd.t1 vss 2.88127e-14
.ends opamp_dut

Vdd vdd 0 1.800000
Vss vss 0 0
Ibias vdd ib 2.785710e-05
Vinp inp 0 DC 0.895000 AC 1 PWL(0 0.895000 3.000000e-09 0.895000 3.300000e-09 0.905000)
Rfb out inn 1m
Cload out 0 2.000000e-13
Xdut vdd vss inp inn out ib opamp_dut
.end
