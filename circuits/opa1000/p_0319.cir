* opa1000[0319]: 2p/folded_cascode_pmos_3v3_i1u_weak (folded_cascode_pmos, VDD=3.3V, CL=2.0pF, Iref=0.2889uA)
.include "pdk_opa.inc"
.temp 27
.option gmin=1e-12 rshunt=1e12 reltol=1e-3 abstol=1e-12 vntol=1e-5 method=gear
* Post-PEX R+C extracted netlist for folded_cascode_pmos_3v3_i1u_weak
.subckt opamp_dut vdd vss inp inn out ib
XMpar0 a_5314_8382.t0 a_3799_1204.t0 vdd.t1 vdd.t0 pfet_03v3 w=2.49u l=6.75u ad=6.9720e-13 pd=3.0500e-06 as=1.0956e-12 ps=4.6150e-06 nf=1 m=4 par=4
XMpar1 a_3799_1204.t1 a_3799_1204.t0 vdd.t1 vdd.t0 pfet_03v3 w=2.49u l=6.75u ad=6.9720e-13 pd=3.0500e-06 as=6.9720e-13 ps=3.0500e-06 nf=1 m=2 par=2
XMpar2 a_3799_1204.t4 ib.t0 vss.t5 vss.t4 nfet_03v3 w=0.78u l=5.25u ad=4.6800e-13 pd=2.7600e-06 as=2.1840e-13 ps=1.3400e-06 nf=1 m=2 par=2
XMpar3 a_4912_17157.t0 a_3799_1204.t6 a_6384_5944.t8 vss.t0 nfet_03v3 w=0.58u l=2.13u ad=1.6240e-13 pd=1.1400e-06 as=3.4800e-13 ps=2.3600e-06 nf=1 m=2 par=2
XMpar4 a_7854_13453.t9 ib.t0 vss.t5 vss.t4 nfet_03v3 w=0.78u l=5.25u ad=2.1840e-13 pd=1.3400e-06 as=4.6800e-13 ps=2.7600e-06 nf=1 m=4 par=4
XMpar5 a_4912_17157.t3 a_4912_17157.t2 vdd.t1 vdd.t0 pfet_03v3 w=2.49u l=6.75u ad=1.4940e-12 pd=6.1800e-06 as=6.9720e-13 ps=3.0500e-06 nf=1 m=2 par=2
XMpar6 a_5314_8382.t2 inn.t0 a_7854_13453.t1 vdd.t6 pfet_03v3 w=1.97u l=5u ad=1.1820e-12 pd=5.1400e-06 as=5.5160e-13 ps=2.5300e-06 nf=1 m=8 par=8
XMpar7 a_6384_5944.t10 ib.t0 vss.t5 vss.t4 nfet_03v3 w=0.78u l=5.25u ad=2.1840e-13 pd=1.3400e-06 as=4.6800e-13 ps=2.7600e-06 nf=1 m=4 par=4
XMpar8 a_7854_13453.t0 a_3799_1204.t6 out.t0 vss.t0 nfet_03v3 w=0.58u l=2.13u ad=3.4800e-13 pd=2.3600e-06 as=1.6240e-13 ps=1.1400e-06 nf=1 m=2 par=2
XMpar9 a_5314_8382.t2 inp.t0 a_6384_5944.t0 vdd.t6 pfet_03v3 w=1.97u l=5u ad=1.1820e-12 pd=5.1400e-06 as=5.5160e-13 ps=2.5300e-06 nf=1 m=8 par=8
XMpar10 out.t1 a_4912_17157.t2 vdd.t1 vdd.t0 pfet_03v3 w=2.49u l=6.75u ad=6.9720e-13 pd=3.0500e-06 as=6.9720e-13 ps=3.0500e-06 nf=1 m=2 par=2
XMpar11 ib.t1 ib.t0 vss.t5 vss.t4 nfet_03v3 w=0.78u l=5.25u ad=4.6800e-13 pd=2.7600e-06 as=2.1840e-13 ps=1.3400e-06 nf=1 m=2 par=2
X6 out.t4 vss.t3 cap_mim_2f0fF c_width=15u c_length=15u
Rpar0 a_3799_1204.t0 a_3799_1204.t1 26.4913
Rpar1 a_3799_1204.t0 a_3799_1204.t4 294.9290
Rpar2 a_3799_1204.t0 a_3799_1204.t6 153.3219
Rpar3 a_3799_1204.t1 a_3799_1204.t4 289.2097
Rpar4 a_3799_1204.t1 a_3799_1204.t6 150.3486
Rpar5 a_3799_1204.t4 a_3799_1204.t6 124.3459
Rpar6 a_4912_17157.t0 a_4912_17157.t2 210.6952
Rpar7 a_4912_17157.t0 a_4912_17157.t3 82.4398
Rpar8 a_4912_17157.t2 a_4912_17157.t3 17.9551
Rpar9 a_5314_8382.t0 a_5314_8382.t2 61.9401
Rpar10 a_6384_5944.t0 a_6384_5944.t10 61.7703
Rpar11 a_6384_5944.t0 a_6384_5944.t8 57.5828
Rpar12 a_6384_5944.t10 a_6384_5944.t8 123.0600
Rpar13 a_7854_13453.t0 a_7854_13453.t1 57.5828
Rpar14 a_7854_13453.t0 a_7854_13453.t9 123.0600
Rpar15 a_7854_13453.t1 a_7854_13453.t9 61.7703
Rpar16 ib ib.t0 9.3156
Rpar17 ib ib.t1 10.6580
Rpar18 ib.t0 ib.t1 32.4964
Rpar19 inn inn.t0 2.7421
Rpar20 inp inp.t0 2.7421
Rpar21 out out.t0 94.8033
Rpar22 out out.t1 169.6613
Rpar23 out out.t4 15.4213
Rpar24 out.t0 out.t1 123.9658
Rpar25 out.t0 out.t4 885.9871
Rpar26 out.t1 out.t4 1585.5747
Rpar27 vdd vdd.t0 37.3618
Rpar28 vdd vdd.t1 48.7100
Rpar29 vdd vdd.t6 853.9397
Rpar30 vdd.t0 vdd.t1 4.9433
Rpar31 vdd.t0 vdd.t6 77.6233
Rpar32 vdd.t1 vdd.t6 129.9344
Rpar33 vss vss.t0 784.6111
Rpar34 vss vss.t5 64.9950
Rpar35 vss vss.t4 92.4805
Rpar36 vss vss.t3 85.0146
Rpar37 vss.t0 vss.t5 170.7645
Rpar38 vss.t0 vss.t4 94.3431
Rpar39 vss.t0 vss.t3 1890.1569
Rpar40 vss.t5 vss.t4 7.3067
Rpar41 vss.t5 vss.t3 140.0409
Rpar42 vss.t4 vss.t3 208.8722
Cpar0 a_3799_1204.t0 vss 2.75641e-14
Cpar1 a_3799_1204.t1 vss 4.46298e-15
Cpar2 a_3799_1204.t4 vss 6.43225e-15
Cpar3 a_3799_1204.t6 vss 6.14248e-15
Cpar4 a_4912_17157.t0 vss 1.86659e-15
Cpar5 a_4912_17157.t2 vss 1.85736e-14
Cpar6 a_4912_17157.t3 vss 5.40610e-15
Cpar7 a_5314_8382.t0 vss 8.82313e-15
Cpar8 a_5314_8382.t2 vss 3.04202e-14
Cpar9 a_6384_5944.t0 vss 1.32216e-14
Cpar10 a_6384_5944.t10 vss 6.05199e-15
Cpar11 a_6384_5944.t8 vss 3.00322e-15
Cpar12 a_7854_13453.t0 vss 2.97553e-15
Cpar13 a_7854_13453.t1 vss 1.30997e-14
Cpar14 a_7854_13453.t9 vss 5.99623e-15
Cpar15 ib inn 2.01600e-17
Cpar16 ib inp 2.01600e-17
Cpar17 ib out 1.75500e-16
Cpar18 ib vdd 2.05200e-17
Cpar19 ib vss 4.20505e-14
Cpar20 ib.t0 vss 7.46511e-15
Cpar21 ib.t1 vss 3.46078e-16
Cpar22 inn inp 2.05060e-16
Cpar23 inn vdd 1.63180e-14
Cpar24 inn vss 4.04802e-15
Cpar25 inn.t0 vss 2.15132e-14
Cpar26 inp vdd 1.62569e-14
Cpar27 inp vss 3.96483e-15
Cpar28 inp.t0 vss 2.15315e-14
Cpar29 out vdd 5.58061e-15
Cpar30 out vss 1.73815e-14
Cpar31 out.t0 vss 6.07824e-16
Cpar32 out.t1 vss 9.47349e-16
Cpar33 out.t4 vss 1.07219e-14
Cpar34 vdd vss 2.15020e-13
Cpar35 vdd.t0 vss 2.90548e-14
Cpar36 vdd.t1 vss 2.03848e-14
Cpar37 vdd.t6 vss 4.50580e-14
.ends opamp_dut

Vdd vdd 0 3.300000
Vss vss 0 0
Ibias vdd ib 2.889000e-07
Vinp inp 0 DC 1.381000 AC 1 PWL(0 1.381000 3.112400e-07 1.381000 3.423640e-07 1.391000)
Rfb out inn 1m
Cload out 0 2.000000e-12
Xdut vdd vss inp inn out ib opamp_dut
.end
