* opa1000[0013]: 200f/cherry_hooper_1v8_i20u_weak (cherry_hooper, VDD=1.8V, CL=0.2pF, Iref=1.0714uA)
.include "pdk_opa.inc"
.temp 27
.option gmin=1e-12 rshunt=1e12 reltol=1e-3 abstol=1e-12 vntol=1e-5 method=gear
* Post-PEX R+C extracted netlist for cherry_hooper_1v8_i20u_weak
.subckt opamp_dut vdd vss inp inn out ib
XMpar0 a_5970_2983.t11 a_5970_2983.t10 vdd.t4 vdd.t3 pfet_03v3 w=8.08u l=0.6u ad=2.2624e-12 pd=8.6400e-06 as=3.5552e-12 ps=1.3000e-05 nf=1 m=4 par=4
XMpar1 a_11494_11010.t2 a_5970_2983.t18 a_7320_9711.t2 vss.t32 nfet_03v3 w=5.6u l=0.5u ad=1.5680e-12 pd=6.1600e-06 as=3.3600e-12 ps=1.2400e-05 nf=1 m=2 par=2
XMpar2 a_5970_2983.t0 a_10458_3236.t8 a_6199_6137.t0 vss.t32 nfet_03v3 w=8.95u l=0.5u ad=3.9380e-12 pd=1.4305e-05 as=2.5060e-12 ps=9.5100e-06 nf=1 m=2 par=2
XMpar3 a_17468_6138.t0 a_8596_7844.t1 a_8596_7844.t2 vdd.t1 pfet_03v3 w=10u l=0.6u ad=3.2000e-12 pd=1.1890e-05 as=2.8000e-12 ps=1.0560e-05 nf=1 m=16 par=16
XMpar4 a_12014_1204.t4 inn.t0 a_7607_6137.t2 vss.t34 nfet_03v3 w=0.97u l=0.9u ad=2.7160e-13 pd=1.5300e-06 as=5.8200e-13 ps=3.1400e-06 nf=1 m=2 par=2
XMpar5 a_6199_6137.t2 ib.t0 vss.t3 vss.t2 nfet_03v3 w=1.08u l=1.2u ad=3.0240e-13 pd=1.6400e-06 as=3.8880e-13 ps=2.0700e-06 nf=1 m=8 par=8
XMpar6 a_7968_7844.t2 a_7968_7844.t1 vdd.t20 vdd.t19 pfet_03v3 w=3.28u l=1.2u ad=1.9680e-12 pd=7.7600e-06 as=1.9680e-12 ps=7.7600e-06 nf=1 m=1
XMpar7 a_12014_1204.t0 a_8596_7844.t33 a_12014_7844.t8 vdd.t0 pfet_03v3 w=6.73u l=1u ad=2.3151e-12 pd=8.7640e-06 as=2.3151e-12 ps=8.7640e-06 nf=1 m=5 par=5
XMpar8 a_12014_7844.t1 a_12014_7844.t0 vdd.t4 vdd.t3 pfet_03v3 w=8.08u l=0.6u ad=2.2624e-12 pd=8.6400e-06 as=3.5552e-12 ps=1.3000e-05 nf=1 m=4 par=4
XMpar9 a_8596_7844.t0 ib.t0 vss.t3 vss.t2 nfet_03v3 w=1.08u l=1.2u ad=6.4800e-13 pd=3.3600e-06 as=6.4800e-13 ps=3.3600e-06 nf=1 m=1
XMpar10 a_12014_7844.t13 a_12014_1204.t8 a_6199_6137.t0 vss.t32 nfet_03v3 w=8.95u l=0.5u ad=3.9380e-12 pd=1.4305e-05 as=2.5060e-12 ps=9.5100e-06 nf=1 m=2 par=2
XMpar11 a_7607_6137.t0 ib.t0 vss.t3 vss.t2 nfet_03v3 w=1.08u l=1.2u ad=3.0240e-13 pd=1.6400e-06 as=3.0240e-13 ps=1.6400e-06 nf=1 m=2 par=2
XMpar12 a_10458_3236.t0 a_8596_7844.t33 a_5970_2983.t5 vdd.t0 pfet_03v3 w=6.73u l=1u ad=2.3151e-12 pd=8.7640e-06 as=2.3151e-12 ps=8.7640e-06 nf=1 m=5 par=5
XMpar13 a_5970_2983.t0 a_10458_3236.t8 a_6199_6137.t0 vss.t0 nfet_03v3 w=8.95u l=0.5u ad=2.5060e-12 pd=9.5100e-06 as=3.4607e-12 ps=1.2707e-05 nf=1 m=3 par=3
XMpar14 a_12014_7844.t13 a_12014_1204.t8 a_6199_6137.t0 vss.t0 nfet_03v3 w=8.95u l=0.5u ad=2.5060e-12 pd=9.5100e-06 as=3.4607e-12 ps=1.2707e-05 nf=1 m=3 par=3
XMpar15 a_10458_3236.t7 a_7968_7844.t1 vdd.t20 vdd.t19 pfet_03v3 w=3.28u l=1.2u ad=1.9680e-12 pd=7.7600e-06 as=1.9680e-12 ps=7.7600e-06 nf=1 m=1
XMpar16 a_12014_1204.t1 a_7968_7844.t1 vdd.t20 vdd.t19 pfet_03v3 w=3.28u l=1.2u ad=1.9680e-12 pd=7.7600e-06 as=1.9680e-12 ps=7.7600e-06 nf=1 m=1
XMpar17 out.t1 a_11494_11010.t0 vdd.t4 vdd.t3 pfet_03v3 w=8.08u l=0.6u ad=4.8480e-12 pd=1.7360e-05 as=2.2624e-12 ps=8.6400e-06 nf=1 m=1
XMpar18 a_7320_9711.t2 a_12014_7844.t18 out.t0 vss.t32 nfet_03v3 w=5.6u l=0.5u ad=3.3600e-12 pd=1.2400e-05 as=1.5680e-12 ps=6.1600e-06 nf=1 m=2 par=2
XMpar19 ib.t1 ib.t0 vss.t3 vss.t2 nfet_03v3 w=1.08u l=1.2u ad=6.4800e-13 pd=3.3600e-06 as=3.0240e-13 ps=1.6400e-06 nf=1 m=1
XMpar20 a_7968_7844.t0 ib.t0 vss.t3 vss.t2 nfet_03v3 w=1.08u l=1.2u ad=6.4800e-13 pd=3.3600e-06 as=3.0240e-13 ps=1.6400e-06 nf=1 m=1
XMpar21 a_7320_9711.t0 ib.t0 vss.t3 vss.t2 nfet_03v3 w=1.08u l=1.2u ad=3.0240e-13 pd=1.6400e-06 as=6.4800e-13 ps=3.3600e-06 nf=1 m=2 par=2
XMpar22 a_17468_6138.t16 a_17468_6138.t15 vdd.t4 vdd.t3 pfet_03v3 w=8.08u l=0.6u ad=4.8480e-12 pd=1.7360e-05 as=4.8480e-12 ps=1.7360e-05 nf=1 m=1
XMpar23 a_11494_11010.t1 a_11494_11010.t0 vdd.t4 vdd.t3 pfet_03v3 w=8.08u l=0.6u ad=4.8480e-12 pd=1.7360e-05 as=2.2624e-12 ps=8.6400e-06 nf=1 m=1
XMpar24 a_10458_3236.t4 inp.t0 a_7607_6137.t2 vss.t34 nfet_03v3 w=0.97u l=0.9u ad=2.7160e-13 pd=1.5300e-06 as=5.8200e-13 ps=3.1400e-06 nf=1 m=2 par=2
X21 out.t3 vss.t39 cap_mim_2f0fF c_width=20u c_length=20u
X22 out.t3 vss.t39 cap_mim_2f0fF c_width=20u c_length=20u
X42 out.t3 vss.t39 cap_mim_2f0fF c_width=20u c_length=20u
X58 out.t3 vss.t39 cap_mim_2f0fF c_width=20u c_length=20u
X64 out.t3 vss.t39 cap_mim_2f0fF c_width=20u c_length=20u
X66 out.t3 vss.t39 cap_mim_2f0fF c_width=20u c_length=20u
X79 out.t3 vss.t39 cap_mim_2f0fF c_width=20u c_length=20u
Rpar0 a_10458_3236.t0 a_10458_3236.t8 166.8110
Rpar1 a_10458_3236.t0 a_10458_3236.t4 138.7345
Rpar2 a_10458_3236.t0 a_10458_3236.t7 96.5026
Rpar3 a_10458_3236.t8 a_10458_3236.t4 102.2698
Rpar4 a_10458_3236.t8 a_10458_3236.t7 372.4779
Rpar5 a_10458_3236.t4 a_10458_3236.t7 309.7850
Rpar6 a_11494_11010.t0 a_11494_11010.t1 71.1298
Rpar7 a_11494_11010.t0 a_11494_11010.t2 417.7914
Rpar8 a_11494_11010.t1 a_11494_11010.t2 48.2058
Rpar9 a_12014_1204.t0 a_12014_1204.t1 80.7659
Rpar10 a_12014_1204.t0 a_12014_1204.t8 105.4503
Rpar11 a_12014_1204.t0 a_12014_1204.t4 86.3663
Rpar12 a_12014_1204.t1 a_12014_1204.t8 409.4268
Rpar13 a_12014_1204.t1 a_12014_1204.t4 335.3305
Rpar14 a_12014_1204.t8 a_12014_1204.t4 126.6525
Rpar15 a_12014_7844.t0 a_12014_7844.t1 35.9168
Rpar16 a_12014_7844.t0 a_12014_7844.t8 675.4179
Rpar17 a_12014_7844.t0 a_12014_7844.t13 1173.6460
Rpar18 a_12014_7844.t0 a_12014_7844.t18 6944.7702
Rpar19 a_12014_7844.t1 a_12014_7844.t8 62.5874
Rpar20 a_12014_7844.t1 a_12014_7844.t13 108.7555
Rpar21 a_12014_7844.t1 a_12014_7844.t18 643.5346
Rpar22 a_12014_7844.t8 a_12014_7844.t13 143.3304
Rpar23 a_12014_7844.t8 a_12014_7844.t18 848.1232
Rpar24 a_12014_7844.t13 a_12014_7844.t18 103.0034
Rpar25 a_17468_6138.t0 a_17468_6138.t15 966.7951
Rpar26 a_17468_6138.t0 a_17468_6138.t16 77.1993
Rpar27 a_17468_6138.t15 a_17468_6138.t16 97.4772
Rpar28 a_5970_2983.t0 a_5970_2983.t10 1298.7270
Rpar29 a_5970_2983.t0 a_5970_2983.t11 120.3461
Rpar30 a_5970_2983.t0 a_5970_2983.t18 104.8744
Rpar31 a_5970_2983.t0 a_5970_2983.t5 273.4114
Rpar32 a_5970_2983.t10 a_5970_2983.t11 36.0426
Rpar33 a_5970_2983.t10 a_5970_2983.t18 4912.6303
Rpar34 a_5970_2983.t10 a_5970_2983.t5 621.4205
Rpar35 a_5970_2983.t11 a_5970_2983.t18 455.2271
Rpar36 a_5970_2983.t11 a_5970_2983.t5 57.5837
Rpar37 a_5970_2983.t18 a_5970_2983.t5 1034.2196
Rpar38 a_6199_6137.t0 a_6199_6137.t2 36.4300
Rpar39 a_7320_9711.t0 a_7320_9711.t2 64.4701
Rpar40 a_7607_6137.t0 a_7607_6137.t2 46.4995
Rpar41 a_7968_7844.t0 a_7968_7844.t1 194.6982
Rpar42 a_7968_7844.t0 a_7968_7844.t2 293.5237
Rpar43 a_7968_7844.t1 a_7968_7844.t2 31.2736
Rpar44 a_8596_7844.t0 a_8596_7844.t1 3478.0102
Rpar45 a_8596_7844.t0 a_8596_7844.t2 402.1448
Rpar46 a_8596_7844.t0 a_8596_7844.t33 105.3361
Rpar47 a_8596_7844.t1 a_8596_7844.t2 19.0248
Rpar48 a_8596_7844.t1 a_8596_7844.t33 1044.5890
Rpar49 a_8596_7844.t2 a_8596_7844.t33 120.7806
Rpar50 ib ib.t0 7.5980
Rpar51 ib ib.t1 122.8722
Rpar52 ib.t0 ib.t1 27.5932
Rpar53 inn inn.t0 11.8263
Rpar54 inp inp.t0 11.8749
Rpar55 out out.t0 45.7361
Rpar56 out out.t1 6.8187
Rpar57 out out.t3 142.0332
Rpar58 out.t0 out.t1 585.0942
Rpar59 out.t0 out.t3 196.9430
Rpar60 out.t1 out.t3 1817.0056
Rpar61 vdd vdd.t0 623.9445
Rpar62 vdd vdd.t1 595.4553
Rpar63 vdd vdd.t3 150.2181
Rpar64 vdd vdd.t4 170.1423
Rpar65 vdd vdd.t19 2014.5673
Rpar66 vdd vdd.t20 813.6362
Rpar67 vdd.t0 vdd.t1 325.9333
Rpar68 vdd.t0 vdd.t3 50.3714
Rpar69 vdd.t0 vdd.t4 77.7496
Rpar70 vdd.t0 vdd.t19 108.2065
Rpar71 vdd.t0 vdd.t20 63.0986
Rpar72 vdd.t1 vdd.t3 81.5604
Rpar73 vdd.t1 vdd.t4 118.5844
Rpar74 vdd.t1 vdd.t19 1052.3605
Rpar75 vdd.t1 vdd.t20 425.0236
Rpar76 vdd.t3 vdd.t4 3.2166
Rpar77 vdd.t3 vdd.t19 195.6191
Rpar78 vdd.t3 vdd.t20 103.2745
Rpar79 vdd.t4 vdd.t19 296.6235
Rpar80 vdd.t4 vdd.t20 151.7280
Rpar81 vdd.t19 vdd.t20 9.2784
Rpar82 vss vss.t0 157.9051
Rpar83 vss vss.t2 172.5701
Rpar84 vss vss.t3 834.0885
Rpar85 vss vss.t32 295.9578
Rpar86 vss vss.t34 518.7158
Rpar87 vss vss.t39 1098.7153
Rpar88 vss.t0 vss.t2 115.7762
Rpar89 vss.t0 vss.t3 538.1060
Rpar90 vss.t0 vss.t32 6.7593
Rpar91 vss.t0 vss.t34 7.2181
Rpar92 vss.t0 vss.t39 143.1774
Rpar93 vss.t2 vss.t3 2.4530
Rpar94 vss.t2 vss.t32 226.0405
Rpar95 vss.t2 vss.t34 396.1308
Rpar96 vss.t2 vss.t39 984.5790
Rpar97 vss.t3 vss.t39 4730.5207
Rpar98 vss.t32 vss.t34 5.7203
Rpar99 vss.t32 vss.t39 245.9037
Rpar100 vss.t34 vss.t39 431.9900
Cpar0 a_10458_3236.t0 vss 7.46158e-15
Cpar1 a_10458_3236.t4 vss 1.76667e-15
Cpar2 a_10458_3236.t7 vss 2.31180e-15
Cpar3 a_10458_3236.t8 vss 4.82072e-15
Cpar4 a_11494_11010.t0 vss 1.57240e-15
Cpar5 a_11494_11010.t1 vss 3.60452e-15
Cpar6 a_11494_11010.t2 vss 2.53252e-15
Cpar7 a_12014_1204.t0 vss 7.07454e-15
Cpar8 a_12014_1204.t1 vss 2.27202e-15
Cpar9 a_12014_1204.t4 vss 1.38879e-15
Cpar10 a_12014_1204.t8 vss 4.38092e-15
Cpar11 a_12014_7844.t0 vss 3.55863e-15
Cpar12 a_12014_7844.t1 vss 7.36030e-15
Cpar13 a_12014_7844.t13 vss 9.19917e-15
Cpar14 a_12014_7844.t18 vss 1.59754e-15
Cpar15 a_12014_7844.t8 vss 7.08672e-15
Cpar16 a_17468_6138.t0 vss 2.78914e-14
Cpar17 a_17468_6138.t15 vss 1.15113e-15
Cpar18 a_17468_6138.t16 vss 6.28360e-15
Cpar19 a_5970_2983.t0 vss 1.20003e-14
Cpar20 a_5970_2983.t10 vss 4.20317e-15
Cpar21 a_5970_2983.t11 vss 1.02083e-14
Cpar22 a_5970_2983.t18 vss 2.30393e-15
Cpar23 a_5970_2983.t5 vss 8.52846e-15
Cpar24 a_6199_6137.t0 vss 1.70667e-14
Cpar25 a_6199_6137.t2 vss 3.32688e-15
Cpar26 a_7320_9711.t0 vss 1.03521e-15
Cpar27 a_7320_9711.t2 vss 5.55629e-15
Cpar28 a_7607_6137.t0 vss 2.11897e-15
Cpar29 a_7607_6137.t2 vss 2.65156e-15
Cpar30 a_7968_7844.t0 vss 4.24370e-15
Cpar31 a_7968_7844.t1 vss 7.01922e-15
Cpar32 a_7968_7844.t2 vss 4.89445e-15
Cpar33 a_8596_7844.t0 vss 3.59249e-15
Cpar34 a_8596_7844.t1 vss 1.59534e-14
Cpar35 a_8596_7844.t2 vss 2.50114e-14
Cpar36 a_8596_7844.t33 vss 1.68934e-14
Cpar37 ib vdd 1.63850e-16
Cpar38 ib vss 1.75532e-14
Cpar39 ib.t0 vss 2.79242e-15
Cpar40 ib.t1 vss 3.25108e-16
Cpar41 inn inp 5.16000e-17
Cpar42 inn vss 1.68358e-15
Cpar43 inn.t0 vss 1.93557e-16
Cpar44 inp vss 1.67707e-15
Cpar45 inp.t0 vss 1.89439e-16
Cpar46 out vdd 6.55588e-15
Cpar47 out vss 6.20779e-14
Cpar48 out.t0 vss 5.03578e-17
Cpar49 out.t1 vss 2.36987e-17
Cpar50 out.t3 vss 9.55429e-15
Cpar51 vdd vss 1.94061e-13
Cpar52 vdd.t0 vss 1.26833e-14
Cpar53 vdd.t1 vss 1.72989e-14
Cpar54 vdd.t19 vss 4.02782e-15
Cpar55 vdd.t20 vss 5.06752e-15
Cpar56 vdd.t3 vss 1.55208e-14
Cpar57 vdd.t4 vss 1.47380e-14
.ends opamp_dut

Vdd vdd 0 1.800000
Vss vss 0 0
Ibias vdd ib 1.071400e-06
Vinp inp 0 DC 1.210600 AC 1 PWL(0 1.210600 3.189945e-08 1.210600 3.508939e-08 1.220600)
Rfb out inn 1m
Cload out 0 2.000000e-13
Xdut vdd vss inp inn out ib opamp_dut
.end
