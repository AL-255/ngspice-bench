* opa1000[0265]: 200f/folded_cascode_pmos_1v8_i20u_weak (folded_cascode_pmos, VDD=1.8V, CL=0.2pF, Iref=3.7778uA)
.include "pdk_opa.inc"
.temp 27
.option gmin=1e-12 rshunt=1e12 reltol=1e-3 abstol=1e-12 vntol=1e-5 method=gear
* Post-PEX R+C extracted netlist for folded_cascode_pmos_1v8_i20u_weak
.subckt opamp_dut vdd vss inp inn out ib
XMpar0 a_1788_6928.t0 inp.t0 a_4890_10914.t4 vdd.t10 pfet_03v3 w=1.96u l=0.72u ad=6.5333e-13 pd=2.9533e-06 as=5.4880e-13 ps=2.5200e-06 nf=1 m=12 par=12
XMpar1 a_1450_6720.t0 ib.t0 vss.t2 vss.t1 nfet_03v3 w=1.9u l=1.2u ad=5.3200e-13 pd=2.4600e-06 as=5.3200e-13 ps=2.4600e-06 nf=1 m=2 par=2
XMpar2 a_1788_6928.t0 inn.t0 a_8014_4962.t4 vdd.t10 pfet_03v3 w=1.96u l=0.72u ad=6.5333e-13 pd=2.9533e-06 as=5.4880e-13 ps=2.5200e-06 nf=1 m=12 par=12
XMpar3 a_1788_6928.t24 a_1450_6720.t2 vdd.t1 vdd.t0 pfet_03v3 w=9.99u l=1.69u ad=2.7972e-12 pd=1.0550e-05 as=4.3956e-12 ps=1.5865e-05 nf=1 m=4 par=4
XMpar4 a_4890_10914.t0 ib.t0 vss.t2 vss.t1 nfet_03v3 w=1.9u l=1.2u ad=5.3200e-13 pd=2.4600e-06 as=8.3600e-13 ps=3.7300e-06 nf=1 m=4 par=4
XMpar5 a_1450_6720.t3 a_1450_6720.t2 vdd.t1 vdd.t0 pfet_03v3 w=9.99u l=1.69u ad=2.7972e-12 pd=1.0550e-05 as=2.7972e-12 ps=1.0550e-05 nf=1 m=2 par=2
XMpar6 a_7096_1294.t3 a_7096_1294.t2 vdd.t1 vdd.t0 pfet_03v3 w=9.99u l=1.69u ad=5.9940e-12 pd=2.1180e-05 as=2.7972e-12 ps=1.0550e-05 nf=1 m=2 par=2
XMpar7 a_4890_10914.t16 a_1450_6720.t6 a_7096_1294.t0 vss.t0 nfet_03v3 w=2.28u l=0.75u ad=1.3680e-12 pd=5.7600e-06 as=6.3840e-13 ps=2.8400e-06 nf=1 m=2 par=2
XMpar8 a_8014_4962.t16 a_1450_6720.t6 out.t0 vss.t0 nfet_03v3 w=2.28u l=0.75u ad=1.3680e-12 pd=5.7600e-06 as=6.3840e-13 ps=2.8400e-06 nf=1 m=2 par=2
XMpar9 out.t2 a_7096_1294.t2 vdd.t1 vdd.t0 pfet_03v3 w=9.99u l=1.69u ad=2.7972e-12 pd=1.0550e-05 as=2.7972e-12 ps=1.0550e-05 nf=1 m=2 par=2
XMpar10 a_8014_4962.t0 ib.t0 vss.t2 vss.t1 nfet_03v3 w=1.9u l=1.2u ad=5.3200e-13 pd=2.4600e-06 as=8.3600e-13 ps=3.7300e-06 nf=1 m=4 par=4
XMpar11 ib.t1 ib.t0 vss.t2 vss.t1 nfet_03v3 w=1.9u l=1.2u ad=1.1400e-12 pd=5.0000e-06 as=5.3200e-13 ps=2.4600e-06 nf=1 m=2 par=2
X23 out.t4 vss.t28 cap_mim_2f0fF c_width=19.27u c_length=19.27u
Rpar0 a_1450_6720.t0 a_1450_6720.t2 279.9989
Rpar1 a_1450_6720.t0 a_1450_6720.t3 93.2308
Rpar2 a_1450_6720.t0 a_1450_6720.t6 131.7176
Rpar3 a_1450_6720.t2 a_1450_6720.t3 26.8916
Rpar4 a_1450_6720.t2 a_1450_6720.t6 481.5837
Rpar5 a_1450_6720.t3 a_1450_6720.t6 160.3521
Rpar6 a_1788_6928.t0 a_1788_6928.t24 55.6156
Rpar7 a_4890_10914.t0 a_4890_10914.t4 57.9947
Rpar8 a_4890_10914.t0 a_4890_10914.t16 80.8906
Rpar9 a_4890_10914.t4 a_4890_10914.t16 190.7219
Rpar10 a_7096_1294.t0 a_7096_1294.t2 269.3456
Rpar11 a_7096_1294.t0 a_7096_1294.t3 48.7509
Rpar12 a_7096_1294.t2 a_7096_1294.t3 23.7899
Rpar13 a_8014_4962.t0 a_8014_4962.t4 57.9947
Rpar14 a_8014_4962.t0 a_8014_4962.t16 80.8906
Rpar15 a_8014_4962.t4 a_8014_4962.t16 190.7219
Rpar16 ib ib.t0 10.6155
Rpar17 ib ib.t1 4.8282
Rpar18 inn inn.t0 2.2279
Rpar19 inp inp.t0 2.6127
Rpar20 out out.t0 7.9231
Rpar21 out out.t2 45.5501
Rpar22 out out.t4 78.7991
Rpar23 out.t2 out.t4 125.1647
Rpar24 vdd vdd.t0 128.6122
Rpar25 vdd vdd.t1 344.6375
Rpar26 vdd vdd.t10 37.2297
Rpar27 vdd.t0 vdd.t1 3.8537
Rpar28 vdd.t0 vdd.t10 145.6314
Rpar29 vdd.t1 vdd.t10 390.2430
Rpar30 vss vss.t0 289.2016
Rpar31 vss vss.t1 88.5462
Rpar32 vss vss.t2 558.4971
Rpar33 vss vss.t28 45.9069
Rpar34 vss.t0 vss.t1 3.0483
Rpar35 vss.t0 vss.t2 21.5758
Rpar36 vss.t0 vss.t28 1507.0345
Rpar37 vss.t1 vss.t2 3.7987
Rpar38 vss.t1 vss.t28 461.4157
Rpar39 vss.t2 vss.t28 2910.3379
Cpar0 a_1450_6720.t0 vss 2.01622e-15
Cpar1 a_1450_6720.t2 vss 1.39977e-14
Cpar2 a_1450_6720.t3 vss 4.45455e-15
Cpar3 a_1450_6720.t6 vss 2.81080e-15
Cpar4 a_1788_6928.t0 vss 1.56425e-14
Cpar5 a_1788_6928.t24 vss 1.02807e-14
Cpar6 a_4890_10914.t0 vss 5.22391e-15
Cpar7 a_4890_10914.t16 vss 4.30205e-15
Cpar8 a_4890_10914.t4 vss 8.42186e-15
Cpar9 a_7096_1294.t0 vss 1.26313e-15
Cpar10 a_7096_1294.t2 vss 8.73303e-15
Cpar11 a_7096_1294.t3 vss 6.15629e-15
Cpar12 a_8014_4962.t0 vss 3.67256e-15
Cpar13 a_8014_4962.t16 vss 3.02448e-15
Cpar14 a_8014_4962.t4 vss 5.92085e-15
Cpar15 ib vdd 8.82720e-16
Cpar16 ib vss 1.55359e-14
Cpar17 ib.t0 vss 3.38024e-15
Cpar18 ib.t1 vss 2.74140e-16
Cpar19 inn inp 5.22700e-17
Cpar20 inn vdd 6.43159e-15
Cpar21 inn vss 5.02514e-15
Cpar22 inn.t0 vss 4.17956e-15
Cpar23 inp vdd 6.46895e-15
Cpar24 inp vss 4.37940e-15
Cpar25 inp.t0 vss 4.89170e-15
Cpar26 out vdd 2.48796e-15
Cpar27 out vss 1.18227e-14
Cpar28 out.t0 vss 2.21426e-17
Cpar29 out.t2 vss 2.50387e-16
Cpar30 out.t4 vss 6.85277e-15
Cpar31 vdd vss 1.18157e-13
Cpar32 vdd.t0 vss 2.30574e-14
Cpar33 vdd.t1 vss 1.12539e-14
Cpar34 vdd.t10 vss 1.59886e-14
.ends opamp_dut

Vdd vdd 0 1.800000
Vss vss 0 0
Ibias vdd ib 3.777800e-06
Vinp inp 0 DC 0.751000 AC 1 PWL(0 0.751000 1.237932e-08 0.751000 1.361725e-08 0.761000)
Rfb out inn 1m
Cload out 0 2.000000e-13
Xdut vdd vss inp inn out ib opamp_dut
.end
