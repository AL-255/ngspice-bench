* opa1000[0201]: 200f/folded_cascode_nmos_3v3_i20u_subth (folded_cascode_nmos, VDD=3.3V, CL=0.2pF, Iref=4.4444uA)
.include "pdk_opa.inc"
.temp 27
.option gmin=1e-12 rshunt=1e12 reltol=1e-3 abstol=1e-12 vntol=1e-5 method=gear
* Post-PEX R+C extracted netlist for folded_cascode_nmos_3v3_i20u_subth
.subckt opamp_dut vdd vss inp inn out ib
XMpar0 a_2098_11773.t48 ib.t10 a_2338_11773.t0 vdd.t8 pfet_03v3 w=1.99u l=0.6u ad=6.0112e-13 pd=2.7314e-06 as=5.7916e-13 ps=2.6407e-06 nf=1 m=58 par=58
XMpar1 a_1921_5294.t0 inn.t0 a_7054_1249.t62 vss.t0 nfet_03v3 w=2.02u l=0.65u ad=6.2436e-13 pd=2.8218e-06 as=5.9498e-13 ps=2.7009e-06 nf=1 m=44 par=44
XMpar2 a_7054_1249.t4 ib.t10 out.t0 vdd.t8 pfet_03v3 w=1.99u l=0.6u ad=6.0112e-13 pd=2.7314e-06 as=5.7916e-13 ps=2.6407e-06 nf=1 m=58 par=58
XMpar3 a_1921_5294.t0 inp.t0 a_2098_11773.t0 vss.t0 nfet_03v3 w=2.02u l=0.65u ad=6.2436e-13 pd=2.8218e-06 as=5.9498e-13 ps=2.7009e-06 nf=1 m=44 par=44
XMpar4 a_2098_11773.t44 a_1207_8144.t0 vdd.t1 vdd.t0 pfet_03v3 w=10u l=1.35u ad=2.8000e-12 pd=1.0560e-05 as=4.4000e-12 ps=1.5880e-05 nf=1 m=4 par=4
XMpar5 a_1921_5294.t44 ib.t0 vss.t30 vss.t0 nfet_03v3 w=6.59u l=1.2u ad=1.8452e-12 pd=7.1500e-06 as=1.8452e-12 ps=7.1500e-06 nf=1 m=4 par=4
XMpar6 a_7054_1249.t0 a_1207_8144.t0 vdd.t1 vdd.t0 pfet_03v3 w=10u l=1.35u ad=2.8000e-12 pd=1.0560e-05 as=4.4000e-12 ps=1.5880e-05 nf=1 m=4 par=4
XMpar7 a_1207_8144.t1 a_1207_8144.t0 vdd.t1 vdd.t0 pfet_03v3 w=10u l=1.35u ad=2.8000e-12 pd=1.0560e-05 as=6.0000e-12 ps=2.1200e-05 nf=1 m=2 par=2
XMpar8 ib.t1 ib.t0 vss.t30 vss.t0 nfet_03v3 w=6.59u l=1.2u ad=3.9540e-12 pd=1.4380e-05 as=1.8452e-12 ps=7.1500e-06 nf=1 m=2 par=2
XMpar9 out.t45 a_2338_11773.t58 vss.t30 vss.t0 nfet_03v3 w=6.59u l=1.2u ad=1.8452e-12 pd=7.1500e-06 as=1.8452e-12 ps=7.1500e-06 nf=1 m=2 par=2
XMpar10 a_2338_11773.t59 a_2338_11773.t58 vss.t30 vss.t0 nfet_03v3 w=6.59u l=1.2u ad=3.9540e-12 pd=1.4380e-05 as=1.8452e-12 ps=7.1500e-06 nf=1 m=2 par=2
XMpar11 a_1207_8144.t4 ib.t0 vss.t30 vss.t0 nfet_03v3 w=6.59u l=1.2u ad=1.8452e-12 pd=7.1500e-06 as=1.8452e-12 ps=7.1500e-06 nf=1 m=2 par=2
X12 out.t60 vss.t47 cap_mim_2f0fF c_width=13.23u c_length=13.23u
Rpar0 a_1207_8144.t0 a_1207_8144.t1 29.7450
Rpar1 a_1207_8144.t0 a_1207_8144.t4 47.3509
Rpar2 a_1207_8144.t1 a_1207_8144.t4 189.8115
Rpar3 a_1921_5294.t0 a_1921_5294.t44 67.4735
Rpar4 a_2098_11773.t0 a_2098_11773.t48 228.0204
Rpar5 a_2098_11773.t0 a_2098_11773.t44 120.8589
Rpar6 a_2098_11773.t48 a_2098_11773.t44 106.8505
Rpar7 a_2338_11773.t0 a_2338_11773.t58 1120.6306
Rpar8 a_2338_11773.t0 a_2338_11773.t59 160.2861
Rpar9 a_2338_11773.t58 a_2338_11773.t59 22.7825
Rpar10 a_7054_1249.t0 a_7054_1249.t4 64.7082
Rpar11 a_7054_1249.t0 a_7054_1249.t62 119.7488
Rpar12 a_7054_1249.t4 a_7054_1249.t62 73.2789
Rpar13 ib ib.t0 14.6714
Rpar14 ib ib.t1 3.6142
Rpar15 ib ib.t10 45.2671
Rpar16 inn inn.t0 2.1461
Rpar17 inp inp.t0 2.1461
Rpar18 out out.t0 65.8565
Rpar19 out out.t45 67.4688
Rpar20 out out.t60 15.4748
Rpar21 out.t0 out.t45 196.3915
Rpar22 out.t0 out.t60 700.3813
Rpar23 out.t45 out.t60 717.5277
Rpar24 vdd vdd.t0 66.1468
Rpar25 vdd vdd.t1 134.6566
Rpar26 vdd vdd.t8 29.8272
Rpar27 vdd.t0 vdd.t1 4.1859
Rpar28 vdd.t0 vdd.t8 191.6767
Rpar29 vdd.t1 vdd.t8 390.2010
Rpar30 vss vss.t0 22.5237
Rpar31 vss vss.t30 580.0172
Rpar32 vss vss.t47 1170.1088
Rpar33 vss.t0 vss.t30 2.9084
Rpar34 vss.t0 vss.t47 66.2119
Rpar35 vss.t30 vss.t47 540.2057
Cpar0 a_1207_8144.t0 vss 1.73731e-14
Cpar1 a_1207_8144.t1 vss 3.87811e-15
Cpar2 a_1207_8144.t4 vss 2.80338e-15
Cpar3 a_1921_5294.t0 vss 4.97488e-14
Cpar4 a_1921_5294.t44 vss 8.17334e-15
Cpar5 a_2098_11773.t0 vss 3.07775e-14
Cpar6 a_2098_11773.t44 vss 1.27203e-14
Cpar7 a_2098_11773.t48 vss 3.56598e-14
Cpar8 a_2338_11773.t0 vss 3.45859e-14
Cpar9 a_2338_11773.t58 vss 8.08063e-15
Cpar10 a_2338_11773.t59 vss 1.23028e-14
Cpar11 a_7054_1249.t0 vss 1.04558e-14
Cpar12 a_7054_1249.t4 vss 3.51944e-14
Cpar13 a_7054_1249.t62 vss 3.01118e-14
Cpar14 ib out 9.07506e-15
Cpar15 ib vdd 4.70538e-14
Cpar16 ib vss 2.18554e-14
Cpar17 ib.t0 vss 1.33258e-14
Cpar18 ib.t1 vss 3.45466e-15
Cpar19 ib.t10 vss 6.24588e-14
Cpar20 inn inp 1.27590e-16
Cpar21 inn vss 2.16564e-14
Cpar22 inn.t0 vss 1.03131e-14
Cpar23 inp vss 2.15907e-14
Cpar24 inp.t0 vss 1.03488e-14
Cpar25 out vdd 7.54257e-15
Cpar26 out vss 1.37787e-14
Cpar27 out.t0 vss 1.46119e-14
Cpar28 out.t45 vss 2.07549e-15
Cpar29 out.t60 vss 3.13377e-14
Cpar30 vdd vss 2.03766e-13
Cpar31 vdd.t0 vss 2.09954e-14
Cpar32 vdd.t1 vss 1.38401e-14
Cpar33 vdd.t8 vss 6.04609e-14
.ends opamp_dut

Vdd vdd 0 3.300000
Vss vss 0 0
Ibias vdd ib 4.444400e-06
Vinp inp 0 DC 1.810000 AC 1 PWL(0 1.810000 4.606830e-09 1.810000 5.067513e-09 1.820000)
Rfb out inn 1m
Cload out 0 2.000000e-13
Xdut vdd vss inp inn out ib opamp_dut
.end
