* opa1000[0943]: 200f/telescopic_pmos_3v3_0p1u_1u_weak (telescopic_pmos, VDD=3.3V, CL=0.2pF, Iref=0.07uA)
.include "pdk_opa.inc"
.temp 27
.option gmin=1e-12 rshunt=1e12 reltol=1e-3 abstol=1e-12 vntol=1e-5 method=gear
* Post-PEX R+C extracted netlist for telescopic_pmos_3v3_0p1u_1u_weak
.subckt opamp_dut vdd vss inp inn out ib
XMpar0 a_2250_4545.t8 a_1650_4337.t0 vdd.t1 vdd.t0 pfet_03v3 w=0.45u l=3u ad=1.2600e-13 pd=1.0100e-06 as=2.3400e-13 ps=1.8275e-06 nf=1 m=8 par=8
XMpar1 a_4404_1249.t0 a_1092_1041.t8 vss.t1 vss.t0 nfet_03v3 w=0.5u l=8u ad=1.4000e-13 pd=1.0600e-06 as=1.4000e-13 ps=1.0600e-06 nf=1 m=2 par=2
XMpar2 a_2250_4545.t0 inp.t0 a_4554_7541.t0 vdd.t13 pfet_03v3 w=2.06u l=4u ad=1.2360e-12 pd=5.3200e-06 as=9.0640e-13 ps=3.9700e-06 nf=1 m=4 par=4
XMpar3 a_972_1249.t0 a_1092_1041.t8 vss.t1 vss.t0 nfet_03v3 w=0.5u l=8u ad=3.0000e-13 pd=2.2000e-06 as=1.4000e-13 ps=1.0600e-06 nf=1 m=2 par=2
XMpar4 a_2250_4545.t0 inn.t0 a_6230_8659.t0 vdd.t13 pfet_03v3 w=2.06u l=4u ad=1.2360e-12 pd=5.3200e-06 as=9.0640e-13 ps=3.9700e-06 nf=1 m=4 par=4
XMpar5 a_1092_1041.t5 a_1092_1041.t4 a_4554_7541.t4 vdd.t4 pfet_03v3 w=1.42u l=2.5u ad=8.5200e-13 pd=4.0400e-06 as=8.5200e-13 ps=4.0400e-06 nf=1 m=2 par=2
XMpar6 a_1650_4337.t4 ib.t0 vss.t11 vss.t10 nfet_03v3 w=0.4u l=3u ad=1.1200e-13 pd=9.6000e-07 as=1.1200e-13 ps=9.6000e-07 nf=1 m=2 par=2
XMpar7 a_1092_1041.t1 a_1092_1041.t0 a_972_1249.t2 vss.t2 nfet_03v3 w=0.5u l=2.5u ad=3.0000e-13 pd=2.2000e-06 as=3.0000e-13 ps=2.2000e-06 nf=1 m=2 par=2
XMpar8 a_1650_4337.t1 a_1650_4337.t0 vdd.t1 vdd.t0 pfet_03v3 w=0.45u l=3u ad=2.7000e-13 pd=2.1000e-06 as=1.2600e-13 ps=1.0100e-06 nf=1 m=2 par=2
XMpar9 ib.t1 ib.t0 vss.t11 vss.t10 nfet_03v3 w=0.4u l=3u ad=2.4000e-13 pd=2.0000e-06 as=1.1200e-13 ps=9.6000e-07 nf=1 m=2 par=2
XMpar10 a_6230_8659.t4 a_1092_1041.t4 out.t1 vdd.t4 pfet_03v3 w=1.42u l=2.5u ad=8.5200e-13 pd=4.0400e-06 as=3.9760e-13 ps=1.9800e-06 nf=1 m=2 par=2
XMpar11 a_4404_1249.t1 a_1092_1041.t0 out.t0 vss.t2 nfet_03v3 w=0.5u l=2.5u ad=3.0000e-13 pd=2.2000e-06 as=1.4000e-13 ps=1.0600e-06 nf=1 m=2 par=2
Rpar0 a_1092_1041.t0 a_1092_1041.t1 25.5162
Rpar1 a_1092_1041.t0 a_1092_1041.t8 218.1538
Rpar2 a_1092_1041.t0 a_1092_1041.t4 330.9015
Rpar3 a_1092_1041.t0 a_1092_1041.t5 182.2906
Rpar4 a_1092_1041.t1 a_1092_1041.t8 152.6335
Rpar5 a_1092_1041.t1 a_1092_1041.t4 231.5186
Rpar6 a_1092_1041.t1 a_1092_1041.t5 127.5415
Rpar7 a_1092_1041.t8 a_1092_1041.t4 422.2508
Rpar8 a_1092_1041.t8 a_1092_1041.t5 232.6141
Rpar9 a_1092_1041.t4 a_1092_1041.t5 23.1810
Rpar10 a_1650_4337.t0 a_1650_4337.t1 15.1644
Rpar11 a_1650_4337.t0 a_1650_4337.t4 99.7951
Rpar12 a_1650_4337.t1 a_1650_4337.t4 106.1863
Rpar13 a_2250_4545.t0 a_2250_4545.t8 41.2288
Rpar14 a_4404_1249.t0 a_4404_1249.t1 79.7527
Rpar15 a_4554_7541.t0 a_4554_7541.t4 70.9647
Rpar16 a_6230_8659.t0 a_6230_8659.t4 64.9523
Rpar17 a_972_1249.t0 a_972_1249.t2 67.6409
Rpar18 ib ib.t0 11.6450
Rpar19 ib ib.t1 8.3694
Rpar20 inn inn.t0 4.6269
Rpar21 inp inp.t0 4.6271
Rpar22 out out.t0 14.6432
Rpar23 out out.t1 53.2150
Rpar24 vdd vdd.t0 1384.6947
Rpar25 vdd vdd.t1 154.1828
Rpar26 vdd vdd.t4 308.3158
Rpar27 vdd vdd.t13 22.8598
Rpar28 vdd.t0 vdd.t1 13.7151
Rpar29 vdd.t0 vdd.t4 536.2028
Rpar30 vdd.t0 vdd.t13 1641.2012
Rpar31 vdd.t1 vdd.t4 59.7050
Rpar32 vdd.t1 vdd.t13 182.7442
Rpar33 vdd.t4 vdd.t13 365.4295
Rpar34 vss vss.t0 147.0837
Rpar35 vss vss.t1 331.9546
Rpar36 vss vss.t10 131.5823
Rpar37 vss vss.t11 298.4876
Rpar38 vss vss.t2 175.5072
Rpar39 vss.t0 vss.t1 38.4923
Rpar40 vss.t0 vss.t10 15.3695
Rpar41 vss.t0 vss.t11 37.0596
Rpar42 vss.t0 vss.t2 10.9662
Rpar43 vss.t1 vss.t10 33.3725
Rpar44 vss.t1 vss.t11 79.9987
Rpar45 vss.t1 vss.t2 47.7954
Rpar46 vss.t10 vss.t11 28.2975
Rpar47 vss.t10 vss.t2 21.0103
Rpar48 vss.t11 vss.t2 50.0843
Cpar0 a_1092_1041.t0 vss 3.57240e-15
Cpar1 a_1092_1041.t1 vss 1.92209e-15
Cpar2 a_1092_1041.t4 vss 4.16013e-15
Cpar3 a_1092_1041.t5 vss 1.90541e-15
Cpar4 a_1092_1041.t8 vss 8.78201e-15
Cpar5 a_1650_4337.t0 vss 2.33912e-14
Cpar6 a_1650_4337.t1 vss 5.44401e-15
Cpar7 a_1650_4337.t4 vss 3.51561e-15
Cpar8 a_2250_4545.t0 vss 2.09806e-14
Cpar9 a_2250_4545.t8 vss 9.70886e-15
Cpar10 a_4404_1249.t0 vss 4.74899e-15
Cpar11 a_4404_1249.t1 vss 4.85462e-15
Cpar12 a_4554_7541.t0 vss 1.17938e-14
Cpar13 a_4554_7541.t4 vss 7.04524e-15
Cpar14 a_6230_8659.t0 vss 1.12200e-14
Cpar15 a_6230_8659.t4 vss 5.72343e-15
Cpar16 a_972_1249.t0 vss 4.09772e-15
Cpar17 a_972_1249.t2 vss 2.99525e-15
Cpar18 ib vdd 1.27600e-17
Cpar19 ib vss 1.03914e-14
Cpar20 ib.t0 vss 1.08926e-15
Cpar21 ib.t1 vss 6.41000e-17
Cpar22 inn inp 7.23100e-17
Cpar23 inn vdd 8.76123e-15
Cpar24 inn vss 3.28246e-15
Cpar25 inn.t0 vss 1.01393e-14
Cpar26 inp vdd 8.65533e-15
Cpar27 inp vss 3.25193e-15
Cpar28 inp.t0 vss 1.01729e-14
Cpar29 out vdd 2.00545e-15
Cpar30 out vss 7.55637e-15
Cpar31 out.t0 vss 3.41978e-16
Cpar32 out.t1 vss 3.03498e-15
Cpar33 vdd vss 1.48937e-13
Cpar34 vdd.t0 vss 1.94057e-14
Cpar35 vdd.t1 vss 5.85960e-15
Cpar36 vdd.t13 vss 3.04920e-14
Cpar37 vdd.t4 vss 1.02227e-14
.ends opamp_dut

Vdd vdd 0 3.300000
Vss vss 0 0
Ibias vdd ib 7.000000e-08
Vinp inp 0 DC 1.480000 AC 1 PWL(0 1.480000 5.812568e-08 1.480000 6.393825e-08 1.490000)
Rfb out inn 1m
Cload out 0 2.000000e-13
Xdut vdd vss inp inn out ib opamp_dut
.end
