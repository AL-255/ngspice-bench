* opa1000[0108]: 200f/current_reuse_3v3_i200n_weak (current_reuse, VDD=3.3V, CL=0.2pF, Iref=0.03uA)
.include "pdk_opa.inc"
.temp 27
.option gmin=1e-12 rshunt=1e12 reltol=1e-3 abstol=1e-12 vntol=1e-5 method=gear
* Post-PEX R+C extracted netlist for current_reuse_3v3_i200n_weak
.subckt opamp_dut vdd vss inp inn out ib
XMpar0 out.t0 a_954_1290.t6 vdd.t1 vdd.t0 pfet_03v3 w=0.4u l=3.2u ad=1.1200e-13 pd=9.6000e-07 as=1.3760e-13 ps=1.1680e-06 nf=1 m=10 par=10
XMpar1 a_6674_9030.t2 a_8644_10327.t4 vdd.t1 vdd.t0 pfet_03v3 w=0.4u l=3.2u ad=1.1200e-13 pd=9.6000e-07 as=2.4000e-13 ps=2.0000e-06 nf=1 m=2 par=2
XMpar2 a_6674_9030.t0 inp.t2 a_954_1290.t0 vdd.t4 pfet_03v3 w=0.43u l=5.2u ad=2.5800e-13 pd=2.0600e-06 as=1.2040e-13 ps=9.9000e-07 nf=1 m=2 par=2
XMpar3 a_7826_4590.t4 ib.t0 vss.t4 vss.t3 nfet_03v3 w=0.4u l=5u ad=2.4000e-13 pd=2.0000e-06 as=1.1200e-13 ps=9.6000e-07 nf=1 m=4 par=4
XMpar4 out.t10 ib.t0 vss.t4 vss.t3 nfet_03v3 w=0.4u l=5u ad=1.8880e-13 pd=1.5840e-06 as=1.6320e-13 ps=1.3760e-06 nf=1 m=10 par=10
XMpar5 a_7826_4590.t0 inp.t0 a_954_1290.t2 vss.t1 nfet_03v3 w=0.4u l=5.2u ad=2.4000e-13 pd=2.0000e-06 as=2.4000e-13 ps=2.0000e-06 nf=1 m=2 par=2
XMpar6 ib.t1 ib.t0 vss.t4 vss.t3 nfet_03v3 w=0.4u l=5u ad=2.4000e-13 pd=2.0000e-06 as=1.1200e-13 ps=9.6000e-07 nf=1 m=2 par=2
XMpar7 a_6674_9030.t0 inn.t2 a_8644_10327.t0 vdd.t4 pfet_03v3 w=0.43u l=5.2u ad=2.5800e-13 pd=2.0600e-06 as=1.2040e-13 ps=9.9000e-07 nf=1 m=2 par=2
XMpar8 a_954_1290.t5 a_8644_10327.t4 vdd.t1 vdd.t0 pfet_03v3 w=0.4u l=3.2u ad=2.4000e-13 pd=2.0000e-06 as=1.1200e-13 ps=9.6000e-07 nf=1 m=1
XMpar9 a_7826_4590.t0 inn.t0 a_8644_10327.t2 vss.t1 nfet_03v3 w=0.4u l=5.2u ad=2.4000e-13 pd=2.0000e-06 as=2.4000e-13 ps=2.0000e-06 nf=1 m=2 par=2
XMpar10 a_8644_10327.t5 a_8644_10327.t4 vdd.t1 vdd.t0 pfet_03v3 w=0.4u l=3.2u ad=2.4000e-13 pd=2.0000e-06 as=1.1200e-13 ps=9.6000e-07 nf=1 m=1
X2 a_954_4930.t0 a_4932_5450.t0 vss.t0 ppolyf_u_1k r_width=1u r_length=19.23u
X5 a_954_1810.t0 a_4932_2330.t0 vss.t0 ppolyf_u_1k r_width=1u r_length=19.23u
X8 a_954_4930.t0 a_4932_4410.t0 vss.t0 ppolyf_u_1k r_width=1u r_length=19.23u
X9 a_954_1810.t0 a_4932_1290.t0 vss.t0 ppolyf_u_1k r_width=1u r_length=19.23u
X12 a_954_7010.t0 a_4932_7530.t0 vss.t0 ppolyf_u_1k r_width=1u r_length=19.23u
X16 a_954_3890.t0 a_4932_4410.t0 vss.t0 ppolyf_u_1k r_width=1u r_length=19.23u
X23 a_954_7010.t0 a_4932_6490.t0 vss.t0 ppolyf_u_1k r_width=1u r_length=19.23u
X33 a_954_1290.t4 a_4932_1290.t0 vss.t0 ppolyf_u_1k r_width=1u r_length=19.23u
X35 a_954_3890.t0 a_4932_3370.t0 vss.t0 ppolyf_u_1k r_width=1u r_length=19.23u
X37 a_954_5970.t0 a_4932_6490.t0 vss.t0 ppolyf_u_1k r_width=1u r_length=19.23u
X40 a_954_2850.t0 a_4932_3370.t0 vss.t0 ppolyf_u_1k r_width=1u r_length=19.23u
X44 a_954_5970.t0 a_4932_5450.t0 vss.t0 ppolyf_u_1k r_width=1u r_length=19.23u
X46 a_954_2850.t0 a_4932_2330.t0 vss.t0 ppolyf_u_1k r_width=1u r_length=19.23u
X49 a_4932_7530.t1 out.t8 cap_mim_2f0fF c_width=13.83u c_length=13.83u
Rpar0 a_4932_7530.t0 a_4932_7530.t1 53.1693
Rpar1 a_6674_9030.t0 a_6674_9030.t2 57.7140
Rpar2 a_7826_4590.t0 a_7826_4590.t4 45.6095
Rpar3 a_8644_10327.t0 a_8644_10327.t2 272.3166
Rpar4 a_8644_10327.t0 a_8644_10327.t4 76.0664
Rpar5 a_8644_10327.t0 a_8644_10327.t5 132.6427
Rpar6 a_8644_10327.t2 a_8644_10327.t4 48.6413
Rpar7 a_8644_10327.t2 a_8644_10327.t5 683.6019
Rpar8 a_8644_10327.t4 a_8644_10327.t5 33.3366
Rpar9 a_954_1290.t0 a_954_1290.t6 135.0122
Rpar10 a_954_1290.t0 a_954_1290.t2 151.3838
Rpar11 a_954_1290.t0 a_954_1290.t4 257.2609
Rpar12 a_954_1290.t0 a_954_1290.t5 188.6654
Rpar13 a_954_1290.t6 a_954_1290.t2 156.9482
Rpar14 a_954_1290.t6 a_954_1290.t4 266.7170
Rpar15 a_954_1290.t6 a_954_1290.t5 185.4175
Rpar16 a_954_1290.t2 a_954_1290.t4 122.2087
Rpar17 a_954_1290.t2 a_954_1290.t5 219.3186
Rpar18 a_954_1290.t4 a_954_1290.t5 372.7091
Rpar19 ib ib.t0 16.4425
Rpar20 ib ib.t1 15.2940
Rpar21 ib.t0 ib.t1 34.2113
Rpar22 inn inn.t0 4.3026
Rpar23 inn inn.t2 55.6104
Rpar24 inp inp.t0 4.3033
Rpar25 inp inp.t2 55.5617
Rpar26 out out.t0 117.6930
Rpar27 out out.t10 73.9419
Rpar28 out out.t8 20.0403
Rpar29 out.t0 out.t10 107.9620
Rpar30 out.t0 out.t8 1563.4283
Rpar31 out.t10 out.t8 982.2413
Rpar32 vdd vdd.t0 22.7340
Rpar33 vdd vdd.t1 50.8280
Rpar34 vdd vdd.t4 164.3894
Rpar35 vdd.t0 vdd.t1 4.4953
Rpar36 vdd.t0 vdd.t4 57.3614
Rpar37 vdd.t1 vdd.t4 79.7976
Rpar38 vss vss.t0 54.1594
Rpar39 vss vss.t1 276.3655
Rpar40 vss vss.t4 105.6368
Rpar41 vss vss.t3 105.8574
Rpar42 vss.t0 vss.t1 324.1209
Rpar43 vss.t0 vss.t4 113.4910
Rpar44 vss.t0 vss.t3 118.6827
Rpar45 vss.t1 vss.t4 55.1406
Rpar46 vss.t1 vss.t3 4.8048
Rpar47 vss.t4 vss.t3 16.3671
Cpar0 a_4932_1290.t0 vss 3.46400e-17
Cpar1 a_4932_2330.t0 vss 3.80200e-17
Cpar2 a_4932_3370.t0 vss 3.86800e-17
Cpar3 a_4932_4410.t0 vss 3.86000e-17
Cpar4 a_4932_5450.t0 vss 3.95400e-17
Cpar5 a_4932_6490.t0 vss 3.90800e-17
Cpar6 a_4932_7530.t0 vss 1.25570e-16
Cpar7 a_4932_7530.t1 vss 2.45691e-15
Cpar8 a_6674_9030.t0 vss 5.92212e-15
Cpar9 a_6674_9030.t2 vss 2.65824e-15
Cpar10 a_7826_4590.t0 vss 9.94339e-15
Cpar11 a_7826_4590.t4 vss 1.80016e-14
Cpar12 a_8644_10327.t0 vss 3.95466e-15
Cpar13 a_8644_10327.t2 vss 4.98672e-15
Cpar14 a_8644_10327.t4 vss 1.27603e-14
Cpar15 a_8644_10327.t5 vss 2.43276e-15
Cpar16 a_954_1290.t0 vss 3.60717e-15
Cpar17 a_954_1290.t2 vss 5.20777e-15
Cpar18 a_954_1290.t4 vss 4.74514e-15
Cpar19 a_954_1290.t5 vss 3.08520e-15
Cpar20 a_954_1290.t6 vss 1.75967e-14
Cpar21 a_954_1810.t0 vss 3.20200e-17
Cpar22 a_954_2850.t0 vss 2.93600e-17
Cpar23 a_954_3890.t0 vss 2.93600e-17
Cpar24 a_954_4930.t0 vss 2.93600e-17
Cpar25 a_954_5970.t0 vss 3.00800e-17
Cpar26 a_954_7010.t0 vss 2.83000e-17
Cpar27 ib out 2.22461e-15
Cpar28 ib vss 5.76653e-14
Cpar29 ib.t0 vss 9.22189e-15
Cpar30 ib.t1 vss 7.03585e-16
Cpar31 inn inp 1.56510e-16
Cpar32 inn vdd 6.90818e-15
Cpar33 inn vss 1.08289e-14
Cpar34 inn.t0 vss 2.46758e-15
Cpar35 inn.t2 vss 5.49196e-15
Cpar36 inp vdd 5.00759e-15
Cpar37 inp vss 1.06685e-14
Cpar38 inp.t0 vss 2.00548e-15
Cpar39 inp.t2 vss 4.46189e-15
Cpar40 out vdd 8.94483e-15
Cpar41 out vss 2.33308e-14
Cpar42 out.t0 vss 5.12679e-15
Cpar43 out.t10 vss 1.15438e-14
Cpar44 out.t8 vss 8.35084e-15
Cpar45 vdd vss 9.77535e-14
Cpar46 vdd.t0 vss 2.26869e-14
Cpar47 vdd.t1 vss 1.25086e-14
Cpar48 vdd.t4 vss 1.29852e-14
.ends opamp_dut

Vdd vdd 0 3.300000
Vss vss 0 0
Ibias vdd ib 3.000000e-08
Vinp inp 0 DC 1.645000 AC 1 PWL(0 1.645000 3.130467e-07 1.645000 3.443514e-07 1.655000)
Rfb out inn 1m
Cload out 0 2.000000e-13
Xdut vdd vss inp inn out ib opamp_dut
.end
