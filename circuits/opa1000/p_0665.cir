* opa1000[0665]: 2p/pmos_miller_3v3_i150u_weak (pmos_miller, VDD=3.3V, CL=2.0pF, Iref=13.125uA)
.include "pdk_opa.inc"
.temp 27
.option gmin=1e-12 rshunt=1e12 reltol=1e-3 abstol=1e-12 vntol=1e-5 method=gear
* Post-PEX R+C extracted netlist for pmos_miller_3v3_i150u_weak
.subckt opamp_dut vdd vss inp inn out ib
XMpar0 out.t0 a_829_1290.t61 vss.t1 vss.t0 nfet_03v3 w=1.9u l=0.6u ad=5.3200e-13 pd=2.4600e-06 as=5.7253e-13 ps=2.6293e-06 nf=1 m=30 par=30
XMpar1 a_6404_8345.t1 a_6404_8345.t0 vss.t1 vss.t0 nfet_03v3 w=1.9u l=0.6u ad=5.3200e-13 pd=2.4600e-06 as=5.3200e-13 ps=2.4600e-06 nf=1 m=6 par=6
XMpar2 a_1468_10513.t0 inp.t0 a_829_1290.t6 vdd.t8 pfet_03v3 w=1.96u l=0.56u ad=6.1849e-13 pd=2.8089e-06 as=5.4880e-13 ps=2.5200e-06 nf=1 m=54 par=54
XMpar3 a_1468_10513.t0 inn.t0 a_6404_8345.t12 vdd.t8 pfet_03v3 w=1.96u l=0.56u ad=6.1849e-13 pd=2.8089e-06 as=5.4880e-13 ps=2.5200e-06 nf=1 m=54 par=54
XMpar4 a_829_1290.t0 a_6404_8345.t0 vss.t1 vss.t0 nfet_03v3 w=1.9u l=0.6u ad=7.3467e-13 pd=3.3067e-06 as=5.3200e-13 ps=2.4600e-06 nf=1 m=6 par=6
XMpar5 out.t2 a_1096_10305.t0 vdd.t1 vdd.t0 pfet_03v3 w=4.47u l=0.65u ad=1.3470e-12 pd=5.3707e-06 as=1.2516e-12 ps=5.0300e-06 nf=1 m=30 par=30
XMpar6 a_1096_10305.t12 ib.t0 vss.t66 vss.t65 nfet_03v3 w=1.14u l=0.65u ad=4.4080e-13 pd=2.2933e-06 as=3.1920e-13 ps=1.7000e-06 nf=1 m=6 par=6
XMpar7 a_1096_10305.t1 a_1096_10305.t0 vdd.t1 vdd.t0 pfet_03v3 w=4.47u l=0.65u ad=1.2516e-12 pd=5.0300e-06 as=1.7284e-12 ps=6.7333e-06 nf=1 m=6 par=6
XMpar8 ib.t1 ib.t0 vss.t66 vss.t65 nfet_03v3 w=1.14u l=0.65u ad=4.4080e-13 pd=2.2933e-06 as=3.1920e-13 ps=1.7000e-06 nf=1 m=6 par=6
XMpar9 a_1468_10513.t54 a_1096_10305.t0 vdd.t1 vdd.t0 pfet_03v3 w=4.47u l=0.65u ad=1.2516e-12 pd=5.0300e-06 as=1.2516e-12 ps=5.0300e-06 nf=1 m=12 par=12
X18 a_1215_1290.t1 out.t18 cap_mim_2f0fF c_width=19.27u c_length=19.27u
X161 a_829_1290.t60 a_1215_1290.t0 vss.t60 ppolyf_u_1k r_width=1u r_length=1.27u
X170 a_1215_1290.t1 out.t18 cap_mim_2f0fF c_width=19.27u c_length=19.27u
Rpar0 a_1096_10305.t0 a_1096_10305.t1 17.7757
Rpar1 a_1096_10305.t0 a_1096_10305.t12 172.2208
Rpar2 a_1096_10305.t1 a_1096_10305.t12 100.2104
Rpar3 a_1215_1290.t0 a_1215_1290.t1 60.8687
Rpar4 a_1468_10513.t0 a_1468_10513.t54 36.4154
Rpar5 a_6404_8345.t0 a_6404_8345.t1 17.6754
Rpar6 a_6404_8345.t0 a_6404_8345.t12 419.9930
Rpar7 a_6404_8345.t1 a_6404_8345.t12 74.8868
Rpar8 a_829_1290.t0 a_829_1290.t6 167.1774
Rpar9 a_829_1290.t0 a_829_1290.t60 248.1559
Rpar10 a_829_1290.t0 a_829_1290.t61 110.1030
Rpar11 a_829_1290.t6 a_829_1290.t60 394.2709
Rpar12 a_829_1290.t6 a_829_1290.t61 174.9319
Rpar13 a_829_1290.t60 a_829_1290.t61 94.2185
Rpar14 ib ib.t0 16.4216
Rpar15 ib ib.t1 6.6642
Rpar16 ib.t0 ib.t1 18.7444
Rpar17 inn inn.t0 2.0265
Rpar18 inp inp.t0 2.0265
Rpar19 out out.t0 1.7095
Rpar20 out out.t2 820.2878
Rpar21 out out.t18 1131.8318
Rpar22 out.t0 out.t2 73.9051
Rpar23 out.t0 out.t18 101.9741
Rpar24 out.t2 out.t18 205.1661
Rpar25 vdd vdd.t0 100.5867
Rpar26 vdd vdd.t1 224.0100
Rpar27 vdd vdd.t8 23.4873
Rpar28 vdd.t0 vdd.t1 2.3255
Rpar29 vdd.t0 vdd.t8 290.9949
Rpar30 vdd.t1 vdd.t8 648.0556
Rpar31 vss vss.t0 79.7538
Rpar32 vss vss.t1 483.0214
Rpar33 vss vss.t60 43.0728
Rpar34 vss vss.t66 1673.6120
Rpar35 vss.t0 vss.t1 1.7818
Rpar36 vss.t0 vss.t60 216.7094
Rpar37 vss.t0 vss.t65 299.4010
Rpar38 vss.t0 vss.t66 66.9609
Rpar39 vss.t1 vss.t60 1373.4963
Rpar40 vss.t1 vss.t65 1651.4827
Rpar41 vss.t1 vss.t66 344.3031
Rpar42 vss.t65 vss.t66 13.2728
Cpar0 a_1096_10305.t0 vss 3.81462e-14
Cpar1 a_1096_10305.t1 vss 9.97263e-15
Cpar2 a_1096_10305.t12 vss 8.00064e-15
Cpar3 a_1215_1290.t0 vss 7.09322e-17
Cpar4 a_1215_1290.t1 vss 6.49625e-15
Cpar5 a_1468_10513.t0 vss 7.33071e-14
Cpar6 a_1468_10513.t54 vss 2.02860e-14
Cpar7 a_6404_8345.t0 vss 7.54405e-15
Cpar8 a_6404_8345.t1 vss 7.55662e-15
Cpar9 a_6404_8345.t12 vss 3.13563e-14
Cpar10 a_829_1290.t0 vss 6.60338e-15
Cpar11 a_829_1290.t6 vss 2.45196e-14
Cpar12 a_829_1290.t60 vss 2.42506e-15
Cpar13 a_829_1290.t61 vss 1.62376e-14
Cpar14 ib out 1.15500e-17
Cpar15 ib vss 1.47652e-14
Cpar16 ib.t0 vss 2.14050e-15
Cpar17 ib.t1 vss 9.00638e-16
Cpar18 inn inp 1.56820e-16
Cpar19 inn vdd 2.09175e-14
Cpar20 inn vss 6.92655e-15
Cpar21 inn.t0 vss 2.86171e-14
Cpar22 inp vdd 2.08782e-14
Cpar23 inp vss 6.90541e-15
Cpar24 inp.t0 vss 2.85512e-14
Cpar25 out vdd 2.61756e-14
Cpar26 out vss 3.38301e-14
Cpar27 out.t0 vss 8.33859e-15
Cpar28 out.t18 vss 2.00035e-14
Cpar29 out.t2 vss 1.63971e-14
Cpar30 vdd vss 2.23861e-13
Cpar31 vdd.t0 vss 4.96812e-14
Cpar32 vdd.t1 vss 1.88164e-14
Cpar33 vdd.t8 vss 6.84102e-14
.ends opamp_dut

Vdd vdd 0 3.300000
Vss vss 0 0
Ibias vdd ib 1.312500e-05
Vinp inp 0 DC 1.480000 AC 1 PWL(0 1.480000 3.835720e-09 1.480000 4.219292e-09 1.490000)
Rfb out inn 1m
Cload out 0 2.000000e-12
Xdut vdd vss inp inn out ib opamp_dut
.end
