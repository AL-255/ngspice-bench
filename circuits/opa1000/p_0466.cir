* opa1000[0466]: 2p/nmos_miller_1v8_i1u_weak (nmos_miller, VDD=1.8V, CL=2.0pF, Iref=0.1857uA)
.include "pdk_opa.inc"
.temp 27
.option gmin=1e-12 rshunt=1e12 reltol=1e-3 abstol=1e-12 vntol=1e-5 method=gear
* Post-PEX R+C extracted netlist for nmos_miller_1v8_i1u_weak
.subckt opamp_dut vdd vss inp inn out ib
XMpar0 out.t2 ib.t0 vss.t1 vss.t0 nfet_03v3 w=0.4u l=3.5u ad=1.8880e-13 pd=1.5840e-06 as=1.6320e-13 ps=1.3760e-06 nf=1 m=10 par=10
XMpar1 a_5552_12152.t1 a_5552_12152.t0 vdd.t1 vdd.t0 pfet_03v3 w=1.49u l=2.25u ad=4.1720e-13 pd=2.0500e-06 as=4.1720e-13 ps=2.0500e-06 nf=1 m=2 par=2
XMpar2 a_3128_1205.t4 inp.t0 a_908_6161.t1 vss.t25 nfet_03v3 w=1u l=3.2u ad=6.0000e-13 pd=3.2000e-06 as=2.8000e-13 ps=1.5600e-06 nf=1 m=2 par=2
XMpar3 out.t0 a_908_6161.t5 vdd.t1 vdd.t0 pfet_03v3 w=1.49u l=2.25u ad=4.1720e-13 pd=2.0500e-06 as=5.1256e-13 ps=2.4760e-06 nf=1 m=10 par=10
XMpar4 a_3128_1205.t4 inn.t0 a_5552_12152.t4 vss.t25 nfet_03v3 w=1u l=3.2u ad=6.0000e-13 pd=3.2000e-06 as=2.8000e-13 ps=1.5600e-06 nf=1 m=2 par=2
XMpar5 a_3128_1205.t0 ib.t0 vss.t1 vss.t0 nfet_03v3 w=0.4u l=3.5u ad=2.4000e-13 pd=2.0000e-06 as=1.1200e-13 ps=9.6000e-07 nf=1 m=4 par=4
XMpar6 ib.t1 ib.t0 vss.t1 vss.t0 nfet_03v3 w=0.4u l=3.5u ad=2.4000e-13 pd=2.0000e-06 as=1.1200e-13 ps=9.6000e-07 nf=1 m=2 par=2
XMpar7 a_908_6161.t0 a_5552_12152.t0 vdd.t1 vdd.t0 pfet_03v3 w=1.49u l=2.25u ad=8.9400e-13 pd=4.1800e-06 as=4.1720e-13 ps=2.0500e-06 nf=1 m=2 par=2
X0 a_908_7721.t0 a_4630_7201.t0 vss.t24 ppolyf_u_1k r_width=1u r_length=17.95u
X5 a_908_6681.t0 a_4630_7201.t0 vss.t24 ppolyf_u_1k r_width=1u r_length=17.95u
X9 a_908_8761.t1 out.t17 cap_mim_2f0fF c_width=14.37u c_length=14.36u
X12 a_908_8761.t1 out.t17 cap_mim_2f0fF c_width=14.37u c_length=14.36u
X22 a_908_6681.t0 a_4630_6161.t0 vss.t24 ppolyf_u_1k r_width=1u r_length=17.95u
X27 a_908_6161.t3 a_4630_6161.t0 vss.t24 ppolyf_u_1k r_width=1u r_length=17.95u
X29 a_908_8761.t0 a_4630_8241.t0 vss.t24 ppolyf_u_1k r_width=1u r_length=17.95u
X36 a_908_7721.t0 a_4630_8241.t0 vss.t24 ppolyf_u_1k r_width=1u r_length=17.95u
Rpar0 a_3128_1205.t0 a_3128_1205.t4 53.4983
Rpar1 a_5552_12152.t0 a_5552_12152.t1 26.5873
Rpar2 a_5552_12152.t0 a_5552_12152.t4 184.0376
Rpar3 a_5552_12152.t1 a_5552_12152.t4 147.8559
Rpar4 a_908_6161.t0 a_908_6161.t1 196.9441
Rpar5 a_908_6161.t0 a_908_6161.t5 80.5484
Rpar6 a_908_6161.t0 a_908_6161.t3 251.9933
Rpar7 a_908_6161.t1 a_908_6161.t5 134.8905
Rpar8 a_908_6161.t1 a_908_6161.t3 422.0011
Rpar9 a_908_6161.t5 a_908_6161.t3 58.2709
Rpar10 a_908_8761.t0 a_908_8761.t1 61.5054
Rpar11 ib ib.t0 14.4630
Rpar12 ib ib.t1 14.6956
Rpar13 ib.t0 ib.t1 34.2142
Rpar14 inn inn.t0 3.6762
Rpar15 inp inp.t0 3.7248
Rpar16 out out.t0 52.0089
Rpar17 out out.t2 142.5734
Rpar18 out out.t17 20.7644
Rpar19 out.t0 out.t2 67.7090
Rpar20 vdd vdd.t0 56.3299
Rpar21 vdd vdd.t1 87.1206
Rpar22 vdd.t0 vdd.t1 4.5286
Rpar23 vss vss.t0 64.8861
Rpar24 vss vss.t1 1407.4887
Rpar25 vss vss.t24 455.3365
Rpar26 vss vss.t25 244.8085
Rpar27 vss.t0 vss.t1 15.7623
Rpar28 vss.t0 vss.t24 4.1486
Rpar29 vss.t0 vss.t25 3.4961
Rpar30 vss.t1 vss.t24 121.1355
Rpar31 vss.t1 vss.t25 71.0718
Rpar32 vss.t24 vss.t25 28.1331
Cpar0 a_3128_1205.t0 vss 1.24689e-14
Cpar1 a_3128_1205.t4 vss 5.53368e-15
Cpar2 a_4630_6161.t0 vss 3.97000e-17
Cpar3 a_4630_7201.t0 vss 3.75800e-17
Cpar4 a_4630_8241.t0 vss 4.13600e-17
Cpar5 a_5552_12152.t0 vss 7.13129e-15
Cpar6 a_5552_12152.t1 vss 3.21553e-15
Cpar7 a_5552_12152.t4 vss 4.57047e-15
Cpar8 a_908_6161.t0 vss 3.46486e-15
Cpar9 a_908_6161.t1 vss 2.78416e-15
Cpar10 a_908_6161.t3 vss 2.49008e-15
Cpar11 a_908_6161.t5 vss 1.35380e-14
Cpar12 a_908_6681.t0 vss 3.88000e-17
Cpar13 a_908_7721.t0 vss 3.85200e-17
Cpar14 a_908_8761.t0 vss 1.16535e-16
Cpar15 a_908_8761.t1 vss 4.92341e-15
Cpar16 ib out 2.23162e-15
Cpar17 ib vss 4.41779e-14
Cpar18 ib.t0 vss 7.33863e-15
Cpar19 ib.t1 vss 6.05573e-16
Cpar20 inn inp 5.19700e-17
Cpar21 inn vss 3.85794e-15
Cpar22 inn.t0 vss 4.12519e-16
Cpar23 inp vss 3.82464e-15
Cpar24 inp.t0 vss 4.14688e-16
Cpar25 out vdd 1.04281e-14
Cpar26 out vss 2.16632e-14
Cpar27 out.t0 vss 3.09893e-15
Cpar28 out.t17 vss 1.34211e-14
Cpar29 out.t2 vss 6.43856e-15
Cpar30 vdd vss 6.33979e-14
Cpar31 vdd.t0 vss 1.91157e-14
Cpar32 vdd.t1 vss 1.13878e-14
.ends opamp_dut

Vdd vdd 0 1.800000
Vss vss 0 0
Ibias vdd ib 1.857000e-07
Vinp inp 0 DC 0.895000 AC 1 PWL(0 0.895000 1.873582e-07 0.895000 2.060940e-07 0.905000)
Rfb out inn 1m
Cload out 0 2.000000e-12
Xdut vdd vss inp inn out ib opamp_dut
.end
