* opa1000[0061]: 2p/cherry_hooper_1v8_i500u_subth (cherry_hooper, VDD=1.8V, CL=2.0pF, Iref=21.875uA)
.include "pdk_opa.inc"
.temp 27
.option gmin=1e-12 rshunt=1e12 reltol=1e-3 abstol=1e-12 vntol=1e-5 method=gear
* Post-PEX R+C extracted netlist for cherry_hooper_1v8_i500u_subth
.subckt opamp_dut vdd vss inp inn out ib
XMpar0 a_1700_12234.t36 inn.t0 a_19214_1294.t14 vss.t0 nfet_03v3 w=1.99u l=0.45u ad=5.9965e-13 pd=2.7253e-06 as=5.9965e-13 ps=2.7253e-06 nf=1 m=90 par=90
XMpar1 a_1332_12234.t4 ib.t0 vss.t0 vss.t0 nfet_03v3 w=9.19u l=0.36u ad=2.9000e-12 pd=1.0842e-05 as=2.6549e-12 ps=1.0023e-05 nf=1 m=72 par=72
XMpar2 a_15946_8516.t12 inp.t0 a_1700_12234.t36 vss.t0 nfet_03v3 w=1.99u l=0.45u ad=5.9965e-13 pd=2.7253e-06 as=5.9965e-13 ps=2.7253e-06 nf=1 m=90 par=90
XMpar3 a_19214_18964.t3 a_19214_18964.t2 vdd.t6 vdd.t6 pfet_03v3 w=10u l=0.32u ad=2.8000e-12 pd=1.0560e-05 as=2.9000e-12 ps=1.0893e-05 nf=1 m=64 par=64
XMpar4 a_12050_19409.t18 a_1748_8516.t150 a_16500_26220.t0 vss.t362 nfet_03v3 w=9.19u l=0.4u ad=3.1614e-12 pd=1.1716e-05 as=2.5732e-12 ps=9.7500e-06 nf=1 m=10 par=10
XMpar5 a_1748_8516.t19 a_1748_8516.t18 vdd.t6 vdd.t6 pfet_03v3 w=10u l=0.32u ad=2.8000e-12 pd=1.0560e-05 as=2.9000e-12 ps=1.0893e-05 nf=1 m=64 par=64
XMpar6 a_12050_19409.t0 ib.t0 vss.t0 vss.t0 nfet_03v3 w=9.19u l=0.36u ad=2.5732e-12 pd=9.7500e-06 as=2.9000e-12 ps=1.0842e-05 nf=1 m=18 par=18
XMpar7 a_7468_19409.t1 a_7588_19201.t9 a_7588_19201.t10 vdd.t6 pfet_03v3 w=10u l=0.32u ad=3.2000e-12 pd=1.1890e-05 as=2.8000e-12 ps=1.0560e-05 nf=1 m=16 par=16
XMpar8 a_1332_12234.t0 a_19214_1294.t106 a_19214_18964.t132 vss.t0 nfet_03v3 w=10u l=0.4u ad=3.2000e-12 pd=1.1890e-05 as=2.8000e-12 ps=1.0560e-05 nf=1 m=16 par=16
XMpar9 a_1700_12234.t0 ib.t0 vss.t0 vss.t0 nfet_03v3 w=9.19u l=0.36u ad=3.2267e-12 pd=1.1934e-05 as=2.5732e-12 ps=9.7500e-06 nf=1 m=36 par=36
XMpar10 a_1332_12234.t0 a_15946_8516.t106 a_1748_8516.t2 vss.t0 nfet_03v3 w=10u l=0.4u ad=3.2000e-12 pd=1.1890e-05 as=2.8000e-12 ps=1.0560e-05 nf=1 m=16 par=16
XMpar11 ib.t1 ib.t0 vss.t0 vss.t0 nfet_03v3 w=9.19u l=0.36u ad=3.5535e-12 pd=1.3027e-05 as=3.2267e-12 ps=1.1934e-05 nf=1 m=9 par=9
XMpar12 a_16500_26220.t11 a_16500_26220.t10 vdd.t6 vdd.t6 pfet_03v3 w=10u l=0.32u ad=2.8000e-12 pd=1.0560e-05 as=3.2000e-12 ps=1.1890e-05 nf=1 m=16 par=16
XMpar13 a_19214_1294.t0 a_7588_19201.t41 a_19214_18964.t0 vdd.t24 pfet_03v3 w=7.33u l=0.32u ad=2.0524e-12 pd=7.8900e-06 as=2.8343e-12 ps=1.0547e-05 nf=1 m=6 par=6
XMpar14 a_15946_8516.t10 a_7588_19201.t41 a_1748_8516.t0 vdd.t24 pfet_03v3 w=7.33u l=0.32u ad=2.0524e-12 pd=7.8900e-06 as=2.8343e-12 ps=1.0547e-05 nf=1 m=6 par=6
XMpar15 a_7468_19409.t1 a_7468_19409.t0 vdd.t6 vdd.t6 pfet_03v3 w=10u l=0.32u ad=2.8000e-12 pd=1.0560e-05 as=3.2000e-12 ps=1.1890e-05 nf=1 m=16 par=16
XMpar16 out.t0 a_16500_26220.t10 vdd.t6 vdd.t6 pfet_03v3 w=10u l=0.32u ad=2.8000e-12 pd=1.0560e-05 as=2.8000e-12 ps=1.0560e-05 nf=1 m=16 par=16
XMpar17 a_7588_19201.t0 ib.t0 vss.t0 vss.t0 nfet_03v3 w=9.19u l=0.36u ad=3.5535e-12 pd=1.3027e-05 as=2.9000e-12 ps=1.0842e-05 nf=1 m=9 par=9
XMpar18 a_12050_19409.t18 a_19214_18964.t150 out.t13 vss.t362 nfet_03v3 w=9.19u l=0.4u ad=3.1614e-12 pd=1.1716e-05 as=2.5732e-12 ps=9.7500e-06 nf=1 m=10 par=10
XMpar19 a_15946_8516.t0 a_7951_15742.t0 vdd.t1 vdd.t0 pfet_03v3 w=8.56u l=0.36u ad=2.3968e-12 pd=9.1200e-06 as=2.9446e-12 ps=1.0960e-05 nf=1 m=10 par=10
XMpar20 a_7951_15742.t10 ib.t0 vss.t0 vss.t0 nfet_03v3 w=9.19u l=0.36u ad=4.2070e-12 pd=1.5211e-05 as=2.5732e-12 ps=9.7500e-06 nf=1 m=9 par=9
XMpar21 a_19214_1294.t1 a_7951_15742.t0 vdd.t1 vdd.t0 pfet_03v3 w=8.56u l=0.36u ad=2.3968e-12 pd=9.1200e-06 as=2.9446e-12 ps=1.0960e-05 nf=1 m=10 par=10
XMpar22 a_7951_15742.t1 a_7951_15742.t0 vdd.t1 vdd.t0 pfet_03v3 w=8.56u l=0.36u ad=2.9446e-12 pd=1.0960e-05 as=2.9446e-12 ps=1.0960e-05 nf=1 m=5 par=5
X22 out.t26 vss.t327 cap_mim_2f0fF c_width=19.37u c_length=19.37u
X108 out.t26 vss.t327 cap_mim_2f0fF c_width=19.37u c_length=19.37u
X150 out.t26 vss.t327 cap_mim_2f0fF c_width=19.37u c_length=19.37u
X258 out.t26 vss.t327 cap_mim_2f0fF c_width=19.37u c_length=19.37u
X308 out.t26 vss.t327 cap_mim_2f0fF c_width=19.37u c_length=19.37u
X314 out.t26 vss.t327 cap_mim_2f0fF c_width=19.37u c_length=19.37u
X374 out.t26 vss.t327 cap_mim_2f0fF c_width=19.37u c_length=19.37u
X588 out.t26 vss.t327 cap_mim_2f0fF c_width=19.37u c_length=19.37u
Rpar0 a_12050_19409.t0 a_12050_19409.t18 41.3605
Rpar1 a_1332_12234.t0 a_1332_12234.t4 53.4350
Rpar2 a_15946_8516.t0 a_15946_8516.t10 37.8344
Rpar3 a_15946_8516.t0 a_15946_8516.t12 416.5628
Rpar4 a_15946_8516.t0 a_15946_8516.t106 293.0067
Rpar5 a_15946_8516.t10 a_15946_8516.t12 917.3575
Rpar6 a_15946_8516.t10 a_15946_8516.t106 645.2615
Rpar7 a_15946_8516.t12 a_15946_8516.t106 44.2013
Rpar8 a_16500_26220.t0 a_16500_26220.t10 302.0829
Rpar9 a_16500_26220.t0 a_16500_26220.t11 41.1699
Rpar10 a_16500_26220.t10 a_16500_26220.t11 19.3051
Rpar11 a_1700_12234.t0 a_1700_12234.t36 60.8431
Rpar12 a_1748_8516.t0 a_1748_8516.t2 844.3704
Rpar13 a_1748_8516.t0 a_1748_8516.t18 4033.2888
Rpar14 a_1748_8516.t0 a_1748_8516.t19 188.1262
Rpar15 a_1748_8516.t0 a_1748_8516.t150 61.4028
Rpar16 a_1748_8516.t2 a_1748_8516.t18 1421.4012
Rpar17 a_1748_8516.t2 a_1748_8516.t19 66.2990
Rpar18 a_1748_8516.t2 a_1748_8516.t150 1161.8166
Rpar19 a_1748_8516.t18 a_1748_8516.t19 14.7811
Rpar20 a_1748_8516.t18 a_1748_8516.t150 5549.6285
Rpar21 a_1748_8516.t19 a_1748_8516.t150 258.8535
Rpar22 a_19214_1294.t0 a_19214_1294.t1 37.8344
Rpar23 a_19214_1294.t0 a_19214_1294.t14 917.3575
Rpar24 a_19214_1294.t0 a_19214_1294.t106 645.2615
Rpar25 a_19214_1294.t1 a_19214_1294.t14 416.5628
Rpar26 a_19214_1294.t1 a_19214_1294.t106 293.0067
Rpar27 a_19214_1294.t14 a_19214_1294.t106 44.2013
Rpar28 a_19214_18964.t0 a_19214_18964.t2 4033.2882
Rpar29 a_19214_18964.t0 a_19214_18964.t3 188.1263
Rpar30 a_19214_18964.t0 a_19214_18964.t132 844.3704
Rpar31 a_19214_18964.t0 a_19214_18964.t150 61.4028
Rpar32 a_19214_18964.t2 a_19214_18964.t3 14.7811
Rpar33 a_19214_18964.t2 a_19214_18964.t132 1421.4010
Rpar34 a_19214_18964.t2 a_19214_18964.t150 5549.6277
Rpar35 a_19214_18964.t3 a_19214_18964.t132 66.2990
Rpar36 a_19214_18964.t3 a_19214_18964.t150 258.8535
Rpar37 a_19214_18964.t132 a_19214_18964.t150 1161.8166
Rpar38 a_7468_19409.t0 a_7468_19409.t1 21.7705
Rpar39 a_7588_19201.t0 a_7588_19201.t10 74.9033
Rpar40 a_7588_19201.t0 a_7588_19201.t9 2154.7754
Rpar41 a_7588_19201.t0 a_7588_19201.t41 242.9530
Rpar42 a_7588_19201.t10 a_7588_19201.t9 22.2118
Rpar43 a_7588_19201.t10 a_7588_19201.t41 87.4935
Rpar44 a_7588_19201.t9 a_7588_19201.t41 2516.9625
Rpar45 a_7951_15742.t0 a_7951_15742.t1 28.1781
Rpar46 a_7951_15742.t0 a_7951_15742.t10 69.8910
Rpar47 a_7951_15742.t1 a_7951_15742.t10 275.8844
Rpar48 ib ib.t0 16.5830
Rpar49 ib ib.t1 2.0617
Rpar50 ib.t0 ib.t1 59.7919
Rpar51 inn inn.t0 2.2992
Rpar52 inp inp.t0 2.2992
Rpar53 out out.t0 95.5825
Rpar54 out out.t13 199.1223
Rpar55 out out.t26 20.5327
Rpar56 out.t0 out.t13 43.7600
Rpar57 out.t0 out.t26 250.8919
Rpar58 out.t13 out.t26 522.6709
Rpar59 vdd vdd.t0 641.3549
Rpar60 vdd vdd.t1 2228.6580
Rpar61 vdd vdd.t6 81.9006
Rpar62 vdd vdd.t24 292.2568
Rpar63 vdd.t0 vdd.t1 3.1329
Rpar64 vdd.t0 vdd.t6 74.4184
Rpar65 vdd.t0 vdd.t24 74.7501
Rpar66 vdd.t1 vdd.t6 184.3096
Rpar67 vdd.t1 vdd.t24 259.7507
Rpar68 vdd.t6 vdd.t24 145.9148
Rpar69 vss vss.t0 47.2975
Rpar70 vss vss.t327 2913.9778
Rpar71 vss vss.t362 2605.0415
Rpar72 vss.t0 vss.t327 105.3131
Rpar73 vss.t0 vss.t362 5.2260
Rpar74 vss.t327 vss.t362 421.5274
Cpar0 a_12050_19409.t0 vss 1.90414e-14
Cpar1 a_12050_19409.t18 vss 2.43423e-14
Cpar2 a_1332_12234.t0 vss 3.21526e-14
Cpar3 a_1332_12234.t4 vss 6.85956e-14
Cpar4 a_15946_8516.t0 vss 2.85610e-14
Cpar5 a_15946_8516.t10 vss 1.44278e-14
Cpar6 a_15946_8516.t106 vss 2.78490e-14
Cpar7 a_15946_8516.t12 vss 6.00228e-14
Cpar8 a_16500_26220.t0 vss 1.86486e-14
Cpar9 a_16500_26220.t10 vss 2.76924e-14
Cpar10 a_16500_26220.t11 vss 3.52881e-14
Cpar11 a_1700_12234.t0 vss 6.88301e-14
Cpar12 a_1700_12234.t36 vss 7.84708e-14
Cpar13 a_1748_8516.t0 vss 1.88718e-14
Cpar14 a_1748_8516.t150 vss 1.52751e-14
Cpar15 a_1748_8516.t18 vss 5.63872e-14
Cpar16 a_1748_8516.t19 vss 1.34396e-13
Cpar17 a_1748_8516.t2 vss 3.60295e-14
Cpar18 a_19214_1294.t0 vss 1.47071e-14
Cpar19 a_19214_1294.t1 vss 2.91138e-14
Cpar20 a_19214_1294.t106 vss 2.83879e-14
Cpar21 a_19214_1294.t14 vss 6.11840e-14
Cpar22 a_19214_18964.t0 vss 1.89996e-14
Cpar23 a_19214_18964.t132 vss 3.62735e-14
Cpar24 a_19214_18964.t150 vss 1.53786e-14
Cpar25 a_19214_18964.t2 vss 5.67687e-14
Cpar26 a_19214_18964.t3 vss 1.35307e-13
Cpar27 a_7468_19409.t0 vss 1.45582e-14
Cpar28 a_7468_19409.t1 vss 7.43538e-14
Cpar29 a_7588_19201.t0 vss 2.09023e-14
Cpar30 a_7588_19201.t10 vss 2.88756e-14
Cpar31 a_7588_19201.t41 vss 9.21894e-15
Cpar32 a_7588_19201.t9 vss 1.00424e-14
Cpar33 a_7951_15742.t0 vss 1.59951e-14
Cpar34 a_7951_15742.t1 vss 9.73627e-15
Cpar35 a_7951_15742.t10 vss 1.85080e-14
Cpar36 ib vdd 5.61420e-16
Cpar37 ib vss 1.18694e-13
Cpar38 ib.t0 vss 2.77715e-14
Cpar39 ib.t1 vss 4.19322e-15
Cpar40 inn inp 3.07270e-16
Cpar41 inn vdd 1.41850e-16
Cpar42 inn vss 3.36248e-14
Cpar43 inn.t0 vss 2.12557e-14
Cpar44 inp vdd 1.41340e-16
Cpar45 inp vss 3.37526e-14
Cpar46 inp.t0 vss 2.12448e-14
Cpar47 out vdd 4.18875e-14
Cpar48 out vss 6.04243e-14
Cpar49 out.t0 vss 1.73269e-15
Cpar50 out.t13 vss 9.80089e-16
Cpar51 out.t26 vss 6.66286e-14
Cpar52 vdd vss 5.28991e-13
Cpar53 vdd.t0 vss 4.88605e-14
Cpar54 vdd.t1 vss 2.98992e-14
Cpar55 vdd.t24 vss 2.50620e-14
Cpar56 vdd.t6 vss 4.84509e-13
.ends opamp_dut

Vdd vdd 0 1.800000
Vss vss 0 0
Ibias vdd ib 2.187500e-05
Vinp inp 0 DC 1.201600 AC 1 PWL(0 1.201600 5.923316e-09 1.201600 6.515648e-09 1.211600)
Rfb out inn 1m
Cload out 0 2.000000e-12
Xdut vdd vss inp inn out ib opamp_dut
.end
