* opa1000[0780]: 200f/symmetrical_ota_3v3_i2u_subth (symmetrical_ota, VDD=3.3V, CL=0.2pF, Iref=0.3833uA)
.include "pdk_opa.inc"
.temp 27
.option gmin=1e-12 rshunt=1e12 reltol=1e-3 abstol=1e-12 vntol=1e-5 method=gear
* Post-PEX R+C extracted netlist for symmetrical_ota_3v3_i2u_subth
.subckt opamp_dut vdd vss inp inn out ib
XMpar0 a_1509_7828.t4 inp.t0 a_1610_10536.t0 vss.t6 nfet_03v3 w=2.14u l=2.38u ad=5.9920e-13 pd=2.7000e-06 as=8.2747e-13 ps=3.6267e-06 nf=1 m=6 par=6
XMpar1 a_6050_10536.t7 a_6050_10536.t6 vdd.t1 vdd.t0 pfet_03v3 w=4.15u l=2.04u ad=1.1620e-12 pd=4.7100e-06 as=1.1620e-12 ps=4.7100e-06 nf=1 m=2 par=2
XMpar2 out.t3 a_1509_7828.t0 vdd.t1 vdd.t0 pfet_03v3 w=4.15u l=2.04u ad=1.1620e-12 pd=4.7100e-06 as=1.8260e-12 ps=7.1050e-06 nf=1 m=4 par=4
XMpar3 ib.t1 ib.t0 vss.t30 vss.t29 nfet_03v3 w=0.8u l=1.56u ad=2.2400e-13 pd=1.3600e-06 as=2.2400e-13 ps=1.3600e-06 nf=1 m=2 par=2
XMpar4 a_1610_10536.t12 ib.t0 vss.t30 vss.t29 nfet_03v3 w=0.8u l=1.56u ad=2.2400e-13 pd=1.3600e-06 as=3.5200e-13 ps=2.0800e-06 nf=1 m=4 par=4
XMpar5 a_1610_10536.t0 inn.t0 a_6050_10536.t0 vss.t6 nfet_03v3 w=2.14u l=2.38u ad=8.2747e-13 pd=3.6267e-06 as=5.9920e-13 ps=2.7000e-06 nf=1 m=6 par=6
XMpar6 out.t0 a_3476_6009.t4 vss.t1 vss.t0 nfet_03v3 w=0.97u l=2.04u ad=2.7160e-13 pd=1.5300e-06 as=4.2680e-13 ps=2.3350e-06 nf=1 m=4 par=4
XMpar7 a_3476_6009.t5 a_3476_6009.t4 vss.t1 vss.t0 nfet_03v3 w=0.97u l=2.04u ad=2.7160e-13 pd=1.5300e-06 as=2.7160e-13 ps=1.5300e-06 nf=1 m=4 par=4
XMpar8 a_1509_7828.t1 a_1509_7828.t0 vdd.t1 vdd.t0 pfet_03v3 w=4.15u l=2.04u ad=1.1620e-12 pd=4.7100e-06 as=1.1620e-12 ps=4.7100e-06 nf=1 m=2 par=2
XMpar9 a_3476_6009.t0 a_6050_10536.t6 vdd.t1 vdd.t0 pfet_03v3 w=4.15u l=2.04u ad=1.1620e-12 pd=4.7100e-06 as=1.8260e-12 ps=7.1050e-06 nf=1 m=4 par=4
X32 out.t8 vss.t18 cap_mim_2f0fF c_width=16.58u c_length=16.59u
Rpar0 a_1509_7828.t0 a_1509_7828.t1 24.1466
Rpar1 a_1509_7828.t0 a_1509_7828.t4 102.4168
Rpar2 a_1509_7828.t1 a_1509_7828.t4 63.1223
Rpar3 a_1610_10536.t0 a_1610_10536.t12 46.3401
Rpar4 a_3476_6009.t0 a_3476_6009.t4 135.7964
Rpar5 a_3476_6009.t0 a_3476_6009.t5 60.3981
Rpar6 a_3476_6009.t4 a_3476_6009.t5 21.2713
Rpar7 a_6050_10536.t0 a_6050_10536.t6 102.4168
Rpar8 a_6050_10536.t0 a_6050_10536.t7 63.1223
Rpar9 a_6050_10536.t6 a_6050_10536.t7 24.1466
Rpar10 ib ib.t0 11.9869
Rpar11 ib ib.t1 13.6970
Rpar12 inn inn.t0 1.4483
Rpar13 inp inp.t0 1.8223
Rpar14 out out.t0 61.5833
Rpar15 out out.t3 131.6649
Rpar16 out out.t8 15.1481
Rpar17 out.t0 out.t3 72.8197
Rpar18 vdd vdd.t0 62.4163
Rpar19 vdd vdd.t1 107.8316
Rpar20 vdd.t0 vdd.t1 3.0827
Rpar21 vss vss.t0 162.5334
Rpar22 vss vss.t1 748.8671
Rpar23 vss vss.t6 569.8894
Rpar24 vss vss.t18 75.7929
Rpar25 vss vss.t29 141.6939
Rpar26 vss vss.t30 395.3866
Rpar27 vss.t0 vss.t1 7.2942
Rpar28 vss.t0 vss.t6 41.3662
Rpar29 vss.t0 vss.t18 242.5075
Rpar30 vss.t0 vss.t29 4.4804
Rpar31 vss.t0 vss.t30 30.5499
Rpar32 vss.t1 vss.t6 191.8448
Rpar33 vss.t1 vss.t18 1117.3450
Rpar34 vss.t1 vss.t29 29.1028
Rpar35 vss.t1 vss.t30 134.3939
Rpar36 vss.t6 vss.t18 850.3019
Rpar37 vss.t6 vss.t29 131.0850
Rpar38 vss.t6 vss.t30 516.1561
Rpar39 vss.t18 vss.t29 211.4139
Rpar40 vss.t18 vss.t30 589.9355
Rpar41 vss.t29 vss.t30 8.6040
Cpar0 a_1509_7828.t0 vss 1.15649e-14
Cpar1 a_1509_7828.t1 vss 2.95225e-15
Cpar2 a_1509_7828.t4 vss 3.92170e-15
Cpar3 a_1610_10536.t0 vss 7.70301e-15
Cpar4 a_1610_10536.t12 vss 2.95083e-15
Cpar5 a_3476_6009.t0 vss 2.81306e-15
Cpar6 a_3476_6009.t4 vss 5.05126e-15
Cpar7 a_3476_6009.t5 vss 1.48009e-15
Cpar8 a_6050_10536.t0 vss 4.01588e-15
Cpar9 a_6050_10536.t6 vss 1.18427e-14
Cpar10 a_6050_10536.t7 vss 3.02317e-15
Cpar11 ib vss 9.34362e-15
Cpar12 ib.t0 vss 1.23412e-15
Cpar13 ib.t1 vss 5.36154e-17
Cpar14 inn inp 5.25100e-17
Cpar15 inn vdd 2.91840e-16
Cpar16 inn vss 8.91565e-15
Cpar17 inn.t0 vss 1.48804e-15
Cpar18 inp vdd 7.90300e-17
Cpar19 inp vss 8.60123e-15
Cpar20 inp.t0 vss 1.62204e-15
Cpar21 out vdd 3.75360e-15
Cpar22 out vss 1.58890e-14
Cpar23 out.t0 vss 3.07313e-16
Cpar24 out.t3 vss 4.21415e-16
Cpar25 out.t8 vss 8.13093e-15
Cpar26 vdd vss 6.79504e-14
Cpar27 vdd.t0 vss 1.65303e-14
Cpar28 vdd.t1 vss 9.66216e-15
.ends opamp_dut

Vdd vdd 0 3.300000
Vss vss 0 0
Ibias vdd ib 3.833000e-07
Vinp inp 0 DC 1.645000 AC 1 PWL(0 1.645000 3.165375e-08 1.645000 3.481913e-08 1.655000)
Rfb out inn 1m
Cload out 0 2.000000e-13
Xdut vdd vss inp inn out ib opamp_dut
.end
