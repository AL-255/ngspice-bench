* opa1000[0400]: 2p/nmos_5t_3v3_i200n_weak (nmos_5t, VDD=3.3V, CL=2.0pF, Iref=0.0575uA)
.include "pdk_opa.inc"
.temp 27
.option gmin=1e-12 rshunt=1e12 reltol=1e-3 abstol=1e-12 vntol=1e-5 method=gear
* Post-PEX R+C extracted netlist for nmos_5t_3v3_i200n_weak
.subckt opamp_dut vdd vss inp inn out ib
XMpar0 a_1476_4134.t4 ib.t0 vss.t3 vss.t2 nfet_03v3 w=0.4u l=4u ad=1.1200e-13 pd=9.6000e-07 as=2.0800e-13 ps=1.7400e-06 nf=1 m=8 par=8
XMpar1 out.t0 a_1880_7035.t0 vdd.t1 vdd.t0 pfet_03v3 w=1.44u l=9.75u ad=8.6400e-13 pd=4.0800e-06 as=4.0320e-13 ps=2.0000e-06 nf=1 m=2 par=2
XMpar2 a_1880_7035.t1 a_1880_7035.t0 vdd.t1 vdd.t0 pfet_03v3 w=1.44u l=9.75u ad=8.6400e-13 pd=4.0800e-06 as=4.0320e-13 ps=2.0000e-06 nf=1 m=2 par=2
XMpar3 a_1476_4134.t0 inn.t0 out.t1 vss.t0 nfet_03v3 w=2.16u l=9.75u ad=1.2960e-12 pd=5.5200e-06 as=1.2960e-12 ps=5.5200e-06 nf=1 m=2 par=2
XMpar4 a_1476_4134.t0 inp.t0 a_1880_7035.t4 vss.t0 nfet_03v3 w=2.16u l=9.75u ad=1.2960e-12 pd=5.5200e-06 as=1.2960e-12 ps=5.5200e-06 nf=1 m=2 par=2
XMpar5 ib.t1 ib.t0 vss.t3 vss.t2 nfet_03v3 w=0.4u l=4u ad=2.4000e-13 pd=2.0000e-06 as=1.1200e-13 ps=9.6000e-07 nf=1 m=2 par=2
Rpar0 a_1476_4134.t0 a_1476_4134.t4 40.4352
Rpar1 a_1880_7035.t0 a_1880_7035.t1 13.7171
Rpar2 a_1880_7035.t0 a_1880_7035.t4 88.6111
Rpar3 a_1880_7035.t1 a_1880_7035.t4 77.3901
Rpar4 ib ib.t0 12.4888
Rpar5 ib ib.t1 13.9255
Rpar6 ib.t0 ib.t1 34.1884
Rpar7 inn inn.t0 4.4997
Rpar8 inp inp.t0 4.4995
Rpar9 out out.t0 10.7211
Rpar10 out out.t1 102.8294
Rpar11 out.t0 out.t1 79.6868
Rpar12 vdd vdd.t0 26.8844
Rpar13 vdd vdd.t1 119.8954
Rpar14 vdd.t0 vdd.t1 21.1322
Rpar15 vss vss.t0 111.0198
Rpar16 vss vss.t2 26.1800
Rpar17 vss vss.t3 185.2171
Rpar18 vss.t0 vss.t2 6.8698
Rpar19 vss.t0 vss.t3 67.1596
Rpar20 vss.t2 vss.t3 16.1631
Cpar0 a_1476_4134.t0 vss 8.62870e-15
Cpar1 a_1476_4134.t4 vss 6.41753e-15
Cpar2 a_1880_7035.t0 vss 2.61847e-14
Cpar3 a_1880_7035.t1 vss 5.56403e-15
Cpar4 a_1880_7035.t4 vss 5.81348e-15
Cpar5 ib inn 1.83200e-17
Cpar6 ib inp 2.07100e-17
Cpar7 ib vss 3.19979e-14
Cpar8 ib.t0 vss 4.49311e-15
Cpar9 ib.t1 vss 3.99941e-16
Cpar10 inn inp 1.02550e-16
Cpar11 inn out 1.39168e-15
Cpar12 inn vss 9.50860e-15
Cpar13 inn.t0 vss 2.02397e-15
Cpar14 inp vdd 1.08600e-17
Cpar15 inp vss 9.41676e-15
Cpar16 inp.t0 vss 2.06443e-15
Cpar17 out vdd 6.14378e-15
Cpar18 out vss 1.13467e-14
Cpar19 out.t0 vss 3.76393e-15
Cpar20 out.t1 vss 7.31729e-15
Cpar21 vdd vss 6.13547e-14
Cpar22 vdd.t0 vss 2.00190e-14
Cpar23 vdd.t1 vss 5.48543e-15
.ends opamp_dut

Vdd vdd 0 3.300000
Vss vss 0 0
Ibias vdd ib 5.750000e-08
Vinp inp 0 DC 1.645000 AC 1 PWL(0 1.645000 6.089437e-07 1.645000 6.698381e-07 1.655000)
Rfb out inn 1m
Cload out 0 2.000000e-12
Xdut vdd vss inp inn out ib opamp_dut
.end
