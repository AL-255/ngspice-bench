* opa1000[0994]: 2p/telescopic_pmos_3v3_i20u_weak (telescopic_pmos, VDD=3.3V, CL=2.0pF, Iref=5.2uA)
.include "pdk_opa.inc"
.temp 27
.option gmin=1e-12 rshunt=1e12 reltol=1e-3 abstol=1e-12 vntol=1e-5 method=gear
* Post-PEX R+C extracted netlist for telescopic_pmos_3v3_i20u_weak
.subckt opamp_dut vdd vss inp inn out ib
XMpar0 a_1887_6091.t1 a_1887_6091.t0 a_4588_12252.t2 vss.t0 nfet_03v3 w=1.88u l=0.9u ad=5.2640e-13 pd=2.4400e-06 as=8.2720e-13 ps=3.7000e-06 nf=1 m=8 par=8
XMpar1 a_3211_6299.t14 inp.t0 a_4782_14148.t0 vdd.t17 pfet_03v3 w=2u l=0.54u ad=6.0267e-13 pd=2.7360e-06 as=6.8800e-13 ps=3.0880e-06 nf=1 m=30 par=30
XMpar2 a_1767_6299.t0 a_1887_6091.t16 out.t0 vdd.t0 pfet_03v3 w=1.98u l=0.9u ad=8.8984e-13 pd=3.9271e-06 as=5.9167e-13 ps=2.6941e-06 nf=1 m=34 par=34
XMpar3 a_1887_6091.t17 a_1887_6091.t16 a_3211_6299.t0 vdd.t0 pfet_03v3 w=1.98u l=0.9u ad=6.6621e-13 pd=3.0024e-06 as=7.4075e-13 ps=3.3106e-06 nf=1 m=34 par=34
XMpar4 ib.t1 ib.t0 vss.t21 vss.t20 nfet_03v3 w=4.15u l=1.8u ad=2.4900e-12 pd=9.5000e-06 as=1.1620e-12 ps=4.7100e-06 nf=1 m=2 par=2
XMpar5 a_1767_6299.t6 inn.t0 a_4782_14148.t0 vdd.t17 pfet_03v3 w=2u l=0.54u ad=6.0267e-13 pd=2.7360e-06 as=6.8800e-13 ps=3.0880e-06 nf=1 m=30 par=30
XMpar6 a_4782_14148.t30 a_2050_12252.t0 vdd.t11 vdd.t10 pfet_03v3 w=10u l=1.8u ad=2.8000e-12 pd=1.0560e-05 as=3.6000e-12 ps=1.3220e-05 nf=1 m=8 par=8
XMpar7 a_4588_12252.t0 a_1887_6091.t126 vss.t1 vss.t0 nfet_03v3 w=2.03u l=2.03u ad=7.8493e-13 pd=3.4800e-06 as=5.6840e-13 ps=2.5900e-06 nf=1 m=6 par=6
XMpar8 a_5632_12252.t2 a_1887_6091.t0 out.t8 vss.t0 nfet_03v3 w=1.88u l=0.9u ad=6.7680e-13 pd=3.0700e-06 as=5.2640e-13 ps=2.4400e-06 nf=1 m=8 par=8
XMpar9 a_5632_12252.t0 a_1887_6091.t126 vss.t1 vss.t0 nfet_03v3 w=2.03u l=2.03u ad=5.6840e-13 pd=2.5900e-06 as=5.6840e-13 ps=2.5900e-06 nf=1 m=6 par=6
XMpar10 a_2050_12252.t4 ib.t0 vss.t21 vss.t20 nfet_03v3 w=4.15u l=1.8u ad=1.1620e-12 pd=4.7100e-06 as=1.1620e-12 ps=4.7100e-06 nf=1 m=2 par=2
XMpar11 a_2050_12252.t1 a_2050_12252.t0 vdd.t11 vdd.t10 pfet_03v3 w=10u l=1.8u ad=2.8000e-12 pd=1.0560e-05 as=2.8000e-12 ps=1.0560e-05 nf=1 m=2 par=2
Rpar0 a_1767_6299.t0 a_1767_6299.t6 38.4910
Rpar1 a_1887_6091.t0 a_1887_6091.t1 15.7450
Rpar2 a_1887_6091.t0 a_1887_6091.t126 1178.7689
Rpar3 a_1887_6091.t1 a_1887_6091.t16 1020.2560
Rpar4 a_1887_6091.t1 a_1887_6091.t126 125.6210
Rpar5 a_1887_6091.t1 a_1887_6091.t17 341.8387
Rpar6 a_1887_6091.t16 a_1887_6091.t126 214.1404
Rpar7 a_1887_6091.t16 a_1887_6091.t17 8.3826
Rpar8 a_1887_6091.t126 a_1887_6091.t17 71.7481
Rpar9 a_2050_12252.t0 a_2050_12252.t1 25.4738
Rpar10 a_2050_12252.t0 a_2050_12252.t4 144.6695
Rpar11 a_2050_12252.t1 a_2050_12252.t4 84.4166
Rpar12 a_3211_6299.t0 a_3211_6299.t14 51.8050
Rpar13 a_4588_12252.t0 a_4588_12252.t2 55.5529
Rpar14 a_4782_14148.t0 a_4782_14148.t30 69.8651
Rpar15 a_5632_12252.t0 a_5632_12252.t2 56.9966
Rpar16 ib ib.t0 14.5992
Rpar17 ib ib.t1 3.6321
Rpar18 inn inn.t0 3.5668
Rpar19 inp inp.t0 3.5668
Rpar20 out out.t0 182.9856
Rpar21 out out.t8 4.3327
Rpar22 out.t0 out.t8 150.9748
Rpar23 vdd vdd.t0 65.6831
Rpar24 vdd vdd.t10 26.1556
Rpar25 vdd vdd.t11 179.0568
Rpar26 vdd vdd.t17 208.2930
Rpar27 vdd.t0 vdd.t10 260.8467
Rpar28 vdd.t0 vdd.t11 1785.7152
Rpar29 vdd.t0 vdd.t17 43.9788
Rpar30 vdd.t10 vdd.t11 5.5687
Rpar31 vdd.t10 vdd.t17 827.1922
Rpar32 vdd.t11 vdd.t17 5662.8270
Rpar33 vss vss.t0 88.5123
Rpar34 vss vss.t1 876.7196
Rpar35 vss vss.t20 424.2798
Rpar36 vss vss.t21 543.4289
Rpar37 vss.t0 vss.t1 4.5633
Rpar38 vss.t0 vss.t20 94.4411
Rpar39 vss.t0 vss.t21 121.0007
Rpar40 vss.t1 vss.t20 779.1116
Rpar41 vss.t1 vss.t21 998.1311
Rpar42 vss.t20 vss.t21 10.0827
Cpar0 a_1767_6299.t0 vss 4.25380e-14
Cpar1 a_1767_6299.t6 vss 2.57122e-14
Cpar2 a_1887_6091.t0 vss 1.13178e-14
Cpar3 a_1887_6091.t1 vss 8.66002e-15
Cpar4 a_1887_6091.t126 vss 2.02948e-14
Cpar5 a_1887_6091.t16 vss 4.79109e-14
Cpar6 a_1887_6091.t17 vss 2.94345e-14
Cpar7 a_2050_12252.t0 vss 2.24871e-14
Cpar8 a_2050_12252.t1 vss 4.03200e-15
Cpar9 a_2050_12252.t4 vss 2.29774e-15
Cpar10 a_3211_6299.t0 vss 4.62487e-14
Cpar11 a_3211_6299.t14 vss 2.87037e-14
Cpar12 a_4588_12252.t0 vss 6.67383e-15
Cpar13 a_4588_12252.t2 vss 6.94175e-15
Cpar14 a_4782_14148.t0 vss 4.26131e-14
Cpar15 a_4782_14148.t30 vss 2.18645e-14
Cpar16 a_5632_12252.t0 vss 6.97830e-15
Cpar17 a_5632_12252.t2 vss 7.83578e-15
Cpar18 ib out 6.58600e-17
Cpar19 ib vss 9.27396e-15
Cpar20 ib.t0 vss 9.98052e-16
Cpar21 ib.t1 vss 2.93570e-16
Cpar22 inn inp 1.56100e-16
Cpar23 inn vdd 1.30376e-14
Cpar24 inn vss 5.35629e-15
Cpar25 inn.t0 vss 1.75150e-14
Cpar26 inp vdd 1.30079e-14
Cpar27 inp vss 5.37835e-15
Cpar28 inp.t0 vss 1.75018e-14
Cpar29 out vdd 1.19123e-14
Cpar30 out vss 1.86757e-14
Cpar31 out.t0 vss 4.48066e-14
Cpar32 out.t8 vss 1.01336e-14
Cpar33 vdd vss 3.12460e-13
Cpar34 vdd.t0 vss 7.57264e-14
Cpar35 vdd.t10 vss 2.33484e-14
Cpar36 vdd.t11 vss 8.32985e-15
Cpar37 vdd.t17 vss 4.00973e-14
.ends opamp_dut

Vdd vdd 0 3.300000
Vss vss 0 0
Ibias vdd ib 5.200000e-06
Vinp inp 0 DC 1.480000 AC 1 PWL(0 1.480000 7.510942e-09 1.480000 8.262036e-09 1.490000)
Rfb out inn 1m
Cload out 0 2.000000e-12
Xdut vdd vss inp inn out ib opamp_dut
.end
