* opa1000[0308]: 2p/folded_cascode_pmos_1v8_10u_100u_subth (folded_cascode_pmos, VDD=1.8V, CL=2.0pF, Iref=7.7778uA)
.include "pdk_opa.inc"
.temp 27
.option gmin=1e-12 rshunt=1e12 reltol=1e-3 abstol=1e-12 vntol=1e-5 method=gear
* Post-PEX R+C extracted netlist for folded_cascode_pmos_1v8_10u_100u_subth
.subckt opamp_dut vdd vss inp inn out ib
XMpar0 a_1479_6792.t4 inn.t0 a_6345_11889.t30 vdd.t0 pfet_03v3 w=4.05u l=0.35u ad=1.2150e-12 pd=4.9031e-06 as=1.1745e-12 ps=4.7566e-06 nf=1 m=64 par=64
XMpar1 a_1479_6792.t4 inp.t0 a_2124_10372.t30 vdd.t0 pfet_03v3 w=4.05u l=0.35u ad=1.2150e-12 pd=4.9031e-06 as=1.1745e-12 ps=4.7566e-06 nf=1 m=64 par=64
XMpar2 a_6345_11889.t0 a_1179_6584.t6 out.t0 vss.t0 nfet_03v3 w=2.03u l=0.8u ad=6.1837e-13 pd=2.7954e-06 as=6.1837e-13 ps=2.7954e-06 nf=1 m=26 par=26
XMpar3 a_6345_11889.t26 ib.t0 vss.t18 vss.t0 nfet_03v3 w=5.34u l=0.65u ad=1.4952e-12 pd=5.9000e-06 as=2.3496e-12 ps=8.8900e-06 nf=1 m=4 par=4
XMpar4 ib.t1 ib.t0 vss.t18 vss.t0 nfet_03v3 w=5.34u l=0.65u ad=3.2040e-12 pd=1.1880e-05 as=1.4952e-12 ps=5.9000e-06 nf=1 m=2 par=2
XMpar5 a_1179_6584.t4 ib.t0 vss.t18 vss.t0 nfet_03v3 w=5.34u l=0.65u ad=1.4952e-12 pd=5.9000e-06 as=1.4952e-12 ps=5.9000e-06 nf=1 m=2 par=2
XMpar6 a_1179_6584.t1 a_1179_6584.t0 vdd.t44 vdd.t43 pfet_03v3 w=10u l=1.5u ad=2.8000e-12 pd=1.0560e-05 as=2.8000e-12 ps=1.0560e-05 nf=1 m=2 par=2
XMpar7 a_1479_6792.t0 a_1179_6584.t0 vdd.t44 vdd.t43 pfet_03v3 w=10u l=1.5u ad=2.8000e-12 pd=1.0560e-05 as=4.4000e-12 ps=1.5880e-05 nf=1 m=4 par=4
XMpar8 a_2124_10372.t0 a_1179_6584.t6 a_2682_3897.t0 vss.t0 nfet_03v3 w=2.03u l=0.8u ad=6.1837e-13 pd=2.7954e-06 as=6.1837e-13 ps=2.7954e-06 nf=1 m=26 par=26
XMpar9 a_2124_10372.t26 ib.t0 vss.t18 vss.t0 nfet_03v3 w=5.34u l=0.65u ad=1.4952e-12 pd=5.9000e-06 as=2.3496e-12 ps=8.8900e-06 nf=1 m=4 par=4
XMpar10 out.t12 a_2682_3897.t26 vdd.t44 vdd.t43 pfet_03v3 w=10u l=1.5u ad=2.8000e-12 pd=1.0560e-05 as=2.8000e-12 ps=1.0560e-05 nf=1 m=2 par=2
XMpar11 a_2682_3897.t27 a_2682_3897.t26 vdd.t44 vdd.t43 pfet_03v3 w=10u l=1.5u ad=6.0000e-12 pd=2.1200e-05 as=2.8000e-12 ps=1.0560e-05 nf=1 m=2 par=2
Rpar0 a_1179_6584.t0 a_1179_6584.t1 25.3207
Rpar1 a_1179_6584.t0 a_1179_6584.t6 986.1054
Rpar2 a_1179_6584.t0 a_1179_6584.t4 1108.3019
Rpar3 a_1179_6584.t1 a_1179_6584.t6 429.8886
Rpar4 a_1179_6584.t1 a_1179_6584.t4 483.1597
Rpar5 a_1179_6584.t6 a_1179_6584.t4 53.0631
Rpar6 a_1479_6792.t0 a_1479_6792.t4 55.4864
Rpar7 a_2124_10372.t0 a_2124_10372.t26 63.4075
Rpar8 a_2124_10372.t0 a_2124_10372.t30 86.1152
Rpar9 a_2124_10372.t26 a_2124_10372.t30 113.4744
Rpar10 a_2682_3897.t0 a_2682_3897.t26 329.0085
Rpar11 a_2682_3897.t0 a_2682_3897.t27 56.4967
Rpar12 a_2682_3897.t26 a_2682_3897.t27 24.3681
Rpar13 a_6345_11889.t0 a_6345_11889.t26 63.4075
Rpar14 a_6345_11889.t0 a_6345_11889.t30 86.1152
Rpar15 a_6345_11889.t26 a_6345_11889.t30 113.4744
Rpar16 ib ib.t0 17.1873
Rpar17 ib ib.t1 3.3798
Rpar18 ib.t0 ib.t1 469.5682
Rpar19 inn inn.t0 2.9162
Rpar20 inp inp.t0 2.9162
Rpar21 out out.t0 2.1030
Rpar22 out out.t12 50.3399
Rpar23 vdd vdd.t0 23.6547
Rpar24 vdd vdd.t43 181.3613
Rpar25 vdd vdd.t44 584.4034
Rpar26 vdd.t0 vdd.t43 57.3834
Rpar27 vdd.t0 vdd.t44 184.9074
Rpar28 vdd.t43 vdd.t44 3.8232
Rpar29 vss vss.t0 45.6753
Rpar30 vss vss.t18 63.8496
Rpar31 vss.t0 vss.t18 3.1150
Cpar0 a_1179_6584.t0 vss 1.28054e-14
Cpar1 a_1179_6584.t1 vss 7.90725e-15
Cpar2 a_1179_6584.t4 vss 4.63413e-15
Cpar3 a_1179_6584.t6 vss 2.40937e-14
Cpar4 a_1479_6792.t0 vss 1.32858e-14
Cpar5 a_1479_6792.t4 vss 1.46865e-13
Cpar6 a_2124_10372.t0 vss 2.18259e-14
Cpar7 a_2124_10372.t26 vss 9.10257e-15
Cpar8 a_2124_10372.t30 vss 7.09105e-14
Cpar9 a_2682_3897.t0 vss 1.21521e-14
Cpar10 a_2682_3897.t26 vss 9.74446e-15
Cpar11 a_2682_3897.t27 vss 8.14360e-15
Cpar12 a_6345_11889.t0 vss 2.20175e-14
Cpar13 a_6345_11889.t26 vss 9.18249e-15
Cpar14 a_6345_11889.t30 vss 7.15335e-14
Cpar15 ib vss 1.59939e-14
Cpar16 ib.t0 vss 1.75793e-15
Cpar17 ib.t1 vss 4.61392e-16
Cpar18 inn inp 1.07850e-16
Cpar19 inn out 1.04400e-17
Cpar20 inn vdd 2.11349e-14
Cpar21 inn vss 8.64580e-15
Cpar22 inn.t0 vss 3.00986e-14
Cpar23 inp vdd 2.09672e-14
Cpar24 inp vss 8.60006e-15
Cpar25 inp.t0 vss 3.00697e-14
Cpar26 out vdd 3.35349e-15
Cpar27 out vss 1.16693e-14
Cpar28 out.t0 vss 1.16603e-14
Cpar29 out.t12 vss 5.15023e-15
Cpar30 vdd vss 2.30908e-13
Cpar31 vdd.t0 vss 6.45055e-14
Cpar32 vdd.t43 vss 2.25504e-14
Cpar33 vdd.t44 vss 1.08356e-14
.ends opamp_dut

Vdd vdd 0 1.800000
Vss vss 0 0
Ibias vdd ib 7.777800e-06
Vinp inp 0 DC 0.751000 AC 1 PWL(0 0.751000 7.792381e-09 0.751000 8.571619e-09 0.761000)
Rfb out inn 1m
Cload out 0 2.000000e-12
Xdut vdd vss inp inn out ib opamp_dut
.end
