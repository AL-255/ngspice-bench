* opa1000[0900]: 2p/telescopic_nmos_3v3_i200n_subth (telescopic_nmos, VDD=3.3V, CL=2.0pF, Iref=0.065uA)
.include "pdk_opa.inc"
.temp 27
.option gmin=1e-12 rshunt=1e12 reltol=1e-3 abstol=1e-12 vntol=1e-5 method=gear
* Post-PEX R+C extracted netlist for telescopic_nmos_3v3_i200n_subth
.subckt opamp_dut vdd vss inp inn out ib
XMpar0 a_2008_16841.t3 a_2128_16633.t44 vdd.t2 vdd.t1 pfet_03v3 w=1.57u l=9.75u ad=9.4200e-13 pd=4.3400e-06 as=4.3960e-13 ps=2.1300e-06 nf=1 m=6 par=6
XMpar1 a_3774_18656.t0 a_2128_16633.t0 out.t0 vdd.t0 pfet_03v3 w=1.88u l=4.2u ad=8.2720e-13 pd=3.7000e-06 as=7.5200e-13 ps=3.3850e-06 nf=1 m=16 par=16
XMpar2 a_2556_1250.t0 inn.t0 a_6092_3136.t1 vss.t2 nfet_03v3 w=1.78u l=7.2u ad=1.0680e-12 pd=4.7600e-06 as=4.9840e-13 ps=2.3400e-06 nf=1 m=8 par=8
XMpar3 a_2128_16633.t33 a_2128_16633.t32 a_3912_3136.t0 vss.t0 nfet_03v3 w=1.65u l=4.2u ad=4.6200e-13 pd=2.2100e-06 as=9.9000e-13 ps=4.5000e-06 nf=1 m=4 par=4
XMpar4 a_3774_18656.t1 a_2128_16633.t44 vdd.t2 vdd.t1 pfet_03v3 w=1.57u l=9.75u ad=6.0707e-13 pd=2.8667e-06 as=4.3960e-13 ps=2.1300e-06 nf=1 m=6 par=6
XMpar5 a_6092_3136.t0 a_2128_16633.t32 out.t8 vss.t0 nfet_03v3 w=1.65u l=4.2u ad=7.2600e-13 pd=3.3550e-06 as=4.6200e-13 ps=2.2100e-06 nf=1 m=4 par=4
XMpar6 a_2008_16841.t0 a_2128_16633.t0 a_2128_16633.t1 vdd.t0 pfet_03v3 w=1.88u l=4.2u ad=8.2720e-13 pd=3.7000e-06 as=8.2720e-13 ps=3.7000e-06 nf=1 m=16 par=16
XMpar7 a_2556_1250.t0 inp.t0 a_3912_3136.t2 vss.t2 nfet_03v3 w=1.78u l=7.2u ad=1.0680e-12 pd=4.7600e-06 as=4.9840e-13 ps=2.3400e-06 nf=1 m=8 par=8
XMpar8 a_2556_1250.t16 ib.t0 vss.t13 vss.t12 nfet_03v3 w=0.63u l=6.25u ad=1.7640e-13 pd=1.1900e-06 as=2.2680e-13 ps=1.5075e-06 nf=1 m=8 par=8
XMpar9 ib.t1 ib.t0 vss.t13 vss.t12 nfet_03v3 w=0.63u l=6.25u ad=1.7640e-13 pd=1.1900e-06 as=1.7640e-13 ps=1.1900e-06 nf=1 m=2 par=2
Rpar0 a_2008_16841.t0 a_2008_16841.t3 56.3618
Rpar1 a_2128_16633.t0 a_2128_16633.t1 5.9061
Rpar2 a_2128_16633.t0 a_2128_16633.t32 1109.0410
Rpar3 a_2128_16633.t0 a_2128_16633.t33 630.2976
Rpar4 a_2128_16633.t0 a_2128_16633.t44 185.0986
Rpar5 a_2128_16633.t1 a_2128_16633.t32 458.8270
Rpar6 a_2128_16633.t1 a_2128_16633.t33 260.7636
Rpar7 a_2128_16633.t1 a_2128_16633.t44 76.5781
Rpar8 a_2128_16633.t32 a_2128_16633.t33 20.4298
Rpar9 a_2128_16633.t32 a_2128_16633.t44 172.2724
Rpar10 a_2128_16633.t33 a_2128_16633.t44 97.9070
Rpar11 a_2556_1250.t0 a_2556_1250.t16 54.6867
Rpar12 a_3774_18656.t0 a_3774_18656.t1 69.8731
Rpar13 a_3912_3136.t0 a_3912_3136.t2 51.9440
Rpar14 a_6092_3136.t0 a_6092_3136.t1 63.2369
Rpar15 ib ib.t0 32.0039
Rpar16 ib ib.t1 23.4511
Rpar17 ib.t0 ib.t1 65.7796
Rpar18 inn inn.t0 2.7772
Rpar19 inp inp.t0 2.7772
Rpar20 out out.t0 4.9669
Rpar21 out out.t8 345.6296
Rpar22 out.t0 out.t8 150.6964
Rpar23 vdd vdd.t0 59.5864
Rpar24 vdd vdd.t1 221.6187
Rpar25 vdd vdd.t2 2654.9439
Rpar26 vdd.t0 vdd.t1 2.1108
Rpar27 vdd.t0 vdd.t2 25.2868
Rpar28 vdd.t1 vdd.t2 19.1890
Rpar29 vss vss.t0 57.3463
Rpar30 vss vss.t12 53.0480
Rpar31 vss vss.t13 223.1264
Rpar32 vss vss.t2 77.5998
Rpar33 vss.t0 vss.t12 2.7998
Rpar34 vss.t0 vss.t13 16.9739
Rpar35 vss.t0 vss.t2 2.7896
Rpar36 vss.t12 vss.t13 15.5550
Rpar37 vss.t12 vss.t2 3.7959
Rpar38 vss.t13 vss.t2 22.9692
Cpar0 a_2008_16841.t0 vss 4.49181e-14
Cpar1 a_2008_16841.t3 vss 3.21542e-14
Cpar2 a_2128_16633.t0 vss 8.41158e-14
Cpar3 a_2128_16633.t1 vss 2.59014e-14
Cpar4 a_2128_16633.t32 vss 2.07688e-14
Cpar5 a_2128_16633.t33 vss 5.46591e-15
Cpar6 a_2128_16633.t44 vss 7.09495e-14
Cpar7 a_2556_1250.t0 vss 2.41592e-14
Cpar8 a_2556_1250.t16 vss 9.91607e-15
Cpar9 a_3774_18656.t0 vss 4.86362e-14
Cpar10 a_3774_18656.t1 vss 3.42173e-14
Cpar11 a_3912_3136.t0 vss 9.32970e-15
Cpar12 a_3912_3136.t2 vss 1.53052e-14
Cpar13 a_6092_3136.t0 vss 9.03240e-15
Cpar14 a_6092_3136.t1 vss 1.48572e-14
Cpar15 ib out 2.09530e-16
Cpar16 ib vss 4.14864e-14
Cpar17 ib.t0 vss 6.04536e-15
Cpar18 ib.t1 vss 3.04055e-16
Cpar19 inn inp 2.07870e-16
Cpar20 inn vdd 1.58800e-17
Cpar21 inn vss 2.32893e-14
Cpar22 inn.t0 vss 8.71011e-15
Cpar23 inp vdd 1.58800e-17
Cpar24 inp vss 2.31179e-14
Cpar25 inp.t0 vss 8.76403e-15
Cpar26 out vdd 2.16455e-14
Cpar27 out vss 2.60344e-14
Cpar28 out.t0 vss 3.23483e-14
Cpar29 out.t8 vss 1.23998e-14
Cpar30 vdd vss 4.01057e-13
Cpar31 vdd.t0 vss 1.35056e-13
Cpar32 vdd.t1 vss 5.67595e-14
Cpar33 vdd.t2 vss 8.41353e-15
.ends opamp_dut

Vdd vdd 0 3.300000
Vss vss 0 0
Ibias vdd ib 6.500000e-08
Vinp inp 0 DC 1.711000 AC 1 PWL(0 1.711000 5.292281e-07 1.711000 5.821509e-07 1.721000)
Rfb out inn 1m
Cload out 0 2.000000e-12
Xdut vdd vss inp inn out ib opamp_dut
.end
