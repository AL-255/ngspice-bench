* opa1000[0810]: 2p/symmetrical_ota_1v8_i150u_subth (symmetrical_ota, VDD=1.8V, CL=2.0pF, Iref=28.75uA)
.include "pdk_opa.inc"
.temp 27
.option gmin=1e-12 rshunt=1e12 reltol=1e-3 abstol=1e-12 vntol=1e-5 method=gear
* Post-PEX R+C extracted netlist for symmetrical_ota_1v8_i150u_subth
.subckt opamp_dut vdd vss inp inn out ib
XMpar0 a_1962_11282.t12 inp.t0 a_2152_11282.t12 vss.t0 nfet_03v3 w=1.98u l=0.35u ad=5.9966e-13 pd=2.7271e-06 as=5.5440e-13 ps=2.5400e-06 nf=1 m=56 par=56
XMpar1 a_1962_11282.t12 inn.t0 a_7564_11282.t0 vss.t0 nfet_03v3 w=1.98u l=0.35u ad=5.9966e-13 pd=2.7271e-06 as=5.5440e-13 ps=2.5400e-06 nf=1 m=56 par=56
XMpar2 a_5124_8552.t13 a_5124_8552.t12 vss.t1 vss.t0 nfet_03v3 w=4.26u l=0.42u ad=1.1928e-12 pd=4.8200e-06 as=1.1928e-12 ps=4.8200e-06 nf=1 m=12 par=12
XMpar3 out.t0 a_2152_11282.t0 vdd.t1 vdd.t0 pfet_03v3 w=10u l=0.42u ad=2.8000e-12 pd=1.0560e-05 as=3.3333e-12 ps=1.2333e-05 nf=1 m=12 par=12
XMpar4 ib.t1 ib.t0 vss.t3 vss.t2 nfet_03v3 w=9.04u l=0.81u ad=2.5312e-12 pd=9.6000e-06 as=2.5312e-12 ps=9.6000e-06 nf=1 m=6 par=6
XMpar5 a_5124_8552.t0 a_7564_11282.t56 vdd.t1 vdd.t0 pfet_03v3 w=10u l=0.42u ad=2.8000e-12 pd=1.0560e-05 as=3.3333e-12 ps=1.2333e-05 nf=1 m=12 par=12
XMpar6 a_1962_11282.t0 ib.t0 vss.t3 vss.t2 nfet_03v3 w=9.04u l=0.81u ad=2.5312e-12 pd=9.6000e-06 as=3.0133e-12 ps=1.1213e-05 nf=1 m=12 par=12
XMpar7 a_7564_11282.t57 a_7564_11282.t56 vdd.t1 vdd.t0 pfet_03v3 w=10u l=0.42u ad=2.8000e-12 pd=1.0560e-05 as=2.8000e-12 ps=1.0560e-05 nf=1 m=6 par=6
XMpar8 out.t4 a_5124_8552.t12 vss.t1 vss.t0 nfet_03v3 w=4.26u l=0.42u ad=1.1928e-12 pd=4.8200e-06 as=1.4200e-12 ps=5.6367e-06 nf=1 m=12 par=12
XMpar9 a_2152_11282.t1 a_2152_11282.t0 vdd.t1 vdd.t0 pfet_03v3 w=10u l=0.42u ad=2.8000e-12 pd=1.0560e-05 as=2.8000e-12 ps=1.0560e-05 nf=1 m=6 par=6
X131 out.t24 vss.t80 cap_mim_2f0fF c_width=11.18u c_length=11.18u
Rpar0 a_1962_11282.t0 a_1962_11282.t12 49.8770
Rpar1 a_2152_11282.t0 a_2152_11282.t1 22.5977
Rpar2 a_2152_11282.t0 a_2152_11282.t12 299.8333
Rpar3 a_2152_11282.t1 a_2152_11282.t12 56.0733
Rpar4 a_5124_8552.t0 a_5124_8552.t12 931.2673
Rpar5 a_5124_8552.t0 a_5124_8552.t13 37.9952
Rpar6 a_5124_8552.t12 a_5124_8552.t13 16.1478
Rpar7 a_7564_11282.t0 a_7564_11282.t56 299.8260
Rpar8 a_7564_11282.t0 a_7564_11282.t57 56.0737
Rpar9 a_7564_11282.t56 a_7564_11282.t57 22.5978
Rpar10 ib ib.t0 40.9208
Rpar11 ib ib.t1 3.6736
Rpar12 ib.t0 ib.t1 30.8965
Rpar13 inn inn.t0 2.0963
Rpar14 inp inp.t0 2.0963
Rpar15 out out.t0 1.6771
Rpar16 out out.t4 65.0113
Rpar17 out out.t24 85.8247
Rpar18 out.t4 out.t24 240.5098
Rpar19 vdd vdd.t0 81.7660
Rpar20 vdd vdd.t1 420.2605
Rpar21 vdd.t0 vdd.t1 2.3690
Rpar22 vss vss.t0 121.4532
Rpar23 vss vss.t1 4238.6008
Rpar24 vss vss.t2 110.5478
Rpar25 vss vss.t3 456.5407
Rpar26 vss vss.t80 74.9344
Rpar27 vss.t0 vss.t1 3.3272
Rpar28 vss.t0 vss.t2 362.9618
Rpar29 vss.t0 vss.t80 155.0906
Rpar30 vss.t1 vss.t80 5411.3543
Rpar31 vss.t2 vss.t3 4.8929
Rpar32 vss.t2 vss.t80 256.0107
Rpar33 vss.t3 vss.t80 1057.2773
Cpar0 a_1962_11282.t0 vss 2.49209e-14
Cpar1 a_1962_11282.t12 vss 6.00522e-14
Cpar2 a_2152_11282.t0 vss 2.12227e-14
Cpar3 a_2152_11282.t1 vss 1.81440e-14
Cpar4 a_2152_11282.t12 vss 3.19515e-14
Cpar5 a_5124_8552.t0 vss 1.40180e-14
Cpar6 a_5124_8552.t12 vss 9.22201e-15
Cpar7 a_5124_8552.t13 vss 8.99988e-15
Cpar8 a_7564_11282.t0 vss 3.15211e-14
Cpar9 a_7564_11282.t56 vss 2.09367e-14
Cpar10 a_7564_11282.t57 vss 1.78994e-14
Cpar11 ib out 2.27100e-17
Cpar12 ib vss 2.64707e-14
Cpar13 ib.t0 vss 4.15103e-15
Cpar14 ib.t1 vss 1.39089e-15
Cpar15 inn inp 1.02650e-16
Cpar16 inn vdd 2.57900e-17
Cpar17 inn vss 2.14626e-14
Cpar18 inn.t0 vss 7.73198e-15
Cpar19 inp vdd 5.52100e-17
Cpar20 inp vss 2.16365e-14
Cpar21 inp.t0 vss 7.73377e-15
Cpar22 out vdd 2.56965e-14
Cpar23 out vss 2.35149e-14
Cpar24 out.t0 vss 7.16561e-15
Cpar25 out.t24 vss 1.99481e-14
Cpar26 out.t4 vss 5.12057e-15
Cpar27 vdd vss 1.17096e-13
Cpar28 vdd.t0 vss 5.94579e-14
Cpar29 vdd.t1 vss 2.97381e-14
.ends opamp_dut

Vdd vdd 0 1.800000
Vss vss 0 0
Ibias vdd ib 2.875000e-05
Vinp inp 0 DC 0.895000 AC 1 PWL(0 0.895000 3.000000e-09 0.895000 3.300000e-09 0.905000)
Rfb out inn 1m
Cload out 0 2.000000e-12
Xdut vdd vss inp inn out ib opamp_dut
.end
