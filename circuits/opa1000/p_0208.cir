* opa1000[0208]: 2p/folded_cascode_nmos_1v8_ulp_lt0p1uw_subth (folded_cascode_nmos, VDD=1.8V, CL=2.0pF, Iref=0.0034uA)
.include "pdk_opa.inc"
.temp 27
.option gmin=1e-12 rshunt=1e12 reltol=1e-3 abstol=1e-12 vntol=1e-5 method=gear
* Post-PEX R+C extracted netlist for folded_cascode_nmos_1v8_ulp_lt0p1uw_subth
.subckt opamp_dut vdd vss inp inn out ib
XMpar0 a_1410_1204.t4 inn.t0 a_7374_9869.t6 vss.t0 nfet_03v3 w=4.18u l=6.5u ad=1.8392e-12 pd=7.1500e-06 as=1.1704e-12 ps=4.7400e-06 nf=1 m=8 par=8
XMpar1 a_2830_1204.t0 a_1088_13336.t0 vdd.t1 vdd.t0 pfet_03v3 w=0.4u l=8u ad=1.1200e-13 pd=9.6000e-07 as=2.4000e-13 ps=2.0000e-06 nf=1 m=4 par=4
XMpar2 a_7374_9869.t0 a_1088_13336.t0 vdd.t1 vdd.t0 pfet_03v3 w=0.4u l=8u ad=1.1200e-13 pd=9.6000e-07 as=2.4000e-13 ps=2.0000e-06 nf=1 m=4 par=4
XMpar3 a_2830_1204.t2 ib.t10 a_3332_8253.t0 vdd.t13 pfet_03v3 w=0.51u l=5.5u ad=3.0600e-13 pd=2.2200e-06 as=1.4280e-13 ps=1.0700e-06 nf=1 m=2 par=2
XMpar4 a_1410_1204.t0 ib.t0 vss.t1 vss.t0 nfet_03v3 w=0.4u l=9.5u ad=2.4000e-13 pd=2.0000e-06 as=1.1200e-13 ps=9.6000e-07 nf=1 m=4 par=4
XMpar5 ib.t1 ib.t0 vss.t1 vss.t0 nfet_03v3 w=0.4u l=9.5u ad=2.4000e-13 pd=2.0000e-06 as=1.1200e-13 ps=9.6000e-07 nf=1 m=2 par=2
XMpar6 a_1088_13336.t1 a_1088_13336.t0 vdd.t1 vdd.t0 pfet_03v3 w=0.4u l=8u ad=1.1200e-13 pd=9.6000e-07 as=2.4000e-13 ps=2.0000e-06 nf=1 m=2 par=2
XMpar7 a_1410_1204.t4 inp.t0 a_2830_1204.t5 vss.t0 nfet_03v3 w=4.18u l=6.5u ad=1.8392e-12 pd=7.1500e-06 as=1.1704e-12 ps=4.7400e-06 nf=1 m=8 par=8
XMpar8 a_7374_9869.t4 ib.t10 out.t0 vdd.t13 pfet_03v3 w=0.51u l=5.5u ad=3.0600e-13 pd=2.2200e-06 as=1.4280e-13 ps=1.0700e-06 nf=1 m=2 par=2
XMpar9 a_1088_13336.t4 ib.t0 vss.t1 vss.t0 nfet_03v3 w=0.4u l=9.5u ad=2.4000e-13 pd=2.0000e-06 as=1.1200e-13 ps=9.6000e-07 nf=1 m=2 par=2
XMpar10 a_3332_8253.t3 a_3332_8253.t2 vss.t1 vss.t0 nfet_03v3 w=0.4u l=9.5u ad=2.4000e-13 pd=2.0000e-06 as=1.1200e-13 ps=9.6000e-07 nf=1 m=2 par=2
XMpar11 out.t1 a_3332_8253.t2 vss.t1 vss.t0 nfet_03v3 w=0.4u l=9.5u ad=1.1200e-13 pd=9.6000e-07 as=1.1200e-13 ps=9.6000e-07 nf=1 m=2 par=2
Rpar0 a_1088_13336.t0 a_1088_13336.t1 25.6122
Rpar1 a_1088_13336.t0 a_1088_13336.t4 55.0897
Rpar2 a_1088_13336.t1 a_1088_13336.t4 437.0813
Rpar3 a_1410_1204.t0 a_1410_1204.t4 49.0694
Rpar4 a_2830_1204.t0 a_2830_1204.t5 87.3431
Rpar5 a_2830_1204.t0 a_2830_1204.t2 110.7640
Rpar6 a_2830_1204.t5 a_2830_1204.t2 82.5064
Rpar7 a_3332_8253.t0 a_3332_8253.t2 131.8974
Rpar8 a_3332_8253.t0 a_3332_8253.t3 104.3878
Rpar9 a_3332_8253.t2 a_3332_8253.t3 22.9631
Rpar10 a_7374_9869.t0 a_7374_9869.t6 71.3013
Rpar11 a_7374_9869.t0 a_7374_9869.t4 89.6631
Rpar12 a_7374_9869.t6 a_7374_9869.t4 91.4066
Rpar13 ib ib.t0 16.1029
Rpar14 ib ib.t1 15.7799
Rpar15 ib ib.t10 52.5685
Rpar16 ib.t0 ib.t1 31.6073
Rpar17 inn inn.t0 2.3287
Rpar18 inp inp.t0 2.3287
Rpar19 out out.t0 64.0531
Rpar20 out out.t1 18.2903
Rpar21 out.t0 out.t1 232.4965
Rpar22 vdd vdd.t0 36.6972
Rpar23 vdd vdd.t1 51.4567
Rpar24 vdd vdd.t13 132.3339
Rpar25 vdd.t0 vdd.t1 7.2985
Rpar26 vdd.t0 vdd.t13 89.6473
Rpar27 vdd.t1 vdd.t13 126.3749
Rpar28 vss vss.t0 43.7824
Rpar29 vss vss.t1 609.8228
Rpar30 vss.t0 vss.t1 6.1802
Cpar0 a_1088_13336.t0 vss 4.36998e-14
Cpar1 a_1088_13336.t1 vss 2.88380e-15
Cpar2 a_1088_13336.t4 vss 1.12804e-14
Cpar3 a_1410_1204.t0 vss 9.05099e-15
Cpar4 a_1410_1204.t4 vss 2.45669e-14
Cpar5 a_2830_1204.t0 vss 6.83661e-15
Cpar6 a_2830_1204.t2 vss 4.02853e-15
Cpar7 a_2830_1204.t5 vss 1.64167e-14
Cpar8 a_3332_8253.t0 vss 9.44994e-16
Cpar9 a_3332_8253.t2 vss 6.27523e-15
Cpar10 a_3332_8253.t3 vss 1.60789e-15
Cpar11 a_7374_9869.t0 vss 6.59943e-15
Cpar12 a_7374_9869.t4 vss 3.78192e-15
Cpar13 a_7374_9869.t6 vss 1.53117e-14
Cpar14 ib inn 2.39100e-17
Cpar15 ib inp 4.69700e-17
Cpar16 ib out 9.81100e-16
Cpar17 ib vdd 1.06308e-14
Cpar18 ib vss 4.99957e-14
Cpar19 ib.t0 vss 1.88606e-14
Cpar20 ib.t1 vss 1.60887e-15
Cpar21 ib.t10 vss 6.46590e-15
Cpar22 inn inp 1.04240e-16
Cpar23 inn vss 2.30322e-14
Cpar24 inn.t0 vss 8.17203e-15
Cpar25 inp vss 2.26680e-14
Cpar26 inp.t0 vss 8.19564e-15
Cpar27 out vdd 1.64504e-15
Cpar28 out vss 9.91161e-15
Cpar29 out.t0 vss 2.46788e-15
Cpar30 out.t1 vss 1.10317e-15
Cpar31 vdd vss 1.20330e-13
Cpar32 vdd.t0 vss 2.66358e-14
Cpar33 vdd.t1 vss 2.01459e-14
Cpar34 vdd.t13 vss 1.41297e-14
.ends opamp_dut

Vdd vdd 0 1.800000
Vss vss 0 0
Ibias vdd ib 3.400000e-09
Vinp inp 0 DC 0.985000 AC 1 PWL(0 0.985000 1.276917e-05 0.985000 1.404609e-05 0.995000)
Rfb out inn 1m
Cload out 0 2.000000e-12
Xdut vdd vss inp inn out ib opamp_dut
.end
