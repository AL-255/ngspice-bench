* opa1000[0412]: 2p/nmos_5t_3v3_10u_100u_subth (nmos_5t, VDD=3.3V, CL=2.0pF, Iref=16.25uA)
.include "pdk_opa.inc"
.temp 27
.option gmin=1e-12 rshunt=1e12 reltol=1e-3 abstol=1e-12 vntol=1e-5 method=gear
* Post-PEX R+C extracted netlist for nmos_5t_3v3_10u_100u_subth
.subckt opamp_dut vdd vss inp inn out ib
XMpar0 a_1355_1204.t0 inp.t0 a_1699_10961.t0 vss.t0 nfet_03v3 w=3.13u l=0.6u ad=9.3999e-13 pd=3.9294e-06 as=9.0820e-13 ps=3.8097e-06 nf=1 m=63 par=63
XMpar1 a_1355_1204.t0 inn.t0 out.t15 vss.t0 nfet_03v3 w=3.13u l=0.6u ad=9.3900e-13 pd=3.9256e-06 as=9.0770e-13 ps=3.8078e-06 nf=1 m=64 par=64
XMpar2 a_1699_10961.t65 a_1699_10961.t64 vdd.t1 vdd.t0 pfet_03v3 w=2.87u l=0.6u ad=9.1840e-13 pd=3.8688e-06 as=8.6100e-13 ps=3.6494e-06 nf=1 m=64 par=64
XMpar3 out.t0 a_1699_10961.t64 vdd.t1 vdd.t0 pfet_03v3 w=2.87u l=0.6u ad=9.4710e-13 pd=3.9784e-06 as=8.6100e-13 ps=3.6494e-06 nf=1 m=64 par=64
XMpar4 ib.t1 ib.t0 vss.t87 vss.t0 nfet_03v3 w=10u l=0.65u ad=2.8000e-12 pd=1.0560e-05 as=2.8000e-12 ps=1.0560e-05 nf=1 m=2 par=2
XMpar5 a_1355_1204.t128 ib.t0 vss.t87 vss.t0 nfet_03v3 w=10u l=0.65u ad=2.8000e-12 pd=1.0560e-05 as=3.7143e-12 ps=1.3600e-05 nf=1 m=7 par=7
XMpar6 a_1355_1204.t128 ib.t0 vss.t87 vss.t25 nfet_03v3 w=10u l=0.65u ad=2.8000e-12 pd=1.0560e-05 as=2.8000e-12 ps=1.0560e-05 nf=1 m=1
XMpar7 a_1355_1204.t0 inp.t0 a_1699_10961.t0 vss.t25 nfet_03v3 w=3.13u l=0.6u ad=8.7640e-13 pd=3.6900e-06 as=8.7640e-13 ps=3.6900e-06 nf=1 m=1
Rpar0 a_1355_1204.t0 a_1355_1204.t128 35.1695
Rpar1 a_1699_10961.t0 a_1699_10961.t64 212.6405
Rpar2 a_1699_10961.t0 a_1699_10961.t65 41.7050
Rpar3 a_1699_10961.t64 a_1699_10961.t65 4.8672
Rpar4 ib ib.t0 25.7431
Rpar5 ib ib.t1 7.5613
Rpar6 ib.t0 ib.t1 135.8534
Rpar7 inn inn.t0 2.0986
Rpar8 inp inp.t0 2.0986
Rpar9 out out.t0 2.7154
Rpar10 out.t0 out.t15 36.8553
Rpar11 vdd vdd.t0 19.0753
Rpar12 vdd vdd.t1 3269.5126
Rpar13 vdd.t0 vdd.t1 9.5355
Rpar14 vss vss.t0 24.9650
Rpar15 vss vss.t87 441.9542
Rpar16 vss vss.t25 2801.6449
Rpar17 vss.t0 vss.t87 4.9548
Rpar18 vss.t0 vss.t25 15.4000
Rpar19 vss.t87 vss.t25 306.9695
Cpar0 a_1355_1204.t0 vss 8.43708e-14
Cpar1 a_1355_1204.t128 vss 1.48299e-14
Cpar2 a_1699_10961.t0 vss 4.98358e-14
Cpar3 a_1699_10961.t64 vss 9.58419e-14
Cpar4 a_1699_10961.t65 vss 6.61114e-14
Cpar5 ib inp 1.28800e-17
Cpar6 ib vss 1.39871e-14
Cpar7 ib.t0 vss 2.36987e-15
Cpar8 ib.t1 vss 5.88735e-16
Cpar9 inn inp 1.01040e-16
Cpar10 inn out 1.14395e-14
Cpar11 inn vdd 1.17500e-17
Cpar12 inn vss 2.91296e-14
Cpar13 inn.t0 vss 1.70809e-14
Cpar14 inp vdd 1.25300e-17
Cpar15 inp vss 2.91562e-14
Cpar16 inp.t0 vss 1.71422e-14
Cpar17 out vdd 5.39815e-14
Cpar18 out vss 1.53306e-14
Cpar19 out.t0 vss 7.07924e-14
Cpar20 out.t15 vss 5.78905e-14
Cpar21 vdd vss 2.15537e-13
Cpar22 vdd.t0 vss 1.49054e-13
Cpar23 vdd.t1 vss 2.84922e-14
.ends opamp_dut

Vdd vdd 0 3.300000
Vss vss 0 0
Ibias vdd ib 1.625000e-05
Vinp inp 0 DC 1.645000 AC 1 PWL(0 1.645000 3.000000e-09 1.645000 3.300000e-09 1.655000)
Rfb out inn 1m
Cload out 0 2.000000e-12
Xdut vdd vss inp inn out ib opamp_dut
.end
