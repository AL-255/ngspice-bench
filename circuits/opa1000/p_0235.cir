* opa1000[0235]: 2p/folded_cascode_nmos_3v3_i1u_subth (folded_cascode_nmos, VDD=3.3V, CL=2.0pF, Iref=0.2889uA)
.include "pdk_opa.inc"
.temp 27
.option gmin=1e-12 rshunt=1e12 reltol=1e-3 abstol=1e-12 vntol=1e-5 method=gear
* Post-PEX R+C extracted netlist for folded_cascode_nmos_3v3_i1u_subth
.subckt opamp_dut vdd vss inp inn out ib
XMpar0 a_2056_3851.t6 ib a_2602_3851.t0 vdd.t16 pfet_03v3 w=1.93u l=2.13u ad=6.0902e-13 pd=2.7756e-06 as=6.0902e-13 ps=2.7756e-06 nf=1 m=18 par=18
XMpar1 a_7750_8619.t8 ib out.t0 vdd.t16 pfet_03v3 w=1.93u l=2.13u ad=6.0902e-13 pd=2.7756e-06 as=6.0902e-13 ps=2.7756e-06 nf=1 m=18 par=18
XMpar2 a_7750_8619.t0 a_2066_10172.t0 vdd.t1 vdd.t0 pfet_03v3 w=5.91u l=5.63u ad=1.6548e-12 pd=6.4700e-06 as=2.6004e-12 ps=9.7450e-06 nf=1 m=4 par=4
XMpar3 a_3258_1249.t8 ib.t0 vss.t1 vss.t0 nfet_03v3 w=1.89u l=4.38u ad=5.2920e-13 pd=2.4500e-06 as=5.2920e-13 ps=2.4500e-06 nf=1 m=4 par=4
XMpar4 a_2056_3851.t4 a_2066_10172.t0 vdd.t1 vdd.t0 pfet_03v3 w=5.91u l=5.63u ad=1.6548e-12 pd=6.4700e-06 as=2.6004e-12 ps=9.7450e-06 nf=1 m=4 par=4
XMpar5 a_2602_3851.t19 a_2602_3851.t18 vss.t1 vss.t0 nfet_03v3 w=1.89u l=4.38u ad=1.1340e-12 pd=4.9800e-06 as=5.2920e-13 ps=2.4500e-06 nf=1 m=2 par=2
XMpar6 a_2056_3851.t0 inp.t0 a_3258_1249.t0 vss.t4 nfet_03v3 w=1.93u l=2.08u ad=5.4040e-13 pd=2.4900e-06 as=8.4920e-13 ps=3.7750e-06 nf=1 m=4 par=4
XMpar7 a_2066_10172.t4 ib.t0 vss.t1 vss.t0 nfet_03v3 w=1.89u l=4.38u ad=5.2920e-13 pd=2.4500e-06 as=5.2920e-13 ps=2.4500e-06 nf=1 m=2 par=2
XMpar8 a_3258_1249.t0 inn.t0 a_7750_8619.t3 vss.t4 nfet_03v3 w=1.93u l=2.08u ad=8.4920e-13 pd=3.7750e-06 as=5.4040e-13 ps=2.4900e-06 nf=1 m=4 par=4
XMpar9 ib.t1 ib.t0 vss.t1 vss.t0 nfet_03v3 w=1.89u l=4.38u ad=1.1340e-12 pd=4.9800e-06 as=5.2920e-13 ps=2.4500e-06 nf=1 m=2 par=2
XMpar10 out.t18 a_2602_3851.t18 vss.t1 vss.t0 nfet_03v3 w=1.89u l=4.38u ad=5.2920e-13 pd=2.4500e-06 as=5.2920e-13 ps=2.4500e-06 nf=1 m=2 par=2
XMpar11 a_2066_10172.t1 a_2066_10172.t0 vdd.t1 vdd.t0 pfet_03v3 w=5.91u l=5.63u ad=1.6548e-12 pd=6.4700e-06 as=3.5460e-12 ps=1.3020e-05 nf=1 m=2 par=2
Rpar0 a_2056_3851.t0 a_2056_3851.t6 171.0758
Rpar1 a_2056_3851.t0 a_2056_3851.t4 65.9112
Rpar2 a_2056_3851.t6 a_2056_3851.t4 65.0600
Rpar3 a_2066_10172.t0 a_2066_10172.t1 21.9300
Rpar4 a_2066_10172.t0 a_2066_10172.t4 143.5913
Rpar5 a_2066_10172.t1 a_2066_10172.t4 131.3155
Rpar6 a_2602_3851.t0 a_2602_3851.t18 128.0851
Rpar7 a_2602_3851.t0 a_2602_3851.t19 56.7446
Rpar8 a_2602_3851.t18 a_2602_3851.t19 18.9525
Rpar9 a_3258_1249.t0 a_3258_1249.t8 80.9155
Rpar10 a_7750_8619.t0 a_7750_8619.t8 65.0600
Rpar11 a_7750_8619.t0 a_7750_8619.t3 65.9112
Rpar12 a_7750_8619.t8 a_7750_8619.t3 171.0758
Rpar13 ib ib.t0 156.5987
Rpar14 ib ib.t1 81.9776
Rpar15 ib.t0 ib.t1 18.2032
Rpar16 inn inn.t0 2.3274
Rpar17 inp inp.t0 2.7122
Rpar18 out out.t0 3.1384
Rpar19 out out.t18 52.6152
Rpar20 vdd vdd.t0 28.1938
Rpar21 vdd vdd.t1 82.7203
Rpar22 vdd vdd.t16 274.3787
Rpar23 vdd.t0 vdd.t1 4.9684
Rpar24 vdd.t0 vdd.t16 108.5698
Rpar25 vdd.t1 vdd.t16 136.3009
Rpar26 vss vss.t0 60.0899
Rpar27 vss vss.t1 144.2251
Rpar28 vss vss.t4 196.6583
Rpar29 vss.t0 vss.t1 5.6196
Rpar30 vss.t0 vss.t4 6.4904
Rpar31 vss.t1 vss.t4 14.1002
Cpar0 a_2056_3851.t0 vss 4.43953e-15
Cpar1 a_2056_3851.t4 vss 8.28739e-15
Cpar2 a_2056_3851.t6 vss 1.33524e-14
Cpar3 a_2066_10172.t0 vss 4.57669e-14
Cpar4 a_2066_10172.t1 vss 4.04636e-15
Cpar5 a_2066_10172.t4 vss 3.98898e-15
Cpar6 a_2602_3851.t0 vss 1.03307e-14
Cpar7 a_2602_3851.t18 vss 9.49684e-15
Cpar8 a_2602_3851.t19 vss 3.23512e-15
Cpar9 a_3258_1249.t0 vss 8.62096e-15
Cpar10 a_3258_1249.t8 vss 8.41514e-15
Cpar11 a_7750_8619.t0 vss 1.00448e-14
Cpar12 a_7750_8619.t3 vss 5.38096e-15
Cpar13 a_7750_8619.t8 vss 1.61839e-14
Cpar14 ib out 4.34321e-15
Cpar15 ib vdd 3.65704e-14
Cpar16 ib vss 6.71271e-14
Cpar17 ib.t0 vss 1.65177e-14
Cpar18 ib.t1 vss 3.59702e-15
Cpar19 inn inp 5.22700e-17
Cpar20 inn vdd 1.29900e-17
Cpar21 inn vss 5.48681e-15
Cpar22 inn.t0 vss 8.17590e-16
Cpar23 inp vss 5.24929e-15
Cpar24 inp.t0 vss 8.91068e-16
Cpar25 out vdd 5.90286e-15
Cpar26 out vss 1.05899e-14
Cpar27 out.t0 vss 1.21757e-14
Cpar28 out.t18 vss 4.16622e-15
Cpar29 vdd vss 2.21789e-13
Cpar30 vdd.t0 vss 3.34648e-14
Cpar31 vdd.t1 vss 2.16042e-14
Cpar32 vdd.t16 vss 4.86801e-14
.ends opamp_dut

Vdd vdd 0 3.300000
Vss vss 0 0
Ibias vdd ib 2.889000e-07
Vinp inp 0 DC 1.810000 AC 1 PWL(0 1.810000 1.955046e-07 1.810000 2.150550e-07 1.820000)
Rfb out inn 1m
Cload out 0 2.000000e-12
Xdut vdd vss inp inn out ib opamp_dut
.end
