* opa1000[0927]: 200f/telescopic_pmos_1v8_i2u_weak (telescopic_pmos, VDD=1.8V, CL=0.2pF, Iref=0.4uA)
.include "pdk_opa.inc"
.temp 27
.option gmin=1e-12 rshunt=1e12 reltol=1e-3 abstol=1e-12 vntol=1e-5 method=gear
* Post-PEX R+C extracted netlist for telescopic_pmos_1v8_i2u_weak
.subckt opamp_dut vdd vss inp inn out ib
XMpar0 a_2722_10029.t24 vss.t21 a_5196_8008.t4 vdd.t0 pfet_03v3 w=2.1u l=1.95u ad=8.1200e-13 pd=3.5733e-06 as=5.8800e-13 ps=2.6600e-06 nf=1 m=6 par=6
XMpar1 a_2002_10029.t48 a_3197_5906.t0 vdd.t2 vdd.t1 pfet_03v3 w=2.61u l=3.25u ad=7.3080e-13 pd=3.1700e-06 as=9.3960e-13 ps=3.9825e-06 nf=1 m=8 par=8
XMpar2 a_3197_5906.t4 ib.t0 vss.t11 vss.t10 nfet_03v3 w=0.65u l=3.25u ad=1.8200e-13 pd=1.2100e-06 as=1.8200e-13 ps=1.2100e-06 nf=1 m=2 par=2
XMpar3 a_7494_3355.t1 a_5196_8008.t10 vss.t1 vss.t0 nfet_03v3 w=0.6u l=2.04u ad=1.6800e-13 pd=1.1600e-06 as=1.6800e-13 ps=1.1600e-06 nf=1 m=2 par=2
XMpar4 a_2002_10029.t0 inp.t0 a_2722_10029.t0 vdd.t7 pfet_03v3 w=1.93u l=3u ad=6.9480e-13 pd=3.1325e-06 as=5.4040e-13 ps=2.4900e-06 nf=1 m=24 par=24
XMpar5 a_2002_10029.t0 inn.t0 a_8014_8008.t0 vdd.t7 pfet_03v3 w=1.93u l=3u ad=6.9480e-13 pd=3.1325e-06 as=5.4040e-13 ps=2.4900e-06 nf=1 m=24 par=24
XMpar6 a_8014_8008.t24 vss.t21 out.t0 vdd.t0 pfet_03v3 w=2.1u l=1.95u ad=8.1200e-13 pd=3.5733e-06 as=5.8800e-13 ps=2.6600e-06 nf=1 m=6 par=6
XMpar7 a_3197_5906.t1 a_3197_5906.t0 vdd.t2 vdd.t1 pfet_03v3 w=2.61u l=3.25u ad=7.3080e-13 pd=3.1700e-06 as=7.3080e-13 ps=3.1700e-06 nf=1 m=2 par=2
XMpar8 a_6715_3355.t0 a_5196_8008.t10 vss.t1 vss.t0 nfet_03v3 w=0.6u l=2.04u ad=3.6000e-13 pd=2.4000e-06 as=1.6800e-13 ps=1.1600e-06 nf=1 m=2 par=2
XMpar9 a_7494_3355.t0 a_5196_8008.t0 out.t1 vss.t2 nfet_03v3 w=1.45u l=1.95u ad=8.7000e-13 pd=4.1000e-06 as=4.0600e-13 ps=2.0100e-06 nf=1 m=2 par=2
XMpar10 ib.t1 ib.t0 vss.t11 vss.t10 nfet_03v3 w=0.65u l=3.25u ad=3.9000e-13 pd=2.5000e-06 as=1.8200e-13 ps=1.2100e-06 nf=1 m=2 par=2
XMpar11 a_5196_8008.t1 a_5196_8008.t0 a_6715_3355.t1 vss.t2 nfet_03v3 w=1.45u l=1.95u ad=8.7000e-13 pd=4.1000e-06 as=8.7000e-13 ps=4.1000e-06 nf=1 m=2 par=2
X30 out.t8 vss.t3 cap_mim_2f0fF c_width=14.37u c_length=14.36u
Rpar0 a_2002_10029.t0 a_2002_10029.t48 29.3120
Rpar1 a_2722_10029.t0 a_2722_10029.t24 49.3888
Rpar2 a_3197_5906.t0 a_3197_5906.t1 24.3426
Rpar3 a_3197_5906.t0 a_3197_5906.t4 119.4088
Rpar4 a_3197_5906.t1 a_3197_5906.t4 111.2949
Rpar5 a_5196_8008.t0 a_5196_8008.t1 24.7834
Rpar6 a_5196_8008.t0 a_5196_8008.t10 131.6349
Rpar7 a_5196_8008.t0 a_5196_8008.t4 207.9810
Rpar8 a_5196_8008.t1 a_5196_8008.t10 74.6861
Rpar9 a_5196_8008.t1 a_5196_8008.t4 118.0029
Rpar10 a_5196_8008.t10 a_5196_8008.t4 127.4999
Rpar11 a_6715_3355.t0 a_6715_3355.t1 78.0680
Rpar12 a_7494_3355.t0 a_7494_3355.t1 61.8004
Rpar13 a_8014_8008.t0 a_8014_8008.t24 49.3888
Rpar14 ib ib.t0 16.9037
Rpar15 ib ib.t1 8.1692
Rpar16 ib.t0 ib.t1 85.5332
Rpar17 inn inn.t0 1.4487
Rpar18 inp inp.t0 1.4487
Rpar19 out out.t0 146.0120
Rpar20 out out.t1 83.4900
Rpar21 out out.t8 15.4115
Rpar22 out.t0 out.t1 120.8376
Rpar23 out.t0 out.t8 1413.9857
Rpar24 out.t1 out.t8 808.5203
Rpar25 vdd vdd.t0 233.5064
Rpar26 vdd vdd.t1 1408.8701
Rpar27 vdd vdd.t7 20.9052
Rpar28 vdd.t0 vdd.t1 54.6329
Rpar29 vdd.t0 vdd.t7 90.1931
Rpar30 vdd.t0 vdd.t2 168.5056
Rpar31 vdd.t1 vdd.t7 544.1838
Rpar32 vdd.t1 vdd.t2 5.1929
Rpar33 vdd.t7 vdd.t2 1678.4411
Rpar34 vss vss.t0 227.7753
Rpar35 vss vss.t1 419.8880
Rpar36 vss vss.t10 303.2648
Rpar37 vss vss.t11 991.7773
Rpar38 vss vss.t2 137.4534
Rpar39 vss vss.t21 404.4977
Rpar40 vss vss.t3 71.0751
Rpar41 vss.t0 vss.t1 28.0140
Rpar42 vss.t0 vss.t10 277.1351
Rpar43 vss.t0 vss.t11 906.9640
Rpar44 vss.t0 vss.t2 7.6037
Rpar45 vss.t0 vss.t21 397.6066
Rpar46 vss.t0 vss.t3 540.3736
Rpar47 vss.t1 vss.t10 522.3139
Rpar48 vss.t1 vss.t11 1709.1967
Rpar49 vss.t1 vss.t2 17.1786
Rpar50 vss.t1 vss.t21 742.3753
Rpar51 vss.t1 vss.t3 996.1412
Rpar52 vss.t10 vss.t11 11.3871
Rpar53 vss.t10 vss.t2 167.0566
Rpar54 vss.t10 vss.t21 104.2086
Rpar55 vss.t10 vss.t3 719.4645
Rpar56 vss.t11 vss.t2 546.7196
Rpar57 vss.t11 vss.t21 340.7735
Rpar58 vss.t11 vss.t3 2352.8896
Rpar59 vss.t2 vss.t21 239.7881
Rpar60 vss.t2 vss.t3 326.0940
Rpar61 vss.t21 vss.t3 959.6292
Cpar0 a_2002_10029.t0 vss 4.68997e-14
Cpar1 a_2002_10029.t48 vss 9.85391e-15
Cpar2 a_2722_10029.t0 vss 2.45319e-14
Cpar3 a_2722_10029.t24 vss 8.02204e-15
Cpar4 a_3197_5906.t0 vss 2.52439e-14
Cpar5 a_3197_5906.t1 vss 3.68202e-15
Cpar6 a_3197_5906.t4 vss 2.11328e-15
Cpar7 a_5196_8008.t0 vss 3.75802e-15
Cpar8 a_5196_8008.t1 vss 2.07768e-15
Cpar9 a_5196_8008.t10 vss 3.46418e-15
Cpar10 a_5196_8008.t4 vss 3.34089e-15
Cpar11 a_6715_3355.t0 vss 2.76398e-15
Cpar12 a_6715_3355.t1 vss 2.89934e-15
Cpar13 a_7494_3355.t0 vss 4.24533e-15
Cpar14 a_7494_3355.t1 vss 3.07408e-15
Cpar15 a_8014_8008.t0 vss 2.52580e-14
Cpar16 a_8014_8008.t24 vss 8.25943e-15
Cpar17 ib out 5.88500e-17
Cpar18 ib vss 1.09416e-14
Cpar19 ib.t0 vss 1.21547e-15
Cpar20 ib.t1 vss 8.82101e-17
Cpar21 inn inp 1.55050e-16
Cpar22 inn out 6.46300e-17
Cpar23 inn vdd 2.87609e-14
Cpar24 inn vss 5.20805e-15
Cpar25 inn.t0 vss 3.93117e-14
Cpar26 inp vdd 2.90604e-14
Cpar27 inp vss 5.24096e-15
Cpar28 inp.t0 vss 3.94904e-14
Cpar29 out vdd 3.10530e-15
Cpar30 out vss 1.52269e-14
Cpar31 out.t0 vss 7.99622e-16
Cpar32 out.t1 vss 4.49543e-16
Cpar33 out.t8 vss 7.97717e-15
Cpar34 vdd vss 2.68747e-13
Cpar35 vdd.t0 vss 1.72106e-14
Cpar36 vdd.t1 vss 1.79442e-14
Cpar37 vdd.t2 vss 7.20050e-15
Cpar38 vdd.t7 vss 6.57708e-14
.ends opamp_dut

Vdd vdd 0 1.800000
Vss vss 0 0
Ibias vdd ib 4.000000e-07
Vinp inp 0 DC 0.805000 AC 1 PWL(0 0.805000 2.817781e-08 0.805000 3.099559e-08 0.815000)
Rfb out inn 1m
Cload out 0 2.000000e-13
Xdut vdd vss inp inn out ib opamp_dut
.end
