* opa1000[0104]: 200f/current_reuse_1v8_i500u_weak (current_reuse, VDD=1.8V, CL=0.2pF, Iref=60.7143uA)
.include "pdk_opa.inc"
.temp 27
.option gmin=1e-12 rshunt=1e12 reltol=1e-3 abstol=1e-12 vntol=1e-5 method=gear
* Post-PEX R+C extracted netlist for current_reuse_1v8_i500u_weak
.subckt opamp_dut vdd vss inp inn out ib
XMpar0 a_828_996.t20 inn.t0 a_898_1204.t2 vdd.t12 pfet_03v3 w=1.94u l=0.28u ad=8.3420e-13 pd=2.8000e-06 as=8.7559e-13 ps=2.9720e-06 nf=1 m=30 par=30
XMpar1 a_3144_3743.t21 inp.t0 a_898_1204.t2 vdd.t12 pfet_03v3 w=1.94u l=0.28u ad=8.3420e-13 pd=2.8000e-06 as=8.7559e-13 ps=2.9720e-06 nf=1 m=30 par=30
XMpar2 a_5218_15077.t20 ib.t0 vss.t22 vss.t0 nfet_03v3 w=1.16u l=0.35u ad=3.2480e-13 pd=1.7200e-06 as=3.2480e-13 ps=1.7200e-06 nf=1 m=32 par=32
XMpar3 ib.t1 ib.t0 vss.t22 vss.t0 nfet_03v3 w=1.16u l=0.35u ad=3.2480e-13 pd=1.7200e-06 as=4.1760e-13 ps=2.1700e-06 nf=1 m=16 par=16
XMpar4 out.t0 ib.t0 vss.t22 vss.t0 nfet_03v3 w=1.16u l=0.35u ad=3.2480e-13 pd=1.7200e-06 as=3.6192e-13 ps=1.9000e-06 nf=1 m=80 par=80
XMpar5 out.t2 a_3144_3743.t59 vdd.t0 vdd.t0 pfet_03v3 w=4.57u l=0.35u ad=1.3162e-12 pd=5.2603e-06 as=1.3527e-12 ps=5.3905e-06 nf=1 m=80 par=80
XMpar6 a_3144_3743.t51 a_828_996.t50 vdd.t0 vdd.t0 pfet_03v3 w=4.57u l=0.35u ad=1.2796e-12 pd=5.1300e-06 as=1.4624e-12 ps=5.7812e-06 nf=1 m=8 par=8
XMpar7 a_3144_3743.t1 inp.t30 a_5218_15077.t0 vss.t0 nfet_03v3 w=1.97u l=0.28u ad=8.4710e-13 pd=2.8300e-06 as=9.1014e-13 ps=3.0910e-06 nf=1 m=20 par=20
XMpar8 a_898_1204.t0 a_828_996.t50 vdd.t0 vdd.t0 pfet_03v3 w=4.57u l=0.35u ad=1.2796e-12 pd=5.1300e-06 as=1.4624e-12 ps=5.7812e-06 nf=1 m=16 par=16
XMpar9 a_5218_15077.t0 inn.t30 a_828_996.t0 vss.t0 nfet_03v3 w=1.97u l=0.28u ad=9.1014e-13 pd=3.0910e-06 as=8.4710e-13 ps=2.8300e-06 nf=1 m=20 par=20
XMpar10 a_828_996.t51 a_828_996.t50 vdd.t0 vdd.t0 pfet_03v3 w=4.57u l=0.35u ad=1.2796e-12 pd=5.1300e-06 as=1.4624e-12 ps=5.7812e-06 nf=1 m=8 par=8
X169 a_5305_5593.t1 out.t63 cap_mim_2f0fF c_width=17.43u c_length=17.43u
X187 a_3144_3743.t0 a_5305_5593.t0 vss.t20 ppolyf_u_1k r_width=1u r_length=1u
Rpar0 a_3144_3743.t0 a_3144_3743.t1 247.5719
Rpar1 a_3144_3743.t0 a_3144_3743.t59 202.4409
Rpar2 a_3144_3743.t0 a_3144_3743.t21 86.7998
Rpar3 a_3144_3743.t0 a_3144_3743.t51 401.4799
Rpar4 a_3144_3743.t1 a_3144_3743.t59 220.7974
Rpar5 a_3144_3743.t1 a_3144_3743.t21 187.5416
Rpar6 a_3144_3743.t1 a_3144_3743.t51 867.4461
Rpar7 a_3144_3743.t59 a_3144_3743.t21 153.3537
Rpar8 a_3144_3743.t59 a_3144_3743.t51 709.3153
Rpar9 a_3144_3743.t21 a_3144_3743.t51 153.4641
Rpar10 a_5218_15077.t0 a_5218_15077.t20 53.9029
Rpar11 a_5305_5593.t0 a_5305_5593.t1 71.4555
Rpar12 a_828_996.t0 a_828_996.t20 81.0497
Rpar13 a_828_996.t0 a_828_996.t50 533.8502
Rpar14 a_828_996.t0 a_828_996.t51 571.8674
Rpar15 a_828_996.t20 a_828_996.t50 176.0124
Rpar16 a_828_996.t20 a_828_996.t51 188.5468
Rpar17 a_828_996.t50 a_828_996.t51 15.6948
Rpar18 a_898_1204.t0 a_898_1204.t2 44.2624
Rpar19 ib ib.t0 1.6400
Rpar20 ib ib.t1 51.5189
Rpar21 ib.t0 ib.t1 9.4731
Rpar22 inn inn.t0 54.9437
Rpar23 inn inn.t30 2.9318
Rpar24 inp inp.t0 54.8951
Rpar25 inp inp.t30 2.9804
Rpar26 out out.t0 152.7857
Rpar27 out out.t2 143.8658
Rpar28 out out.t63 20.1784
Rpar29 out.t0 out.t2 48.0672
Rpar30 out.t0 out.t63 1673.8167
Rpar31 out.t2 out.t63 1576.0958
Rpar32 vdd vdd.t0 130.6450
Rpar33 vdd vdd.t12 266.0910
Rpar34 vdd.t0 vdd.t12 40.9483
Rpar35 vss vss.t0 183.1806
Rpar36 vss vss.t22 446.8261
Rpar37 vss vss.t20 1465.9258
Rpar38 vss.t0 vss.t22 4.4008
Rpar39 vss.t0 vss.t20 13.5151
Rpar40 vss.t22 vss.t20 456.8400
Cpar0 a_3144_3743.t0 vss 4.75575e-15
Cpar1 a_3144_3743.t1 vss 1.59712e-14
Cpar2 a_3144_3743.t21 vss 2.29844e-14
Cpar3 a_3144_3743.t51 vss 1.20830e-14
Cpar4 a_3144_3743.t59 vss 5.33179e-14
Cpar5 a_5218_15077.t0 vss 1.93797e-14
Cpar6 a_5218_15077.t20 vss 1.72382e-14
Cpar7 a_5305_5593.t0 vss 1.59130e-16
Cpar8 a_5305_5593.t1 vss 5.49043e-15
Cpar9 a_828_996.t0 vss 1.62133e-14
Cpar10 a_828_996.t20 vss 2.38883e-14
Cpar11 a_828_996.t50 vss 2.28968e-14
Cpar12 a_828_996.t51 vss 1.39895e-14
Cpar13 a_898_1204.t0 vss 1.89100e-14
Cpar14 a_898_1204.t2 vss 3.98276e-14
Cpar15 ib out 7.35828e-15
Cpar16 ib vdd 8.58850e-16
Cpar17 ib vss 7.66336e-14
Cpar18 ib.t0 vss 8.13167e-15
Cpar19 ib.t1 vss 1.23476e-15
Cpar20 inn inp 1.00770e-16
Cpar21 inn vdd 1.59156e-14
Cpar22 inn vss 2.29191e-14
Cpar23 inn.t0 vss 1.34030e-14
Cpar24 inn.t30 vss 2.48445e-15
Cpar25 inp out 7.56750e-16
Cpar26 inp vdd 1.36772e-14
Cpar27 inp vss 2.30349e-14
Cpar28 inp.t0 vss 1.32593e-14
Cpar29 inp.t30 vss 2.52744e-15
Cpar30 out vdd 1.03930e-13
Cpar31 out vss 6.05829e-14
Cpar32 out.t0 vss 2.96545e-14
Cpar33 out.t2 vss 8.49759e-14
Cpar34 out.t63 vss 1.63841e-14
Cpar35 vdd vss 2.62301e-13
Cpar36 vdd.t0 vss 1.77111e-13
Cpar37 vdd.t12 vss 6.10519e-14
.ends opamp_dut

Vdd vdd 0 1.800000
Vss vss 0 0
Ibias vdd ib 6.071430e-05
Vinp inp 0 DC 0.895000 AC 1 PWL(0 0.895000 3.000000e-09 0.895000 3.300000e-09 0.905000)
Rfb out inn 1m
Cload out 0 2.000000e-13
Xdut vdd vss inp inn out ib opamp_dut
.end
