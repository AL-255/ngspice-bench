* opa1000[0323]: 2p/folded_cascode_pmos_3v3_1u_10u_weak (folded_cascode_pmos, VDD=3.3V, CL=2.0pF, Iref=1.4444uA)
.include "pdk_opa.inc"
.temp 27
.option gmin=1e-12 rshunt=1e12 reltol=1e-3 abstol=1e-12 vntol=1e-5 method=gear
* Post-PEX R+C extracted netlist for folded_cascode_pmos_3v3_1u_10u_weak
.subckt opamp_dut vdd vss inp inn out ib
XMpar0 a_1550_1205.t1 inn.t0 a_7374_1205.t6 vdd.t4 pfet_03v3 w=1.95u l=2.5u ad=6.1533e-13 pd=2.7978e-06 as=6.1533e-13 ps=2.7978e-06 nf=1 m=36 par=36
XMpar1 a_1244_6007.t0 ib.t0 vss.t4 vss.t3 nfet_03v3 w=1.02u l=1.6u ad=2.8560e-13 pd=1.5800e-06 as=2.8560e-13 ps=1.5800e-06 nf=1 m=2 par=2
XMpar2 a_1550_1205.t1 inp.t0 a_2170_1205.t0 vdd.t4 pfet_03v3 w=1.95u l=2.5u ad=6.1533e-13 pd=2.7978e-06 as=6.1533e-13 ps=2.7978e-06 nf=1 m=36 par=36
XMpar3 out.t2 a_5632_13047.t0 vdd.t1 vdd.t0 pfet_03v3 w=10u l=3.75u ad=2.8000e-12 pd=1.0560e-05 as=2.8000e-12 ps=1.0560e-05 nf=1 m=2 par=2
XMpar4 a_1550_1205.t0 a_1244_6007.t2 vdd.t1 vdd.t0 pfet_03v3 w=10u l=3.75u ad=2.8000e-12 pd=1.0560e-05 as=4.4000e-12 ps=1.5880e-05 nf=1 m=4 par=4
XMpar5 a_2170_1205.t36 a_1244_6007.t10 a_5632_13047.t4 vss.t0 nfet_03v3 w=1.58u l=1.3u ad=9.4800e-13 pd=4.3600e-06 as=4.4240e-13 ps=2.1400e-06 nf=1 m=2 par=2
XMpar6 a_2170_1205.t37 ib.t0 vss.t4 vss.t3 nfet_03v3 w=1.02u l=1.6u ad=2.8560e-13 pd=1.5800e-06 as=4.4880e-13 ps=2.4100e-06 nf=1 m=4 par=4
XMpar7 a_7374_1205.t2 ib.t0 vss.t4 vss.t3 nfet_03v3 w=1.02u l=1.6u ad=2.8560e-13 pd=1.5800e-06 as=4.4880e-13 ps=2.4100e-06 nf=1 m=4 par=4
XMpar8 a_5632_13047.t1 a_5632_13047.t0 vdd.t1 vdd.t0 pfet_03v3 w=10u l=3.75u ad=6.0000e-12 pd=2.1200e-05 as=2.8000e-12 ps=1.0560e-05 nf=1 m=2 par=2
XMpar9 a_1244_6007.t3 a_1244_6007.t2 vdd.t1 vdd.t0 pfet_03v3 w=10u l=3.75u ad=2.8000e-12 pd=1.0560e-05 as=2.8000e-12 ps=1.0560e-05 nf=1 m=2 par=2
XMpar10 ib.t1 ib.t0 vss.t4 vss.t3 nfet_03v3 w=1.02u l=1.6u ad=6.1200e-13 pd=3.2400e-06 as=2.8560e-13 ps=1.5800e-06 nf=1 m=2 par=2
XMpar11 a_7374_1205.t0 a_1244_6007.t10 out.t0 vss.t0 nfet_03v3 w=1.58u l=1.3u ad=9.4800e-13 pd=4.3600e-06 as=4.4240e-13 ps=2.1400e-06 nf=1 m=2 par=2
Rpar0 a_1244_6007.t0 a_1244_6007.t10 60.2928
Rpar1 a_1244_6007.t0 a_1244_6007.t2 581.7012
Rpar2 a_1244_6007.t0 a_1244_6007.t3 206.1587
Rpar3 a_1244_6007.t10 a_1244_6007.t2 382.3586
Rpar4 a_1244_6007.t10 a_1244_6007.t3 135.5104
Rpar5 a_1244_6007.t2 a_1244_6007.t3 24.8238
Rpar6 a_1550_1205.t0 a_1550_1205.t1 48.7639
Rpar7 a_2170_1205.t0 a_2170_1205.t36 126.5046
Rpar8 a_2170_1205.t0 a_2170_1205.t37 83.8948
Rpar9 a_2170_1205.t36 a_2170_1205.t37 51.8555
Rpar10 a_5632_13047.t0 a_5632_13047.t1 20.4970
Rpar11 a_5632_13047.t0 a_5632_13047.t4 229.2378
Rpar12 a_5632_13047.t1 a_5632_13047.t4 54.0365
Rpar13 a_7374_1205.t0 a_7374_1205.t6 126.5046
Rpar14 a_7374_1205.t0 a_7374_1205.t2 51.8555
Rpar15 a_7374_1205.t6 a_7374_1205.t2 83.8948
Rpar16 ib ib.t0 10.4518
Rpar17 ib ib.t1 6.9203
Rpar18 ib.t0 ib.t1 490.9542
Rpar19 inn inn.t0 1.4005
Rpar20 inp inp.t0 1.4005
Rpar21 out out.t0 9.2223
Rpar22 out out.t2 39.3230
Rpar23 vdd vdd.t0 31.2271
Rpar24 vdd vdd.t1 82.4427
Rpar25 vdd vdd.t4 159.6807
Rpar26 vdd.t0 vdd.t1 4.2712
Rpar27 vdd.t0 vdd.t4 41.8173
Rpar28 vdd.t1 vdd.t4 111.0010
Rpar29 vss vss.t0 201.1193
Rpar30 vss vss.t4 450.2018
Rpar31 vss vss.t3 196.0900
Rpar32 vss.t0 vss.t4 14.9764
Rpar33 vss.t0 vss.t3 2.6500
Rpar34 vss.t4 vss.t3 5.8550
Cpar0 a_1244_6007.t0 vss 1.42300e-15
Cpar1 a_1244_6007.t10 vss 3.05211e-15
Cpar2 a_1244_6007.t2 vss 2.20749e-14
Cpar3 a_1244_6007.t3 vss 3.86311e-15
Cpar4 a_1550_1205.t0 vss 1.21105e-14
Cpar5 a_1550_1205.t1 vss 5.94499e-14
Cpar6 a_2170_1205.t0 vss 3.54512e-14
Cpar7 a_2170_1205.t36 vss 3.57692e-15
Cpar8 a_2170_1205.t37 vss 4.66413e-15
Cpar9 a_5632_13047.t0 vss 1.44504e-14
Cpar10 a_5632_13047.t1 vss 5.00828e-15
Cpar11 a_5632_13047.t4 vss 8.69426e-16
Cpar12 a_7374_1205.t0 vss 3.34423e-15
Cpar13 a_7374_1205.t2 vss 4.36074e-15
Cpar14 a_7374_1205.t6 vss 3.31448e-14
Cpar15 ib vdd 2.20410e-16
Cpar16 ib vss 1.83914e-14
Cpar17 ib.t0 vss 2.42418e-15
Cpar18 ib.t1 vss 1.00972e-16
Cpar19 inn inp 2.07750e-16
Cpar20 inn vdd 3.55432e-14
Cpar21 inn vss 5.58513e-15
Cpar22 inn.t0 vss 5.21142e-14
Cpar23 inp vdd 3.55671e-14
Cpar24 inp vss 5.42321e-15
Cpar25 inp.t0 vss 5.21794e-14
Cpar26 out vdd 4.45757e-15
Cpar27 out vss 4.59603e-15
Cpar28 out.t0 vss 2.29477e-16
Cpar29 out.t2 vss 6.17774e-15
Cpar30 vdd vss 3.25176e-13
Cpar31 vdd.t0 vss 3.47164e-14
Cpar32 vdd.t1 vss 1.63006e-14
Cpar33 vdd.t4 vss 8.24572e-14
.ends opamp_dut

Vdd vdd 0 3.300000
Vss vss 0 0
Ibias vdd ib 1.444400e-06
Vinp inp 0 DC 1.381000 AC 1 PWL(0 1.381000 4.567635e-08 1.381000 5.024399e-08 1.391000)
Rfb out inn 1m
Cload out 0 2.000000e-12
Xdut vdd vss inp inn out ib opamp_dut
.end
