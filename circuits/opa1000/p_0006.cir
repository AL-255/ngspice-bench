* opa1000[0006]: 200f/cherry_hooper_1v8_i1u_subth (cherry_hooper, VDD=1.8V, CL=0.2pF, Iref=0.0639uA)
.include "pdk_opa.inc"
.temp 27
.option gmin=1e-12 rshunt=1e12 reltol=1e-3 abstol=1e-12 vntol=1e-5 method=gear
* Post-PEX R+C extracted netlist for cherry_hooper_1v8_i1u_subth
.subckt opamp_dut vdd vss inp inn out ib
XMpar0 a_3436_13756.t0 ib.t0 vss.t1 vss.t0 nfet_03v3 w=0.51u l=2.8u ad=3.0600e-13 pd=2.2200e-06 as=3.0600e-13 ps=2.2200e-06 nf=1 m=1
XMpar1 a_1315_13191.t0 a_3436_13756.t1 a_3436_13756.t2 vdd.t0 pfet_03v3 w=10u l=1u ad=3.2000e-12 pd=1.1890e-05 as=2.8000e-12 ps=1.0560e-05 nf=1 m=16 par=16
XMpar2 a_6026_4126.t0 ib.t0 vss.t1 vss.t0 nfet_03v3 w=0.51u l=2.8u ad=1.9720e-13 pd=1.4533e-06 as=2.5160e-13 ps=1.8367e-06 nf=1 m=6 par=6
XMpar3 a_8566_11064.t2 a_8566_11064.t1 vdd.t4 vdd.t3 pfet_03v3 w=3.09u l=1.3u ad=1.1948e-12 pd=4.8933e-06 as=1.1948e-12 ps=4.8933e-06 nf=1 m=3 par=3
XMpar4 a_12494_9519.t5 a_1226_3873.t1 vdd.t9 vdd.t8 pfet_03v3 w=1.44u l=2.8u ad=8.6400e-13 pd=4.0800e-06 as=8.6400e-13 ps=4.0800e-06 nf=1 m=1
XMpar5 out.t1 a_11108_17220.t0 vdd.t4 vdd.t3 pfet_03v3 w=3.09u l=1.3u ad=8.6520e-13 pd=3.6500e-06 as=8.6520e-13 ps=3.6500e-06 nf=1 m=4 par=4
XMpar6 a_12494_7234.t4 a_12494_7234.t3 vdd.t4 vdd.t3 pfet_03v3 w=3.09u l=1.3u ad=1.1948e-12 pd=4.8933e-06 as=1.1948e-12 ps=4.8933e-06 nf=1 m=3 par=3
XMpar7 a_6600_1294.t0 ib.t0 vss.t1 vss.t0 nfet_03v3 w=0.51u l=2.8u ad=1.4280e-13 pd=1.0700e-06 as=2.2440e-13 ps=1.6450e-06 nf=1 m=8 par=8
XMpar8 a_12494_9519.t3 inn.t0 a_7378_4126.t2 vss.t30 nfet_03v3 w=0.72u l=2.08u ad=2.0160e-13 pd=1.2800e-06 as=4.3200e-13 ps=2.6400e-06 nf=1 m=1
XMpar9 a_11108_17220.t1 a_11108_17220.t0 vdd.t4 vdd.t3 pfet_03v3 w=3.09u l=1.3u ad=8.6520e-13 pd=3.6500e-06 as=1.3596e-12 ps=5.5150e-06 nf=1 m=4 par=4
XMpar10 a_11562_11272.t0 inp.t0 a_7378_4126.t2 vss.t30 nfet_03v3 w=0.72u l=2.08u ad=2.0160e-13 pd=1.2800e-06 as=4.3200e-13 ps=2.6400e-06 nf=1 m=1
XMpar11 a_11108_17220.t8 a_8566_11064.t10 a_6600_1294.t8 vss.t31 nfet_03v3 w=5.76u l=2.08u ad=3.4560e-12 pd=1.2720e-05 as=3.4560e-12 ps=1.2720e-05 nf=1 m=1
XMpar12 a_1226_3873.t2 a_1226_3873.t1 vdd.t9 vdd.t8 pfet_03v3 w=1.44u l=2.8u ad=8.6400e-13 pd=4.0800e-06 as=8.6400e-13 ps=4.0800e-06 nf=1 m=1
XMpar13 a_11562_11272.t2 a_3436_13756.t33 a_8566_11064.t0 vdd.t1 pfet_03v3 w=5.91u l=1u ad=2.2852e-12 pd=8.6533e-06 as=2.2852e-12 ps=8.6533e-06 nf=1 m=3 par=3
XMpar14 a_11562_11272.t5 a_1226_3873.t1 vdd.t9 vdd.t8 pfet_03v3 w=1.44u l=2.8u ad=8.6400e-13 pd=4.0800e-06 as=8.6400e-13 ps=4.0800e-06 nf=1 m=1
XMpar15 a_7378_4126.t0 ib.t0 vss.t1 vss.t0 nfet_03v3 w=0.51u l=2.8u ad=3.0600e-13 pd=2.2200e-06 as=1.4280e-13 ps=1.0700e-06 nf=1 m=2 par=2
XMpar16 a_12494_7234.t0 a_3436_13756.t33 a_12494_9519.t0 vdd.t1 pfet_03v3 w=5.91u l=1u ad=2.2852e-12 pd=8.6533e-06 as=2.2852e-12 ps=8.6533e-06 nf=1 m=3 par=3
XMpar17 a_6600_1294.t8 a_12494_7234.t10 out.t0 vss.t31 nfet_03v3 w=5.76u l=2.08u ad=3.4560e-12 pd=1.2720e-05 as=3.4560e-12 ps=1.2720e-05 nf=1 m=1
XMpar18 a_1315_13191.t17 a_1315_13191.t16 vdd.t4 vdd.t3 pfet_03v3 w=3.09u l=1.3u ad=1.8540e-12 pd=7.3800e-06 as=1.8540e-12 ps=7.3800e-06 nf=1 m=1
XMpar19 a_12494_7234.t9 a_12494_9519.t6 a_6026_4126.t6 vss.t30 nfet_03v3 w=4.32u l=2.08u ad=2.5920e-12 pd=9.8400e-06 as=2.5920e-12 ps=9.8400e-06 nf=1 m=1
XMpar20 a_6026_4126.t6 a_11562_11272.t6 a_8566_11064.t7 vss.t30 nfet_03v3 w=4.32u l=2.08u ad=2.5920e-12 pd=9.8400e-06 as=2.5920e-12 ps=9.8400e-06 nf=1 m=1
XMpar21 ib.t1 ib.t0 vss.t1 vss.t0 nfet_03v3 w=0.51u l=2.8u ad=3.0600e-13 pd=2.2200e-06 as=1.4280e-13 ps=1.0700e-06 nf=1 m=1
XMpar22 a_11562_11272.t0 inp.t0 a_7378_4126.t2 vss.t33 nfet_03v3 w=0.72u l=2.08u ad=2.0160e-13 pd=1.2800e-06 as=4.3200e-13 ps=2.6400e-06 nf=1 m=1
XMpar23 a_1226_3873.t0 ib.t0 vss.t1 vss.t0 nfet_03v3 w=0.51u l=2.8u ad=3.0600e-13 pd=2.2200e-06 as=1.4280e-13 ps=1.0700e-06 nf=1 m=1
XMpar24 a_12494_9519.t3 inn.t0 a_7378_4126.t2 vss.t33 nfet_03v3 w=0.72u l=2.08u ad=2.0160e-13 pd=1.2800e-06 as=4.3200e-13 ps=2.6400e-06 nf=1 m=1
X32 out.t5 vss.t35 cap_mim_2f0fF c_width=20u c_length=20u
X33 out.t5 vss.t35 cap_mim_2f0fF c_width=20u c_length=20u
X61 out.t5 vss.t35 cap_mim_2f0fF c_width=20u c_length=20u
X64 out.t5 vss.t35 cap_mim_2f0fF c_width=20u c_length=20u
Rpar0 a_11108_17220.t0 a_11108_17220.t1 17.9960
Rpar1 a_11108_17220.t0 a_11108_17220.t8 199.7840
Rpar2 a_11108_17220.t1 a_11108_17220.t8 68.4127
Rpar3 a_11562_11272.t0 a_11562_11272.t2 266.8724
Rpar4 a_11562_11272.t0 a_11562_11272.t5 242.2609
Rpar5 a_11562_11272.t0 a_11562_11272.t6 112.6164
Rpar6 a_11562_11272.t2 a_11562_11272.t5 102.6473
Rpar7 a_11562_11272.t2 a_11562_11272.t6 143.4732
Rpar8 a_11562_11272.t5 a_11562_11272.t6 130.2418
Rpar9 a_1226_3873.t0 a_1226_3873.t1 76.0698
Rpar10 a_1226_3873.t0 a_1226_3873.t2 238.2878
Rpar11 a_1226_3873.t1 a_1226_3873.t2 28.8059
Rpar12 a_12494_7234.t0 a_12494_7234.t10 115.1387
Rpar13 a_12494_7234.t0 a_12494_7234.t3 387.6825
Rpar14 a_12494_7234.t0 a_12494_7234.t4 93.1309
Rpar15 a_12494_7234.t0 a_12494_7234.t9 71.7311
Rpar16 a_12494_7234.t10 a_12494_7234.t3 574.0027
Rpar17 a_12494_7234.t10 a_12494_7234.t4 137.8896
Rpar18 a_12494_7234.t10 a_12494_7234.t9 352.8812
Rpar19 a_12494_7234.t3 a_12494_7234.t4 23.1905
Rpar20 a_12494_7234.t3 a_12494_7234.t9 1188.1834
Rpar21 a_12494_7234.t4 a_12494_7234.t9 285.4310
Rpar22 a_12494_9519.t0 a_12494_9519.t3 266.8724
Rpar23 a_12494_9519.t0 a_12494_9519.t5 102.6473
Rpar24 a_12494_9519.t0 a_12494_9519.t6 143.4732
Rpar25 a_12494_9519.t3 a_12494_9519.t5 242.2609
Rpar26 a_12494_9519.t3 a_12494_9519.t6 112.6164
Rpar27 a_12494_9519.t5 a_12494_9519.t6 130.2418
Rpar28 a_1315_13191.t0 a_1315_13191.t16 300.4798
Rpar29 a_1315_13191.t0 a_1315_13191.t17 55.3564
Rpar30 a_1315_13191.t16 a_1315_13191.t17 49.5725
Rpar31 a_3436_13756.t0 a_3436_13756.t1 8074.5631
Rpar32 a_3436_13756.t0 a_3436_13756.t2 154.7448
Rpar33 a_3436_13756.t0 a_3436_13756.t33 77.1441
Rpar34 a_3436_13756.t1 a_3436_13756.t2 16.7778
Rpar35 a_3436_13756.t1 a_3436_13756.t33 4447.9071
Rpar36 a_3436_13756.t2 a_3436_13756.t33 85.2418
Rpar37 a_6026_4126.t0 a_6026_4126.t6 49.4315
Rpar38 a_6600_1294.t0 a_6600_1294.t8 81.9362
Rpar39 a_7378_4126.t0 a_7378_4126.t2 57.4924
Rpar40 a_8566_11064.t0 a_8566_11064.t1 387.6825
Rpar41 a_8566_11064.t0 a_8566_11064.t10 115.1387
Rpar42 a_8566_11064.t0 a_8566_11064.t2 93.1309
Rpar43 a_8566_11064.t0 a_8566_11064.t7 71.7311
Rpar44 a_8566_11064.t1 a_8566_11064.t10 574.0027
Rpar45 a_8566_11064.t1 a_8566_11064.t2 23.1905
Rpar46 a_8566_11064.t1 a_8566_11064.t7 1188.1834
Rpar47 a_8566_11064.t10 a_8566_11064.t2 137.8896
Rpar48 a_8566_11064.t10 a_8566_11064.t7 352.8812
Rpar49 a_8566_11064.t2 a_8566_11064.t7 285.4310
Rpar50 ib ib.t0 2.3729
Rpar51 ib ib.t1 1421.2981
Rpar52 ib.t0 ib.t1 24.0723
Rpar53 inn inn.t0 4.5421
Rpar54 inp inp.t0 4.5907
Rpar55 out out.t0 129.1668
Rpar56 out out.t1 181.7620
Rpar57 out out.t5 18.2317
Rpar58 out.t0 out.t1 66.5740
Rpar59 out.t0 out.t5 495.4568
Rpar60 out.t1 out.t5 697.2007
Rpar61 vdd vdd.t0 313.6182
Rpar62 vdd vdd.t1 128.0198
Rpar63 vdd vdd.t3 72.2524
Rpar64 vdd vdd.t4 104.1070
Rpar65 vdd vdd.t8 1449.5685
Rpar66 vdd vdd.t9 939.5219
Rpar67 vdd.t0 vdd.t1 227.2764
Rpar68 vdd.t0 vdd.t3 131.8584
Rpar69 vdd.t0 vdd.t4 126.3152
Rpar70 vdd.t0 vdd.t8 574.6216
Rpar71 vdd.t0 vdd.t9 372.4346
Rpar72 vdd.t1 vdd.t3 114.0507
Rpar73 vdd.t1 vdd.t4 131.1535
Rpar74 vdd.t1 vdd.t8 1050.4900
Rpar75 vdd.t1 vdd.t9 680.8635
Rpar76 vdd.t3 vdd.t4 2.5755
Rpar77 vdd.t3 vdd.t8 264.9677
Rpar78 vdd.t3 vdd.t9 174.6597
Rpar79 vdd.t4 vdd.t8 220.3196
Rpar80 vdd.t4 vdd.t9 146.1997
Rpar81 vdd.t8 vdd.t9 11.5134
Rpar82 vss vss.t0 151.6601
Rpar83 vss vss.t1 189.2864
Rpar84 vss vss.t30 331.9833
Rpar85 vss vss.t31 6467.1727
Rpar86 vss vss.t33 506.1246
Rpar87 vss vss.t35 70.4739
Rpar88 vss.t0 vss.t1 4.4011
Rpar89 vss.t0 vss.t30 5.6882
Rpar90 vss.t0 vss.t31 170.1945
Rpar91 vss.t0 vss.t33 8.2217
Rpar92 vss.t0 vss.t35 352.1849
Rpar93 vss.t1 vss.t30 33.4759
Rpar94 vss.t1 vss.t31 360.5917
Rpar95 vss.t1 vss.t33 42.0866
Rpar96 vss.t1 vss.t35 439.5607
Rpar97 vss.t30 vss.t31 475.2134
Rpar98 vss.t30 vss.t33 20.7124
Rpar99 vss.t30 vss.t35 770.9314
Rpar100 vss.t31 vss.t33 350.0467
Rpar101 vss.t33 vss.t35 1175.3223
Cpar0 a_11108_17220.t0 vss 9.44277e-15
Cpar1 a_11108_17220.t1 vss 4.35315e-15
Cpar2 a_11108_17220.t8 vss 3.24140e-15
Cpar3 a_11562_11272.t0 vss 2.70950e-15
Cpar4 a_11562_11272.t2 vss 6.36120e-15
Cpar5 a_11562_11272.t5 vss 2.38005e-15
Cpar6 a_11562_11272.t6 vss 4.20647e-15
Cpar7 a_1226_3873.t0 vss 3.26257e-15
Cpar8 a_1226_3873.t1 vss 8.69250e-15
Cpar9 a_1226_3873.t2 vss 2.69645e-15
Cpar10 a_12494_7234.t0 vss 4.93133e-15
Cpar11 a_12494_7234.t10 vss 2.87910e-15
Cpar12 a_12494_7234.t3 vss 3.19249e-15
Cpar13 a_12494_7234.t4 vss 3.74131e-15
Cpar14 a_12494_7234.t9 vss 2.53333e-15
Cpar15 a_12494_9519.t0 vss 4.89170e-15
Cpar16 a_12494_9519.t3 vss 2.08358e-15
Cpar17 a_12494_9519.t5 vss 1.83024e-15
Cpar18 a_12494_9519.t6 vss 3.23473e-15
Cpar19 a_1315_13191.t0 vss 2.50642e-14
Cpar20 a_1315_13191.t16 vss 1.18616e-15
Cpar21 a_1315_13191.t17 vss 2.36248e-15
Cpar22 a_3436_13756.t0 vss 2.56771e-15
Cpar23 a_3436_13756.t1 vss 2.18476e-14
Cpar24 a_3436_13756.t2 vss 2.01322e-14
Cpar25 a_3436_13756.t33 vss 7.68420e-15
Cpar26 a_6026_4126.t0 vss 4.71224e-15
Cpar27 a_6026_4126.t6 vss 3.61089e-15
Cpar28 a_6600_1294.t0 vss 5.97057e-15
Cpar29 a_6600_1294.t8 vss 5.99774e-15
Cpar30 a_7378_4126.t0 vss 5.21967e-15
Cpar31 a_7378_4126.t2 vss 3.78026e-15
Cpar32 a_8566_11064.t0 vss 5.69674e-15
Cpar33 a_8566_11064.t1 vss 3.68801e-15
Cpar34 a_8566_11064.t10 vss 3.32596e-15
Cpar35 a_8566_11064.t2 vss 4.32200e-15
Cpar36 a_8566_11064.t7 vss 2.92654e-15
Cpar37 ib out 1.39400e-17
Cpar38 ib vss 4.01025e-14
Cpar39 ib.t0 vss 4.94290e-15
Cpar40 ib.t1 vss 2.73372e-16
Cpar41 inn inp 5.16800e-17
Cpar42 inn vss 2.78630e-15
Cpar43 inn.t0 vss 2.89409e-16
Cpar44 inp vss 2.74015e-15
Cpar45 inp.t0 vss 2.98061e-16
Cpar46 out vdd 4.18993e-15
Cpar47 out vss 3.55537e-14
Cpar48 out.t0 vss 6.82036e-17
Cpar49 out.t1 vss 7.78680e-17
Cpar50 out.t5 vss 8.37613e-15
Cpar51 vdd vss 1.89143e-13
Cpar52 vdd.t0 vss 2.26339e-14
Cpar53 vdd.t1 vss 8.65826e-15
Cpar54 vdd.t3 vss 1.54096e-14
Cpar55 vdd.t4 vss 1.27389e-14
Cpar56 vdd.t8 vss 4.78217e-15
Cpar57 vdd.t9 vss 4.65130e-15
.ends opamp_dut

Vdd vdd 0 1.800000
Vss vss 0 0
Ibias vdd ib 6.390000e-08
Vinp inp 0 DC 1.190900 AC 1 PWL(0 1.190900 1.833297e-07 1.190900 2.016626e-07 1.200900)
Rfb out inn 1m
Cload out 0 2.000000e-13
Xdut vdd vss inp inn out ib opamp_dut
.end
