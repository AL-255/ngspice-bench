* opa1000[0906]: 2p/telescopic_nmos_3v3_1u_10u_subth (telescopic_nmos, VDD=3.3V, CL=2.0pF, Iref=1.4375uA)
.include "pdk_opa.inc"
.temp 27
.option gmin=1e-12 rshunt=1e12 reltol=1e-3 abstol=1e-12 vntol=1e-5 method=gear
* Post-PEX R+C extracted netlist for telescopic_nmos_3v3_1u_10u_subth
.subckt opamp_dut vdd vss inp inn out ib
XMpar0 a_2810_15289.t0 a_1909_15081.t0 out.t0 vdd.t0 pfet_03v3 w=3.5u l=1.3u ad=1.3300e-12 pd=5.3537e-06 as=1.2600e-12 ps=5.0950e-06 nf=1 m=64 par=64
XMpar1 a_1909_15081.t129 a_1909_15081.t128 a_2314_1204.t0 vss.t0 nfet_03v3 w=2.05u l=1.3u ad=5.7400e-13 pd=2.6100e-06 as=9.0200e-13 ps=3.9550e-06 nf=1 m=16 par=16
XMpar2 a_1874_1204.t8 inp.t0 a_2314_1204.t5 vss.t0 nfet_03v3 w=8u l=1.6u ad=2.4000e-12 pd=9.1000e-06 as=2.3200e-12 ps=8.8300e-06 nf=1 m=64 par=64
XMpar3 a_1789_15289.t0 a_1909_15081.t0 a_1909_15081.t1 vdd.t0 pfet_03v3 w=3.5u l=1.3u ad=1.3300e-12 pd=5.3537e-06 as=1.2250e-12 ps=4.9656e-06 nf=1 m=64 par=64
XMpar4 a_1874_1204.t0 ib.t0 vss.t4 vss.t0 nfet_03v3 w=2.39u l=1.3u ad=6.6920e-13 pd=2.9500e-06 as=1.2428e-12 ps=5.2225e-06 nf=1 m=8 par=8
XMpar5 a_1789_15289.t4 a_1909_15081.t240 vdd.t24 vdd.t23 pfet_03v3 w=1.93u l=2u ad=5.4040e-13 pd=2.4900e-06 as=6.1760e-13 ps=2.8112e-06 nf=1 m=24 par=24
XMpar6 a_10188_8972.t0 a_1909_15081.t128 out.t9 vss.t0 nfet_03v3 w=2.05u l=1.3u ad=7.3800e-13 pd=3.2825e-06 as=5.7400e-13 ps=2.6100e-06 nf=1 m=16 par=16
XMpar7 a_10188_8972.t6 inn.t0 a_1874_1204.t8 vss.t0 nfet_03v3 w=8u l=1.6u ad=2.3200e-12 pd=8.8300e-06 as=2.4000e-12 ps=9.1000e-06 nf=1 m=64 par=64
XMpar8 a_2810_15289.t22 a_1909_15081.t240 vdd.t24 vdd.t23 pfet_03v3 w=1.93u l=2u ad=5.4040e-13 pd=2.4900e-06 as=6.1760e-13 ps=2.8112e-06 nf=1 m=24 par=24
XMpar9 ib.t1 ib.t0 vss.t4 vss.t0 nfet_03v3 w=2.39u l=1.3u ad=1.4340e-12 pd=5.9800e-06 as=6.6920e-13 ps=2.9500e-06 nf=1 m=2 par=2
Rpar0 a_10188_8972.t0 a_10188_8972.t6 43.1654
Rpar1 a_1789_15289.t0 a_1789_15289.t4 63.7145
Rpar2 a_1874_1204.t0 a_1874_1204.t8 38.4127
Rpar3 a_1909_15081.t0 a_1909_15081.t1 5.4361
Rpar4 a_1909_15081.t1 a_1909_15081.t128 1286.7165
Rpar5 a_1909_15081.t1 a_1909_15081.t129 105.2306
Rpar6 a_1909_15081.t1 a_1909_15081.t240 65.8533
Rpar7 a_1909_15081.t128 a_1909_15081.t129 7.6446
Rpar8 a_1909_15081.t128 a_1909_15081.t240 1603.6205
Rpar9 a_1909_15081.t129 a_1909_15081.t240 131.1477
Rpar10 a_2314_1204.t0 a_2314_1204.t5 74.3283
Rpar11 a_2810_15289.t0 a_2810_15289.t22 49.8931
Rpar12 ib ib.t0 14.2112
Rpar13 ib ib.t1 7.3197
Rpar14 ib.t0 ib.t1 26.1464
Rpar15 inn inn.t0 1.7714
Rpar16 inp inp.t0 1.7714
Rpar17 out out.t0 3.1746
Rpar18 out out.t9 39.5968
Rpar19 vdd vdd.t0 115.1773
Rpar20 vdd vdd.t24 604.8456
Rpar21 vdd vdd.t23 22.6935
Rpar22 vdd.t0 vdd.t24 1203.1891
Rpar23 vdd.t0 vdd.t23 45.1430
Rpar24 vdd.t24 vdd.t23 9.8424
Rpar25 vss vss.t0 129.2301
Rpar26 vss vss.t4 265.4067
Rpar27 vss.t0 vss.t4 9.5655
Cpar0 a_10188_8972.t0 vss 1.52465e-14
Cpar1 a_10188_8972.t6 vss 8.42917e-14
Cpar2 a_1789_15289.t0 vss 9.98765e-14
Cpar3 a_1789_15289.t4 vss 3.18892e-14
Cpar4 a_1874_1204.t0 vss 6.52282e-15
Cpar5 a_1874_1204.t8 vss 1.44333e-13
Cpar6 a_1909_15081.t0 vss 1.54974e-13
Cpar7 a_1909_15081.t1 vss 7.15503e-14
Cpar8 a_1909_15081.t128 vss 2.98314e-14
Cpar9 a_1909_15081.t129 vss 1.54140e-14
Cpar10 a_1909_15081.t240 vss 6.68676e-14
Cpar11 a_2314_1204.t0 vss 1.57679e-14
Cpar12 a_2314_1204.t5 vss 7.94778e-14
Cpar13 a_2810_15289.t0 vss 1.05528e-13
Cpar14 a_2810_15289.t22 vss 3.30432e-14
Cpar15 ib inp 1.00400e-17
Cpar16 ib vdd 1.52600e-17
Cpar17 ib vss 1.79522e-14
Cpar18 ib.t0 vss 2.73816e-15
Cpar19 ib.t1 vss 7.10321e-16
Cpar20 inn inp 8.67900e-17
Cpar21 inn vss 5.39850e-14
Cpar22 inn.t0 vss 5.52596e-14
Cpar23 inp vss 5.42594e-14
Cpar24 inp.t0 vss 5.51300e-14
Cpar25 out vdd 3.34709e-14
Cpar26 out vss 2.40035e-14
Cpar27 out.t0 vss 9.58116e-14
Cpar28 out.t9 vss 2.06669e-14
Cpar29 vdd vss 5.59165e-13
Cpar30 vdd.t0 vss 1.93003e-13
Cpar31 vdd.t23 vss 6.74521e-14
Cpar32 vdd.t24 vss 8.80002e-15
.ends opamp_dut

Vdd vdd 0 3.300000
Vss vss 0 0
Ibias vdd ib 1.437500e-06
Vinp inp 0 DC 1.711000 AC 1 PWL(0 1.711000 2.638334e-08 1.711000 2.902167e-08 1.721000)
Rfb out inn 1m
Cload out 0 2.000000e-12
Xdut vdd vss inp inn out ib opamp_dut
.end
