* opa1000[0763]: 200f/symmetrical_ota_1v8_i10u_weak (symmetrical_ota, VDD=1.8V, CL=0.2pF, Iref=1.75uA)
.include "pdk_opa.inc"
.temp 27
.option gmin=1e-12 rshunt=1e12 reltol=1e-3 abstol=1e-12 vntol=1e-5 method=gear
* Post-PEX R+C extracted netlist for symmetrical_ota_1v8_i10u_weak
.subckt opamp_dut vdd vss inp inn out ib
XMpar0 a_2847_4647.t3 a_2847_4647.t2 vdd.t1 vdd.t0 pfet_03v3 w=2.59u l=1.17u ad=7.2520e-13 pd=3.1500e-06 as=7.2520e-13 ps=3.1500e-06 nf=1 m=2 par=2
XMpar1 a_5942_3056.t3 a_5942_3056.t2 vdd.t1 vdd.t0 pfet_03v3 w=2.59u l=1.17u ad=7.2520e-13 pd=3.1500e-06 as=7.2520e-13 ps=3.1500e-06 nf=1 m=2 par=2
XMpar2 out.t1 a_4332_6745.t4 vss.t5 vss.t4 nfet_03v3 w=0.61u l=1.17u ad=1.7080e-13 pd=1.1700e-06 as=2.6840e-13 ps=1.7950e-06 nf=1 m=4 par=4
XMpar3 a_4332_6745.t0 a_5942_3056.t2 vdd.t1 vdd.t0 pfet_03v3 w=2.59u l=1.17u ad=7.2520e-13 pd=3.1500e-06 as=1.1396e-12 ps=4.7650e-06 nf=1 m=4 par=4
XMpar4 ib.t1 ib.t0 vss.t10 vss.t9 nfet_03v3 w=1.13u l=1.5u ad=3.1640e-13 pd=1.6900e-06 as=3.1640e-13 ps=1.6900e-06 nf=1 m=2 par=2
XMpar5 a_4641_1250.t4 ib.t0 vss.t10 vss.t9 nfet_03v3 w=1.13u l=1.5u ad=3.1640e-13 pd=1.6900e-06 as=4.9720e-13 ps=2.5750e-06 nf=1 m=4 par=4
XMpar6 out.t0 a_2847_4647.t2 vdd.t1 vdd.t0 pfet_03v3 w=2.59u l=1.17u ad=7.2520e-13 pd=3.1500e-06 as=1.1396e-12 ps=4.7650e-06 nf=1 m=4 par=4
XMpar7 a_2847_4647.t0 inp.t0 a_4641_1250.t0 vss.t0 nfet_03v3 w=1.89u l=1.04u ad=5.2920e-13 pd=2.4500e-06 as=1.1340e-12 ps=4.9800e-06 nf=1 m=2 par=2
XMpar8 a_4332_6745.t5 a_4332_6745.t4 vss.t5 vss.t4 nfet_03v3 w=0.61u l=1.17u ad=1.7080e-13 pd=1.1700e-06 as=1.7080e-13 ps=1.1700e-06 nf=1 m=4 par=4
XMpar9 a_4641_1250.t0 inn.t0 a_5942_3056.t0 vss.t0 nfet_03v3 w=1.89u l=1.04u ad=1.1340e-12 pd=4.9800e-06 as=5.2920e-13 ps=2.4500e-06 nf=1 m=2 par=2
X0 out.t8 vss.t6 cap_mim_2f0fF c_width=9.22u c_length=9.22u
Rpar0 a_2847_4647.t0 a_2847_4647.t2 147.2917
Rpar1 a_2847_4647.t0 a_2847_4647.t3 89.1560
Rpar2 a_2847_4647.t2 a_2847_4647.t3 23.7234
Rpar3 a_4332_6745.t0 a_4332_6745.t4 185.2074
Rpar4 a_4332_6745.t0 a_4332_6745.t5 89.0550
Rpar5 a_4332_6745.t4 a_4332_6745.t5 20.6365
Rpar6 a_4641_1250.t0 a_4641_1250.t4 48.8200
Rpar7 a_5942_3056.t0 a_5942_3056.t2 147.2917
Rpar8 a_5942_3056.t0 a_5942_3056.t3 89.1560
Rpar9 a_5942_3056.t2 a_5942_3056.t3 23.7234
Rpar10 ib ib.t0 15.7340
Rpar11 ib ib.t1 14.4024
Rpar12 ib.t0 ib.t1 162.8694
Rpar13 inn inn.t0 10.8616
Rpar14 inp inp.t0 10.9102
Rpar15 out out.t0 4.0727
Rpar16 out out.t1 66.4295
Rpar17 out out.t8 116.7069
Rpar18 out.t1 out.t8 344.6118
Rpar19 vdd vdd.t0 96.0506
Rpar20 vdd vdd.t1 121.1682
Rpar21 vdd.t0 vdd.t1 3.3024
Rpar22 vss vss.t0 110.2988
Rpar23 vss vss.t10 127.4118
Rpar24 vss vss.t9 76.2509
Rpar25 vss vss.t4 369.3613
Rpar26 vss vss.t5 412.9396
Rpar27 vss vss.t6 59.2250
Rpar28 vss.t0 vss.t10 18.5227
Rpar29 vss.t0 vss.t9 2.6489
Rpar30 vss.t0 vss.t4 115.4588
Rpar31 vss.t0 vss.t5 129.8206
Rpar32 vss.t0 vss.t6 901.6007
Rpar33 vss.t10 vss.t9 12.3376
Rpar34 vss.t10 vss.t4 445.3625
Rpar35 vss.t10 vss.t5 500.3025
Rpar36 vss.t10 vss.t6 1041.4850
Rpar37 vss.t9 vss.t4 153.7374
Rpar38 vss.t9 vss.t5 172.6883
Rpar39 vss.t9 vss.t6 623.2876
Rpar40 vss.t4 vss.t5 8.1199
Rpar41 vss.t4 vss.t6 3019.2199
Rpar42 vss.t5 vss.t6 3375.4364
Cpar0 a_2847_4647.t0 vss 2.65459e-15
Cpar1 a_2847_4647.t2 vss 7.14248e-15
Cpar2 a_2847_4647.t3 vss 3.06061e-15
Cpar3 a_4332_6745.t0 vss 2.43876e-15
Cpar4 a_4332_6745.t4 vss 3.35321e-15
Cpar5 a_4332_6745.t5 vss 1.44283e-15
Cpar6 a_4641_1250.t0 vss 3.07351e-15
Cpar7 a_4641_1250.t4 vss 1.84567e-15
Cpar8 a_5942_3056.t0 vss 2.38097e-15
Cpar9 a_5942_3056.t2 vss 6.40628e-15
Cpar10 a_5942_3056.t3 vss 2.74514e-15
Cpar11 ib out 3.56300e-17
Cpar12 ib vss 9.23469e-15
Cpar13 ib.t0 vss 1.35755e-15
Cpar14 ib.t1 vss 6.32317e-17
Cpar15 inn inp 5.25900e-17
Cpar16 inn vss 1.89496e-15
Cpar17 inn.t0 vss 2.86552e-16
Cpar18 inp vss 1.87235e-15
Cpar19 inp.t0 vss 2.98878e-16
Cpar20 out vdd 3.30189e-15
Cpar21 out vss 1.40801e-14
Cpar22 out.t0 vss 2.84491e-16
Cpar23 out.t1 vss 7.45053e-16
Cpar24 out.t8 vss 6.99075e-15
Cpar25 vdd vss 4.96910e-14
Cpar26 vdd.t0 vss 1.03275e-14
Cpar27 vdd.t1 vss 7.24359e-15
.ends opamp_dut

Vdd vdd 0 1.800000
Vss vss 0 0
Ibias vdd ib 1.750000e-06
Vinp inp 0 DC 0.895000 AC 1 PWL(0 0.895000 5.157171e-09 0.895000 5.672888e-09 0.905000)
Rfb out inn 1m
Cload out 0 2.000000e-13
Xdut vdd vss inp inn out ib opamp_dut
.end
