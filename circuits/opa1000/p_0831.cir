* opa1000[0831]: 2p/symmetrical_ota_3v3_i150u_weak (symmetrical_ota, VDD=3.3V, CL=2.0pF, Iref=28.75uA)
.include "pdk_opa.inc"
.temp 27
.option gmin=1e-12 rshunt=1e12 reltol=1e-3 abstol=1e-12 vntol=1e-5 method=gear
* Post-PEX R+C extracted netlist for symmetrical_ota_3v3_i150u_weak
.subckt opamp_dut vdd vss inp inn out ib
XMpar0 a_3652_1041.t13 a_3652_1041.t12 vss.t1 vss.t0 nfet_03v3 w=2.16u l=0.7u ad=6.0480e-13 pd=2.7200e-06 as=6.0480e-13 ps=2.7200e-06 nf=1 m=12 par=12
XMpar1 out.t0 a_3652_1041.t12 vss.t1 vss.t0 nfet_03v3 w=2.16u l=0.7u ad=6.0480e-13 pd=2.7200e-06 as=7.2000e-13 ps=3.1867e-06 nf=1 m=12 par=12
XMpar2 a_1348_7301.t12 inp.t0 a_3122_10763.t0 vss.t14 nfet_03v3 w=1.99u l=0.56u ad=5.5720e-13 pd=2.5500e-06 as=6.4817e-13 ps=2.9257e-06 nf=1 m=28 par=28
XMpar3 a_3122_10763.t0 inn.t0 a_6806_10763.t0 vss.t14 nfet_03v3 w=1.99u l=0.56u ad=6.4817e-13 pd=2.9257e-06 as=5.5720e-13 ps=2.5500e-06 nf=1 m=28 par=28
XMpar4 a_1348_7301.t1 a_1348_7301.t0 vdd.t1 vdd.t0 pfet_03v3 w=8.37u l=0.7u ad=2.3436e-12 pd=8.9300e-06 as=2.3436e-12 ps=8.9300e-06 nf=1 m=6 par=6
XMpar5 a_3122_10763.t28 ib.t0 vss.t48 vss.t0 nfet_03v3 w=2.5u l=0.65u ad=9.6667e-13 pd=4.1067e-06 as=8.3333e-13 ps=3.5833e-06 nf=1 m=12 par=12
XMpar6 out.t2 a_1348_7301.t0 vdd.t1 vdd.t0 pfet_03v3 w=8.37u l=0.7u ad=2.3436e-12 pd=8.9300e-06 as=2.7900e-12 ps=1.0432e-05 nf=1 m=12 par=12
XMpar7 a_3652_1041.t0 a_6806_10763.t28 vdd.t1 vdd.t0 pfet_03v3 w=8.37u l=0.7u ad=2.3436e-12 pd=8.9300e-06 as=2.7900e-12 ps=1.0432e-05 nf=1 m=12 par=12
XMpar8 ib.t1 ib.t0 vss.t48 vss.t0 nfet_03v3 w=2.5u l=0.65u ad=9.6667e-13 pd=4.1067e-06 as=7.0000e-13 ps=3.0600e-06 nf=1 m=6 par=6
XMpar9 a_6806_10763.t29 a_6806_10763.t28 vdd.t1 vdd.t0 pfet_03v3 w=8.37u l=0.7u ad=2.3436e-12 pd=8.9300e-06 as=2.3436e-12 ps=8.9300e-06 nf=1 m=6 par=6
X32 out.t24 vss.t46 cap_mim_2f0fF c_width=12.99u c_length=12.99u
Rpar0 a_1348_7301.t0 a_1348_7301.t1 20.1011
Rpar1 a_1348_7301.t0 a_1348_7301.t12 192.1011
Rpar2 a_1348_7301.t1 a_1348_7301.t12 46.4738
Rpar3 a_3122_10763.t0 a_3122_10763.t28 102.3490
Rpar4 a_3652_1041.t0 a_3652_1041.t12 860.7052
Rpar5 a_3652_1041.t0 a_3652_1041.t13 43.6815
Rpar6 a_3652_1041.t12 a_3652_1041.t13 15.0120
Rpar7 a_6806_10763.t0 a_6806_10763.t28 192.1011
Rpar8 a_6806_10763.t0 a_6806_10763.t29 46.4738
Rpar9 a_6806_10763.t28 a_6806_10763.t29 20.1011
Rpar10 ib ib.t0 18.6696
Rpar11 ib ib.t1 4.0125
Rpar12 ib.t0 ib.t1 16.5946
Rpar13 inn inn.t0 2.6208
Rpar14 inp inp.t0 2.6208
Rpar15 out out.t0 151.1047
Rpar16 out out.t2 70.6190
Rpar17 out out.t24 15.3064
Rpar18 out.t0 out.t2 272.6150
Rpar19 out.t0 out.t24 1588.9803
Rpar20 out.t2 out.t24 742.6118
Rpar21 vdd vdd.t0 82.6384
Rpar22 vdd vdd.t1 408.3213
Rpar23 vdd.t0 vdd.t1 2.2596
Rpar24 vss vss.t0 62.2871
Rpar25 vss vss.t1 575.3162
Rpar26 vss vss.t14 98.7142
Rpar27 vss vss.t46 293.3275
Rpar28 vss vss.t48 262.0058
Rpar29 vss.t0 vss.t1 3.3242
Rpar30 vss.t0 vss.t14 249.5768
Rpar31 vss.t0 vss.t46 69.8461
Rpar32 vss.t0 vss.t48 9.8310
Rpar33 vss.t1 vss.t14 2308.8020
Rpar34 vss.t1 vss.t46 667.7766
Rpar35 vss.t1 vss.t48 301.3326
Rpar36 vss.t14 vss.t46 1225.4065
Rpar37 vss.t14 vss.t48 1093.9227
Rpar38 vss.t46 vss.t48 126.8922
Cpar0 a_1348_7301.t0 vss 2.23991e-14
Cpar1 a_1348_7301.t1 vss 1.17262e-14
Cpar2 a_1348_7301.t12 vss 1.33318e-14
Cpar3 a_3122_10763.t0 vss 3.29288e-14
Cpar4 a_3122_10763.t28 vss 1.71849e-14
Cpar5 a_3652_1041.t0 vss 1.26183e-14
Cpar6 a_3652_1041.t12 vss 9.66357e-15
Cpar7 a_3652_1041.t13 vss 6.72118e-15
Cpar8 a_6806_10763.t0 vss 1.39413e-14
Cpar9 a_6806_10763.t28 vss 2.34231e-14
Cpar10 a_6806_10763.t29 vss 1.22623e-14
Cpar11 ib out 1.73750e-16
Cpar12 ib vdd 4.31400e-17
Cpar13 ib vss 2.16212e-14
Cpar14 ib.t0 vss 3.11342e-15
Cpar15 ib.t1 vss 1.55556e-15
Cpar16 inn inp 1.03350e-16
Cpar17 inn vdd 2.24090e-16
Cpar18 inn vss 1.41116e-14
Cpar19 inn.t0 vss 5.05937e-15
Cpar20 inp vdd 5.68600e-17
Cpar21 inp vss 1.41966e-14
Cpar22 inp.t0 vss 4.94514e-15
Cpar23 out vdd 1.65904e-14
Cpar24 out vss 2.36091e-14
Cpar25 out.t0 vss 3.65630e-15
Cpar26 out.t2 vss 5.94612e-15
Cpar27 out.t24 vss 1.85456e-14
Cpar28 vdd vss 1.16115e-13
Cpar29 vdd.t0 vss 5.25480e-14
Cpar30 vdd.t1 vss 2.27848e-14
.ends opamp_dut

Vdd vdd 0 3.300000
Vss vss 0 0
Ibias vdd ib 2.875000e-05
Vinp inp 0 DC 1.645000 AC 1 PWL(0 1.645000 3.000000e-09 1.645000 3.300000e-09 1.655000)
Rfb out inn 1m
Cload out 0 2.000000e-12
Xdut vdd vss inp inn out ib opamp_dut
.end
