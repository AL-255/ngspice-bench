* opa1000[0858]: 200f/telescopic_nmos_3v3_i200n_weak (telescopic_nmos, VDD=3.3V, CL=0.2pF, Iref=0.0575uA)
.include "pdk_opa.inc"
.temp 27
.option gmin=1e-12 rshunt=1e12 reltol=1e-3 abstol=1e-12 vntol=1e-5 method=gear
* Post-PEX R+C extracted netlist for telescopic_nmos_3v3_i200n_weak
.subckt opamp_dut vdd vss inp inn out ib
XMpar0 a_1182_2992.t4 ib.t0 vss.t6 vss.t7 nfet_03v3 w=0.4u l=3u ad=1.1200e-13 pd=9.6000e-07 as=1.4857e-13 ps=1.2571e-06 nf=1 m=7 par=7
XMpar1 a_1567_6959.t0 a_1687_6751.t10 vdd.t1 vdd.t0 pfet_03v3 w=1.29u l=9.75u ad=7.7400e-13 pd=3.7800e-06 as=3.6120e-13 ps=1.8500e-06 nf=1 m=2 par=2
XMpar2 a_2769_10461.t2 a_1687_6751.t4 out.t1 vdd.t5 pfet_03v3 w=1.29u l=2.8u ad=7.7400e-13 pd=3.7800e-06 as=3.6120e-13 ps=1.8500e-06 nf=1 m=2 par=2
XMpar3 a_1567_6959.t1 a_1687_6751.t4 a_1687_6751.t5 vdd.t5 pfet_03v3 w=1.29u l=2.8u ad=7.7400e-13 pd=3.7800e-06 as=7.7400e-13 ps=3.7800e-06 nf=1 m=2 par=2
XMpar4 a_1182_2992.t0 inn.t0 a_2769_5012.t1 vss.t0 nfet_03v3 w=2.36u l=8.13u ad=1.4160e-12 pd=5.9200e-06 as=6.6080e-13 ps=2.9200e-06 nf=1 m=2 par=2
XMpar5 ib.t1 ib.t0 vss.t6 vss.t7 nfet_03v3 w=0.4u l=3u ad=1.1200e-13 pd=9.6000e-07 as=1.1200e-13 ps=9.6000e-07 nf=1 m=2 par=2
XMpar6 a_2769_10461.t0 a_1687_6751.t10 vdd.t1 vdd.t0 pfet_03v3 w=1.29u l=9.75u ad=7.7400e-13 pd=3.7800e-06 as=3.6120e-13 ps=1.8500e-06 nf=1 m=2 par=2
XMpar7 a_1687_6751.t1 a_1687_6751.t0 a_1821_5012.t2 vss.t2 nfet_03v3 w=0.4u l=2.8u ad=2.4000e-13 pd=2.0000e-06 as=2.4000e-13 ps=2.0000e-06 nf=1 m=2 par=2
XMpar8 a_2769_5012.t0 a_1687_6751.t0 out.t0 vss.t2 nfet_03v3 w=0.4u l=2.8u ad=2.4000e-13 pd=2.0000e-06 as=1.1200e-13 ps=9.6000e-07 nf=1 m=1
XMpar9 a_1182_2992.t0 inp.t0 a_1821_5012.t0 vss.t0 nfet_03v3 w=2.36u l=8.13u ad=1.4160e-12 pd=5.9200e-06 as=6.6080e-13 ps=2.9200e-06 nf=1 m=2 par=2
XMpar10 a_1182_2992.t4 ib.t0 vss.t6 vss.t3 nfet_03v3 w=0.4u l=3u ad=1.1200e-13 pd=9.6000e-07 as=1.1200e-13 ps=9.6000e-07 nf=1 m=1
XMpar11 a_2769_5012.t0 a_1687_6751.t0 out.t0 vss.t3 nfet_03v3 w=0.4u l=2.8u ad=2.4000e-13 pd=2.0000e-06 as=1.1200e-13 ps=9.6000e-07 nf=1 m=1
Rpar0 a_1182_2992.t0 a_1182_2992.t4 29.2750
Rpar1 a_1567_6959.t0 a_1567_6959.t1 54.3790
Rpar2 a_1687_6751.t0 a_1687_6751.t1 25.0652
Rpar3 a_1687_6751.t0 a_1687_6751.t10 112.4707
Rpar4 a_1687_6751.t0 a_1687_6751.t4 838.8279
Rpar5 a_1687_6751.t0 a_1687_6751.t5 490.9412
Rpar6 a_1687_6751.t1 a_1687_6751.t10 86.5871
Rpar7 a_1687_6751.t1 a_1687_6751.t4 645.7835
Rpar8 a_1687_6751.t1 a_1687_6751.t5 377.9580
Rpar9 a_1687_6751.t10 a_1687_6751.t4 178.7509
Rpar10 a_1687_6751.t10 a_1687_6751.t5 104.6176
Rpar11 a_1687_6751.t4 a_1687_6751.t5 22.2071
Rpar12 a_1821_5012.t0 a_1821_5012.t2 47.1487
Rpar13 a_2769_10461.t0 a_2769_10461.t2 59.3335
Rpar14 a_2769_5012.t0 a_2769_5012.t1 50.4519
Rpar15 ib ib.t0 10.9071
Rpar16 ib ib.t1 16.7799
Rpar17 inn inn.t0 3.8399
Rpar18 inp inp.t0 3.8777
Rpar19 out out.t0 15.1428
Rpar20 out out.t1 66.0086
Rpar21 vdd vdd.t0 120.7663
Rpar22 vdd vdd.t1 257.5575
Rpar23 vdd vdd.t5 27.9012
Rpar24 vdd.t0 vdd.t1 27.0091
Rpar25 vdd.t0 vdd.t5 69.9166
Rpar26 vdd.t1 vdd.t5 149.1107
Rpar27 vss vss.t0 157.5925
Rpar28 vss vss.t6 448.0953
Rpar29 vss vss.t7 83.7994
Rpar30 vss vss.t2 124.9366
Rpar31 vss vss.t3 220.7790
Rpar32 vss.t0 vss.t6 25.4902
Rpar33 vss.t0 vss.t7 5.0203
Rpar34 vss.t0 vss.t2 7.5711
Rpar35 vss.t0 vss.t3 5.0528
Rpar36 vss.t6 vss.t7 13.2768
Rpar37 vss.t6 vss.t2 19.3312
Rpar38 vss.t6 vss.t3 45.2118
Rpar39 vss.t7 vss.t2 3.5099
Rpar40 vss.t7 vss.t3 7.8011
Rpar41 vss.t2 vss.t3 11.7753
Cpar0 a_1182_2992.t0 vss 5.79398e-15
Cpar1 a_1182_2992.t4 vss 3.71379e-15
Cpar2 a_1567_6959.t0 vss 1.13536e-14
Cpar3 a_1567_6959.t1 vss 6.37407e-15
Cpar4 a_1687_6751.t0 vss 5.78040e-15
Cpar5 a_1687_6751.t1 vss 2.34471e-15
Cpar6 a_1687_6751.t10 vss 2.29456e-14
Cpar7 a_1687_6751.t4 vss 7.32981e-15
Cpar8 a_1687_6751.t5 vss 2.98258e-15
Cpar9 a_1821_5012.t0 vss 2.79220e-15
Cpar10 a_1821_5012.t2 vss 2.45279e-15
Cpar11 a_2769_10461.t0 vss 1.18443e-14
Cpar12 a_2769_10461.t2 vss 6.65513e-15
Cpar13 a_2769_5012.t0 vss 3.06096e-15
Cpar14 a_2769_5012.t1 vss 3.37469e-15
Cpar15 ib inn 2.75000e-17
Cpar16 ib inp 2.70600e-17
Cpar17 ib vss 2.28147e-14
Cpar18 ib.t0 vss 2.82033e-15
Cpar19 ib.t1 vss 1.44141e-16
Cpar20 inn inp 5.12300e-17
Cpar21 inn vss 8.14144e-15
Cpar22 inn.t0 vss 1.13718e-15
Cpar23 inp vss 8.41002e-15
Cpar24 inp.t0 vss 1.05304e-15
Cpar25 out vdd 2.83163e-15
Cpar26 out vss 8.66206e-15
Cpar27 out.t0 vss 2.11995e-16
Cpar28 out.t1 vss 2.76659e-15
Cpar29 vdd vss 8.22077e-14
Cpar30 vdd.t0 vss 1.60759e-14
Cpar31 vdd.t1 vss 8.36067e-15
Cpar32 vdd.t5 vss 1.31923e-14
.ends opamp_dut

Vdd vdd 0 3.300000
Vss vss 0 0
Ibias vdd ib 5.750000e-08
Vinp inp 0 DC 1.711000 AC 1 PWL(0 1.711000 8.977605e-08 1.711000 9.875366e-08 1.721000)
Rfb out inn 1m
Cload out 0 2.000000e-13
Xdut vdd vss inp inn out ib opamp_dut
.end
