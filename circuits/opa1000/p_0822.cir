* opa1000[0822]: 2p/symmetrical_ota_3v3_i2u_subth (symmetrical_ota, VDD=3.3V, CL=2.0pF, Iref=0.4333uA)
.include "pdk_opa.inc"
.temp 27
.option gmin=1e-12 rshunt=1e12 reltol=1e-3 abstol=1e-12 vntol=1e-5 method=gear
* Post-PEX R+C extracted netlist for symmetrical_ota_3v3_i2u_subth
.subckt opamp_dut vdd vss inp inn out ib
XMpar0 a_2053_1294.t0 inn.t0 a_8024_5580.t0 vss.t2 nfet_03v3 w=1.98u l=1.14u ad=6.3704e-13 pd=2.8817e-06 as=5.8195e-13 ps=2.6539e-06 nf=1 m=46 par=46
XMpar1 a_6750_12177.t8 a_8024_5580.t46 vdd.t1 vdd.t0 pfet_03v3 w=5.38u l=2.72u ad=1.5064e-12 pd=5.9400e-06 as=2.3672e-12 ps=8.9500e-06 nf=1 m=4 par=4
XMpar2 a_1403_8381.t0 inp.t0 a_2053_1294.t0 vss.t2 nfet_03v3 w=1.98u l=1.14u ad=5.8195e-13 pd=2.6539e-06 as=6.3704e-13 ps=2.8817e-06 nf=1 m=46 par=46
XMpar3 a_6750_12177.t1 a_6750_12177.t0 vss.t1 vss.t0 nfet_03v3 w=1.34u l=2.72u ad=3.7520e-13 pd=1.9000e-06 as=3.7520e-13 ps=1.9000e-06 nf=1 m=4 par=4
XMpar4 out.t0 a_1403_8381.t46 vdd.t1 vdd.t0 pfet_03v3 w=5.38u l=2.72u ad=1.5064e-12 pd=5.9400e-06 as=2.3672e-12 ps=8.9500e-06 nf=1 m=4 par=4
XMpar5 a_2053_1294.t92 ib.t0 vss.t60 vss.t2 nfet_03v3 w=2.06u l=3.25u ad=5.7680e-13 pd=2.6200e-06 as=9.0640e-13 ps=3.9700e-06 nf=1 m=4 par=4
XMpar6 a_8024_5580.t47 a_8024_5580.t46 vdd.t1 vdd.t0 pfet_03v3 w=5.38u l=2.72u ad=1.5064e-12 pd=5.9400e-06 as=1.5064e-12 ps=5.9400e-06 nf=1 m=2 par=2
XMpar7 out.t1 a_6750_12177.t0 vss.t1 vss.t0 nfet_03v3 w=1.34u l=2.72u ad=8.0400e-13 pd=3.8800e-06 as=3.7520e-13 ps=1.9000e-06 nf=1 m=4 par=4
XMpar8 ib.t1 ib.t0 vss.t60 vss.t2 nfet_03v3 w=2.06u l=3.25u ad=5.7680e-13 pd=2.6200e-06 as=5.7680e-13 ps=2.6200e-06 nf=1 m=2 par=2
XMpar9 a_1403_8381.t47 a_1403_8381.t46 vdd.t1 vdd.t0 pfet_03v3 w=5.38u l=2.72u ad=1.5064e-12 pd=5.9400e-06 as=1.5064e-12 ps=5.9400e-06 nf=1 m=2 par=2
X49 out.t8 vss.t57 cap_mim_2f0fF c_width=11.18u c_length=11.18u
Rpar0 a_1403_8381.t0 a_1403_8381.t46 104.1570
Rpar1 a_1403_8381.t0 a_1403_8381.t47 65.8868
Rpar2 a_1403_8381.t46 a_1403_8381.t47 24.4304
Rpar3 a_2053_1294.t0 a_2053_1294.t92 40.6748
Rpar4 a_6750_12177.t0 a_6750_12177.t1 13.8559
Rpar5 a_6750_12177.t0 a_6750_12177.t8 86.3527
Rpar6 a_6750_12177.t1 a_6750_12177.t8 77.1252
Rpar7 a_8024_5580.t0 a_8024_5580.t46 104.1570
Rpar8 a_8024_5580.t0 a_8024_5580.t47 65.8868
Rpar9 a_8024_5580.t46 a_8024_5580.t47 24.4304
Rpar10 ib ib.t0 11.9144
Rpar11 ib ib.t1 9.8535
Rpar12 inn inn.t0 1.7479
Rpar13 inp inp.t0 1.7479
Rpar14 out out.t0 4.1676
Rpar15 out out.t1 47.2426
Rpar16 out out.t8 64.2138
Rpar17 out.t1 out.t8 93.2682
Rpar18 vdd vdd.t0 60.1598
Rpar19 vdd vdd.t1 129.2732
Rpar20 vdd.t0 vdd.t1 3.0573
Rpar21 vss vss.t0 4477.2030
Rpar22 vss vss.t1 1472.2360
Rpar23 vss vss.t2 36.0737
Rpar24 vss vss.t57 654.0790
Rpar25 vss vss.t60 362.3113
Rpar26 vss.t0 vss.t1 15.5633
Rpar27 vss.t0 vss.t2 286.9718
Rpar28 vss.t0 vss.t57 839.2712
Rpar29 vss.t1 vss.t2 110.9802
Rpar30 vss.t1 vss.t57 273.3380
Rpar31 vss.t2 vss.t57 49.7705
Rpar32 vss.t2 vss.t60 4.6897
Rpar33 vss.t57 vss.t60 1905.5595
Cpar0 a_1403_8381.t0 vss 2.40179e-14
Cpar1 a_1403_8381.t46 vss 1.97723e-14
Cpar2 a_1403_8381.t47 vss 4.26940e-15
Cpar3 a_2053_1294.t0 vss 5.22039e-14
Cpar4 a_2053_1294.t92 vss 4.91493e-15
Cpar5 a_6750_12177.t0 vss 7.51522e-15
Cpar6 a_6750_12177.t1 vss 1.79902e-15
Cpar7 a_6750_12177.t8 vss 3.14991e-15
Cpar8 a_8024_5580.t0 vss 2.39059e-14
Cpar9 a_8024_5580.t46 vss 1.96802e-14
Cpar10 a_8024_5580.t47 vss 4.24950e-15
Cpar11 ib inp 1.90800e-17
Cpar12 ib vss 1.57154e-14
Cpar13 ib.t0 vss 2.35795e-15
Cpar14 ib.t1 vss 1.46903e-16
Cpar15 inn inp 1.44150e-16
Cpar16 inn vss 2.86282e-14
Cpar17 inn.t0 vss 1.66369e-14
Cpar18 inp vss 2.88434e-14
Cpar19 inp.t0 vss 1.67136e-14
Cpar20 out vdd 4.83948e-15
Cpar21 out vss 1.47069e-14
Cpar22 out.t0 vss 6.88913e-16
Cpar23 out.t1 vss 1.21400e-15
Cpar24 out.t8 vss 9.58689e-15
Cpar25 vdd vss 9.48753e-14
Cpar26 vdd.t0 vss 2.08986e-14
Cpar27 vdd.t1 vss 1.06867e-14
.ends opamp_dut

Vdd vdd 0 3.300000
Vss vss 0 0
Ibias vdd ib 4.333000e-07
Vinp inp 0 DC 1.645000 AC 1 PWL(0 1.645000 6.441455e-08 1.645000 7.085601e-08 1.655000)
Rfb out inn 1m
Cload out 0 2.000000e-12
Xdut vdd vss inp inn out ib opamp_dut
.end
