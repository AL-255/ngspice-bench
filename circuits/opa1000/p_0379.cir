* opa1000[0379]: 2p/nmos_5t_1v8_i200n_subth (nmos_5t, VDD=1.8V, CL=2.0pF, Iref=0.065uA)
.include "pdk_opa.inc"
.temp 27
.option gmin=1e-12 rshunt=1e12 reltol=1e-3 abstol=1e-12 vntol=1e-5 method=gear
* Post-PEX R+C extracted netlist for nmos_5t_1v8_i200n_subth
.subckt opamp_dut vdd vss inp inn out ib
XMpar0 a_2698_9615.t13 a_2698_9615.t12 vdd.t1 vdd.t0 pfet_03v3 w=2u l=9.75u ad=1.2000e-12 pd=5.2000e-06 as=5.6000e-13 ps=2.5600e-06 nf=1 m=6 par=6
XMpar1 a_1762_4452.t0 inn.t0 out.t1 vss.t0 nfet_03v3 w=2.03u l=7.2u ad=7.8493e-13 pd=3.4800e-06 as=7.8493e-13 ps=3.4800e-06 nf=1 m=12 par=12
XMpar2 out.t0 a_2698_9615.t12 vdd.t1 vdd.t0 pfet_03v3 w=2u l=9.75u ad=5.6000e-13 pd=2.5600e-06 as=5.6000e-13 ps=2.5600e-06 nf=1 m=6 par=6
XMpar3 a_1762_4452.t0 inp.t0 a_2698_9615.t0 vss.t0 nfet_03v3 w=2.03u l=7.2u ad=7.8493e-13 pd=3.4800e-06 as=7.8493e-13 ps=3.4800e-06 nf=1 m=12 par=12
XMpar4 ib.t1 ib.t0 vss.t4 vss.t0 nfet_03v3 w=0.63u l=6.25u ad=3.7800e-13 pd=2.4600e-06 as=1.7640e-13 ps=1.1900e-06 nf=1 m=2 par=2
XMpar5 a_1762_4452.t12 ib.t0 vss.t4 vss.t0 nfet_03v3 w=0.63u l=6.25u ad=1.7640e-13 pd=1.1900e-06 as=3.2760e-13 ps=2.1425e-06 nf=1 m=8 par=8
X19 out.t18 vss.t18 cap_mim_2f0fF c_width=7.75u c_length=7.75u
Rpar0 a_1762_4452.t0 a_1762_4452.t12 40.6419
Rpar1 a_2698_9615.t0 a_2698_9615.t12 128.7182
Rpar2 a_2698_9615.t0 a_2698_9615.t13 54.1829
Rpar3 a_2698_9615.t12 a_2698_9615.t13 5.9330
Rpar4 ib ib.t0 14.6401
Rpar5 ib ib.t1 13.4038
Rpar6 ib.t0 ib.t1 31.2302
Rpar7 inn inn.t0 2.1519
Rpar8 inp inp.t0 2.1519
Rpar9 out out.t0 6.8053
Rpar10 out out.t1 218.7733
Rpar11 out out.t18 594.9191
Rpar12 out.t0 out.t1 78.0996
Rpar13 out.t0 out.t18 212.3795
Rpar14 out.t1 out.t18 64.5235
Rpar15 vdd vdd.t0 21.9244
Rpar16 vdd vdd.t1 220.9390
Rpar17 vdd.t0 vdd.t1 11.9001
Rpar18 vss vss.t0 65.8197
Rpar19 vss vss.t4 77.3497
Rpar20 vss vss.t18 148.1929
Rpar21 vss.t0 vss.t4 9.9107
Rpar22 vss.t0 vss.t18 116.0633
Rpar23 vss.t4 vss.t18 136.3949
Cpar0 a_1762_4452.t0 vss 3.35976e-14
Cpar1 a_1762_4452.t12 vss 9.57245e-15
Cpar2 a_2698_9615.t0 vss 1.73359e-14
Cpar3 a_2698_9615.t12 vss 7.74900e-14
Cpar4 a_2698_9615.t13 vss 1.81976e-14
Cpar5 ib inn 2.00300e-17
Cpar6 ib inp 3.79700e-17
Cpar7 ib out 2.37600e-17
Cpar8 ib vss 4.48779e-14
Cpar9 ib.t0 vss 6.37726e-15
Cpar10 ib.t1 vss 5.06201e-16
Cpar11 inn inp 2.09740e-16
Cpar12 inn out 8.37779e-15
Cpar13 inn vdd 2.18700e-17
Cpar14 inn vss 3.27826e-14
Cpar15 inn.t0 vss 1.28172e-14
Cpar16 inp vdd 1.85000e-17
Cpar17 inp vss 3.25874e-14
Cpar18 inp.t0 vss 1.27971e-14
Cpar19 out vdd 1.41678e-14
Cpar20 out vss 2.00761e-14
Cpar21 out.t0 vss 8.88023e-15
Cpar22 out.t1 vss 1.57609e-14
Cpar23 out.t18 vss 2.01189e-14
Cpar24 vdd vss 1.57387e-13
Cpar25 vdd.t0 vss 6.94167e-14
Cpar26 vdd.t1 vss 1.12868e-14
.ends opamp_dut

Vdd vdd 0 1.800000
Vss vss 0 0
Ibias vdd ib 6.500000e-08
Vinp inp 0 DC 0.895000 AC 1 PWL(0 0.895000 4.886530e-07 0.895000 5.375183e-07 0.905000)
Rfb out inn 1m
Cload out 0 2.000000e-12
Xdut vdd vss inp inn out ib opamp_dut
.end
