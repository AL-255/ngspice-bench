* opa1000[0146]: 2p/current_reuse_3v3_i50n_subth (current_reuse, VDD=3.3V, CL=2.0pF, Iref=0.0071uA)
.include "pdk_opa.inc"
.temp 27
.option gmin=1e-12 rshunt=1e12 reltol=1e-3 abstol=1e-12 vntol=1e-5 method=gear
* Post-PEX R+C extracted netlist for current_reuse_3v3_i50n_subth
.subckt opamp_dut vdd vss inp inn out ib
XMpar0 a_11004_15002.t0 inn.t2 a_9714_12239.t0 vdd.t4 pfet_03v3 w=0.59u l=4.4u ad=1.6520e-13 pd=1.1500e-06 as=3.5400e-13 ps=2.3800e-06 nf=1 m=2 par=2
XMpar1 a_9714_10784.t4 ib.t0 vss.t10 vss.t9 nfet_03v3 w=0.4u l=6.25u ad=2.4000e-13 pd=2.0000e-06 as=1.1200e-13 ps=9.6000e-07 nf=1 m=4 par=4
XMpar2 out.t12 ib.t0 vss.t10 vss.t9 nfet_03v3 w=0.4u l=6.25u ad=1.8880e-13 pd=1.5840e-06 as=1.6320e-13 ps=1.3760e-06 nf=1 m=10 par=10
XMpar3 out.t0 a_992_10824.t6 vdd.t1 vdd.t0 pfet_03v3 w=0.51u l=5u ad=1.4280e-13 pd=1.0700e-06 as=1.7544e-13 ps=1.3000e-06 nf=1 m=10 par=10
XMpar4 ib.t1 ib.t0 vss.t10 vss.t9 nfet_03v3 w=0.4u l=6.25u ad=2.4000e-13 pd=2.0000e-06 as=1.1200e-13 ps=9.6000e-07 nf=1 m=2 par=2
XMpar5 a_11004_15002.t2 inn.t0 a_9714_10784.t0 vss.t2 nfet_03v3 w=0.4u l=4.4u ad=1.1200e-13 pd=9.6000e-07 as=2.4000e-13 ps=2.0000e-06 nf=1 m=2 par=2
XMpar6 a_9714_12239.t4 a_11004_15002.t4 vdd.t1 vdd.t0 pfet_03v3 w=0.51u l=5u ad=1.4280e-13 pd=1.0700e-06 as=3.0600e-13 ps=2.2200e-06 nf=1 m=2 par=2
XMpar7 a_9714_12239.t0 inp.t2 a_992_10824.t0 vdd.t4 pfet_03v3 w=0.59u l=4.4u ad=3.5400e-13 pd=2.3800e-06 as=1.6520e-13 ps=1.1500e-06 nf=1 m=2 par=2
XMpar8 a_992_10824.t4 a_11004_15002.t4 vdd.t1 vdd.t0 pfet_03v3 w=0.51u l=5u ad=3.0600e-13 pd=2.2200e-06 as=1.4280e-13 ps=1.0700e-06 nf=1 m=1
XMpar9 a_9714_10784.t0 inp.t0 a_992_10824.t2 vss.t2 nfet_03v3 w=0.4u l=4.4u ad=2.4000e-13 pd=2.0000e-06 as=1.1200e-13 ps=9.6000e-07 nf=1 m=2 par=2
XMpar10 a_11004_15002.t5 a_11004_15002.t4 vdd.t1 vdd.t0 pfet_03v3 w=0.51u l=5u ad=3.0600e-13 pd=2.2200e-06 as=1.4280e-13 ps=1.0700e-06 nf=1 m=1
X0 a_992_14464.t0 a_4970_14984.t0 vss.t0 ppolyf_u_1k r_width=1u r_length=19.23u
X1 a_992_11344.t0 a_4970_11864.t0 vss.t0 ppolyf_u_1k r_width=1u r_length=19.23u
X5 a_992_14464.t0 a_4970_13944.t0 vss.t0 ppolyf_u_1k r_width=1u r_length=19.23u
X6 a_992_11344.t0 a_4970_10824.t0 vss.t0 ppolyf_u_1k r_width=1u r_length=19.23u
X11 a_992_13424.t0 a_4970_13944.t0 vss.t0 ppolyf_u_1k r_width=1u r_length=19.23u
X13 a_992_16544.t0 a_4970_17064.t0 vss.t0 ppolyf_u_1k r_width=1u r_length=19.23u
X14 a_992_10824.t5 a_4970_10824.t0 vss.t0 ppolyf_u_1k r_width=1u r_length=19.23u
X16 a_4970_17064.t1 out.t4 cap_mim_2f0fF c_width=18.91u c_length=18.91u
X18 a_992_16544.t0 a_4970_16024.t0 vss.t0 ppolyf_u_1k r_width=1u r_length=19.23u
X22 a_4970_17064.t1 out.t4 cap_mim_2f0fF c_width=18.91u c_length=18.91u
X23 a_992_13424.t0 a_4970_12904.t0 vss.t0 ppolyf_u_1k r_width=1u r_length=19.23u
X30 a_992_12384.t0 a_4970_12904.t0 vss.t0 ppolyf_u_1k r_width=1u r_length=19.23u
X31 a_992_15504.t0 a_4970_16024.t0 vss.t0 ppolyf_u_1k r_width=1u r_length=19.23u
X34 a_992_15504.t0 a_4970_14984.t0 vss.t0 ppolyf_u_1k r_width=1u r_length=19.23u
X46 a_4970_17064.t1 out.t4 cap_mim_2f0fF c_width=18.91u c_length=18.91u
X49 a_4970_17064.t1 out.t4 cap_mim_2f0fF c_width=18.91u c_length=18.91u
X52 a_992_12384.t0 a_4970_11864.t0 vss.t0 ppolyf_u_1k r_width=1u r_length=19.23u
Rpar0 a_11004_15002.t0 a_11004_15002.t2 118.3662
Rpar1 a_11004_15002.t0 a_11004_15002.t4 89.0284
Rpar2 a_11004_15002.t0 a_11004_15002.t5 304.5412
Rpar3 a_11004_15002.t2 a_11004_15002.t4 95.0012
Rpar4 a_11004_15002.t2 a_11004_15002.t5 484.7771
Rpar5 a_11004_15002.t4 a_11004_15002.t5 30.6722
Rpar6 a_4970_17064.t0 a_4970_17064.t1 67.4730
Rpar7 a_9714_10784.t0 a_9714_10784.t4 77.0559
Rpar8 a_9714_12239.t0 a_9714_12239.t4 68.6741
Rpar9 a_992_10824.t0 a_992_10824.t6 149.4016
Rpar10 a_992_10824.t0 a_992_10824.t2 108.0739
Rpar11 a_992_10824.t0 a_992_10824.t4 688.9351
Rpar12 a_992_10824.t0 a_992_10824.t5 396.1733
Rpar13 a_992_10824.t6 a_992_10824.t2 115.9638
Rpar14 a_992_10824.t6 a_992_10824.t4 83.8264
Rpar15 a_992_10824.t6 a_992_10824.t5 68.7373
Rpar16 a_992_10824.t2 a_992_10824.t4 534.7436
Rpar17 a_992_10824.t2 a_992_10824.t5 307.5052
Rpar18 a_992_10824.t4 a_992_10824.t5 316.9680
Rpar19 ib ib.t0 18.1486
Rpar20 ib ib.t1 15.7665
Rpar21 ib.t0 ib.t1 34.3541
Rpar22 inn inn.t0 3.1426
Rpar23 inn inn.t2 41.5052
Rpar24 inp inp.t0 3.1912
Rpar25 inp inp.t2 42.5834
Rpar26 out out.t0 563.9544
Rpar27 out out.t12 4.9616
Rpar28 out out.t4 541.0600
Rpar29 out.t0 out.t12 278.6213
Rpar30 out.t0 out.t4 209.3439
Rpar31 out.t12 out.t4 267.3103
Rpar32 vdd vdd.t0 35.1453
Rpar33 vdd vdd.t1 66.9295
Rpar34 vdd vdd.t4 575.0642
Rpar35 vdd.t0 vdd.t1 4.5024
Rpar36 vdd.t0 vdd.t4 81.9310
Rpar37 vdd.t1 vdd.t4 104.7785
Rpar38 vss vss.t0 182.8405
Rpar39 vss vss.t10 63.3794
Rpar40 vss vss.t9 155.4722
Rpar41 vss vss.t2 344.4992
Rpar42 vss.t0 vss.t10 1300.3033
Rpar43 vss.t0 vss.t9 254.2880
Rpar44 vss.t0 vss.t2 488.0175
Rpar45 vss.t10 vss.t9 17.7217
Rpar46 vss.t10 vss.t2 43.9349
Rpar47 vss.t9 vss.t2 2.0683
Cpar0 a_11004_15002.t0 vss 4.28273e-15
Cpar1 a_11004_15002.t2 vss 3.54471e-15
Cpar2 a_11004_15002.t4 vss 1.47694e-14
Cpar3 a_11004_15002.t5 vss 2.94076e-15
Cpar4 a_4970_10824.t0 vss 3.93800e-17
Cpar5 a_4970_11864.t0 vss 3.20800e-17
Cpar6 a_4970_12904.t0 vss 3.45200e-17
Cpar7 a_4970_13944.t0 vss 3.24800e-17
Cpar8 a_4970_14984.t0 vss 3.14400e-17
Cpar9 a_4970_16024.t0 vss 3.20200e-17
Cpar10 a_4970_17064.t0 vss 8.83357e-17
Cpar11 a_4970_17064.t1 vss 9.32531e-15
Cpar12 a_9714_10784.t0 vss 7.64009e-15
Cpar13 a_9714_10784.t4 vss 2.08063e-14
Cpar14 a_9714_12239.t0 vss 6.97803e-15
Cpar15 a_9714_12239.t4 vss 4.10486e-15
Cpar16 a_992_10824.t0 vss 2.49042e-15
Cpar17 a_992_10824.t2 vss 2.50015e-15
Cpar18 a_992_10824.t4 vss 2.83396e-15
Cpar19 a_992_10824.t5 vss 3.28943e-15
Cpar20 a_992_10824.t6 vss 2.47371e-14
Cpar21 a_992_11344.t0 vss 3.87600e-17
Cpar22 a_992_12384.t0 vss 3.60800e-17
Cpar23 a_992_13424.t0 vss 3.60800e-17
Cpar24 a_992_14464.t0 vss 3.60800e-17
Cpar25 a_992_15504.t0 vss 3.68200e-17
Cpar26 a_992_16544.t0 vss 3.33800e-17
Cpar27 ib out 2.85778e-15
Cpar28 ib vss 6.88049e-14
Cpar29 ib.t0 vss 1.12074e-14
Cpar30 ib.t1 vss 8.31812e-16
Cpar31 inn inp 1.03940e-16
Cpar32 inn vdd 4.80661e-15
Cpar33 inn vss 7.32432e-15
Cpar34 inn.t0 vss 1.38640e-15
Cpar35 inn.t2 vss 3.49234e-15
Cpar36 inp out 1.08000e-17
Cpar37 inp vdd 4.33695e-15
Cpar38 inp vss 7.73156e-15
Cpar39 inp.t0 vss 1.41851e-15
Cpar40 inp.t2 vss 3.73486e-15
Cpar41 out vdd 1.25892e-14
Cpar42 out vss 4.65196e-14
Cpar43 out.t0 vss 5.55746e-15
Cpar44 out.t12 vss 5.60815e-15
Cpar45 out.t4 vss 2.54450e-14
Cpar46 vdd vss 1.28831e-13
Cpar47 vdd.t0 vss 3.15752e-14
Cpar48 vdd.t1 vss 1.62879e-14
Cpar49 vdd.t4 vss 1.16118e-14
.ends opamp_dut

Vdd vdd 0 3.300000
Vss vss 0 0
Ibias vdd ib 7.100000e-09
Vinp inp 0 DC 1.645000 AC 1 PWL(0 1.645000 7.318646e-06 1.645000 8.050511e-06 1.655000)
Rfb out inn 1m
Cload out 0 2.000000e-12
Xdut vdd vss inp inn out ib opamp_dut
.end
