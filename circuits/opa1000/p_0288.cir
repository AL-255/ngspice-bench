* opa1000[0288]: 200f/folded_cascode_pmos_3v3_i150u_subth (folded_cascode_pmos, VDD=3.3V, CL=0.2pF, Iref=33.3333uA)
.include "pdk_opa.inc"
.temp 27
.option gmin=1e-12 rshunt=1e12 reltol=1e-3 abstol=1e-12 vntol=1e-5 method=gear
* Post-PEX R+C extracted netlist for folded_cascode_pmos_3v3_i150u_subth
.subckt opamp_dut vdd vss inp inn out ib
XMpar0 a_1466_4352.t0 inp.t0 a_3664_11891.t0 vdd.t34 pfet_03v3 w=8u l=0.35u ad=2.4000e-12 pd=9.1000e-06 as=2.2400e-12 ps=8.5600e-06 nf=1 m=64 par=64
XMpar1 a_9708_10125.t76 a_1326_4144.t30 out.t2 vss.t0 nfet_03v3 w=1.95u l=0.38u ad=5.9057e-13 pd=2.6950e-06 as=5.6829e-13 ps=2.6025e-06 nf=1 m=56 par=56
XMpar2 a_1326_4144.t0 ib.t0 vss.t45 vss.t0 nfet_03v3 w=8.06u l=0.65u ad=2.2568e-12 pd=8.6200e-06 as=2.2568e-12 ps=8.6200e-06 nf=1 m=6 par=6
XMpar3 a_1466_4352.t0 inn.t0 a_9708_10125.t0 vdd.t34 pfet_03v3 w=8u l=0.35u ad=2.4000e-12 pd=9.1000e-06 as=2.2400e-12 ps=8.5600e-06 nf=1 m=64 par=64
XMpar4 ib.t1 ib.t0 vss.t45 vss.t0 nfet_03v3 w=8.06u l=0.65u ad=3.1165e-12 pd=1.1520e-05 as=2.2568e-12 ps=8.6200e-06 nf=1 m=6 par=6
XMpar5 a_9708_10125.t64 ib.t0 vss.t45 vss.t0 nfet_03v3 w=8.06u l=0.65u ad=2.2568e-12 pd=8.6200e-06 as=2.6867e-12 ps=1.0070e-05 nf=1 m=12 par=12
XMpar6 a_1466_4352.t128 a_1326_4144.t6 vdd.t1 vdd.t0 pfet_03v3 w=10u l=0.7u ad=2.8000e-12 pd=1.0560e-05 as=3.3333e-12 ps=1.2333e-05 nf=1 m=12 par=12
XMpar7 a_3664_11891.t76 a_1326_4144.t30 a_5922_7933.t0 vss.t0 nfet_03v3 w=1.95u l=0.38u ad=5.9057e-13 pd=2.6950e-06 as=5.6829e-13 ps=2.6025e-06 nf=1 m=56 par=56
XMpar8 a_3664_11891.t64 ib.t0 vss.t45 vss.t0 nfet_03v3 w=8.06u l=0.65u ad=2.2568e-12 pd=8.6200e-06 as=2.6867e-12 ps=1.0070e-05 nf=1 m=12 par=12
XMpar9 out.t0 a_5922_7933.t50 vdd.t1 vdd.t0 pfet_03v3 w=10u l=0.7u ad=2.8000e-12 pd=1.0560e-05 as=2.8000e-12 ps=1.0560e-05 nf=1 m=6 par=6
XMpar10 a_1326_4144.t7 a_1326_4144.t6 vdd.t1 vdd.t0 pfet_03v3 w=10u l=0.7u ad=2.8000e-12 pd=1.0560e-05 as=2.8000e-12 ps=1.0560e-05 nf=1 m=6 par=6
XMpar11 a_5922_7933.t51 a_5922_7933.t50 vdd.t1 vdd.t0 pfet_03v3 w=10u l=0.7u ad=3.8667e-12 pd=1.4107e-05 as=2.8000e-12 ps=1.0560e-05 nf=1 m=6 par=6
X177 out.t62 vss.t12 cap_mim_2f0fF c_width=17.75u c_length=17.75u
Rpar0 a_1326_4144.t0 a_1326_4144.t6 1063.4174
Rpar1 a_1326_4144.t0 a_1326_4144.t30 158.8005
Rpar2 a_1326_4144.t0 a_1326_4144.t7 90.9259
Rpar3 a_1326_4144.t6 a_1326_4144.t30 2210.6717
Rpar4 a_1326_4144.t6 a_1326_4144.t7 19.8016
Rpar5 a_1326_4144.t30 a_1326_4144.t7 189.0202
Rpar6 a_1466_4352.t0 a_1466_4352.t128 49.8968
Rpar7 a_3664_11891.t0 a_3664_11891.t76 56.9780
Rpar8 a_3664_11891.t0 a_3664_11891.t64 243.8962
Rpar9 a_3664_11891.t76 a_3664_11891.t64 70.2572
Rpar10 a_5922_7933.t0 a_5922_7933.t50 1376.0121
Rpar11 a_5922_7933.t0 a_5922_7933.t51 167.6591
Rpar12 a_5922_7933.t50 a_5922_7933.t51 19.9885
Rpar13 a_9708_10125.t0 a_9708_10125.t76 56.9780
Rpar14 a_9708_10125.t0 a_9708_10125.t64 243.8962
Rpar15 a_9708_10125.t76 a_9708_10125.t64 70.2572
Rpar16 ib ib.t0 14.5383
Rpar17 ib ib.t1 2.1588
Rpar18 ib.t0 ib.t1 109.0431
Rpar19 inn inn.t0 3.3111
Rpar20 inp inp.t0 3.3111
Rpar21 out out.t0 66.7649
Rpar22 out out.t2 88.4815
Rpar23 out out.t62 15.9203
Rpar24 out.t0 out.t2 127.3603
Rpar25 out.t0 out.t62 552.5525
Rpar26 out.t2 out.t62 732.2815
Rpar27 vdd vdd.t0 422.5740
Rpar28 vdd vdd.t1 1931.6807
Rpar29 vdd vdd.t34 22.9150
Rpar30 vdd.t0 vdd.t1 2.5611
Rpar31 vdd.t0 vdd.t34 124.9249
Rpar32 vdd.t1 vdd.t34 571.0599
Rpar33 vss vss.t0 66.6691
Rpar34 vss vss.t45 61.3869
Rpar35 vss vss.t12 168.5097
Rpar36 vss.t0 vss.t45 2.6644
Rpar37 vss.t0 vss.t12 151.7025
Rpar38 vss.t45 vss.t12 518.9787
Cpar0 a_1326_4144.t0 vss 7.58993e-15
Cpar1 a_1326_4144.t30 vss 3.06224e-14
Cpar2 a_1326_4144.t6 vss 1.65338e-14
Cpar3 a_1326_4144.t7 vss 1.03337e-14
Cpar4 a_1466_4352.t0 vss 2.41521e-13
Cpar5 a_1466_4352.t128 vss 3.19876e-14
Cpar6 a_3664_11891.t0 vss 1.13103e-13
Cpar7 a_3664_11891.t64 vss 2.46815e-14
Cpar8 a_3664_11891.t76 vss 3.79279e-14
Cpar9 a_5922_7933.t0 vss 3.40482e-14
Cpar10 a_5922_7933.t50 vss 1.91508e-14
Cpar11 a_5922_7933.t51 vss 2.35450e-14
Cpar12 a_9708_10125.t0 vss 1.14097e-13
Cpar13 a_9708_10125.t64 vss 2.48984e-14
Cpar14 a_9708_10125.t76 vss 3.82612e-14
Cpar15 ib vdd 3.22900e-17
Cpar16 ib vss 4.18098e-14
Cpar17 ib.t0 vss 6.96264e-15
Cpar18 ib.t1 vss 1.60771e-15
Cpar19 inn inp 1.03940e-16
Cpar20 inn out 1.08900e-17
Cpar21 inn vdd 2.17434e-14
Cpar22 inn vss 1.16471e-14
Cpar23 inn.t0 vss 3.32218e-14
Cpar24 inp vdd 2.16250e-14
Cpar25 inp vss 1.16454e-14
Cpar26 inp.t0 vss 3.31613e-14
Cpar27 out vdd 9.61102e-15
Cpar28 out vss 1.78291e-14
Cpar29 out.t0 vss 4.34221e-15
Cpar30 out.t2 vss 9.89974e-15
Cpar31 out.t62 vss 4.16999e-14
Cpar32 vdd vss 3.33913e-13
Cpar33 vdd.t0 vss 3.89678e-14
Cpar34 vdd.t1 vss 1.65742e-14
Cpar35 vdd.t34 vss 8.77895e-14
.ends opamp_dut

Vdd vdd 0 3.300000
Vss vss 0 0
Ibias vdd ib 3.333330e-05
Vinp inp 0 DC 1.381000 AC 1 PWL(0 1.381000 3.000000e-09 1.381000 3.300000e-09 1.391000)
Rfb out inn 1m
Cload out 0 2.000000e-13
Xdut vdd vss inp inn out ib opamp_dut
.end
