* opa1000[0541]: 200f/pmos_5t_3v3_i500u_weak (pmos_5t, VDD=3.3V, CL=0.2pF, Iref=100.0uA)
.include "pdk_opa.inc"
.temp 27
.option gmin=1e-12 rshunt=1e12 reltol=1e-3 abstol=1e-12 vntol=1e-5 method=gear
* Post-PEX R+C extracted netlist for pmos_5t_3v3_i500u_weak
.subckt opamp_dut vdd vss inp inn out ib
XMpar0 a_1413_14387.t35 inn.t0 out.t0 vdd.t84 pfet_03v3 w=3.13u l=0.36u ad=9.2648e-13 pd=3.8785e-06 as=8.7640e-13 ps=3.6900e-06 nf=1 m=160 par=160
XMpar1 a_2450_8389.t161 a_2450_8389.t160 vss.t50 vss.t1 nfet_03v3 w=2.02u l=0.5u ad=5.6560e-13 pd=2.5800e-06 as=5.6560e-13 ps=2.5800e-06 nf=1 m=28 par=28
XMpar2 a_1413_14387.t35 inp.t0 a_2450_8389.t0 vdd.t84 pfet_03v3 w=3.13u l=0.36u ad=9.2648e-13 pd=3.8785e-06 as=8.7640e-13 ps=3.6900e-06 nf=1 m=160 par=160
XMpar3 a_1323_14179.t17 a_1323_14179.t16 vdd.t1 vdd.t0 pfet_03v3 w=7.98u l=0.45u ad=2.2344e-12 pd=8.5400e-06 as=2.2344e-12 ps=8.5400e-06 nf=1 m=16 par=16
XMpar4 out.t33 a_2450_8389.t160 vss.t50 vss.t1 nfet_03v3 w=2.02u l=0.5u ad=5.6560e-13 pd=2.5800e-06 as=6.1177e-13 ps=2.7700e-06 nf=1 m=28 par=28
XMpar5 a_1413_14387.t0 a_1323_14179.t16 vdd.t1 vdd.t0 pfet_03v3 w=7.98u l=0.45u ad=2.2344e-12 pd=8.5400e-06 as=2.3142e-12 ps=8.8094e-06 nf=1 m=64 par=64
XMpar6 ib.t1 ib.t0 vss.t2 vss.t1 nfet_03v3 w=2.28u l=0.45u ad=6.3840e-13 pd=2.8400e-06 as=7.2960e-13 ps=3.2050e-06 nf=1 m=16 par=16
XMpar7 a_1323_14179.t0 ib.t0 vss.t2 vss.t1 nfet_03v3 w=2.28u l=0.45u ad=6.3840e-13 pd=2.8400e-06 as=7.2960e-13 ps=3.2050e-06 nf=1 m=16 par=16
X288 out.t188 vss.t0 cap_mim_2f0fF c_width=17.75u c_length=17.75u
Rpar0 a_1323_14179.t0 a_1323_14179.t16 275.0532
Rpar1 a_1323_14179.t0 a_1323_14179.t17 84.4261
Rpar2 a_1323_14179.t16 a_1323_14179.t17 17.1590
Rpar3 a_1413_14387.t0 a_1413_14387.t35 44.3829
Rpar4 a_2450_8389.t0 a_2450_8389.t160 268.2291
Rpar5 a_2450_8389.t0 a_2450_8389.t161 72.6297
Rpar6 a_2450_8389.t160 a_2450_8389.t161 14.5979
Rpar7 ib ib.t0 12.3910
Rpar8 ib ib.t1 2.9676
Rpar9 ib.t0 ib.t1 16.4507
Rpar10 inn inn.t0 1.7017
Rpar11 inp inp.t0 1.7017
Rpar12 out out.t0 162.7071
Rpar13 out out.t33 74.1579
Rpar14 out out.t188 15.7504
Rpar15 out.t0 out.t33 45.2514
Rpar16 out.t0 out.t188 1340.6775
Rpar17 out.t33 out.t188 611.0478
Rpar18 vdd vdd.t0 97.3057
Rpar19 vdd vdd.t1 1226.2150
Rpar20 vdd vdd.t84 82.1653
Rpar21 vdd.t0 vdd.t1 3.6436
Rpar22 vdd.t0 vdd.t84 11.9841
Rpar23 vdd.t1 vdd.t84 151.0203
Rpar24 vss vss.t0 81.3340
Rpar25 vss vss.t1 175.0619
Rpar26 vss vss.t2 81.9868
Rpar27 vss vss.t50 3378.9215
Rpar28 vss.t0 vss.t1 240.0332
Rpar29 vss.t0 vss.t2 112.4149
Rpar30 vss.t0 vss.t50 4632.9514
Rpar31 vss.t1 vss.t2 9.0460
Rpar32 vss.t1 vss.t50 2.7874
Rpar33 vss.t2 vss.t50 662.5940
Cpar0 a_1323_14179.t0 vss 1.29466e-14
Cpar1 a_1323_14179.t16 vss 6.53249e-14
Cpar2 a_1323_14179.t17 vss 2.84636e-14
Cpar3 a_1413_14387.t0 vss 1.30997e-13
Cpar4 a_1413_14387.t35 vss 2.86779e-13
Cpar5 a_2450_8389.t0 vss 1.18085e-13
Cpar6 a_2450_8389.t160 vss 3.29975e-14
Cpar7 a_2450_8389.t161 vss 2.25607e-14
Cpar8 ib out 1.16600e-17
Cpar9 ib vss 3.23551e-14
Cpar10 ib.t0 vss 3.48880e-15
Cpar11 ib.t1 vss 2.19186e-15
Cpar12 inn inp 2.10380e-16
Cpar13 inn out 2.26954e-14
Cpar14 inn vdd 4.67644e-14
Cpar15 inn vss 1.14331e-14
Cpar16 inn.t0 vss 7.46958e-14
Cpar17 inp vdd 4.66578e-14
Cpar18 inp vss 1.14408e-14
Cpar19 inp.t0 vss 7.45310e-14
Cpar20 out vdd 1.39947e-14
Cpar21 out vss 3.46437e-14
Cpar22 out.t0 vss 7.07342e-14
Cpar23 out.t188 vss 8.58693e-14
Cpar24 out.t33 vss 1.31267e-14
Cpar25 vdd vss 4.64860e-13
Cpar26 vdd.t0 vss 9.06620e-14
Cpar27 vdd.t1 vss 3.68641e-14
Cpar28 vdd.t84 vss 1.71171e-13
.ends opamp_dut

Vdd vdd 0 3.300000
Vss vss 0 0
Ibias vdd ib 1.000000e-04
Vinp inp 0 DC 1.480000 AC 1 PWL(0 1.480000 3.000000e-09 1.480000 3.300000e-09 1.490000)
Rfb out inn 1m
Cload out 0 2.000000e-13
Xdut vdd vss inp inn out ib opamp_dut
.end
