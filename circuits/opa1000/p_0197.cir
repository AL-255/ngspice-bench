* opa1000[0197]: 200f/folded_cascode_nmos_3v3_1u_10u_weak (folded_cascode_nmos, VDD=3.3V, CL=0.2pF, Iref=0.7778uA)
.include "pdk_opa.inc"
.temp 27
.option gmin=1e-12 rshunt=1e12 reltol=1e-3 abstol=1e-12 vntol=1e-5 method=gear
* Post-PEX R+C extracted netlist for folded_cascode_nmos_3v3_1u_10u_weak
.subckt opamp_dut vdd vss inp inn out ib
XMpar0 ib.t1 ib.t0 vss.t5 vss.t4 nfet_03v3 w=0.93u l=2.5u ad=5.5800e-13 pd=3.0600e-06 as=2.6040e-13 ps=1.4900e-06 nf=1 m=2 par=2
XMpar1 a_3892_8734.t1 a_3892_8734.t0 vss.t5 vss.t4 nfet_03v3 w=0.93u l=2.5u ad=5.5800e-13 pd=3.0600e-06 as=2.6040e-13 ps=1.4900e-06 nf=1 m=2 par=2
XMpar2 a_2430_1249.t0 inp.t0 a_2612_4834.t0 vss.t0 nfet_03v3 w=1.86u l=1.6u ad=1.1160e-12 pd=4.9200e-06 as=5.2080e-13 ps=2.4200e-06 nf=1 m=2 par=2
XMpar3 a_1986_4626.t4 ib.t0 vss.t5 vss.t4 nfet_03v3 w=0.93u l=2.5u ad=2.6040e-13 pd=1.4900e-06 as=2.6040e-13 ps=1.4900e-06 nf=1 m=2 par=2
XMpar4 a_2430_1249.t4 ib.t0 vss.t5 vss.t4 nfet_03v3 w=0.93u l=2.5u ad=2.6040e-13 pd=1.4900e-06 as=2.6040e-13 ps=1.4900e-06 nf=1 m=4 par=4
XMpar5 a_5134_6918.t6 ib.t10 out.t1 vdd.t14 pfet_03v3 w=2.2u l=0.8u ad=1.3200e-12 pd=5.6000e-06 as=6.1600e-13 ps=2.7600e-06 nf=1 m=2 par=2
XMpar6 a_2612_4834.t2 a_1986_4626.t0 vdd.t1 vdd.t0 pfet_03v3 w=3.54u l=3.13u ad=9.9120e-13 pd=4.1000e-06 as=1.5576e-12 ps=6.1900e-06 nf=1 m=4 par=4
XMpar7 a_5134_6918.t2 a_1986_4626.t0 vdd.t1 vdd.t0 pfet_03v3 w=3.54u l=3.13u ad=9.9120e-13 pd=4.1000e-06 as=1.5576e-12 ps=6.1900e-06 nf=1 m=4 par=4
XMpar8 a_2430_1249.t0 inn.t0 a_5134_6918.t0 vss.t0 nfet_03v3 w=1.86u l=1.6u ad=1.1160e-12 pd=4.9200e-06 as=5.2080e-13 ps=2.4200e-06 nf=1 m=2 par=2
XMpar9 a_2612_4834.t6 ib.t10 a_3892_8734.t4 vdd.t14 pfet_03v3 w=2.2u l=0.8u ad=1.3200e-12 pd=5.6000e-06 as=6.1600e-13 ps=2.7600e-06 nf=1 m=2 par=2
XMpar10 a_1986_4626.t1 a_1986_4626.t0 vdd.t1 vdd.t0 pfet_03v3 w=3.54u l=3.13u ad=9.9120e-13 pd=4.1000e-06 as=2.1240e-12 ps=8.2800e-06 nf=1 m=2 par=2
XMpar11 out.t0 a_3892_8734.t0 vss.t5 vss.t4 nfet_03v3 w=0.93u l=2.5u ad=2.6040e-13 pd=1.4900e-06 as=2.6040e-13 ps=1.4900e-06 nf=1 m=2 par=2
Rpar0 a_1986_4626.t0 a_1986_4626.t1 19.6884
Rpar1 a_1986_4626.t0 a_1986_4626.t4 116.9830
Rpar2 a_1986_4626.t1 a_1986_4626.t4 193.5772
Rpar3 a_2430_1249.t0 a_2430_1249.t4 30.9673
Rpar4 a_2612_4834.t0 a_2612_4834.t2 75.3111
Rpar5 a_2612_4834.t0 a_2612_4834.t6 144.0005
Rpar6 a_2612_4834.t2 a_2612_4834.t6 48.3931
Rpar7 a_3892_8734.t0 a_3892_8734.t1 20.3208
Rpar8 a_3892_8734.t0 a_3892_8734.t4 163.4788
Rpar9 a_3892_8734.t1 a_3892_8734.t4 97.7442
Rpar10 a_5134_6918.t0 a_5134_6918.t2 82.3155
Rpar11 a_5134_6918.t0 a_5134_6918.t6 123.8834
Rpar12 a_5134_6918.t2 a_5134_6918.t6 64.1587
Rpar13 ib ib.t0 11.1249
Rpar14 ib ib.t1 7.6432
Rpar15 ib ib.t10 93.9661
Rpar16 ib.t1 ib.t10 279.1861
Rpar17 inn inn.t0 6.3578
Rpar18 inp inp.t0 6.4064
Rpar19 out out.t0 43.3339
Rpar20 out out.t1 7.6568
Rpar21 vdd vdd.t0 129.5733
Rpar22 vdd vdd.t1 275.9766
Rpar23 vdd vdd.t14 34.9985
Rpar24 vdd.t0 vdd.t1 4.4599
Rpar25 vdd.t0 vdd.t14 71.8843
Rpar26 vdd.t1 vdd.t14 153.1055
Rpar27 vss vss.t0 122.4271
Rpar28 vss vss.t4 49.0517
Rpar29 vss vss.t5 111.4270
Rpar30 vss.t0 vss.t4 2.7592
Rpar31 vss.t0 vss.t5 23.1691
Rpar32 vss.t4 vss.t5 6.2945
Cpar0 a_1986_4626.t0 vss 2.44618e-14
Cpar1 a_1986_4626.t1 vss 3.53072e-15
Cpar2 a_1986_4626.t4 vss 3.98620e-15
Cpar3 a_2430_1249.t0 vss 5.28947e-15
Cpar4 a_2430_1249.t4 vss 3.49730e-15
Cpar5 a_2612_4834.t0 vss 1.98311e-15
Cpar6 a_2612_4834.t2 vss 4.51463e-15
Cpar7 a_2612_4834.t6 vss 2.79312e-15
Cpar8 a_3892_8734.t0 vss 2.16390e-15
Cpar9 a_3892_8734.t1 vss 8.48035e-16
Cpar10 a_3892_8734.t4 vss 8.06638e-16
Cpar11 a_5134_6918.t0 vss 3.12010e-15
Cpar12 a_5134_6918.t2 vss 6.05531e-15
Cpar13 a_5134_6918.t6 vss 3.75425e-15
Cpar14 ib out 1.88300e-16
Cpar15 ib vdd 4.78126e-15
Cpar16 ib vss 2.28600e-14
Cpar17 ib.t0 vss 5.45304e-15
Cpar18 ib.t1 vss 9.06911e-16
Cpar19 ib.t10 vss 3.21961e-15
Cpar20 inn inp 5.19700e-17
Cpar21 inn vss 2.33490e-15
Cpar22 inn.t0 vss 3.96404e-16
Cpar23 inp vss 2.36722e-15
Cpar24 inp.t0 vss 3.78890e-16
Cpar25 out vdd 2.07616e-15
Cpar26 out vss 4.78213e-15
Cpar27 out.t0 vss 2.05137e-15
Cpar28 out.t1 vss 6.57305e-16
Cpar29 vdd vss 7.88148e-14
Cpar30 vdd.t0 vss 2.03460e-14
Cpar31 vdd.t1 vss 1.26266e-14
Cpar32 vdd.t14 vss 6.01957e-15
.ends opamp_dut

Vdd vdd 0 3.300000
Vss vss 0 0
Ibias vdd ib 7.778000e-07
Vinp inp 0 DC 1.810000 AC 1 PWL(0 1.810000 9.683453e-09 1.810000 1.065180e-08 1.820000)
Rfb out inn 1m
Cload out 0 2.000000e-13
Xdut vdd vss inp inn out ib opamp_dut
.end
