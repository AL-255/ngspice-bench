* opa1000[0769]: 200f/symmetrical_ota_1v8_i150u_subth (symmetrical_ota, VDD=1.8V, CL=0.2pF, Iref=25.0uA)
.include "pdk_opa.inc"
.temp 27
.option gmin=1e-12 rshunt=1e12 reltol=1e-3 abstol=1e-12 vntol=1e-5 method=gear
* Post-PEX R+C extracted netlist for symmetrical_ota_1v8_i150u_subth
.subckt opamp_dut vdd vss inp inn out ib
XMpar0 a_2750_14462.t84 ib.t0 vss.t65 vss.t64 nfet_03v3 w=9.63u l=0.98u ad=3.7236e-12 pd=1.3613e-05 as=3.2100e-12 ps=1.1902e-05 nf=1 m=12 par=12
XMpar1 a_1299_10111.t12 inp.t0 a_2750_14462.t0 vss.t0 nfet_03v3 w=1.97u l=0.28u ad=8.7712e-13 pd=2.9543e-06 as=8.7712e-13 ps=2.9543e-06 nf=1 m=42 par=42
XMpar2 out.t0 a_1299_10111.t0 vdd.t1 vdd.t0 pfet_03v3 w=10u l=0.42u ad=2.8000e-12 pd=1.0560e-05 as=3.3333e-12 ps=1.2333e-05 nf=1 m=12 par=12
XMpar3 a_2750_14462.t0 inn.t0 a_7854_14462.t0 vss.t0 nfet_03v3 w=1.97u l=0.28u ad=8.7712e-13 pd=2.9543e-06 as=8.7712e-13 ps=2.9543e-06 nf=1 m=42 par=42
XMpar4 a_6886_10111.t11 a_6886_10111.t10 vss.t22 vss.t0 nfet_03v3 w=3.21u l=0.42u ad=8.9880e-13 pd=3.7700e-06 as=8.9880e-13 ps=3.7700e-06 nf=1 m=12 par=12
XMpar5 out.t12 a_6886_10111.t10 vss.t22 vss.t0 nfet_03v3 w=3.21u l=0.42u ad=1.2412e-12 pd=5.0533e-06 as=8.9880e-13 ps=3.7700e-06 nf=1 m=12 par=12
XMpar6 ib.t1 ib.t0 vss.t65 vss.t64 nfet_03v3 w=9.63u l=0.98u ad=3.7236e-12 pd=1.3613e-05 as=2.6964e-12 ps=1.0190e-05 nf=1 m=6 par=6
XMpar7 a_1299_10111.t1 a_1299_10111.t0 vdd.t1 vdd.t0 pfet_03v3 w=10u l=0.42u ad=2.8000e-12 pd=1.0560e-05 as=2.8000e-12 ps=1.0560e-05 nf=1 m=6 par=6
XMpar8 a_7854_14462.t43 a_7854_14462.t42 vdd.t1 vdd.t0 pfet_03v3 w=10u l=0.42u ad=2.8000e-12 pd=1.0560e-05 as=2.8000e-12 ps=1.0560e-05 nf=1 m=6 par=6
XMpar9 a_6886_10111.t0 a_7854_14462.t42 vdd.t1 vdd.t0 pfet_03v3 w=10u l=0.42u ad=2.8000e-12 pd=1.0560e-05 as=3.3333e-12 ps=1.2333e-05 nf=1 m=12 par=12
X12 out.t24 vss.t25 cap_mim_2f0fF c_width=17.75u c_length=17.75u
X47 out.t24 vss.t25 cap_mim_2f0fF c_width=17.75u c_length=17.75u
X56 out.t24 vss.t25 cap_mim_2f0fF c_width=17.75u c_length=17.75u
Rpar0 a_1299_10111.t0 a_1299_10111.t1 22.9681
Rpar1 a_1299_10111.t0 a_1299_10111.t12 238.9203
Rpar2 a_1299_10111.t1 a_1299_10111.t12 44.6794
Rpar3 a_2750_14462.t0 a_2750_14462.t84 61.4385
Rpar4 a_6886_10111.t0 a_6886_10111.t10 309.8304
Rpar5 a_6886_10111.t0 a_6886_10111.t11 37.7327
Rpar6 a_6886_10111.t10 a_6886_10111.t11 9.3854
Rpar7 a_7854_14462.t0 a_7854_14462.t42 238.9146
Rpar8 a_7854_14462.t0 a_7854_14462.t43 44.6797
Rpar9 a_7854_14462.t42 a_7854_14462.t43 22.9682
Rpar10 ib ib.t0 25.3021
Rpar11 ib ib.t1 3.7334
Rpar12 ib.t0 ib.t1 17.2170
Rpar13 inn inn.t0 2.6760
Rpar14 inp inp.t0 2.6760
Rpar15 out out.t0 85.9857
Rpar16 out out.t12 46.9787
Rpar17 out out.t24 16.7031
Rpar18 out.t0 out.t12 45.0221
Rpar19 vdd vdd.t0 63.9800
Rpar20 vdd vdd.t1 328.7553
Rpar21 vdd.t0 vdd.t1 2.3718
Rpar22 vss vss.t0 193.1068
Rpar23 vss vss.t22 1163.1713
Rpar24 vss vss.t25 50.9838
Rpar25 vss vss.t64 391.5280
Rpar26 vss vss.t65 37.3709
Rpar27 vss.t0 vss.t22 8.9117
Rpar28 vss.t0 vss.t25 1223.8874
Rpar29 vss.t0 vss.t64 458.5378
Rpar30 vss.t0 vss.t65 136.7916
Rpar31 vss.t22 vss.t25 7372.0389
Rpar32 vss.t22 vss.t65 835.4871
Rpar33 vss.t25 vss.t64 2481.4570
Rpar34 vss.t25 vss.t65 236.8521
Rpar35 vss.t64 vss.t65 13.2782
Cpar0 a_1299_10111.t0 vss 1.73436e-14
Cpar1 a_1299_10111.t1 vss 1.46975e-14
Cpar2 a_1299_10111.t12 vss 2.37312e-14
Cpar3 a_2750_14462.t0 vss 3.56877e-14
Cpar4 a_2750_14462.t84 vss 2.42375e-14
Cpar5 a_6886_10111.t0 vss 1.48959e-14
Cpar6 a_6886_10111.t10 vss 8.77631e-15
Cpar7 a_6886_10111.t11 vss 9.15969e-15
Cpar8 a_7854_14462.t0 vss 2.35839e-14
Cpar9 a_7854_14462.t42 vss 1.72360e-14
Cpar10 a_7854_14462.t43 vss 1.46062e-14
Cpar11 ib out 1.14400e-17
Cpar12 ib vdd 3.19890e-16
Cpar13 ib vss 3.39884e-14
Cpar14 ib.t0 vss 6.62038e-15
Cpar15 ib.t1 vss 2.94659e-15
Cpar16 inn inp 1.00030e-16
Cpar17 inn vdd 2.89900e-17
Cpar18 inn vss 1.99356e-14
Cpar19 inn.t0 vss 5.27579e-15
Cpar20 inp vdd 4.97900e-17
Cpar21 inp vss 1.99328e-14
Cpar22 inp.t0 vss 5.26000e-15
Cpar23 out vdd 2.59315e-14
Cpar24 out vss 4.04884e-14
Cpar25 out.t0 vss 1.81350e-15
Cpar26 out.t12 vss 1.13140e-15
Cpar27 out.t24 vss 3.18247e-14
Cpar28 vdd vss 1.29976e-13
Cpar29 vdd.t0 vss 5.95027e-14
Cpar30 vdd.t1 vss 2.86961e-14
.ends opamp_dut

Vdd vdd 0 1.800000
Vss vss 0 0
Ibias vdd ib 2.500000e-05
Vinp inp 0 DC 0.895000 AC 1 PWL(0 0.895000 3.000000e-09 0.895000 3.300000e-09 0.905000)
Rfb out inn 1m
Cload out 0 2.000000e-13
Xdut vdd vss inp inn out ib opamp_dut
.end
