* opa1000[0722]: 2p/rail_to_rail_1v8_i20u_subth (rail_to_rail, VDD=1.8V, CL=2.0pF, Iref=2.5uA)
.include "pdk_opa.inc"
.temp 27
.option gmin=1e-12 rshunt=1e12 reltol=1e-3 abstol=1e-12 vntol=1e-5 method=gear
* Post-PEX R+C extracted netlist for rail_to_rail_1v8_i20u_subth
.subckt opamp_dut vdd vss inp inn out ib
XMpar0 a_5184_13684.t0 inp.t14 a_992_3840.t0 vdd.t0 pfet_03v3 w=3.79u l=0.65u ad=1.0991e-12 pd=4.4884e-06 as=1.1370e-12 ps=4.6269e-06 nf=1 m=64 par=64
XMpar1 out.t7 ib.t0 vss.t32 vss.t31 nfet_03v3 w=3.68u l=1.2u ad=1.0304e-12 pd=4.2400e-06 as=1.3248e-12 ps=5.3200e-06 nf=1 m=8 par=8
XMpar2 a_2313_1249.t0 inp.t0 a_895_18787.t2 vss.t2 nfet_03v3 w=1.79u l=0.65u ad=5.8303e-13 pd=2.6971e-06 as=5.8303e-13 ps=2.6971e-06 nf=1 m=14 par=14
XMpar3 a_9912_7258.t0 inn.t14 a_992_3840.t0 vdd.t0 pfet_03v3 w=3.79u l=0.65u ad=1.0991e-12 pd=4.4884e-06 as=1.1370e-12 ps=4.6269e-06 nf=1 m=64 par=64
XMpar4 a_10212_3677.t0 inn.t0 a_2313_1249.t0 vss.t2 nfet_03v3 w=1.79u l=0.65u ad=5.8303e-13 pd=2.6971e-06 as=5.8303e-13 ps=2.6971e-06 nf=1 m=14 par=14
XMpar5 a_10212_3677.t14 a_5184_13684.t64 vss.t1 vss.t0 nfet_03v3 w=1.61u l=1.35u ad=4.5080e-13 pd=2.1700e-06 as=4.5080e-13 ps=2.1700e-06 nf=1 m=2 par=2
XMpar6 a_895_18787.t0 a_9912_7258.t64 vss.t1 vss.t0 nfet_03v3 w=1.61u l=1.35u ad=9.6600e-13 pd=4.4200e-06 as=4.5080e-13 ps=2.1700e-06 nf=1 m=2 par=2
XMpar7 a_1112_3632.t0 ib.t0 vss.t32 vss.t31 nfet_03v3 w=3.68u l=1.2u ad=1.0304e-12 pd=4.2400e-06 as=1.0304e-12 ps=4.2400e-06 nf=1 m=2 par=2
XMpar8 out.t1 a_895_18787.t19 vdd.t44 vdd.t43 pfet_03v3 w=10u l=0.6u ad=2.8000e-12 pd=1.0560e-05 as=3.6000e-12 ps=1.3220e-05 nf=1 m=8 par=8
XMpar9 a_992_3840.t128 a_1112_3632.t2 vdd.t46 vdd.t45 pfet_03v3 w=10u l=1.2u ad=6.0000e-12 pd=2.1200e-05 as=2.8000e-12 ps=1.0560e-05 nf=1 m=2 par=2
XMpar10 ib.t1 ib.t0 vss.t32 vss.t31 nfet_03v3 w=3.68u l=1.2u ad=2.2080e-12 pd=8.5600e-06 as=1.0304e-12 ps=4.2400e-06 nf=1 m=2 par=2
XMpar11 a_2313_1249.t28 ib.t0 vss.t32 vss.t31 nfet_03v3 w=3.68u l=1.2u ad=2.2080e-12 pd=8.5600e-06 as=1.0304e-12 ps=4.2400e-06 nf=1 m=2 par=2
XMpar12 a_895_18787.t17 a_10212_3677.t16 vdd.t44 vdd.t43 pfet_03v3 w=10u l=0.6u ad=6.0000e-12 pd=2.1200e-05 as=2.8000e-12 ps=1.0560e-05 nf=1 m=2 par=2
XMpar13 a_1112_3632.t3 a_1112_3632.t2 vdd.t46 vdd.t45 pfet_03v3 w=10u l=1.2u ad=2.8000e-12 pd=1.0560e-05 as=2.8000e-12 ps=1.0560e-05 nf=1 m=2 par=2
XMpar14 a_5184_13684.t65 a_5184_13684.t64 vss.t1 vss.t0 nfet_03v3 w=1.61u l=1.35u ad=9.6600e-13 pd=4.4200e-06 as=4.5080e-13 ps=2.1700e-06 nf=1 m=2 par=2
XMpar15 a_10212_3677.t17 a_10212_3677.t16 vdd.t44 vdd.t43 pfet_03v3 w=10u l=0.6u ad=2.8000e-12 pd=1.0560e-05 as=2.8000e-12 ps=1.0560e-05 nf=1 m=2 par=2
XMpar16 a_9912_7258.t65 a_9912_7258.t64 vss.t1 vss.t0 nfet_03v3 w=1.61u l=1.35u ad=4.5080e-13 pd=2.1700e-06 as=4.5080e-13 ps=2.1700e-06 nf=1 m=2 par=2
X9 a_2579_18787.t1 out.t0 cap_mim_2f0fF c_width=17.42u c_length=17.42u
X65 a_2579_18787.t1 out.t0 cap_mim_2f0fF c_width=17.42u c_length=17.42u
X92 a_2579_18787.t1 out.t0 cap_mim_2f0fF c_width=17.42u c_length=17.42u
X139 a_895_18787.t16 a_2579_18787.t0 vss.t28 ppolyf_u_1k r_width=1u r_length=7.76u
Rpar0 a_10212_3677.t0 a_10212_3677.t14 159.3139
Rpar1 a_10212_3677.t0 a_10212_3677.t16 575.3046
Rpar2 a_10212_3677.t0 a_10212_3677.t17 102.3791
Rpar3 a_10212_3677.t14 a_10212_3677.t16 481.4658
Rpar4 a_10212_3677.t14 a_10212_3677.t17 85.6799
Rpar5 a_10212_3677.t16 a_10212_3677.t17 45.7324
Rpar6 a_1112_3632.t0 a_1112_3632.t2 192.9324
Rpar7 a_1112_3632.t0 a_1112_3632.t3 60.8048
Rpar8 a_1112_3632.t2 a_1112_3632.t3 32.7831
Rpar9 a_2313_1249.t0 a_2313_1249.t28 62.5407
Rpar10 a_2579_18787.t0 a_2579_18787.t1 129.1180
Rpar11 a_5184_13684.t0 a_5184_13684.t64 402.3922
Rpar12 a_5184_13684.t0 a_5184_13684.t65 146.0614
Rpar13 a_5184_13684.t64 a_5184_13684.t65 19.1359
Rpar14 a_895_18787.t0 a_895_18787.t2 178.1399
Rpar15 a_895_18787.t0 a_895_18787.t16 400.9313
Rpar16 a_895_18787.t0 a_895_18787.t17 105.4045
Rpar17 a_895_18787.t0 a_895_18787.t19 141.3727
Rpar18 a_895_18787.t2 a_895_18787.t16 169.0744
Rpar19 a_895_18787.t2 a_895_18787.t17 260.7126
Rpar20 a_895_18787.t2 a_895_18787.t19 349.6783
Rpar21 a_895_18787.t16 a_895_18787.t17 586.7739
Rpar22 a_895_18787.t16 a_895_18787.t19 787.0048
Rpar23 a_895_18787.t17 a_895_18787.t19 119.2260
Rpar24 a_9912_7258.t0 a_9912_7258.t64 177.7179
Rpar25 a_9912_7258.t0 a_9912_7258.t65 106.5810
Rpar26 a_9912_7258.t64 a_9912_7258.t65 25.6456
Rpar27 a_992_3840.t0 a_992_3840.t128 52.0213
Rpar28 ib ib.t0 29.7413
Rpar29 ib ib.t1 5.7391
Rpar30 ib.t0 ib.t1 37.6741
Rpar31 inn inn.t0 3.7899
Rpar32 inn inn.t14 45.4304
Rpar33 inp inp.t0 3.7899
Rpar34 inp inp.t14 74.9738
Rpar35 out out.t0 370.0064
Rpar36 out out.t1 221.5217
Rpar37 out out.t7 3.0269
Rpar38 out.t0 out.t1 212.3028
Rpar39 out.t0 out.t7 183.1676
Rpar40 out.t1 out.t7 109.6619
Rpar41 vdd vdd.t0 66.9806
Rpar42 vdd vdd.t43 178.7496
Rpar43 vdd vdd.t44 601.7889
Rpar44 vdd vdd.t45 789.6671
Rpar45 vdd vdd.t46 2551.3875
Rpar46 vdd.t0 vdd.t43 87.3264
Rpar47 vdd.t0 vdd.t44 293.9983
Rpar48 vdd.t0 vdd.t45 385.7844
Rpar49 vdd.t0 vdd.t46 1246.4562
Rpar50 vdd.t43 vdd.t44 4.0416
Rpar51 vdd.t43 vdd.t45 31.5517
Rpar52 vdd.t43 vdd.t46 101.9426
Rpar53 vdd.t44 vdd.t45 88.1984
Rpar54 vdd.t44 vdd.t46 284.9661
Rpar55 vdd.t45 vdd.t46 9.7577
Rpar56 vss vss.t0 168.0712
Rpar57 vss vss.t1 240.0386
Rpar58 vss vss.t2 90.7041
Rpar59 vss vss.t28 559.9434
Rpar60 vss vss.t31 79.0388
Rpar61 vss vss.t32 259.9046
Rpar62 vss.t0 vss.t1 9.6016
Rpar63 vss.t0 vss.t2 2.9174
Rpar64 vss.t0 vss.t28 415.4631
Rpar65 vss.t0 vss.t31 248.1107
Rpar66 vss.t0 vss.t32 816.8433
Rpar67 vss.t1 vss.t2 7.5312
Rpar68 vss.t1 vss.t28 691.8511
Rpar69 vss.t1 vss.t31 382.2451
Rpar70 vss.t2 vss.t28 176.7911
Rpar71 vss.t2 vss.t31 118.5032
Rpar72 vss.t2 vss.t32 390.2294
Rpar73 vss.t28 vss.t31 756.5170
Rpar74 vss.t28 vss.t32 2757.6697
Rpar75 vss.t31 vss.t32 4.3453
Cpar0 a_10212_3677.t0 vss 7.10574e-15
Cpar1 a_10212_3677.t14 vss 3.01616e-15
Cpar2 a_10212_3677.t16 vss 5.11624e-15
Cpar3 a_10212_3677.t17 vss 7.14316e-15
Cpar4 a_1112_3632.t0 vss 2.87769e-15
Cpar5 a_1112_3632.t2 vss 6.18228e-15
Cpar6 a_1112_3632.t3 vss 3.93959e-15
Cpar7 a_2313_1249.t0 vss 1.52756e-14
Cpar8 a_2313_1249.t28 vss 1.26445e-14
Cpar9 a_2579_18787.t0 vss 3.22890e-16
Cpar10 a_2579_18787.t1 vss 1.70598e-14
Cpar11 a_5184_13684.t0 vss 6.24217e-14
Cpar12 a_5184_13684.t64 vss 6.51849e-15
Cpar13 a_5184_13684.t65 vss 7.14198e-15
Cpar14 a_895_18787.t0 vss 4.41040e-15
Cpar15 a_895_18787.t16 vss 4.12308e-15
Cpar16 a_895_18787.t17 vss 8.54047e-15
Cpar17 a_895_18787.t19 vss 1.12846e-14
Cpar18 a_895_18787.t2 vss 7.66717e-15
Cpar19 a_9912_7258.t0 vss 5.89908e-14
Cpar20 a_9912_7258.t64 vss 6.42538e-15
Cpar21 a_9912_7258.t65 vss 4.05314e-15
Cpar22 a_992_3840.t0 vss 1.11975e-13
Cpar23 a_992_3840.t128 vss 1.11346e-14
Cpar24 ib out 1.57332e-15
Cpar25 ib vss 1.71738e-14
Cpar26 ib.t0 vss 6.32576e-15
Cpar27 ib.t1 vss 1.18687e-15
Cpar28 inn inp 2.04020e-16
Cpar29 inn vdd 2.68446e-14
Cpar30 inn vss 1.40779e-14
Cpar31 inn.t0 vss 4.83224e-15
Cpar32 inn.t14 vss 4.61923e-14
Cpar33 inp out 2.92900e-17
Cpar34 inp vdd 2.74274e-14
Cpar35 inp vss 1.56156e-14
Cpar36 inp.t0 vss 5.02883e-15
Cpar37 inp.t14 vss 4.86711e-14
Cpar38 out vdd 1.31559e-14
Cpar39 out vss 2.10820e-14
Cpar40 out.t0 vss 1.90020e-14
Cpar41 out.t1 vss 7.11370e-15
Cpar42 out.t7 vss 3.68573e-15
Cpar43 vdd vss 2.91546e-13
Cpar44 vdd.t0 vss 8.31089e-14
Cpar45 vdd.t43 vss 1.79486e-14
Cpar46 vdd.t44 vss 1.07942e-14
Cpar47 vdd.t45 vss 9.55364e-15
Cpar48 vdd.t46 vss 4.39264e-15
.ends opamp_dut

Vdd vdd 0 1.800000
Vss vss 0 0
Ibias vdd ib 2.500000e-06
Vinp inp 0 DC 0.895000 AC 1 PWL(0 0.895000 2.178836e-08 0.895000 2.396720e-08 0.905000)
Rfb out inn 1m
Cload out 0 2.000000e-12
Xdut vdd vss inp inn out ib opamp_dut
.end
