* opa1000[0585]: 200f/pmos_miller_1v8_ulp_lt0p1uw_weak (pmos_miller, VDD=1.8V, CL=0.2pF, Iref=0.0011uA)
.include "pdk_opa.inc"
.temp 27
.option gmin=1e-12 rshunt=1e12 reltol=1e-3 abstol=1e-12 vntol=1e-5 method=gear
* Post-PEX R+C extracted netlist for pmos_miller_1v8_ulp_lt0p1uw_weak
.subckt opamp_dut vdd vss inp inn out ib
XMpar0 a_5126_1249.t0 inp.t0 a_926_6827.t0 vdd.t2 pfet_03v3 w=0.4u l=9.5u ad=2.4000e-13 pd=2.0000e-06 as=2.4000e-13 ps=2.0000e-06 nf=1 m=2 par=2
XMpar1 out.t0 a_1814_1041.t0 vdd.t1 vdd.t0 pfet_03v3 w=0.4u l=8u ad=1.8880e-13 pd=1.5840e-06 as=1.6320e-13 ps=1.3760e-06 nf=1 m=10 par=10
XMpar2 out.t1 a_926_6827.t5 vss.t2 vss.t1 nfet_03v3 w=0.4u l=9.5u ad=1.3760e-13 pd=1.1680e-06 as=1.3760e-13 ps=1.1680e-06 nf=1 m=10 par=10
XMpar3 a_5126_1249.t0 inn.t0 a_7170_9597.t4 vdd.t2 pfet_03v3 w=0.4u l=9.5u ad=2.4000e-13 pd=2.0000e-06 as=2.4000e-13 ps=2.0000e-06 nf=1 m=2 par=2
XMpar4 a_926_6827.t2 a_7170_9597.t0 vss.t2 vss.t1 nfet_03v3 w=0.4u l=9.5u ad=2.4000e-13 pd=2.0000e-06 as=1.1200e-13 ps=9.6000e-07 nf=1 m=2 par=2
XMpar5 a_7170_9597.t1 a_7170_9597.t0 vss.t2 vss.t1 nfet_03v3 w=0.4u l=9.5u ad=2.4000e-13 pd=2.0000e-06 as=1.1200e-13 ps=9.6000e-07 nf=1 m=2 par=2
XMpar6 a_1814_1041.t4 ib.t0 vss.t15 vss.t14 nfet_03v3 w=0.4u l=8u ad=2.4000e-13 pd=2.0000e-06 as=1.1200e-13 ps=9.6000e-07 nf=1 m=2 par=2
XMpar7 a_1814_1041.t1 a_1814_1041.t0 vdd.t1 vdd.t0 pfet_03v3 w=0.4u l=8u ad=2.4000e-13 pd=2.0000e-06 as=1.1200e-13 ps=9.6000e-07 nf=1 m=2 par=2
XMpar8 ib.t1 ib.t0 vss.t15 vss.t14 nfet_03v3 w=0.4u l=8u ad=2.4000e-13 pd=2.0000e-06 as=1.1200e-13 ps=9.6000e-07 nf=1 m=2 par=2
XMpar9 a_5126_1249.t2 a_1814_1041.t0 vdd.t1 vdd.t0 pfet_03v3 w=0.4u l=8u ad=2.4000e-13 pd=2.0000e-06 as=1.1200e-13 ps=9.6000e-07 nf=1 m=4 par=4
X0 a_926_11507.t0 a_4904_10987.t0 vss.t0 ppolyf_u_1k r_width=1u r_length=19.23u
X5 a_926_8387.t0 a_4904_7867.t0 vss.t0 ppolyf_u_1k r_width=1u r_length=19.23u
X10 a_926_7347.t0 a_4904_7867.t0 vss.t0 ppolyf_u_1k r_width=1u r_length=19.23u
X19 a_926_10467.t0 a_4904_10987.t0 vss.t0 ppolyf_u_1k r_width=1u r_length=19.23u
X20 a_926_7347.t0 a_4904_6827.t0 vss.t0 ppolyf_u_1k r_width=1u r_length=19.23u
X21 a_926_9427.t0 a_4904_9947.t0 vss.t0 ppolyf_u_1k r_width=1u r_length=19.23u
X24 a_926_6827.t4 a_4904_6827.t0 vss.t0 ppolyf_u_1k r_width=1u r_length=19.23u
X30 a_926_10467.t0 a_4904_9947.t0 vss.t0 ppolyf_u_1k r_width=1u r_length=19.23u
X31 a_4904_13067.t1 out.t18 cap_mim_2f0fF c_width=19.62u c_length=19.63u
X33 a_926_9427.t0 a_4904_8907.t0 vss.t0 ppolyf_u_1k r_width=1u r_length=19.23u
X37 a_926_12547.t0 a_4904_13067.t0 vss.t0 ppolyf_u_1k r_width=1u r_length=19.23u
X39 a_926_8387.t0 a_4904_8907.t0 vss.t0 ppolyf_u_1k r_width=1u r_length=19.23u
X40 a_926_12547.t0 a_4904_12027.t0 vss.t0 ppolyf_u_1k r_width=1u r_length=19.23u
X46 a_926_11507.t0 a_4904_12027.t0 vss.t0 ppolyf_u_1k r_width=1u r_length=19.23u
Rpar0 a_1814_1041.t0 a_1814_1041.t1 18.7352
Rpar1 a_1814_1041.t0 a_1814_1041.t4 176.3165
Rpar2 a_1814_1041.t1 a_1814_1041.t4 133.9819
Rpar3 a_4904_13067.t0 a_4904_13067.t1 71.2625
Rpar4 a_5126_1249.t0 a_5126_1249.t2 57.3370
Rpar5 a_7170_9597.t0 a_7170_9597.t1 18.0203
Rpar6 a_7170_9597.t0 a_7170_9597.t4 102.3875
Rpar7 a_7170_9597.t1 a_7170_9597.t4 93.0662
Rpar8 a_926_6827.t0 a_926_6827.t5 149.0183
Rpar9 a_926_6827.t0 a_926_6827.t2 414.3825
Rpar10 a_926_6827.t0 a_926_6827.t4 147.4294
Rpar11 a_926_6827.t5 a_926_6827.t2 69.0192
Rpar12 a_926_6827.t5 a_926_6827.t4 60.0693
Rpar13 a_926_6827.t2 a_926_6827.t4 167.0378
Rpar14 ib ib.t0 9.6876
Rpar15 ib ib.t1 11.7983
Rpar16 ib.t0 ib.t1 44.0529
Rpar17 inn inn.t0 4.0671
Rpar18 inp inp.t0 4.0668
Rpar19 out out.t0 91.7328
Rpar20 out out.t1 87.8312
Rpar21 out out.t18 20.6981
Rpar22 out.t0 out.t1 219.1829
Rpar23 out.t0 out.t18 925.2190
Rpar24 out.t1 out.t18 885.8679
Rpar25 vdd vdd.t0 189.3053
Rpar26 vdd vdd.t1 2026.2499
Rpar27 vdd vdd.t2 102.0588
Rpar28 vdd.t0 vdd.t1 13.1722
Rpar29 vdd.t0 vdd.t2 60.6574
Rpar30 vdd.t1 vdd.t2 649.2534
Rpar31 vss vss.t0 286.8378
Rpar32 vss vss.t1 103.7528
Rpar33 vss vss.t2 971.9589
Rpar34 vss vss.t14 273.3452
Rpar35 vss vss.t15 515.5553
Rpar36 vss.t0 vss.t1 5.1306
Rpar37 vss.t0 vss.t2 53.2535
Rpar38 vss.t0 vss.t14 14.7415
Rpar39 vss.t0 vss.t15 116.9449
Rpar40 vss.t1 vss.t2 12.6348
Rpar41 vss.t1 vss.t14 2.9675
Rpar42 vss.t1 vss.t15 25.7199
Rpar43 vss.t2 vss.t14 29.0031
Rpar44 vss.t2 vss.t15 234.8186
Rpar45 vss.t14 vss.t15 46.9431
Cpar0 a_1814_1041.t0 vss 7.80044e-14
Cpar1 a_1814_1041.t1 vss 1.35443e-14
Cpar2 a_1814_1041.t4 vss 1.22554e-14
Cpar3 a_4904_10987.t0 vss 3.21400e-17
Cpar4 a_4904_12027.t0 vss 3.59200e-17
Cpar5 a_4904_13067.t0 vss 1.05310e-16
Cpar6 a_4904_13067.t1 vss 3.15381e-15
Cpar7 a_4904_6827.t0 vss 3.10200e-17
Cpar8 a_4904_7867.t0 vss 3.14600e-17
Cpar9 a_4904_8907.t0 vss 2.93600e-17
Cpar10 a_4904_9947.t0 vss 2.96800e-17
Cpar11 a_5126_1249.t0 vss 1.50482e-14
Cpar12 a_5126_1249.t2 vss 2.83053e-14
Cpar13 a_7170_9597.t0 vss 8.91339e-15
Cpar14 a_7170_9597.t1 vss 2.35366e-15
Cpar15 a_7170_9597.t4 vss 2.23213e-15
Cpar16 a_926_10467.t0 vss 3.65400e-17
Cpar17 a_926_11507.t0 vss 3.72800e-17
Cpar18 a_926_12547.t0 vss 3.75200e-17
Cpar19 a_926_6827.t0 vss 1.27782e-15
Cpar20 a_926_6827.t2 vss 1.78998e-15
Cpar21 a_926_6827.t4 vss 1.16674e-15
Cpar22 a_926_6827.t5 vss 9.55070e-15
Cpar23 a_926_7347.t0 vss 4.01400e-17
Cpar24 a_926_8387.t0 vss 3.65400e-17
Cpar25 a_926_9427.t0 vss 3.65400e-17
Cpar26 ib inp 1.62700e-17
Cpar27 ib vdd 1.40260e-16
Cpar28 ib vss 2.46726e-14
Cpar29 ib.t0 vss 3.50200e-15
Cpar30 ib.t1 vss 3.60974e-16
Cpar31 inn inp 1.03420e-16
Cpar32 inn vdd 8.21268e-15
Cpar33 inn vss 4.93882e-15
Cpar34 inn.t0 vss 5.95464e-15
Cpar35 inp vdd 8.02133e-15
Cpar36 inp vss 4.85539e-15
Cpar37 inp.t0 vss 5.87473e-15
Cpar38 out vdd 2.13659e-14
Cpar39 out vss 3.80070e-14
Cpar40 out.t0 vss 1.47906e-14
Cpar41 out.t1 vss 1.04966e-14
Cpar42 out.t18 vss 1.08846e-14
Cpar43 vdd vss 2.15956e-13
Cpar44 vdd.t0 vss 8.64294e-14
Cpar45 vdd.t1 vss 1.23768e-14
Cpar46 vdd.t2 vss 2.05502e-14
.ends opamp_dut

Vdd vdd 0 1.800000
Vss vss 0 0
Ibias vdd ib 1.100000e-09
Vinp inp 0 DC 0.805000 AC 1 PWL(0 0.805000 1.894739e-05 0.805000 2.084213e-05 0.815000)
Rfb out inn 1m
Cload out 0 2.000000e-13
Xdut vdd vss inp inn out ib opamp_dut
.end
