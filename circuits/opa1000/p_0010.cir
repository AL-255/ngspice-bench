* opa1000[0010]: 200f/cherry_hooper_1v8_1u_10u_weak (cherry_hooper, VDD=1.8V, CL=0.2pF, Iref=0.2125uA)
.include "pdk_opa.inc"
.temp 27
.option gmin=1e-12 rshunt=1e12 reltol=1e-3 abstol=1e-12 vntol=1e-5 method=gear
* Post-PEX R+C extracted netlist for cherry_hooper_1v8_1u_10u_weak
.subckt opamp_dut vdd vss inp inn out ib
XMpar0 a_9370_13551.t6 a_1382_13388.t33 a_9690_13551.t3 vdd.t12 pfet_03v3 w=7.22u l=1u ad=2.2783e-12 pd=8.6533e-06 as=2.2783e-12 ps=8.6533e-06 nf=1 m=9 par=9
XMpar1 a_2076_4491.t1 ib.t0 vss.t10 vss.t9 nfet_03v3 w=0.51u l=2.5u ad=1.4280e-13 pd=1.0700e-06 as=2.2440e-13 ps=1.6450e-06 nf=1 m=8 par=8
XMpar2 a_2076_4491.t0 a_12494_7323.t16 out.t4 vss.t4 nfet_03v3 w=8.88u l=0.5u ad=5.3280e-12 pd=1.8960e-05 as=5.3280e-12 ps=1.8960e-05 nf=1 m=1
XMpar3 a_9690_13551.t2 a_1276_7115.t0 vdd.t1 vdd.t0 pfet_03v3 w=1.31u l=2.5u ad=3.6680e-13 pd=1.8700e-06 as=7.8600e-13 ps=3.8200e-06 nf=1 m=2 par=2
XMpar4 a_12494_13551.t3 a_1382_13388.t33 a_12494_7323.t0 vdd.t12 pfet_03v3 w=7.22u l=1u ad=2.2783e-12 pd=8.6533e-06 as=2.2783e-12 ps=8.6533e-06 nf=1 m=9 par=9
XMpar5 a_1262_13596.t9 a_1262_13596.t8 vdd.t3 vdd.t2 pfet_03v3 w=1.6u l=0.6u ad=9.6000e-13 pd=4.4000e-06 as=9.6000e-13 ps=4.4000e-06 nf=1 m=1
XMpar6 a_11668_4282.t2 a_11668_4282.t1 vdd.t3 vdd.t2 pfet_03v3 w=1.6u l=0.6u ad=4.4800e-13 pd=2.1600e-06 as=7.0400e-13 ps=3.2800e-06 nf=1 m=4 par=4
XMpar7 a_12494_13551.t1 inn.t0 a_3816_7322.t0 vss.t0 nfet_03v3 w=1.04u l=1.6u ad=2.9120e-13 pd=1.6000e-06 as=6.2400e-13 ps=3.2800e-06 nf=1 m=2 par=2
XMpar8 a_3984_8703.t2 ib.t0 vss.t10 vss.t9 nfet_03v3 w=0.51u l=2.5u ad=2.5160e-13 pd=1.8367e-06 as=1.9720e-13 ps=1.4533e-06 nf=1 m=6 par=6
XMpar9 a_3816_7322.t0 inp.t0 a_9690_13551.t0 vss.t0 nfet_03v3 w=1.04u l=1.6u ad=6.2400e-13 pd=3.2800e-06 as=2.9120e-13 ps=1.6000e-06 nf=1 m=2 par=2
XMpar10 a_1262_13596.t0 a_1382_13388.t0 a_1382_13388.t1 vdd.t22 pfet_03v3 w=10u l=0.6u ad=3.2000e-12 pd=1.1890e-05 as=2.8000e-12 ps=1.0560e-05 nf=1 m=16 par=16
XMpar11 a_9370_13551.t1 a_9370_13551.t0 vdd.t3 vdd.t2 pfet_03v3 w=1.6u l=0.6u ad=6.1867e-13 pd=2.9067e-06 as=6.1867e-13 ps=2.9067e-06 nf=1 m=3 par=3
XMpar12 a_12494_7323.t9 a_12494_7323.t8 vdd.t3 vdd.t2 pfet_03v3 w=1.6u l=0.6u ad=6.1867e-13 pd=2.9067e-06 as=6.1867e-13 ps=2.9067e-06 nf=1 m=3 par=3
XMpar13 out.t0 a_11668_4282.t1 vdd.t3 vdd.t2 pfet_03v3 w=1.6u l=0.6u ad=4.4800e-13 pd=2.1600e-06 as=4.4800e-13 ps=2.1600e-06 nf=1 m=4 par=4
XMpar14 a_3816_7322.t4 ib.t0 vss.t10 vss.t9 nfet_03v3 w=0.51u l=2.5u ad=3.0600e-13 pd=2.2200e-06 as=1.4280e-13 ps=1.0700e-06 nf=1 m=4 par=4
XMpar15 a_3984_8703.t0 a_9690_13551.t13 a_9370_13551.t15 vss.t5 nfet_03v3 w=6.66u l=0.5u ad=3.9960e-12 pd=1.4520e-05 as=3.9960e-12 ps=1.4520e-05 nf=1 m=1
XMpar16 a_12494_13551.t0 a_1276_7115.t0 vdd.t1 vdd.t0 pfet_03v3 w=1.31u l=2.5u ad=3.6680e-13 pd=1.8700e-06 as=7.8600e-13 ps=3.8200e-06 nf=1 m=2 par=2
XMpar17 a_1276_7115.t1 a_1276_7115.t0 vdd.t1 vdd.t0 pfet_03v3 w=1.31u l=2.5u ad=7.8600e-13 pd=3.8200e-06 as=7.8600e-13 ps=3.8200e-06 nf=1 m=1
XMpar18 a_1382_13388.t32 ib.t0 vss.t10 vss.t9 nfet_03v3 w=0.51u l=2.5u ad=3.0600e-13 pd=2.2200e-06 as=3.0600e-13 ps=2.2200e-06 nf=1 m=1
XMpar19 a_12494_7323.t14 a_12494_13551.t13 a_3984_8703.t0 vss.t5 nfet_03v3 w=6.66u l=0.5u ad=3.9960e-12 pd=1.4520e-05 as=3.9960e-12 ps=1.4520e-05 nf=1 m=1
XMpar20 ib.t1 ib.t0 vss.t10 vss.t9 nfet_03v3 w=0.51u l=2.5u ad=3.0600e-13 pd=2.2200e-06 as=1.4280e-13 ps=1.0700e-06 nf=1 m=1
XMpar21 a_1276_7115.t2 ib.t0 vss.t10 vss.t9 nfet_03v3 w=0.51u l=2.5u ad=3.0600e-13 pd=2.2200e-06 as=1.4280e-13 ps=1.0700e-06 nf=1 m=1
XMpar22 a_11668_4282.t0 a_9370_13551.t16 a_2076_4491.t0 vss.t4 nfet_03v3 w=8.88u l=0.5u ad=5.3280e-12 pd=1.8960e-05 as=5.3280e-12 ps=1.8960e-05 nf=1 m=1
X38 out.t5 vss.t7 cap_mim_2f0fF c_width=20u c_length=20u
X39 out.t5 vss.t7 cap_mim_2f0fF c_width=20u c_length=20u
X83 out.t5 vss.t7 cap_mim_2f0fF c_width=20u c_length=20u
X85 out.t5 vss.t7 cap_mim_2f0fF c_width=20u c_length=20u
Rpar0 a_11668_4282.t0 a_11668_4282.t1 227.0136
Rpar1 a_11668_4282.t0 a_11668_4282.t2 79.3427
Rpar2 a_11668_4282.t1 a_11668_4282.t2 20.1375
Rpar3 a_12494_13551.t0 a_12494_13551.t1 290.0945
Rpar4 a_12494_13551.t0 a_12494_13551.t3 53.5594
Rpar5 a_12494_13551.t0 a_12494_13551.t13 877.1226
Rpar6 a_12494_13551.t1 a_12494_13551.t3 101.7332
Rpar7 a_12494_13551.t1 a_12494_13551.t13 218.2528
Rpar8 a_12494_13551.t3 a_12494_13551.t13 307.5979
Rpar9 a_12494_7323.t0 a_12494_7323.t8 306.3246
Rpar10 a_12494_7323.t0 a_12494_7323.t9 70.4011
Rpar11 a_12494_7323.t0 a_12494_7323.t14 225.6765
Rpar12 a_12494_7323.t0 a_12494_7323.t16 999.5818
Rpar13 a_12494_7323.t8 a_12494_7323.t9 29.5533
Rpar14 a_12494_7323.t8 a_12494_7323.t14 479.3465
Rpar15 a_12494_7323.t8 a_12494_7323.t16 2123.1541
Rpar16 a_12494_7323.t9 a_12494_7323.t14 110.1659
Rpar17 a_12494_7323.t9 a_12494_7323.t16 487.9545
Rpar18 a_12494_7323.t14 a_12494_7323.t16 238.8705
Rpar19 a_1262_13596.t0 a_1262_13596.t8 221.3821
Rpar20 a_1262_13596.t0 a_1262_13596.t9 49.0613
Rpar21 a_1262_13596.t8 a_1262_13596.t9 63.2727
Rpar22 a_1276_7115.t0 a_1276_7115.t1 31.5997
Rpar23 a_1276_7115.t0 a_1276_7115.t2 118.6226
Rpar24 a_1276_7115.t1 a_1276_7115.t2 210.9670
Rpar25 a_1382_13388.t0 a_1382_13388.t1 18.7879
Rpar26 a_1382_13388.t0 a_1382_13388.t32 6031.0179
Rpar27 a_1382_13388.t0 a_1382_13388.t33 3351.6282
Rpar28 a_1382_13388.t1 a_1382_13388.t32 125.7825
Rpar29 a_1382_13388.t1 a_1382_13388.t33 69.9013
Rpar30 a_1382_13388.t32 a_1382_13388.t33 178.5042
Rpar31 a_2076_4491.t0 a_2076_4491.t1 74.0935
Rpar32 a_3816_7322.t0 a_3816_7322.t4 53.9333
Rpar33 a_3984_8703.t0 a_3984_8703.t2 49.5092
Rpar34 a_9370_13551.t0 a_9370_13551.t1 29.5533
Rpar35 a_9370_13551.t0 a_9370_13551.t6 306.3246
Rpar36 a_9370_13551.t0 a_9370_13551.t15 479.3465
Rpar37 a_9370_13551.t0 a_9370_13551.t16 2123.1541
Rpar38 a_9370_13551.t1 a_9370_13551.t6 70.4011
Rpar39 a_9370_13551.t1 a_9370_13551.t15 110.1659
Rpar40 a_9370_13551.t1 a_9370_13551.t16 487.9545
Rpar41 a_9370_13551.t6 a_9370_13551.t15 225.6765
Rpar42 a_9370_13551.t6 a_9370_13551.t16 999.5818
Rpar43 a_9370_13551.t15 a_9370_13551.t16 238.8705
Rpar44 a_9690_13551.t0 a_9690_13551.t3 101.7332
Rpar45 a_9690_13551.t0 a_9690_13551.t2 290.0945
Rpar46 a_9690_13551.t0 a_9690_13551.t13 218.2528
Rpar47 a_9690_13551.t3 a_9690_13551.t2 53.5594
Rpar48 a_9690_13551.t3 a_9690_13551.t13 307.5979
Rpar49 a_9690_13551.t2 a_9690_13551.t13 877.1226
Rpar50 ib ib.t0 2.2394
Rpar51 ib ib.t1 272.8507
Rpar52 ib.t0 ib.t1 26.5611
Rpar53 inn inn.t0 5.4223
Rpar54 inp inp.t0 5.4709
Rpar55 out out.t0 94.1653
Rpar56 out out.t4 178.0985
Rpar57 out out.t5 18.4396
Rpar58 out.t0 out.t4 51.4630
Rpar59 out.t0 out.t5 361.1984
Rpar60 out.t4 out.t5 683.1482
Rpar61 vdd vdd.t0 266.7435
Rpar62 vdd vdd.t1 78.5621
Rpar63 vdd vdd.t2 201.4640
Rpar64 vdd vdd.t3 117.3432
Rpar65 vdd vdd.t12 326.2916
Rpar66 vdd vdd.t22 240.2055
Rpar67 vdd.t0 vdd.t1 11.4854
Rpar68 vdd.t0 vdd.t2 708.3429
Rpar69 vdd.t0 vdd.t3 369.3313
Rpar70 vdd.t0 vdd.t12 1440.8163
Rpar71 vdd.t0 vdd.t22 560.6600
Rpar72 vdd.t1 vdd.t2 242.4574
Rpar73 vdd.t1 vdd.t3 128.8681
Rpar74 vdd.t1 vdd.t12 471.2953
Rpar75 vdd.t1 vdd.t22 204.3698
Rpar76 vdd.t2 vdd.t3 3.1061
Rpar77 vdd.t2 vdd.t12 54.8897
Rpar78 vdd.t2 vdd.t22 160.0066
Rpar79 vdd.t3 vdd.t12 39.4600
Rpar80 vdd.t3 vdd.t22 76.6916
Rpar81 vdd.t12 vdd.t22 414.3107
Rpar82 vss vss.t0 214.3407
Rpar83 vss vss.t10 123.1009
Rpar84 vss vss.t9 62.9598
Rpar85 vss vss.t4 72.7001
Rpar86 vss vss.t5 291.9241
Rpar87 vss vss.t7 67.8311
Rpar88 vss.t0 vss.t9 955.9497
Rpar89 vss.t0 vss.t4 184.9003
Rpar90 vss.t0 vss.t5 9.9811
Rpar91 vss.t0 vss.t7 1045.6852
Rpar92 vss.t10 vss.t9 3.8290
Rpar93 vss.t10 vss.t4 961.0105
Rpar94 vss.t10 vss.t7 903.3349
Rpar95 vss.t9 vss.t4 483.9550
Rpar96 vss.t9 vss.t5 1358.1324
Rpar97 vss.t9 vss.t7 461.7453
Rpar98 vss.t4 vss.t5 253.4332
Rpar99 vss.t4 vss.t7 354.5720
Rpar100 vss.t5 vss.t7 1424.1324
Cpar0 a_11668_4282.t0 vss 4.82095e-15
Cpar1 a_11668_4282.t1 vss 5.05019e-15
Cpar2 a_11668_4282.t2 vss 3.23005e-15
Cpar3 a_12494_13551.t0 vss 2.23332e-15
Cpar4 a_12494_13551.t1 vss 3.05280e-15
Cpar5 a_12494_13551.t13 vss 1.47136e-15
Cpar6 a_12494_13551.t3 vss 1.44250e-14
Cpar7 a_12494_7323.t0 vss 1.14566e-14
Cpar8 a_12494_7323.t14 vss 4.85997e-15
Cpar9 a_12494_7323.t16 vss 1.45846e-15
Cpar10 a_12494_7323.t8 vss 1.67920e-15
Cpar11 a_12494_7323.t9 vss 3.48175e-15
Cpar12 a_1262_13596.t0 vss 3.13237e-14
Cpar13 a_1262_13596.t8 vss 7.67854e-16
Cpar14 a_1262_13596.t9 vss 1.96713e-15
Cpar15 a_1276_7115.t0 vss 1.21000e-14
Cpar16 a_1276_7115.t1 vss 2.78455e-15
Cpar17 a_1276_7115.t2 vss 3.68630e-15
Cpar18 a_1382_13388.t0 vss 1.55778e-14
Cpar19 a_1382_13388.t1 vss 2.44828e-14
Cpar20 a_1382_13388.t32 vss 4.07137e-15
Cpar21 a_1382_13388.t33 vss 2.57080e-14
Cpar22 a_2076_4491.t0 vss 3.52707e-15
Cpar23 a_2076_4491.t1 vss 2.64843e-15
Cpar24 a_3816_7322.t0 vss 2.77972e-15
Cpar25 a_3816_7322.t4 vss 6.16311e-15
Cpar26 a_3984_8703.t0 vss 4.51818e-15
Cpar27 a_3984_8703.t2 vss 5.81413e-15
Cpar28 a_9370_13551.t0 vss 2.05362e-15
Cpar29 a_9370_13551.t1 vss 4.25812e-15
Cpar30 a_9370_13551.t15 vss 5.94364e-15
Cpar31 a_9370_13551.t16 vss 1.78367e-15
Cpar32 a_9370_13551.t6 vss 1.40112e-14
Cpar33 a_9690_13551.t0 vss 3.27997e-15
Cpar34 a_9690_13551.t13 vss 1.58085e-15
Cpar35 a_9690_13551.t2 vss 2.39952e-15
Cpar36 a_9690_13551.t3 vss 1.54983e-14
Cpar37 ib vdd 4.45110e-16
Cpar38 ib vss 4.34922e-14
Cpar39 ib.t0 vss 5.65466e-15
Cpar40 ib.t1 vss 3.71632e-16
Cpar41 inn inp 5.19700e-17
Cpar42 inn out 2.58200e-17
Cpar43 inn vss 2.34161e-15
Cpar44 inn.t0 vss 2.97261e-16
Cpar45 inp vss 2.30154e-15
Cpar46 inp.t0 vss 2.97893e-16
Cpar47 out vdd 2.90905e-15
Cpar48 out vss 3.33194e-14
Cpar49 out.t0 vss 5.54482e-17
Cpar50 out.t4 vss 7.32575e-17
Cpar51 out.t5 vss 9.59260e-15
Cpar52 vdd vss 1.90781e-13
Cpar53 vdd.t0 vss 4.99256e-15
Cpar54 vdd.t1 vss 6.77479e-15
Cpar55 vdd.t12 vss 2.29854e-14
Cpar56 vdd.t2 vss 1.01298e-14
Cpar57 vdd.t22 vss 1.96398e-14
Cpar58 vdd.t3 vss 9.10691e-15
.ends opamp_dut

Vdd vdd 0 1.800000
Vss vss 0 0
Ibias vdd ib 2.125000e-07
Vinp inp 0 DC 1.199500 AC 1 PWL(0 1.199500 3.796322e-08 1.199500 4.175954e-08 1.209500)
Rfb out inn 1m
Cload out 0 2.000000e-13
Xdut vdd vss inp inn out ib opamp_dut
.end
