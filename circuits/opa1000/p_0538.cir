* opa1000[0538]: 200f/pmos_5t_3v3_i150u_weak (pmos_5t, VDD=3.3V, CL=0.2pF, Iref=25.5uA)
.include "pdk_opa.inc"
.temp 27
.option gmin=1e-12 rshunt=1e12 reltol=1e-3 abstol=1e-12 vntol=1e-5 method=gear
* Post-PEX R+C extracted netlist for pmos_5t_3v3_i150u_weak
.subckt opamp_dut vdd vss inp inn out ib
XMpar0 a_1482_1205.t9 inp.t0 a_1738_1205.t0 vdd.t22 pfet_03v3 w=3.29u l=0.68u ad=9.7384e-13 pd=4.0465e-06 as=9.4752e-13 ps=3.9482e-06 nf=1 m=160 par=160
XMpar1 a_1482_1205.t9 inn.t0 out.t0 vdd.t22 pfet_03v3 w=3.29u l=0.68u ad=9.7384e-13 pd=4.0465e-06 as=9.4752e-13 ps=3.9482e-06 nf=1 m=160 par=160
XMpar2 a_1738_1205.t161 a_1738_1205.t160 vss.t27 vss.t26 nfet_03v3 w=1.98u l=1.05u ad=6.4491e-13 pd=2.9143e-06 as=5.5440e-13 ps=2.5400e-06 nf=1 m=14 par=14
XMpar3 ib.t1 ib.t0 vss.t1 vss.t0 nfet_03v3 w=1.76u l=0.52u ad=6.8053e-13 pd=3.1200e-06 as=4.9280e-13 ps=2.3200e-06 nf=1 m=6 par=6
XMpar4 a_1482_1205.t0 a_1631_11948.t0 vdd.t1 vdd.t0 pfet_03v3 w=6.39u l=0.52u ad=1.7892e-12 pd=6.9500e-06 as=1.9596e-12 ps=7.5358e-06 nf=1 m=24 par=24
XMpar5 a_1631_11948.t12 ib.t0 vss.t1 vss.t0 nfet_03v3 w=1.76u l=0.52u ad=4.9280e-13 pd=2.3200e-06 as=4.9280e-13 ps=2.3200e-06 nf=1 m=6 par=6
XMpar6 a_1631_11948.t1 a_1631_11948.t0 vdd.t1 vdd.t0 pfet_03v3 w=6.39u l=0.52u ad=1.7892e-12 pd=6.9500e-06 as=1.7892e-12 ps=6.9500e-06 nf=1 m=6 par=6
XMpar7 out.t160 a_1738_1205.t160 vss.t27 vss.t26 nfet_03v3 w=1.98u l=1.05u ad=5.5440e-13 pd=2.5400e-06 as=5.5440e-13 ps=2.5400e-06 nf=1 m=14 par=14
X357 out.t174 vss.t24 cap_mim_2f0fF c_width=16.21u c_length=16.2u
X380 out.t174 vss.t24 cap_mim_2f0fF c_width=16.21u c_length=16.2u
Rpar0 a_1482_1205.t0 a_1482_1205.t9 60.7120
Rpar1 a_1631_11948.t0 a_1631_11948.t1 19.2191
Rpar2 a_1631_11948.t0 a_1631_11948.t12 152.8488
Rpar3 a_1631_11948.t1 a_1631_11948.t12 46.7779
Rpar4 a_1738_1205.t0 a_1738_1205.t160 239.1328
Rpar5 a_1738_1205.t0 a_1738_1205.t161 59.6561
Rpar6 a_1738_1205.t160 a_1738_1205.t161 14.1049
Rpar7 ib ib.t0 13.2564
Rpar8 ib ib.t1 2.8275
Rpar9 inn inn.t0 1.6394
Rpar10 inp inp.t0 1.6394
Rpar11 out out.t0 375.5579
Rpar12 out out.t160 3.3909
Rpar13 out out.t174 539.0937
Rpar14 out.t0 out.t160 68.4906
Rpar15 out.t0 out.t174 234.3819
Rpar16 out.t160 out.t174 98.3147
Rpar17 vdd vdd.t0 50.2604
Rpar18 vdd vdd.t1 544.0462
Rpar19 vdd vdd.t22 204.7245
Rpar20 vdd.t0 vdd.t1 3.7441
Rpar21 vdd.t0 vdd.t22 113.3297
Rpar22 vdd.t1 vdd.t22 1226.7445
Rpar23 vss vss.t0 190.5090
Rpar24 vss vss.t1 992.7924
Rpar25 vss vss.t24 571.8203
Rpar26 vss vss.t26 150.0322
Rpar27 vss vss.t27 797.8041
Rpar28 vss.t0 vss.t1 5.8847
Rpar29 vss.t0 vss.t24 179.7385
Rpar30 vss.t0 vss.t26 6.0981
Rpar31 vss.t0 vss.t27 34.0117
Rpar32 vss.t1 vss.t24 438.3931
Rpar33 vss.t1 vss.t26 33.9733
Rpar34 vss.t1 vss.t27 210.3856
Rpar35 vss.t24 vss.t26 219.9842
Rpar36 vss.t24 vss.t27 1264.3597
Rpar37 vss.t26 vss.t27 4.4426
Cpar0 a_1482_1205.t0 vss 3.58383e-14
Cpar1 a_1482_1205.t9 vss 2.55381e-13
Cpar2 a_1631_11948.t0 vss 2.49303e-14
Cpar3 a_1631_11948.t1 vss 1.00977e-14
Cpar4 a_1631_11948.t12 vss 2.87271e-15
Cpar5 a_1738_1205.t0 vss 1.13516e-13
Cpar6 a_1738_1205.t160 vss 2.53097e-14
Cpar7 a_1738_1205.t161 vss 1.18230e-14
Cpar8 ib vss 1.23129e-14
Cpar9 ib.t0 vss 1.13202e-15
Cpar10 ib.t1 vss 2.53836e-16
Cpar11 inn inp 2.53610e-16
Cpar12 inn out 3.35592e-14
Cpar13 inn vdd 6.17473e-14
Cpar14 inn vss 9.20260e-15
Cpar15 inn.t0 vss 1.11033e-13
Cpar16 inp vdd 6.13311e-14
Cpar17 inp vss 9.48874e-15
Cpar18 inp.t0 vss 1.10639e-13
Cpar19 out vdd 2.34467e-14
Cpar20 out vss 2.74075e-14
Cpar21 out.t0 vss 5.30268e-14
Cpar22 out.t160 vss 5.14394e-15
Cpar23 out.t174 vss 9.92032e-14
Cpar24 vdd vss 5.00349e-13
Cpar25 vdd.t0 vss 2.95412e-14
Cpar26 vdd.t1 vss 1.12865e-14
Cpar27 vdd.t22 vss 1.90031e-13
.ends opamp_dut

Vdd vdd 0 3.300000
Vss vss 0 0
Ibias vdd ib 2.550000e-05
Vinp inp 0 DC 1.480000 AC 1 PWL(0 1.480000 3.000000e-09 1.480000 3.300000e-09 1.490000)
Rfb out inn 1m
Cload out 0 2.000000e-13
Xdut vdd vss inp inn out ib opamp_dut
.end
