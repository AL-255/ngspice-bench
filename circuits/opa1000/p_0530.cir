* opa1000[0530]: 200f/pmos_5t_3v3_i2u_subth (pmos_5t, VDD=3.3V, CL=0.2pF, Iref=0.52uA)
.include "pdk_opa.inc"
.temp 27
.option gmin=1e-12 rshunt=1e12 reltol=1e-3 abstol=1e-12 vntol=1e-5 method=gear
* Post-PEX R+C extracted netlist for pmos_5t_3v3_i2u_subth
.subckt opamp_dut vdd vss inp inn out ib
XMpar0 a_2290_8818.t0 inn.t0 out.t0 vdd.t0 pfet_03v3 w=3.85u l=1.52u ad=1.1935e-12 pd=4.8309e-06 as=1.1550e-12 ps=4.6906e-06 nf=1 m=64 par=64
XMpar1 a_6026_3135.t3 a_6026_3135.t2 vdd.t26 vdd.t25 pfet_03v3 w=10u l=3.9u ad=2.8000e-12 pd=1.0560e-05 as=2.8000e-12 ps=1.0560e-05 nf=1 m=2 par=2
XMpar2 a_2290_8818.t128 a_6026_3135.t2 vdd.t26 vdd.t25 pfet_03v3 w=10u l=3.9u ad=2.8000e-12 pd=1.0560e-05 as=3.6000e-12 ps=1.3220e-05 nf=1 m=8 par=8
XMpar3 out.t12 a_2714_8818.t0 vss.t1 vss.t0 nfet_03v3 w=2.02u l=2.04u ad=5.6560e-13 pd=2.5800e-06 as=5.6560e-13 ps=2.5800e-06 nf=1 m=2 par=2
XMpar4 a_2290_8818.t0 inp.t0 a_2714_8818.t4 vdd.t0 pfet_03v3 w=3.85u l=1.52u ad=1.1935e-12 pd=4.8309e-06 as=1.1550e-12 ps=4.6906e-06 nf=1 m=64 par=64
XMpar5 ib.t1 ib.t0 vss.t6 vss.t5 nfet_03v3 w=3.02u l=3.9u ad=1.8120e-12 pd=7.2400e-06 as=8.4560e-13 ps=3.5800e-06 nf=1 m=2 par=2
XMpar6 a_6026_3135.t0 ib.t0 vss.t6 vss.t5 nfet_03v3 w=3.02u l=3.9u ad=8.4560e-13 pd=3.5800e-06 as=8.4560e-13 ps=3.5800e-06 nf=1 m=2 par=2
XMpar7 a_2714_8818.t1 a_2714_8818.t0 vss.t1 vss.t0 nfet_03v3 w=2.02u l=2.04u ad=1.2120e-12 pd=5.2400e-06 as=5.6560e-13 ps=2.5800e-06 nf=1 m=2 par=2
X26 out.t66 vss.t2 cap_mim_2f0fF c_width=18.88u c_length=18.88u
Rpar0 a_2290_8818.t0 a_2290_8818.t128 49.1549
Rpar1 a_2714_8818.t0 a_2714_8818.t1 18.4033
Rpar2 a_2714_8818.t0 a_2714_8818.t4 202.6079
Rpar3 a_2714_8818.t1 a_2714_8818.t4 69.5314
Rpar4 a_6026_3135.t0 a_6026_3135.t2 104.6750
Rpar5 a_6026_3135.t0 a_6026_3135.t3 80.9891
Rpar6 a_6026_3135.t2 a_6026_3135.t3 27.1687
Rpar7 ib ib.t0 12.6581
Rpar8 ib ib.t1 4.1177
Rpar9 inn inn.t0 1.6157
Rpar10 inp inp.t0 1.6157
Rpar11 out out.t0 107.8160
Rpar12 out out.t12 74.4678
Rpar13 out out.t66 15.2867
Rpar14 out.t0 out.t12 153.6416
Rpar15 vdd vdd.t0 20.5240
Rpar16 vdd vdd.t25 212.7858
Rpar17 vdd vdd.t26 1117.4112
Rpar18 vdd.t0 vdd.t25 75.7882
Rpar19 vdd.t0 vdd.t26 397.9899
Rpar20 vdd.t25 vdd.t26 6.0756
Rpar21 vss vss.t0 202.1653
Rpar22 vss vss.t1 331.9522
Rpar23 vss vss.t6 108.9648
Rpar24 vss vss.t5 147.2662
Rpar25 vss vss.t2 89.1381
Rpar26 vss.t0 vss.t1 9.4654
Rpar27 vss.t0 vss.t6 622.2350
Rpar28 vss.t0 vss.t5 840.9492
Rpar29 vss.t0 vss.t2 527.2860
Rpar30 vss.t1 vss.t6 1021.7086
Rpar31 vss.t1 vss.t5 1380.8371
Rpar32 vss.t1 vss.t2 865.7960
Rpar33 vss.t6 vss.t5 15.1952
Rpar34 vss.t6 vss.t2 146.5836
Rpar35 vss.t5 vss.t2 198.1082
Cpar0 a_2290_8818.t0 vss 1.14160e-13
Cpar1 a_2290_8818.t128 vss 1.83026e-14
Cpar2 a_2714_8818.t0 vss 6.77893e-15
Cpar3 a_2714_8818.t1 vss 4.45307e-15
Cpar4 a_2714_8818.t4 vss 5.90882e-14
Cpar5 a_6026_3135.t0 vss 1.94613e-15
Cpar6 a_6026_3135.t2 vss 3.82022e-14
Cpar7 a_6026_3135.t3 vss 3.73261e-15
Cpar8 ib out 1.86100e-17
Cpar9 ib vdd 1.48900e-17
Cpar10 ib vss 1.35872e-14
Cpar11 ib.t0 vss 1.70417e-15
Cpar12 ib.t1 vss 2.37630e-16
Cpar13 inn inp 2.23550e-16
Cpar14 inn out 2.26936e-14
Cpar15 inn vdd 4.34884e-14
Cpar16 inn vss 6.52905e-15
Cpar17 inn.t0 vss 7.75037e-14
Cpar18 inp out 3.22600e-17
Cpar19 inp vdd 4.31444e-14
Cpar20 inp vss 6.52396e-15
Cpar21 inp.t0 vss 7.73156e-14
Cpar22 out vdd 1.61183e-14
Cpar23 out vss 1.73355e-14
Cpar24 out.t0 vss 2.35725e-14
Cpar25 out.t12 vss 1.74785e-15
Cpar26 out.t66 vss 5.08341e-14
Cpar27 vdd vss 4.27812e-13
Cpar28 vdd.t0 vss 1.14480e-13
Cpar29 vdd.t25 vss 3.36791e-14
Cpar30 vdd.t26 vss 1.08609e-14
.ends opamp_dut

Vdd vdd 0 3.300000
Vss vss 0 0
Ibias vdd ib 5.200000e-07
Vinp inp 0 DC 1.480000 AC 1 PWL(0 1.480000 2.935923e-08 1.480000 3.229515e-08 1.490000)
Rfb out inn 1m
Cload out 0 2.000000e-13
Xdut vdd vss inp inn out ib opamp_dut
.end
