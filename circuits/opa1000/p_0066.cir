* opa1000[0066]: 2p/cherry_hooper_3v3_0p1u_1u_subth (cherry_hooper, VDD=3.3V, CL=2.0pF, Iref=0.0175uA)
.include "pdk_opa.inc"
.temp 27
.option gmin=1e-12 rshunt=1e12 reltol=1e-3 abstol=1e-12 vntol=1e-5 method=gear
* Post-PEX R+C extracted netlist for cherry_hooper_3v3_0p1u_1u_subth
.subckt opamp_dut vdd vss inp inn out ib
XMpar0 a_7694_13367.t0 a_5464_11143.t1 vdd.t4 vdd.t3 pfet_03v3 w=0.97u l=7.5u ad=2.7160e-13 pd=1.5300e-06 as=5.8200e-13 ps=3.1400e-06 nf=1 m=2 par=2
XMpar1 a_4819_6280.t0 a_5194_9292.t1 a_5194_9292.t2 vdd.t0 pfet_03v3 w=0.77u l=1u ad=4.6200e-13 pd=2.7400e-06 as=4.6200e-13 ps=2.7400e-06 nf=1 m=1
XMpar2 a_1607_1294.t0 ib.t0 vss.t3 vss.t2 nfet_03v3 w=0.41u l=7.5u ad=2.4600e-13 pd=2.0200e-06 as=1.8040e-13 ps=1.4950e-06 nf=1 m=4 par=4
XMpar3 a_9614_4406.t3 a_9614_4406.t2 vdd.t2 vdd.t1 pfet_03v3 w=1.26u l=3.13u ad=4.8720e-13 pd=2.4533e-06 as=4.8720e-13 ps=2.4533e-06 nf=1 m=3 par=3
XMpar4 a_1411_9426.t0 a_7694_13367.t5 a_4839_1294.t0 vss.t0 nfet_03v3 w=1.33u l=2.4u ad=7.9800e-13 pd=3.8600e-06 as=7.9800e-13 ps=3.8600e-06 nf=1 m=1
XMpar5 a_1607_1294.t4 inp.t0 a_7694_13367.t1 vss.t0 nfet_03v3 w=0.45u l=2.4u ad=2.7000e-13 pd=2.1000e-06 as=1.2600e-13 ps=1.0100e-06 nf=1 m=1
XMpar6 a_6764_14952.t1 a_6764_14952.t0 vdd.t2 vdd.t1 pfet_03v3 w=1.26u l=3.13u ad=3.5280e-13 pd=1.8200e-06 as=5.5440e-13 ps=2.7700e-06 nf=1 m=4 par=4
XMpar7 a_4819_6280.t2 a_4819_6280.t1 vdd.t2 vdd.t1 pfet_03v3 w=1.26u l=3.13u ad=7.5600e-13 pd=3.7200e-06 as=7.5600e-13 ps=3.7200e-06 nf=1 m=1
XMpar8 a_1411_9426.t3 a_1411_9426.t2 vdd.t2 vdd.t1 pfet_03v3 w=1.26u l=3.13u ad=4.8720e-13 pd=2.4533e-06 as=4.8720e-13 ps=2.4533e-06 nf=1 m=3 par=3
XMpar9 a_5194_9292.t0 ib.t0 vss.t3 vss.t2 nfet_03v3 w=0.41u l=7.5u ad=2.4600e-13 pd=2.0200e-06 as=2.4600e-13 ps=2.0200e-06 nf=1 m=1
XMpar10 a_8706_11457.t0 ib.t0 vss.t3 vss.t2 nfet_03v3 w=0.41u l=7.5u ad=1.1480e-13 pd=9.7000e-07 as=2.4600e-13 ps=2.0200e-06 nf=1 m=8 par=8
XMpar11 a_5464_11143.t0 ib.t0 vss.t3 vss.t2 nfet_03v3 w=0.41u l=7.5u ad=2.4600e-13 pd=2.0200e-06 as=1.1480e-13 ps=9.7000e-07 nf=1 m=1
XMpar12 out.t0 a_6764_14952.t0 vdd.t2 vdd.t1 pfet_03v3 w=1.26u l=3.13u ad=3.5280e-13 pd=1.8200e-06 as=3.5280e-13 ps=1.8200e-06 nf=1 m=4 par=4
XMpar13 a_6764_14952.t8 a_1411_9426.t8 a_8706_11457.t8 vss.t33 nfet_03v3 w=1.77u l=2.4u ad=1.0620e-12 pd=4.7400e-06 as=1.0620e-12 ps=4.7400e-06 nf=1 m=1
XMpar14 a_1607_1294.t4 inn.t0 a_9614_8000.t2 vss.t0 nfet_03v3 w=0.45u l=2.4u ad=2.7000e-13 pd=2.1000e-06 as=1.2600e-13 ps=1.0100e-06 nf=1 m=1
XMpar15 a_4839_1294.t0 a_9614_8000.t5 a_9614_4406.t0 vss.t0 nfet_03v3 w=1.33u l=2.4u ad=7.9800e-13 pd=3.8600e-06 as=7.9800e-13 ps=3.8600e-06 nf=1 m=1
XMpar16 a_9614_8000.t0 a_5464_11143.t1 vdd.t4 vdd.t3 pfet_03v3 w=0.97u l=7.5u ad=2.7160e-13 pd=1.5300e-06 as=5.8200e-13 ps=3.1400e-06 nf=1 m=2 par=2
XMpar17 ib.t1 ib.t0 vss.t3 vss.t2 nfet_03v3 w=0.41u l=7.5u ad=2.4600e-13 pd=2.0200e-06 as=1.1480e-13 ps=9.7000e-07 nf=1 m=1
XMpar18 a_9614_4406.t1 a_5194_9292.t3 a_9614_8000.t4 vdd.t11 pfet_03v3 w=0.4u l=5.14u ad=2.4000e-13 pd=2.0000e-06 as=2.4000e-13 ps=2.0000e-06 nf=1 m=1
XMpar19 a_1411_9426.t1 a_5194_9292.t3 a_7694_13367.t4 vdd.t11 pfet_03v3 w=0.4u l=5.14u ad=2.4000e-13 pd=2.0000e-06 as=2.4000e-13 ps=2.0000e-06 nf=1 m=1
XMpar20 a_1607_1294.t4 inp.t0 a_7694_13367.t1 vss.t34 nfet_03v3 w=0.45u l=2.4u ad=2.7000e-13 pd=2.1000e-06 as=1.2600e-13 ps=1.0100e-06 nf=1 m=1
XMpar21 a_5464_11143.t2 a_5464_11143.t1 vdd.t4 vdd.t3 pfet_03v3 w=0.97u l=7.5u ad=5.8200e-13 pd=3.1400e-06 as=5.8200e-13 ps=3.1400e-06 nf=1 m=1
XMpar22 a_4839_1294.t2 ib.t0 vss.t3 vss.t2 nfet_03v3 w=0.41u l=7.5u ad=1.5853e-13 pd=1.3200e-06 as=1.1480e-13 ps=9.7000e-07 nf=1 m=6 par=6
XMpar23 a_8706_11457.t8 a_9614_4406.t8 out.t1 vss.t33 nfet_03v3 w=1.77u l=2.4u ad=1.0620e-12 pd=4.7400e-06 as=1.0620e-12 ps=4.7400e-06 nf=1 m=1
XMpar24 a_1607_1294.t4 inn.t0 a_9614_8000.t2 vss.t34 nfet_03v3 w=0.45u l=2.4u ad=2.7000e-13 pd=2.1000e-06 as=1.2600e-13 ps=1.0100e-06 nf=1 m=1
X52 out.t5 vss.t36 cap_mim_2f0fF c_width=15u c_length=15u
Rpar0 a_1411_9426.t0 a_1411_9426.t1 143.7356
Rpar1 a_1411_9426.t0 a_1411_9426.t2 877.7481
Rpar2 a_1411_9426.t0 a_1411_9426.t3 333.9976
Rpar3 a_1411_9426.t0 a_1411_9426.t8 206.1089
Rpar4 a_1411_9426.t1 a_1411_9426.t2 511.3696
Rpar5 a_1411_9426.t1 a_1411_9426.t3 194.5845
Rpar6 a_1411_9426.t1 a_1411_9426.t8 120.0775
Rpar7 a_1411_9426.t2 a_1411_9426.t3 20.9672
Rpar8 a_1411_9426.t2 a_1411_9426.t8 402.4907
Rpar9 a_1411_9426.t3 a_1411_9426.t8 153.1543
Rpar10 a_1607_1294.t0 a_1607_1294.t4 45.1186
Rpar11 a_4819_6280.t0 a_4819_6280.t1 130.7143
Rpar12 a_4819_6280.t0 a_4819_6280.t2 85.1892
Rpar13 a_4819_6280.t1 a_4819_6280.t2 34.3206
Rpar14 a_4839_1294.t0 a_4839_1294.t2 42.9592
Rpar15 a_5194_9292.t0 a_5194_9292.t1 749.4832
Rpar16 a_5194_9292.t0 a_5194_9292.t2 298.7168
Rpar17 a_5194_9292.t0 a_5194_9292.t3 120.7439
Rpar18 a_5194_9292.t1 a_5194_9292.t2 52.7438
Rpar19 a_5194_9292.t1 a_5194_9292.t3 269.1641
Rpar20 a_5194_9292.t2 a_5194_9292.t3 107.2791
Rpar21 a_5464_11143.t0 a_5464_11143.t1 81.3104
Rpar22 a_5464_11143.t0 a_5464_11143.t2 131.6045
Rpar23 a_5464_11143.t1 a_5464_11143.t2 27.1539
Rpar24 a_6764_14952.t0 a_6764_14952.t1 19.7232
Rpar25 a_6764_14952.t0 a_6764_14952.t8 145.8605
Rpar26 a_6764_14952.t1 a_6764_14952.t8 96.5942
Rpar27 a_7694_13367.t0 a_7694_13367.t1 193.9865
Rpar28 a_7694_13367.t0 a_7694_13367.t4 207.1493
Rpar29 a_7694_13367.t0 a_7694_13367.t5 337.5630
Rpar30 a_7694_13367.t1 a_7694_13367.t4 75.0103
Rpar31 a_7694_13367.t1 a_7694_13367.t5 111.0001
Rpar32 a_7694_13367.t4 a_7694_13367.t5 130.5282
Rpar33 a_8706_11457.t0 a_8706_11457.t8 96.2057
Rpar34 a_9614_4406.t0 a_9614_4406.t1 120.1761
Rpar35 a_9614_4406.t0 a_9614_4406.t2 805.7509
Rpar36 a_9614_4406.t0 a_9614_4406.t3 306.6014
Rpar37 a_9614_4406.t0 a_9614_4406.t8 315.9910
Rpar38 a_9614_4406.t1 a_9614_4406.t2 641.8311
Rpar39 a_9614_4406.t1 a_9614_4406.t3 244.2273
Rpar40 a_9614_4406.t1 a_9614_4406.t8 251.7067
Rpar41 a_9614_4406.t2 a_9614_4406.t3 21.2498
Rpar42 a_9614_4406.t2 a_9614_4406.t8 273.5505
Rpar43 a_9614_4406.t3 a_9614_4406.t8 104.0905
Rpar44 a_9614_8000.t0 a_9614_8000.t2 290.7851
Rpar45 a_9614_8000.t0 a_9614_8000.t4 420.4273
Rpar46 a_9614_8000.t0 a_9614_8000.t5 282.7615
Rpar47 a_9614_8000.t2 a_9614_8000.t4 97.1516
Rpar48 a_9614_8000.t2 a_9614_8000.t5 145.7998
Rpar49 a_9614_8000.t4 a_9614_8000.t5 210.8025
Rpar50 ib ib.t0 2.0223
Rpar51 ib ib.t1 1472.3138
Rpar52 ib.t0 ib.t1 25.8240
Rpar53 inn inn.t0 3.8664
Rpar54 inp inp.t0 3.9150
Rpar55 out out.t0 113.2959
Rpar56 out out.t1 9.8770
Rpar57 out out.t5 100.1023
Rpar58 out.t0 out.t5 108.0920
Rpar59 vdd vdd.t0 10797.2628
Rpar60 vdd vdd.t1 110.6567
Rpar61 vdd vdd.t4 561.9408
Rpar62 vdd vdd.t11 4308.9600
Rpar63 vdd vdd.t3 255.4392
Rpar64 vdd vdd.t2 209.5077
Rpar65 vdd.t0 vdd.t1 208.2068
Rpar66 vdd.t0 vdd.t4 1015.1669
Rpar67 vdd.t0 vdd.t11 617.4262
Rpar68 vdd.t0 vdd.t3 588.2926
Rpar69 vdd.t0 vdd.t2 244.9751
Rpar70 vdd.t1 vdd.t4 169.6795
Rpar71 vdd.t1 vdd.t11 93.1500
Rpar72 vdd.t1 vdd.t3 86.3454
Rpar73 vdd.t1 vdd.t2 3.0008
Rpar74 vdd.t4 vdd.t11 405.1317
Rpar75 vdd.t4 vdd.t3 7.8526
Rpar76 vdd.t4 vdd.t2 271.9584
Rpar77 vdd.t11 vdd.t3 234.7752
Rpar78 vdd.t11 vdd.t2 144.8041
Rpar79 vdd.t3 vdd.t2 141.2059
Rpar80 vss vss.t0 284.5172
Rpar81 vss vss.t2 76.4682
Rpar82 vss vss.t3 81.8313
Rpar83 vss vss.t33 5648.0527
Rpar84 vss vss.t34 390.1253
Rpar85 vss vss.t36 6458.4431
Rpar86 vss.t0 vss.t2 6.3668
Rpar87 vss.t0 vss.t3 53.9396
Rpar88 vss.t0 vss.t33 2311.0290
Rpar89 vss.t0 vss.t34 48.8929
Rpar90 vss.t0 vss.t36 2687.0908
Rpar91 vss.t2 vss.t3 4.2847
Rpar92 vss.t2 vss.t33 19.0509
Rpar93 vss.t2 vss.t34 12.1517
Rpar94 vss.t2 vss.t36 60.8026
Rpar95 vss.t3 vss.t33 91.3986
Rpar96 vss.t3 vss.t34 87.5510
Rpar97 vss.t3 vss.t36 279.3107
Rpar98 vss.t33 vss.t36 423.2160
Rpar99 vss.t34 vss.t36 4089.4663
Cpar0 a_1411_9426.t0 vss 2.30730e-15
Cpar1 a_1411_9426.t1 vss 2.44371e-15
Cpar2 a_1411_9426.t2 vss 6.17664e-15
Cpar3 a_1411_9426.t3 vss 3.29839e-15
Cpar4 a_1411_9426.t8 vss 3.40196e-15
Cpar5 a_1607_1294.t0 vss 9.40070e-15
Cpar6 a_1607_1294.t4 vss 3.90171e-15
Cpar7 a_4819_6280.t0 vss 1.86406e-15
Cpar8 a_4819_6280.t1 vss 2.72566e-15
Cpar9 a_4819_6280.t2 vss 1.73811e-15
Cpar10 a_4839_1294.t0 vss 2.50160e-15
Cpar11 a_4839_1294.t2 vss 9.73333e-15
Cpar12 a_5194_9292.t0 vss 5.33439e-15
Cpar13 a_5194_9292.t1 vss 1.53642e-15
Cpar14 a_5194_9292.t2 vss 2.80130e-15
Cpar15 a_5194_9292.t3 vss 8.54943e-15
Cpar16 a_5464_11143.t0 vss 3.71852e-15
Cpar17 a_5464_11143.t1 vss 2.53609e-14
Cpar18 a_5464_11143.t2 vss 2.73036e-15
Cpar19 a_6764_14952.t0 vss 1.91473e-14
Cpar20 a_6764_14952.t1 vss 4.98896e-15
Cpar21 a_6764_14952.t8 vss 3.39324e-15
Cpar22 a_7694_13367.t0 vss 4.26742e-15
Cpar23 a_7694_13367.t1 vss 3.05787e-15
Cpar24 a_7694_13367.t4 vss 2.79713e-15
Cpar25 a_7694_13367.t5 vss 3.24799e-15
Cpar26 a_8706_11457.t0 vss 6.02324e-15
Cpar27 a_8706_11457.t8 vss 3.02596e-15
Cpar28 a_9614_4406.t0 vss 3.08011e-15
Cpar29 a_9614_4406.t1 vss 3.15649e-15
Cpar30 a_9614_4406.t2 vss 6.70094e-15
Cpar31 a_9614_4406.t3 vss 4.00250e-15
Cpar32 a_9614_4406.t8 vss 4.22851e-15
Cpar33 a_9614_8000.t0 vss 5.78880e-15
Cpar34 a_9614_8000.t2 vss 3.52899e-15
Cpar35 a_9614_8000.t4 vss 2.79474e-15
Cpar36 a_9614_8000.t5 vss 4.05854e-15
Cpar37 ib vdd 6.28030e-16
Cpar38 ib vss 9.77870e-14
Cpar39 ib.t0 vss 7.69543e-15
Cpar40 ib.t1 vss 3.33355e-16
Cpar41 inn inp 5.19700e-17
Cpar42 inn vss 3.02279e-15
Cpar43 inn.t0 vss 3.04304e-16
Cpar44 inp vss 3.03756e-15
Cpar45 inp.t0 vss 3.03325e-16
Cpar46 out vdd 6.49123e-15
Cpar47 out vss 1.01482e-14
Cpar48 out.t0 vss 8.77831e-16
Cpar49 out.t1 vss 3.66100e-17
Cpar50 out.t5 vss 1.46001e-14
Cpar51 vdd vss 1.59322e-13
Cpar52 vdd.t0 vss 2.81299e-15
Cpar53 vdd.t1 vss 3.22397e-14
Cpar54 vdd.t11 vss 5.65859e-15
Cpar55 vdd.t2 vss 1.72982e-14
Cpar56 vdd.t3 vss 1.91607e-14
Cpar57 vdd.t4 vss 1.05364e-14
.ends opamp_dut

Vdd vdd 0 3.300000
Vss vss 0 0
Ibias vdd ib 1.750000e-08
Vinp inp 0 DC 2.071700 AC 1 PWL(0 2.071700 1.824783e-07 2.071700 2.007261e-07 2.081700)
Rfb out inn 1m
Cload out 0 2.000000e-12
Xdut vdd vss inp inn out ib opamp_dut
.end
