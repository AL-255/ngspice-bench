* opa1000[0344]: 200f/nmos_5t_1v8_1u_10u_subth (nmos_5t, VDD=1.8V, CL=0.2pF, Iref=1.3125uA)
.include "pdk_opa.inc"
.temp 27
.option gmin=1e-12 rshunt=1e12 reltol=1e-3 abstol=1e-12 vntol=1e-5 method=gear
* Post-PEX R+C extracted netlist for nmos_5t_1v8_1u_10u_subth
.subckt opamp_dut vdd vss inp inn out ib
XMpar0 out.t0 a_1730_4453.t42 vdd.t1 vdd.t0 pfet_03v3 w=1.91u l=1.6u ad=5.3480e-13 pd=2.4700e-06 as=5.3480e-13 ps=2.4700e-06 nf=1 m=20 par=20
XMpar1 a_1730_4453.t43 a_1730_4453.t42 vdd.t1 vdd.t0 pfet_03v3 w=1.91u l=1.6u ad=6.5704e-13 pd=2.9800e-06 as=5.3480e-13 ps=2.4700e-06 nf=1 m=20 par=20
XMpar2 a_1410_4453.t0 inn.t0 out.t14 vss.t0 nfet_03v3 w=1.97u l=1u ad=6.4166e-13 pd=2.9029e-06 as=5.5160e-13 ps=2.5300e-06 nf=1 m=42 par=42
XMpar3 a_1410_4453.t84 ib.t0 vss.t30 vss.t0 nfet_03v3 w=3.63u l=2u ad=1.0164e-12 pd=4.1900e-06 as=1.3068e-12 ps=5.2575e-06 nf=1 m=8 par=8
XMpar4 a_1410_4453.t0 inp.t0 a_1730_4453.t0 vss.t0 nfet_03v3 w=1.97u l=1u ad=6.4166e-13 pd=2.9029e-06 as=5.5160e-13 ps=2.5300e-06 nf=1 m=42 par=42
XMpar5 ib.t1 ib.t0 vss.t30 vss.t0 nfet_03v3 w=3.63u l=2u ad=1.0164e-12 pd=4.1900e-06 as=1.0164e-12 ps=4.1900e-06 nf=1 m=2 par=2
X80 out.t62 vss.t28 cap_mim_2f0fF c_width=7.99u c_length=7.99u
Rpar0 a_1410_4453.t0 a_1410_4453.t84 27.4467
Rpar1 a_1730_4453.t0 a_1730_4453.t42 164.6598
Rpar2 a_1730_4453.t0 a_1730_4453.t43 45.0240
Rpar3 a_1730_4453.t42 a_1730_4453.t43 7.1295
Rpar4 ib ib.t0 12.1406
Rpar5 ib ib.t1 8.9598
Rpar6 inn inn.t0 1.5773
Rpar7 inp inp.t0 1.5773
Rpar8 out out.t0 3.6077
Rpar9 out out.t14 801.3897
Rpar10 out out.t62 3180.5129
Rpar11 out.t0 out.t14 48.2628
Rpar12 out.t0 out.t62 191.5430
Rpar13 out.t14 out.t62 78.8133
Rpar14 vdd vdd.t0 20.0275
Rpar15 vdd vdd.t1 544.2355
Rpar16 vdd.t0 vdd.t1 10.5004
Rpar17 vss vss.t0 38.5031
Rpar18 vss vss.t28 102.0116
Rpar19 vss vss.t30 516.0578
Rpar20 vss.t0 vss.t28 56.4983
Rpar21 vss.t0 vss.t30 4.0273
Rpar22 vss.t28 vss.t30 757.2486
Cpar0 a_1410_4453.t0 vss 4.36995e-14
Cpar1 a_1410_4453.t84 vss 7.83655e-15
Cpar2 a_1730_4453.t0 vss 2.53294e-14
Cpar3 a_1730_4453.t42 vss 5.27309e-14
Cpar4 a_1730_4453.t43 vss 2.01647e-14
Cpar5 ib out 1.17600e-17
Cpar6 ib vss 1.85804e-14
Cpar7 ib.t0 vss 3.45938e-15
Cpar8 ib.t1 vss 2.64055e-16
Cpar9 inn inp 1.56380e-16
Cpar10 inn out 8.37122e-15
Cpar11 inn vdd 1.55700e-17
Cpar12 inn vss 2.48345e-14
Cpar13 inn.t0 vss 1.27566e-14
Cpar14 inp vdd 1.70800e-17
Cpar15 inp vss 2.47752e-14
Cpar16 inp.t0 vss 1.26723e-14
Cpar17 out vdd 1.48915e-14
Cpar18 out vss 1.70605e-14
Cpar19 out.t0 vss 1.17591e-14
Cpar20 out.t14 vss 1.87858e-14
Cpar21 out.t62 vss 2.00253e-14
Cpar22 vdd vss 1.09905e-13
Cpar23 vdd.t0 vss 5.91619e-14
Cpar24 vdd.t1 vss 8.02287e-15
.ends opamp_dut

Vdd vdd 0 1.800000
Vss vss 0 0
Ibias vdd ib 1.312500e-06
Vinp inp 0 DC 0.895000 AC 1 PWL(0 0.895000 6.753896e-09 0.895000 7.429286e-09 0.905000)
Rfb out inn 1m
Cload out 0 2.000000e-13
Xdut vdd vss inp inn out ib opamp_dut
.end
