* opa1000[0577]: 2p/pmos_5t_3v3_i20u_subth (pmos_5t, VDD=3.3V, CL=2.0pF, Iref=4.6uA)
.include "pdk_opa.inc"
.temp 27
.option gmin=1e-12 rshunt=1e12 reltol=1e-3 abstol=1e-12 vntol=1e-5 method=gear
* Post-PEX R+C extracted netlist for pmos_5t_3v3_i20u_subth
.subckt opamp_dut vdd vss inp inn out ib
XMpar0 a_1328_1204.t0 inn.t0 out.t0 vdd.t8 pfet_03v3 w=8u l=0.98u ad=2.5600e-12 pd=9.6400e-06 as=2.2400e-12 ps=8.5600e-06 nf=1 m=64 par=64
XMpar1 out.t7 a_1436_4487.t0 vss.t1 vss.t0 nfet_03v3 w=2.04u l=1.69u ad=5.7120e-13 pd=2.6000e-06 as=5.7120e-13 ps=2.6000e-06 nf=1 m=12 par=12
XMpar2 a_1328_1204.t0 inp.t0 a_1436_4487.t24 vdd.t8 pfet_03v3 w=8u l=0.98u ad=2.5600e-12 pd=9.6400e-06 as=2.2400e-12 ps=8.5600e-06 nf=1 m=64 par=64
XMpar3 a_1184_996.t3 a_1184_996.t2 vdd.t1 vdd.t0 pfet_03v3 w=10u l=0.72u ad=2.8000e-12 pd=1.0560e-05 as=2.8000e-12 ps=1.0560e-05 nf=1 m=2 par=2
XMpar4 a_1436_4487.t1 a_1436_4487.t0 vss.t1 vss.t0 nfet_03v3 w=2.04u l=1.69u ad=5.7120e-13 pd=2.6000e-06 as=6.8000e-13 ps=3.0467e-06 nf=1 m=12 par=12
XMpar5 a_1328_1204.t128 a_1184_996.t2 vdd.t1 vdd.t0 pfet_03v3 w=10u l=0.72u ad=2.8000e-12 pd=1.0560e-05 as=3.6000e-12 ps=1.3220e-05 nf=1 m=8 par=8
XMpar6 a_1184_996.t0 ib.t0 vss.t26 vss.t25 nfet_03v3 w=3.72u l=0.72u ad=1.0416e-12 pd=4.2800e-06 as=1.0416e-12 ps=4.2800e-06 nf=1 m=2 par=2
XMpar7 ib.t1 ib.t0 vss.t26 vss.t25 nfet_03v3 w=3.72u l=0.72u ad=2.2320e-12 pd=8.6400e-06 as=1.0416e-12 ps=4.2800e-06 nf=1 m=2 par=2
X112 out.t76 vss.t14 cap_mim_2f0fF c_width=6.71u c_length=6.71u
Rpar0 a_1184_996.t0 a_1184_996.t2 230.7569
Rpar1 a_1184_996.t0 a_1184_996.t3 69.3181
Rpar2 a_1184_996.t2 a_1184_996.t3 28.5262
Rpar3 a_1328_1204.t0 a_1328_1204.t128 31.3263
Rpar4 a_1436_4487.t0 a_1436_4487.t1 15.3546
Rpar5 a_1436_4487.t0 a_1436_4487.t24 190.6931
Rpar6 a_1436_4487.t1 a_1436_4487.t24 67.1540
Rpar7 ib ib.t0 20.1170
Rpar8 ib ib.t1 3.5504
Rpar9 inn inn.t0 2.3532
Rpar10 inp inp.t0 2.3532
Rpar11 out out.t0 386.4081
Rpar12 out out.t7 3.8853
Rpar13 out out.t76 539.0139
Rpar14 out.t0 out.t7 57.3381
Rpar15 out.t0 out.t76 144.2569
Rpar16 out.t7 out.t76 79.9829
Rpar17 vdd vdd.t0 110.8993
Rpar18 vdd vdd.t1 398.1331
Rpar19 vdd vdd.t8 22.4090
Rpar20 vdd.t0 vdd.t1 5.5606
Rpar21 vdd.t0 vdd.t8 323.0336
Rpar22 vdd.t1 vdd.t8 1159.7045
Rpar23 vss vss.t0 60.3776
Rpar24 vss vss.t1 309.9987
Rpar25 vss vss.t14 90.5517
Rpar26 vss vss.t25 211.7860
Rpar27 vss vss.t26 241.0344
Rpar28 vss.t0 vss.t1 4.6643
Rpar29 vss.t0 vss.t14 108.9734
Rpar30 vss.t0 vss.t25 2.3627
Rpar31 vss.t0 vss.t26 11.1409
Rpar32 vss.t1 vss.t14 645.1300
Rpar33 vss.t1 vss.t25 25.3846
Rpar34 vss.t1 vss.t26 97.7694
Rpar35 vss.t14 vss.t25 343.4836
Rpar36 vss.t14 vss.t26 346.0898
Rpar37 vss.t25 vss.t26 26.5823
Cpar0 a_1184_996.t0 vss 2.34908e-15
Cpar1 a_1184_996.t2 vss 1.13591e-14
Cpar2 a_1184_996.t3 vss 4.79180e-15
Cpar3 a_1328_1204.t0 vss 1.76934e-13
Cpar4 a_1328_1204.t128 vss 1.42431e-14
Cpar5 a_1436_4487.t0 vss 2.47846e-14
Cpar6 a_1436_4487.t1 vss 8.60180e-15
Cpar7 a_1436_4487.t24 vss 7.15471e-14
Cpar8 ib out 1.35400e-17
Cpar9 ib vdd 8.67200e-17
Cpar10 ib vss 6.67427e-15
Cpar11 ib.t0 vss 4.10829e-16
Cpar12 ib.t1 vss 2.85300e-16
Cpar13 inn inp 2.05580e-16
Cpar14 inn out 2.63737e-14
Cpar15 inn vdd 3.45237e-14
Cpar16 inn vss 1.02727e-14
Cpar17 inn.t0 vss 7.35978e-14
Cpar18 inp vdd 3.45840e-14
Cpar19 inp vss 1.02821e-14
Cpar20 inp.t0 vss 7.36689e-14
Cpar21 out vdd 9.43582e-15
Cpar22 out vss 1.86112e-14
Cpar23 out.t0 vss 7.48257e-14
Cpar24 out.t7 vss 7.95672e-15
Cpar25 out.t76 vss 1.60445e-14
Cpar26 vdd vss 4.10364e-13
Cpar27 vdd.t0 vss 1.12322e-14
Cpar28 vdd.t1 vss 5.44726e-15
Cpar29 vdd.t8 vss 1.11102e-13
.ends opamp_dut

Vdd vdd 0 3.300000
Vss vss 0 0
Ibias vdd ib 4.600000e-06
Vinp inp 0 DC 1.480000 AC 1 PWL(0 1.480000 7.252855e-09 1.480000 7.978140e-09 1.490000)
Rfb out inn 1m
Cload out 0 2.000000e-12
Xdut vdd vss inp inn out ib opamp_dut
.end
