* opa1000[0057]: 2p/cherry_hooper_1v8_10u_100u_weak (cherry_hooper, VDD=1.8V, CL=2.0pF, Iref=3.0357uA)
.include "pdk_opa.inc"
.temp 27
.option gmin=1e-12 rshunt=1e12 reltol=1e-3 abstol=1e-12 vntol=1e-5 method=gear
* Post-PEX R+C extracted netlist for cherry_hooper_1v8_10u_100u_weak
.subckt opamp_dut vdd vss inp inn out ib
XMpar0 a_17111_1294.t0 a_8312_10192.t2 a_8312_10192.t3 vdd.t5 pfet_03v3 w=10u l=0.32u ad=3.2000e-12 pd=1.1890e-05 as=2.8000e-12 ps=1.0560e-05 nf=1 m=16 par=16
XMpar1 a_10974_3013.t1 a_10974_3013.t0 vdd.t0 vdd.t0 pfet_03v3 w=9.07u l=0.32u ad=2.5396e-12 pd=9.6300e-06 as=2.9024e-12 ps=1.0844e-05 nf=1 m=16 par=16
XMpar2 a_7231_18637.t3 a_7231_18637.t2 vdd.t0 vdd.t0 pfet_03v3 w=9.07u l=0.32u ad=2.5396e-12 pd=9.6300e-06 as=2.7815e-12 ps=1.0439e-05 nf=1 m=24 par=24
XMpar3 a_3908_13544.t0 a_11610_21961.t4 a_7231_18637.t0 vss.t6 nfet_03v3 w=6.28u l=0.36u ad=3.7680e-12 pd=1.3760e-05 as=1.7584e-12 ps=6.8400e-06 nf=1 m=2 par=2
XMpar4 a_12280_9984.t4 a_12280_9984.t3 vdd.t0 vdd.t0 pfet_03v3 w=9.07u l=0.32u ad=2.5396e-12 pd=9.6300e-06 as=2.7815e-12 ps=1.0439e-05 nf=1 m=24 par=24
XMpar5 a_11610_21961.t3 a_7824_10192.t2 vdd.t28 vdd.t27 pfet_03v3 w=3.64u l=0.5u ad=2.1840e-12 pd=8.4800e-06 as=2.1840e-12 ps=8.4800e-06 nf=1 m=1
XMpar6 out.t0 a_10974_3013.t0 vdd.t0 vdd.t0 pfet_03v3 w=9.07u l=0.32u ad=2.5396e-12 pd=9.6300e-06 as=2.9024e-12 ps=1.0844e-05 nf=1 m=16 par=16
XMpar7 a_3957_10192.t2 ib.t0 vss.t14 vss.t13 nfet_03v3 w=7.61u l=0.5u ad=2.1308e-12 pd=8.1700e-06 as=2.7396e-12 ps=1.0233e-05 nf=1 m=8 par=8
XMpar8 a_17111_1294.t16 a_17111_1294.t15 vdd.t0 vdd.t0 pfet_03v3 w=9.07u l=0.32u ad=2.5396e-12 pd=9.6300e-06 as=3.2652e-12 ps=1.2058e-05 nf=1 m=8 par=8
XMpar9 a_7824_10192.t0 ib.t0 vss.t14 vss.t13 nfet_03v3 w=7.61u l=0.5u ad=4.5660e-12 pd=1.6420e-05 as=2.1308e-12 ps=8.1700e-06 nf=1 m=2 par=2
XMpar10 ib.t1 ib.t0 vss.t14 vss.t13 nfet_03v3 w=7.61u l=0.5u ad=4.5660e-12 pd=1.6420e-05 as=3.3484e-12 ps=1.2295e-05 nf=1 m=2 par=2
XMpar11 a_11610_21961.t0 inp.t0 a_4332_13544.t0 vss.t0 nfet_03v3 w=2.09u l=0.36u ad=5.8520e-13 pd=2.6500e-06 as=1.2540e-12 ps=5.3800e-06 nf=1 m=2 par=2
XMpar12 a_3908_13544.t4 ib.t0 vss.t14 vss.t13 nfet_03v3 w=7.61u l=0.5u ad=2.1308e-12 pd=8.1700e-06 as=2.5367e-12 ps=9.5450e-06 nf=1 m=12 par=12
XMpar13 a_4332_13544.t4 ib.t0 vss.t14 vss.t13 nfet_03v3 w=7.61u l=0.5u ad=2.1308e-12 pd=8.1700e-06 as=2.1308e-12 ps=8.1700e-06 nf=1 m=4 par=4
XMpar14 a_12174_13376.t3 a_7824_10192.t2 vdd.t28 vdd.t27 pfet_03v3 w=3.64u l=0.5u ad=2.1840e-12 pd=8.4800e-06 as=2.1840e-12 ps=8.4800e-06 nf=1 m=1
XMpar15 a_12174_13376.t2 a_8312_10192.t34 a_12280_9984.t2 vdd.t4 pfet_03v3 w=7.77u l=0.32u ad=4.6620e-12 pd=1.6740e-05 as=4.6620e-12 ps=1.6740e-05 nf=1 m=1
XMpar16 a_3957_10192.t0 a_12280_9984.t51 out.t5 vss.t5 nfet_03v3 w=8.37u l=0.36u ad=5.0220e-12 pd=1.7940e-05 as=5.0220e-12 ps=1.7940e-05 nf=1 m=1
XMpar17 a_12280_9984.t0 a_12174_13376.t4 a_3908_13544.t0 vss.t6 nfet_03v3 w=6.28u l=0.36u ad=1.7584e-12 pd=6.8400e-06 as=3.7680e-12 ps=1.3760e-05 nf=1 m=2 par=2
XMpar18 a_8312_10192.t0 ib.t0 vss.t14 vss.t13 nfet_03v3 w=7.61u l=0.5u ad=2.1308e-12 pd=8.1700e-06 as=3.3484e-12 ps=1.2295e-05 nf=1 m=2 par=2
XMpar19 a_11610_21961.t2 a_8312_10192.t34 a_7231_18637.t50 vdd.t4 pfet_03v3 w=7.77u l=0.32u ad=4.6620e-12 pd=1.6740e-05 as=4.6620e-12 ps=1.6740e-05 nf=1 m=1
XMpar20 a_12174_13376.t0 inn.t0 a_4332_13544.t0 vss.t0 nfet_03v3 w=2.09u l=0.36u ad=5.8520e-13 pd=2.6500e-06 as=1.2540e-12 ps=5.3800e-06 nf=1 m=2 par=2
XMpar21 a_10974_3013.t32 a_7231_18637.t51 a_3957_10192.t0 vss.t5 nfet_03v3 w=8.37u l=0.36u ad=5.0220e-12 pd=1.7940e-05 as=5.0220e-12 ps=1.7940e-05 nf=1 m=1
XMpar22 a_7824_10192.t3 a_7824_10192.t2 vdd.t28 vdd.t27 pfet_03v3 w=3.64u l=0.5u ad=2.1840e-12 pd=8.4800e-06 as=2.1840e-12 ps=8.4800e-06 nf=1 m=1
X28 out.t17 vss.t2 cap_mim_2f0fF c_width=17.32u c_length=17.32u
X84 out.t17 vss.t2 cap_mim_2f0fF c_width=17.32u c_length=17.32u
X104 out.t17 vss.t2 cap_mim_2f0fF c_width=17.32u c_length=17.32u
Rpar0 a_10974_3013.t0 a_10974_3013.t1 11.3348
Rpar1 a_10974_3013.t0 a_10974_3013.t32 621.5374
Rpar2 a_10974_3013.t1 a_10974_3013.t32 79.3122
Rpar3 a_11610_21961.t0 a_11610_21961.t2 203.8141
Rpar4 a_11610_21961.t0 a_11610_21961.t3 117.3573
Rpar5 a_11610_21961.t0 a_11610_21961.t4 759.2502
Rpar6 a_11610_21961.t2 a_11610_21961.t3 57.5300
Rpar7 a_11610_21961.t2 a_11610_21961.t4 269.5343
Rpar8 a_11610_21961.t3 a_11610_21961.t4 214.3112
Rpar9 a_12174_13376.t0 a_12174_13376.t2 203.8141
Rpar10 a_12174_13376.t0 a_12174_13376.t3 117.3573
Rpar11 a_12174_13376.t0 a_12174_13376.t4 759.2502
Rpar12 a_12174_13376.t2 a_12174_13376.t3 57.5300
Rpar13 a_12174_13376.t2 a_12174_13376.t4 269.5343
Rpar14 a_12174_13376.t3 a_12174_13376.t4 214.3112
Rpar15 a_12280_9984.t0 a_12280_9984.t4 55.4969
Rpar16 a_12280_9984.t0 a_12280_9984.t3 989.4758
Rpar17 a_12280_9984.t0 a_12280_9984.t2 173.7497
Rpar18 a_12280_9984.t0 a_12280_9984.t51 1631.4622
Rpar19 a_12280_9984.t4 a_12280_9984.t3 18.5795
Rpar20 a_12280_9984.t4 a_12280_9984.t2 60.1806
Rpar21 a_12280_9984.t4 a_12280_9984.t51 565.0799
Rpar22 a_12280_9984.t3 a_12280_9984.t2 1072.9842
Rpar23 a_12280_9984.t3 a_12280_9984.t51 10075.0310
Rpar24 a_12280_9984.t2 a_12280_9984.t51 254.9442
Rpar25 a_17111_1294.t0 a_17111_1294.t15 631.6049
Rpar26 a_17111_1294.t0 a_17111_1294.t16 43.0760
Rpar27 a_17111_1294.t15 a_17111_1294.t16 31.8265
Rpar28 a_3908_13544.t0 a_3908_13544.t4 82.8405
Rpar29 a_3957_10192.t0 a_3957_10192.t2 85.3030
Rpar30 a_4332_13544.t0 a_4332_13544.t4 120.4006
Rpar31 a_7231_18637.t0 a_7231_18637.t2 989.4758
Rpar32 a_7231_18637.t0 a_7231_18637.t3 55.4969
Rpar33 a_7231_18637.t0 a_7231_18637.t50 173.7497
Rpar34 a_7231_18637.t0 a_7231_18637.t51 1631.4622
Rpar35 a_7231_18637.t2 a_7231_18637.t3 18.5795
Rpar36 a_7231_18637.t2 a_7231_18637.t50 1072.9842
Rpar37 a_7231_18637.t2 a_7231_18637.t51 10075.0310
Rpar38 a_7231_18637.t3 a_7231_18637.t50 60.1806
Rpar39 a_7231_18637.t3 a_7231_18637.t51 565.0799
Rpar40 a_7231_18637.t50 a_7231_18637.t51 254.9442
Rpar41 a_7824_10192.t0 a_7824_10192.t2 80.8819
Rpar42 a_7824_10192.t0 a_7824_10192.t3 51.2597
Rpar43 a_7824_10192.t2 a_7824_10192.t3 58.5403
Rpar44 a_8312_10192.t0 a_8312_10192.t2 4445.8111
Rpar45 a_8312_10192.t0 a_8312_10192.t3 259.3249
Rpar46 a_8312_10192.t0 a_8312_10192.t34 269.6710
Rpar47 a_8312_10192.t2 a_8312_10192.t3 22.0591
Rpar48 a_8312_10192.t2 a_8312_10192.t34 3177.8201
Rpar49 a_8312_10192.t3 a_8312_10192.t34 185.3628
Rpar50 ib ib.t0 7.3278
Rpar51 ib ib.t1 102.6416
Rpar52 ib.t0 ib.t1 25.5206
Rpar53 inn inn.t0 32.2718
Rpar54 inp inp.t0 32.3204
Rpar55 out out.t0 116.3207
Rpar56 out out.t17 138.0903
Rpar57 out out.t5 6.4688
Rpar58 out.t0 out.t17 73.4600
Rpar59 vdd vdd.t0 60.9921
Rpar60 vdd vdd.t27 5228.8378
Rpar61 vdd vdd.t28 1362.5166
Rpar62 vdd vdd.t4 985.4961
Rpar63 vdd.t0 vdd.t27 211.1794
Rpar64 vdd.t0 vdd.t28 49.3043
Rpar65 vdd.t0 vdd.t5 58.5549
Rpar66 vdd.t0 vdd.t4 67.0927
Rpar67 vdd.t27 vdd.t28 13.3405
Rpar68 vdd.t27 vdd.t5 1728.0055
Rpar69 vdd.t27 vdd.t4 234.6497
Rpar70 vdd.t28 vdd.t5 375.1049
Rpar71 vdd.t28 vdd.t4 67.9089
Rpar72 vdd.t5 vdd.t4 1093.4093
Rpar73 vss vss.t0 57.1792
Rpar74 vss vss.t6 3798.3014
Rpar75 vss vss.t5 669.0382
Rpar76 vss vss.t13 295.7403
Rpar77 vss vss.t14 569.5295
Rpar78 vss vss.t2 48.4985
Rpar79 vss.t0 vss.t6 7849.4205
Rpar80 vss.t0 vss.t5 1576.3339
Rpar81 vss.t0 vss.t13 652.7031
Rpar82 vss.t0 vss.t14 1300.0144
Rpar83 vss.t0 vss.t2 347.6833
Rpar84 vss.t6 vss.t5 640.9994
Rpar85 vss.t6 vss.t13 135.7970
Rpar86 vss.t6 vss.t14 289.0929
Rpar87 vss.t5 vss.t13 49.1245
Rpar88 vss.t5 vss.t14 94.4507
Rpar89 vss.t5 vss.t2 4068.1493
Rpar90 vss.t13 vss.t14 1.8332
Rpar91 vss.t13 vss.t2 1798.2767
Rpar92 vss.t14 vss.t2 3463.0772
Cpar0 a_10974_3013.t0 vss 2.51681e-14
Cpar1 a_10974_3013.t1 vss 3.84932e-14
Cpar2 a_10974_3013.t32 vss 5.80081e-15
Cpar3 a_11610_21961.t0 vss 4.76495e-15
Cpar4 a_11610_21961.t2 vss 5.84156e-15
Cpar5 a_11610_21961.t3 vss 6.32367e-15
Cpar6 a_11610_21961.t4 vss 2.84854e-15
Cpar7 a_12174_13376.t0 vss 4.56703e-15
Cpar8 a_12174_13376.t2 vss 5.59893e-15
Cpar9 a_12174_13376.t3 vss 6.06101e-15
Cpar10 a_12174_13376.t4 vss 2.73022e-15
Cpar11 a_12280_9984.t0 vss 5.27209e-15
Cpar12 a_12280_9984.t2 vss 7.75495e-15
Cpar13 a_12280_9984.t3 vss 1.83264e-14
Cpar14 a_12280_9984.t4 vss 4.68041e-14
Cpar15 a_12280_9984.t51 vss 1.51167e-15
Cpar16 a_17111_1294.t0 vss 3.75907e-14
Cpar17 a_17111_1294.t15 vss 6.70401e-15
Cpar18 a_17111_1294.t16 vss 1.91385e-14
Cpar19 a_3908_13544.t0 vss 6.66245e-15
Cpar20 a_3908_13544.t4 vss 9.41761e-15
Cpar21 a_3957_10192.t0 vss 3.51356e-15
Cpar22 a_3957_10192.t2 vss 5.47507e-15
Cpar23 a_4332_13544.t0 vss 5.81888e-15
Cpar24 a_4332_13544.t4 vss 6.18376e-15
Cpar25 a_7231_18637.t0 vss 5.49277e-15
Cpar26 a_7231_18637.t2 vss 1.90935e-14
Cpar27 a_7231_18637.t3 vss 4.87630e-14
Cpar28 a_7231_18637.t50 vss 8.07954e-15
Cpar29 a_7231_18637.t51 vss 1.57494e-15
Cpar30 a_7824_10192.t0 vss 6.07319e-15
Cpar31 a_7824_10192.t2 vss 2.14495e-15
Cpar32 a_7824_10192.t3 vss 2.57061e-15
Cpar33 a_8312_10192.t0 vss 1.01487e-14
Cpar34 a_8312_10192.t2 vss 1.13737e-14
Cpar35 a_8312_10192.t3 vss 3.46704e-14
Cpar36 a_8312_10192.t34 vss 4.37791e-15
Cpar37 ib out 1.01530e-16
Cpar38 ib vss 2.98101e-14
Cpar39 ib.t0 vss 6.17947e-15
Cpar40 ib.t1 vss 2.08121e-15
Cpar41 inn inp 5.21200e-17
Cpar42 inn vss 1.22589e-15
Cpar43 inn.t0 vss 1.46794e-16
Cpar44 inp vss 1.22635e-15
Cpar45 inp.t0 vss 1.47703e-16
Cpar46 out vdd 3.67844e-14
Cpar47 out vss 2.86522e-14
Cpar48 out.t0 vss 4.05099e-15
Cpar49 out.t17 vss 4.68092e-14
Cpar50 out.t5 vss 3.11890e-16
Cpar51 vdd vss 2.98664e-13
Cpar52 vdd.t0 vss 2.10909e-13
Cpar53 vdd.t27 vss 5.53852e-15
Cpar54 vdd.t28 vss 1.22700e-14
Cpar55 vdd.t4 vss 8.75422e-15
Cpar56 vdd.t5 vss 2.85845e-14
.ends opamp_dut

Vdd vdd 0 1.800000
Vss vss 0 0
Ibias vdd ib 3.035700e-06
Vinp inp 0 DC 1.233300 AC 1 PWL(0 1.233300 7.174181e-09 1.233300 7.891599e-09 1.243300)
Rfb out inn 1m
Cload out 0 2.000000e-12
Xdut vdd vss inp inn out ib opamp_dut
.end
