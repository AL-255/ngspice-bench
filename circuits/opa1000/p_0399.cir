* opa1000[0399]: 2p/nmos_5t_3v3_i200n_subth (nmos_5t, VDD=3.3V, CL=2.0pF, Iref=0.0575uA)
.include "pdk_opa.inc"
.temp 27
.option gmin=1e-12 rshunt=1e12 reltol=1e-3 abstol=1e-12 vntol=1e-5 method=gear
* Post-PEX R+C extracted netlist for nmos_5t_3v3_i200n_subth
.subckt opamp_dut vdd vss inp inn out ib
XMpar0 out.t0 a_3228_19774.t0 vdd.t1 vdd.t0 pfet_03v3 w=2.08u l=9.75u ad=5.8240e-13 pd=2.6400e-06 as=5.8240e-13 ps=2.6400e-06 nf=1 m=4 par=4
XMpar1 a_1746_4241.t0 inp.t0 a_3228_19774.t8 vss.t0 nfet_03v3 w=3.32u l=7.2u ad=1.2616e-12 pd=5.1175e-06 as=9.6280e-13 ps=4.0038e-06 nf=1 m=64 par=64
XMpar2 a_1746_4241.t64 ib.t0 vss.t12 vss.t0 nfet_03v3 w=0.4u l=3u ad=1.1200e-13 pd=9.6000e-07 as=1.4400e-13 ps=1.2200e-06 nf=1 m=8 par=8
XMpar3 a_1746_4241.t0 inn.t0 out.t1 vss.t0 nfet_03v3 w=3.32u l=7.2u ad=1.2616e-12 pd=5.1175e-06 as=9.6280e-13 ps=4.0038e-06 nf=1 m=64 par=64
XMpar4 a_3228_19774.t1 a_3228_19774.t0 vdd.t1 vdd.t0 pfet_03v3 w=2.08u l=9.75u ad=5.8240e-13 pd=2.6400e-06 as=9.1520e-13 ps=4.0000e-06 nf=1 m=4 par=4
XMpar5 ib.t1 ib.t0 vss.t12 vss.t0 nfet_03v3 w=0.4u l=3u ad=1.1200e-13 pd=9.6000e-07 as=1.1200e-13 ps=9.6000e-07 nf=1 m=2 par=2
X52 out.t68 vss.t31 cap_mim_2f0fF c_width=6.71u c_length=6.71u
Rpar0 a_1746_4241.t0 a_1746_4241.t64 45.2198
Rpar1 a_3228_19774.t0 a_3228_19774.t1 20.8928
Rpar2 a_3228_19774.t0 a_3228_19774.t8 115.0417
Rpar3 a_3228_19774.t1 a_3228_19774.t8 73.5732
Rpar4 ib ib.t0 10.8675
Rpar5 ib ib.t1 16.8213
Rpar6 inn inn.t0 1.6043
Rpar7 inp inp.t0 1.6043
Rpar8 out out.t0 10.0526
Rpar9 out out.t1 46.4247
Rpar10 out out.t68 220.4520
Rpar11 out.t1 out.t68 99.1627
Rpar12 vdd vdd.t0 28.5621
Rpar13 vdd vdd.t1 68.5220
Rpar14 vdd.t0 vdd.t1 7.3394
Rpar15 vss vss.t0 33.1179
Rpar16 vss vss.t12 751.6822
Rpar17 vss vss.t31 95.0235
Rpar18 vss.t0 vss.t12 5.0960
Rpar19 vss.t0 vss.t31 60.8347
Rpar20 vss.t12 vss.t31 1683.3011
Cpar0 a_1746_4241.t0 vss 1.84169e-13
Cpar1 a_1746_4241.t64 vss 5.94721e-15
Cpar2 a_3228_19774.t0 vss 5.92159e-14
Cpar3 a_3228_19774.t1 vss 1.05256e-14
Cpar4 a_3228_19774.t8 vss 9.74482e-14
Cpar5 ib vss 2.27350e-14
Cpar6 ib.t0 vss 2.92699e-15
Cpar7 ib.t1 vss 1.51406e-16
Cpar8 inn inp 4.70450e-16
Cpar9 inn out 5.32861e-14
Cpar10 inn vdd 3.21400e-17
Cpar11 inn vss 1.47248e-13
Cpar12 inn.t0 vss 8.66890e-14
Cpar13 inp out 5.91900e-17
Cpar14 inp vdd 3.32200e-17
Cpar15 inp vss 1.47273e-13
Cpar16 inp.t0 vss 8.64047e-14
Cpar17 out vdd 8.82857e-15
Cpar18 out vss 4.08924e-14
Cpar19 out.t0 vss 5.26981e-15
Cpar20 out.t1 vss 9.31444e-14
Cpar21 out.t68 vss 2.15304e-14
Cpar22 vdd vss 1.17354e-13
Cpar23 vdd.t0 vss 2.97508e-14
Cpar24 vdd.t1 vss 1.42916e-14
.ends opamp_dut

Vdd vdd 0 3.300000
Vss vss 0 0
Ibias vdd ib 5.750000e-08
Vinp inp 0 DC 1.645000 AC 1 PWL(0 1.645000 5.078206e-07 1.645000 5.586026e-07 1.655000)
Rfb out inn 1m
Cload out 0 2.000000e-12
Xdut vdd vss inp inn out ib opamp_dut
.end
