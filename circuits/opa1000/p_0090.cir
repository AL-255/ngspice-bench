* opa1000[0090]: 200f/current_reuse_1v8_0p1u_1u_weak (current_reuse, VDD=1.8V, CL=0.2pF, Iref=0.0929uA)
.include "pdk_opa.inc"
.temp 27
.option gmin=1e-12 rshunt=1e12 reltol=1e-3 abstol=1e-12 vntol=1e-5 method=gear
* Post-PEX R+C extracted netlist for current_reuse_1v8_0p1u_1u_weak
.subckt opamp_dut vdd vss inp inn out ib
XMpar0 out.t8 ib.t0 vss.t11 vss.t10 nfet_03v3 w=0.4u l=5u ad=1.8880e-13 pd=1.5840e-06 as=1.6320e-13 ps=1.3760e-06 nf=1 m=10 par=10
XMpar1 a_1487_10765.t2 inp.t0 a_1513_1249.t0 vdd.t6 pfet_03v3 w=1.82u l=8u ad=5.0960e-13 pd=2.3800e-06 as=1.0920e-12 ps=4.8400e-06 nf=1 m=4 par=4
XMpar2 a_1513_1249.t4 a_1013_1041.t6 vdd.t1 vdd.t0 pfet_03v3 w=0.76u l=2.5u ad=2.1280e-13 pd=1.3200e-06 as=4.5600e-13 ps=2.7200e-06 nf=1 m=2 par=2
XMpar3 out.t0 a_1487_10765.t8 vdd.t1 vdd.t0 pfet_03v3 w=0.76u l=2.5u ad=2.6144e-13 pd=1.6000e-06 as=2.6144e-13 ps=1.6000e-06 nf=1 m=10 par=10
XMpar4 a_1487_10765.t0 inp.t4 a_4114_7444.t0 vss.t1 nfet_03v3 w=1.88u l=8u ad=5.2640e-13 pd=2.4400e-06 as=1.1280e-12 ps=4.9600e-06 nf=1 m=2 par=2
XMpar5 a_1013_1041.t2 inn.t0 a_1513_1249.t0 vdd.t6 pfet_03v3 w=1.82u l=8u ad=5.0960e-13 pd=2.3800e-06 as=1.0920e-12 ps=4.8400e-06 nf=1 m=4 par=4
XMpar6 a_1013_1041.t7 a_1013_1041.t6 vdd.t1 vdd.t0 pfet_03v3 w=0.76u l=2.5u ad=4.5600e-13 pd=2.7200e-06 as=2.1280e-13 ps=1.3200e-06 nf=1 m=1
XMpar7 ib.t1 ib.t0 vss.t11 vss.t10 nfet_03v3 w=0.4u l=5u ad=2.4000e-13 pd=2.0000e-06 as=1.1200e-13 ps=9.6000e-07 nf=1 m=2 par=2
XMpar8 a_1487_10765.t7 a_1013_1041.t6 vdd.t1 vdd.t0 pfet_03v3 w=0.76u l=2.5u ad=4.5600e-13 pd=2.7200e-06 as=2.1280e-13 ps=1.3200e-06 nf=1 m=1
XMpar9 a_4114_7444.t4 ib.t0 vss.t11 vss.t10 nfet_03v3 w=0.4u l=5u ad=2.4000e-13 pd=2.0000e-06 as=1.1200e-13 ps=9.6000e-07 nf=1 m=4 par=4
XMpar10 a_1013_1041.t0 inn.t4 a_4114_7444.t0 vss.t1 nfet_03v3 w=1.88u l=8u ad=5.2640e-13 pd=2.4400e-06 as=1.1280e-12 ps=4.9600e-06 nf=1 m=2 par=2
X0 a_9784_15694.t0 a_13618_16214.t0 vss.t0 ppolyf_u_1k r_width=1u r_length=18.51u
X9 a_9784_12574.t0 a_13618_13094.t0 vss.t0 ppolyf_u_1k r_width=1u r_length=18.51u
X16 a_9784_15694.t0 a_13618_15174.t0 vss.t0 ppolyf_u_1k r_width=1u r_length=18.51u
X17 a_9784_12574.t0 a_13618_12054.t0 vss.t0 ppolyf_u_1k r_width=1u r_length=18.51u
X24 a_9784_14654.t0 a_13618_15174.t0 vss.t0 ppolyf_u_1k r_width=1u r_length=18.51u
X28 a_9784_11534.t0 a_13618_12054.t0 vss.t0 ppolyf_u_1k r_width=1u r_length=18.51u
X30 a_13618_17254.t1 out.t20 cap_mim_2f0fF c_width=12.99u c_length=12.99u
X31 a_9784_14654.t0 a_13618_14134.t0 vss.t0 ppolyf_u_1k r_width=1u r_length=18.51u
X34 a_9784_11534.t0 a_13618_11014.t0 vss.t0 ppolyf_u_1k r_width=1u r_length=18.51u
X40 a_9784_16734.t0 a_13618_17254.t0 vss.t0 ppolyf_u_1k r_width=1u r_length=18.51u
X41 a_9784_13614.t0 a_13618_14134.t0 vss.t0 ppolyf_u_1k r_width=1u r_length=18.51u
X44 a_1487_10765.t6 a_13618_11014.t0 vss.t0 ppolyf_u_1k r_width=1u r_length=18.51u
X48 a_9784_16734.t0 a_13618_16214.t0 vss.t0 ppolyf_u_1k r_width=1u r_length=18.51u
X50 a_9784_13614.t0 a_13618_13094.t0 vss.t0 ppolyf_u_1k r_width=1u r_length=18.51u
Rpar0 a_1013_1041.t0 a_1013_1041.t6 165.4128
Rpar1 a_1013_1041.t0 a_1013_1041.t2 72.9755
Rpar2 a_1013_1041.t0 a_1013_1041.t7 880.7097
Rpar3 a_1013_1041.t6 a_1013_1041.t2 138.8315
Rpar4 a_1013_1041.t6 a_1013_1041.t7 27.4630
Rpar5 a_1013_1041.t2 a_1013_1041.t7 739.1826
Rpar6 a_13618_17254.t0 a_13618_17254.t1 60.9626
Rpar7 a_1487_10765.t0 a_1487_10765.t8 68.2585
Rpar8 a_1487_10765.t0 a_1487_10765.t2 101.5405
Rpar9 a_1487_10765.t0 a_1487_10765.t6 496.4642
Rpar10 a_1487_10765.t0 a_1487_10765.t7 245.0353
Rpar11 a_1487_10765.t8 a_1487_10765.t2 136.2775
Rpar12 a_1487_10765.t8 a_1487_10765.t6 666.3045
Rpar13 a_1487_10765.t8 a_1487_10765.t7 74.0474
Rpar14 a_1487_10765.t2 a_1487_10765.t6 232.1888
Rpar15 a_1487_10765.t2 a_1487_10765.t7 489.2112
Rpar16 a_1487_10765.t6 a_1487_10765.t7 2391.9107
Rpar17 a_1513_1249.t0 a_1513_1249.t4 47.2596
Rpar18 a_4114_7444.t0 a_4114_7444.t4 63.5765
Rpar19 ib ib.t0 16.4427
Rpar20 ib ib.t1 15.2951
Rpar21 ib.t0 ib.t1 34.2074
Rpar22 inn inn.t0 51.7799
Rpar23 inn inn.t4 3.7367
Rpar24 inp inp.t0 43.8509
Rpar25 inp inp.t4 3.7853
Rpar26 out out.t0 4.1593
Rpar27 out out.t8 194.3366
Rpar28 out out.t20 101.3198
Rpar29 out.t0 out.t8 336.3053
Rpar30 out.t0 out.t20 175.3369
Rpar31 out.t8 out.t20 149.5783
Rpar32 vdd vdd.t0 268.3903
Rpar33 vdd vdd.t1 60.9045
Rpar34 vdd vdd.t6 699.2492
Rpar35 vdd.t0 vdd.t1 7.0868
Rpar36 vdd.t0 vdd.t6 165.2064
Rpar37 vdd.t1 vdd.t6 83.0887
Rpar38 vss vss.t0 637.6856
Rpar39 vss vss.t1 489.9558
Rpar40 vss vss.t10 27.3066
Rpar41 vss vss.t11 139.4505
Rpar42 vss.t0 vss.t1 30.8739
Rpar43 vss.t0 vss.t10 328.0297
Rpar44 vss.t0 vss.t11 1680.0752
Rpar45 vss.t1 vss.t10 247.1206
Rpar46 vss.t1 vss.t11 1268.7592
Rpar47 vss.t10 vss.t11 14.7576
Cpar0 a_1013_1041.t0 vss 5.30052e-15
Cpar1 a_1013_1041.t2 vss 7.96791e-15
Cpar2 a_1013_1041.t6 vss 1.22079e-14
Cpar3 a_1013_1041.t7 vss 2.62438e-15
Cpar4 a_13618_11014.t0 vss 2.64400e-17
Cpar5 a_13618_12054.t0 vss 3.00800e-17
Cpar6 a_13618_13094.t0 vss 2.93600e-17
Cpar7 a_13618_14134.t0 vss 2.93600e-17
Cpar8 a_13618_15174.t0 vss 2.93600e-17
Cpar9 a_13618_16214.t0 vss 3.20200e-17
Cpar10 a_13618_17254.t0 vss 1.31160e-16
Cpar11 a_13618_17254.t1 vss 2.38394e-15
Cpar12 a_1487_10765.t0 vss 4.71689e-15
Cpar13 a_1487_10765.t2 vss 9.01413e-15
Cpar14 a_1487_10765.t6 vss 7.08476e-15
Cpar15 a_1487_10765.t7 vss 2.10905e-15
Cpar16 a_1487_10765.t8 vss 1.62235e-14
Cpar17 a_1513_1249.t0 vss 1.72195e-14
Cpar18 a_1513_1249.t4 vss 3.28698e-15
Cpar19 a_4114_7444.t0 vss 1.11751e-14
Cpar20 a_4114_7444.t4 vss 1.72964e-14
Cpar21 a_9784_11534.t0 vss 4.30600e-17
Cpar22 a_9784_12574.t0 vss 4.03800e-17
Cpar23 a_9784_13614.t0 vss 3.94600e-17
Cpar24 a_9784_14654.t0 vss 3.90200e-17
Cpar25 a_9784_15694.t0 vss 3.68800e-17
Cpar26 a_9784_16734.t0 vss 3.49600e-17
Cpar27 ib inn 2.65100e-17
Cpar28 ib inp 2.48100e-17
Cpar29 ib out 2.22880e-15
Cpar30 ib vdd 4.64800e-17
Cpar31 ib vss 5.73815e-14
Cpar32 ib.t0 vss 9.49135e-15
Cpar33 ib.t1 vss 7.24182e-16
Cpar34 inn inp 1.55910e-16
Cpar35 inn vdd 1.30983e-14
Cpar36 inn vss 1.22307e-14
Cpar37 inn.t0 vss 1.30426e-14
Cpar38 inn.t4 vss 4.04522e-15
Cpar39 inp vdd 1.43619e-14
Cpar40 inp vss 1.17588e-14
Cpar41 inp.t0 vss 1.44302e-14
Cpar42 inp.t4 vss 4.48603e-15
Cpar43 out vdd 1.54736e-14
Cpar44 out vss 2.37194e-14
Cpar45 out.t0 vss 3.61509e-15
Cpar46 out.t20 vss 1.12540e-14
Cpar47 out.t8 vss 1.32462e-14
Cpar48 vdd vss 1.48914e-13
Cpar49 vdd.t0 vss 2.30260e-14
Cpar50 vdd.t1 vss 1.51238e-14
Cpar51 vdd.t6 vss 3.98982e-14
.ends opamp_dut

Vdd vdd 0 1.800000
Vss vss 0 0
Ibias vdd ib 9.290000e-08
Vinp inp 0 DC 0.895000 AC 1 PWL(0 0.895000 8.841281e-08 0.895000 9.725410e-08 0.905000)
Rfb out inn 1m
Cload out 0 2.000000e-13
Xdut vdd vss inp inn out ib opamp_dut
.end
