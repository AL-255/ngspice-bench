* opa1000[0738]: 2p/rail_to_rail_3v3_i2u_weak (rail_to_rail, VDD=3.3V, CL=2.0pF, Iref=0.2875uA)
.include "pdk_opa.inc"
.temp 27
.option gmin=1e-12 rshunt=1e12 reltol=1e-3 abstol=1e-12 vntol=1e-5 method=gear
* Post-PEX R+C extracted netlist for rail_to_rail_3v3_i2u_weak
.subckt opamp_dut vdd vss inp inn out ib
XMpar0 out.t10 ib.t0 vss.t17 vss.t16 nfet_03v3 w=0.4u l=2.08u ad=1.1200e-13 pd=9.6000e-07 as=1.4400e-13 ps=1.2200e-06 nf=1 m=8 par=8
XMpar1 a_7672_5813.t5 a_7672_5813.t4 vdd.t1 vdd.t0 pfet_03v3 w=1.35u l=1.35u ad=3.7800e-13 pd=1.9100e-06 as=3.7800e-13 ps=1.9100e-06 nf=1 m=2 par=2
XMpar2 a_1216_14409.t1 inp.t0 a_7004_15498.t0 vdd.t8 pfet_03v3 w=0.82u l=1.8u ad=4.9200e-13 pd=2.8400e-06 as=2.2960e-13 ps=1.3800e-06 nf=1 m=2 par=2
XMpar3 a_1216_14409.t1 inn.t0 a_7886_16906.t0 vdd.t8 pfet_03v3 w=0.82u l=1.8u ad=4.9200e-13 pd=2.8400e-06 as=2.2960e-13 ps=1.3800e-06 nf=1 m=2 par=2
XMpar4 ib.t1 ib.t0 vss.t17 vss.t16 nfet_03v3 w=0.4u l=2.08u ad=2.4000e-13 pd=2.0000e-06 as=1.1200e-13 ps=9.6000e-07 nf=1 m=2 par=2
XMpar5 a_1530_9734.t3 a_7672_5813.t4 vdd.t1 vdd.t0 pfet_03v3 w=1.35u l=1.35u ad=8.1000e-13 pd=3.9000e-06 as=3.7800e-13 ps=1.9100e-06 nf=1 m=2 par=2
XMpar6 out.t1 a_1530_9734.t7 vdd.t1 vdd.t0 pfet_03v3 w=1.35u l=1.35u ad=4.8600e-13 pd=2.4075e-06 as=5.9400e-13 ps=2.9050e-06 nf=1 m=8 par=8
XMpar7 a_1530_9734.t1 inp.t2 a_3154_7917.t0 vss.t3 nfet_03v3 w=0.4u l=1.8u ad=2.4000e-13 pd=2.0000e-06 as=2.4000e-13 ps=2.0000e-06 nf=1 m=2 par=2
XMpar8 a_3154_7917.t0 inn.t2 a_7672_5813.t2 vss.t3 nfet_03v3 w=0.4u l=1.8u ad=2.4000e-13 pd=2.0000e-06 as=2.4000e-13 ps=2.0000e-06 nf=1 m=2 par=2
XMpar9 a_7886_16906.t3 a_7886_16906.t2 vss.t1 vss.t0 nfet_03v3 w=0.4u l=2.72u ad=2.4000e-13 pd=2.0000e-06 as=1.1200e-13 ps=9.6000e-07 nf=1 m=2 par=2
XMpar10 a_1336_14201.t1 a_1336_14201.t0 vdd.t3 vdd.t2 pfet_03v3 w=1.16u l=2.08u ad=3.2480e-13 pd=1.7200e-06 as=3.2480e-13 ps=1.7200e-06 nf=1 m=2 par=2
XMpar11 a_1216_14409.t0 a_1336_14201.t0 vdd.t3 vdd.t2 pfet_03v3 w=1.16u l=2.08u ad=6.9600e-13 pd=3.5200e-06 as=3.2480e-13 ps=1.7200e-06 nf=1 m=2 par=2
XMpar12 a_1336_14201.t4 ib.t0 vss.t17 vss.t16 nfet_03v3 w=0.4u l=2.08u ad=1.1200e-13 pd=9.6000e-07 as=1.1200e-13 ps=9.6000e-07 nf=1 m=2 par=2
XMpar13 a_3154_7917.t4 ib.t0 vss.t17 vss.t16 nfet_03v3 w=0.4u l=2.08u ad=2.4000e-13 pd=2.0000e-06 as=1.1200e-13 ps=9.6000e-07 nf=1 m=2 par=2
XMpar14 a_7672_5813.t0 a_7004_15498.t2 vss.t1 vss.t0 nfet_03v3 w=0.4u l=2.72u ad=1.1200e-13 pd=9.6000e-07 as=1.1200e-13 ps=9.6000e-07 nf=1 m=2 par=2
XMpar15 a_7004_15498.t3 a_7004_15498.t2 vss.t1 vss.t0 nfet_03v3 w=0.4u l=2.72u ad=2.4000e-13 pd=2.0000e-06 as=1.1200e-13 ps=9.6000e-07 nf=1 m=2 par=2
XMpar16 a_1530_9734.t0 a_7886_16906.t2 vss.t1 vss.t0 nfet_03v3 w=0.4u l=2.72u ad=2.4000e-13 pd=2.0000e-06 as=1.1200e-13 ps=9.6000e-07 nf=1 m=2 par=2
X2 a_15230_9993.t1 out.t0 cap_mim_2f0fF c_width=15.62u c_length=15.61u
X16 a_15230_9993.t1 out.t0 cap_mim_2f0fF c_width=15.62u c_length=15.61u
X19 a_11340_9473.t0 a_15230_9993.t0 vss.t2 ppolyf_u_1k r_width=1u r_length=18.79u
X27 a_11340_9473.t0 a_15230_8953.t0 vss.t2 ppolyf_u_1k r_width=1u r_length=18.79u
X33 a_11340_8433.t0 a_15230_8953.t0 vss.t2 ppolyf_u_1k r_width=1u r_length=18.79u
X42 a_11340_8433.t0 a_15230_7913.t0 vss.t2 ppolyf_u_1k r_width=1u r_length=18.79u
X48 a_1530_9734.t5 a_15230_7913.t0 vss.t2 ppolyf_u_1k r_width=1u r_length=18.79u
Rpar0 a_1216_14409.t0 a_1216_14409.t1 62.1304
Rpar1 a_1336_14201.t0 a_1336_14201.t1 27.0764
Rpar2 a_1336_14201.t0 a_1336_14201.t4 134.6073
Rpar3 a_1336_14201.t1 a_1336_14201.t4 136.1627
Rpar4 a_15230_9993.t0 a_15230_9993.t1 85.3250
Rpar5 a_1530_9734.t0 a_1530_9734.t1 107.1844
Rpar6 a_1530_9734.t0 a_1530_9734.t7 219.3362
Rpar7 a_1530_9734.t0 a_1530_9734.t3 504.7107
Rpar8 a_1530_9734.t0 a_1530_9734.t5 754.3362
Rpar9 a_1530_9734.t1 a_1530_9734.t7 155.1211
Rpar10 a_1530_9734.t1 a_1530_9734.t3 356.9465
Rpar11 a_1530_9734.t1 a_1530_9734.t5 533.4891
Rpar12 a_1530_9734.t7 a_1530_9734.t3 117.4184
Rpar13 a_1530_9734.t7 a_1530_9734.t5 175.4925
Rpar14 a_1530_9734.t3 a_1530_9734.t5 227.1979
Rpar15 a_3154_7917.t0 a_3154_7917.t4 67.1655
Rpar16 a_7004_15498.t0 a_7004_15498.t2 113.8351
Rpar17 a_7004_15498.t0 a_7004_15498.t3 83.3149
Rpar18 a_7004_15498.t2 a_7004_15498.t3 21.8899
Rpar19 a_7672_5813.t0 a_7672_5813.t2 64.5645
Rpar20 a_7672_5813.t0 a_7672_5813.t4 372.8130
Rpar21 a_7672_5813.t0 a_7672_5813.t5 283.8278
Rpar22 a_7672_5813.t2 a_7672_5813.t4 425.9706
Rpar23 a_7672_5813.t2 a_7672_5813.t5 324.2974
Rpar24 a_7672_5813.t4 a_7672_5813.t5 27.4982
Rpar25 a_7886_16906.t0 a_7886_16906.t2 134.1182
Rpar26 a_7886_16906.t0 a_7886_16906.t3 143.9088
Rpar27 a_7886_16906.t2 a_7886_16906.t3 16.0533
Rpar28 ib ib.t0 25.4179
Rpar29 ib ib.t1 12.1627
Rpar30 ib.t0 ib.t1 52.4389
Rpar31 inn inn.t0 44.1998
Rpar32 inn inn.t2 10.5915
Rpar33 inp inp.t0 44.6174
Rpar34 inp inp.t2 10.5915
Rpar35 out out.t0 73.4645
Rpar36 out out.t1 39.9975
Rpar37 out out.t10 5.4088
Rpar38 out.t0 out.t1 193.8340
Rpar39 vdd vdd.t0 597.3777
Rpar40 vdd vdd.t1 178.0280
Rpar41 vdd vdd.t2 123.2288
Rpar42 vdd vdd.t3 212.5450
Rpar43 vdd vdd.t8 567.8230
Rpar44 vdd.t0 vdd.t1 6.1134
Rpar45 vdd.t0 vdd.t2 517.7969
Rpar46 vdd.t0 vdd.t3 893.0962
Rpar47 vdd.t0 vdd.t8 178.2080
Rpar48 vdd.t1 vdd.t2 154.3117
Rpar49 vdd.t1 vdd.t3 266.1568
Rpar50 vdd.t1 vdd.t8 147.8504
Rpar51 vdd.t2 vdd.t3 12.4694
Rpar52 vdd.t2 vdd.t8 492.1793
Rpar53 vdd.t3 vdd.t8 848.9111
Rpar54 vss vss.t0 380.4252
Rpar55 vss vss.t1 1553.3301
Rpar56 vss vss.t3 1170.6402
Rpar57 vss vss.t16 169.5804
Rpar58 vss vss.t17 860.6172
Rpar59 vss vss.t2 121.8637
Rpar60 vss.t0 vss.t1 8.2185
Rpar61 vss.t0 vss.t3 7.3051
Rpar62 vss.t0 vss.t16 217.4755
Rpar63 vss.t0 vss.t2 286.8982
Rpar64 vss.t1 vss.t3 37.7639
Rpar65 vss.t1 vss.t16 890.8326
Rpar66 vss.t1 vss.t2 1170.0058
Rpar67 vss.t3 vss.t16 672.5395
Rpar68 vss.t3 vss.t2 888.1742
Rpar69 vss.t16 vss.t17 5.1087
Rpar70 vss.t16 vss.t2 115.0691
Rpar71 vss.t17 vss.t2 584.1220
Cpar0 a_11340_8433.t0 vss 4.25200e-17
Cpar1 a_11340_9473.t0 vss 3.54000e-17
Cpar2 a_1216_14409.t0 vss 4.33578e-15
Cpar3 a_1216_14409.t1 vss 5.32284e-15
Cpar4 a_1336_14201.t0 vss 6.90629e-15
Cpar5 a_1336_14201.t1 vss 2.69974e-15
Cpar6 a_1336_14201.t4 vss 5.05860e-15
Cpar7 a_15230_7913.t0 vss 2.64400e-17
Cpar8 a_15230_8953.t0 vss 3.27400e-17
Cpar9 a_15230_9993.t0 vss 1.78211e-16
Cpar10 a_15230_9993.t1 vss 6.45041e-15
Cpar11 a_1530_9734.t0 vss 4.51056e-15
Cpar12 a_1530_9734.t1 vss 3.95321e-15
Cpar13 a_1530_9734.t3 vss 4.92786e-15
Cpar14 a_1530_9734.t5 vss 4.71072e-15
Cpar15 a_1530_9734.t7 vss 1.09166e-14
Cpar16 a_3154_7917.t0 vss 7.43622e-15
Cpar17 a_3154_7917.t4 vss 7.70731e-15
Cpar18 a_7004_15498.t0 vss 9.73642e-16
Cpar19 a_7004_15498.t2 vss 3.28980e-15
Cpar20 a_7004_15498.t3 vss 1.28941e-15
Cpar21 a_7672_5813.t0 vss 3.23262e-15
Cpar22 a_7672_5813.t2 vss 3.61369e-15
Cpar23 a_7672_5813.t4 vss 4.79541e-15
Cpar24 a_7672_5813.t5 vss 2.62439e-15
Cpar25 a_7886_16906.t0 vss 1.03866e-15
Cpar26 a_7886_16906.t2 vss 3.15342e-15
Cpar27 a_7886_16906.t3 vss 1.29933e-15
Cpar28 ib out 9.12450e-16
Cpar29 ib vdd 1.88450e-16
Cpar30 ib vss 2.14895e-14
Cpar31 ib.t0 vss 6.99756e-15
Cpar32 ib.t1 vss 5.84079e-16
Cpar33 inn inp 1.53820e-16
Cpar34 inn vdd 2.16116e-15
Cpar35 inn vss 6.45869e-15
Cpar36 inn.t0 vss 2.25170e-15
Cpar37 inn.t2 vss 9.18600e-16
Cpar38 inp vdd 2.60737e-15
Cpar39 inp vss 6.22181e-15
Cpar40 inp.t0 vss 2.41260e-15
Cpar41 inp.t2 vss 9.70380e-16
Cpar42 out vdd 1.06869e-14
Cpar43 out vss 1.84043e-14
Cpar44 out.t0 vss 1.39618e-14
Cpar45 out.t1 vss 3.36172e-15
Cpar46 out.t10 vss 8.94695e-16
Cpar47 vdd vss 9.15485e-14
Cpar48 vdd.t0 vss 2.04531e-14
Cpar49 vdd.t1 vss 6.90335e-15
Cpar50 vdd.t2 vss 6.33027e-15
Cpar51 vdd.t3 vss 3.12855e-15
Cpar52 vdd.t8 vss 7.42653e-15
.ends opamp_dut

Vdd vdd 0 3.300000
Vss vss 0 0
Ibias vdd ib 2.875000e-07
Vinp inp 0 DC 1.645000 AC 1 PWL(0 1.645000 1.457147e-07 1.645000 1.602862e-07 1.655000)
Rfb out inn 1m
Cload out 0 2.000000e-12
Xdut vdd vss inp inn out ib opamp_dut
.end
