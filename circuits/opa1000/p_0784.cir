* opa1000[0784]: 200f/symmetrical_ota_3v3_i10u_weak (symmetrical_ota, VDD=3.3V, CL=0.2pF, Iref=2.1667uA)
.include "pdk_opa.inc"
.temp 27
.option gmin=1e-12 rshunt=1e12 reltol=1e-3 abstol=1e-12 vntol=1e-5 method=gear
* Post-PEX R+C extracted netlist for symmetrical_ota_3v3_i10u_weak
.subckt opamp_dut vdd vss inp inn out ib
XMpar0 a_4756_7904.t8 a_6530_5861.t2 vdd.t1 vdd.t0 pfet_03v3 w=3.58u l=1.44u ad=1.0024e-12 pd=4.1400e-06 as=1.5752e-12 ps=6.2500e-06 nf=1 m=4 par=4
XMpar1 a_5402_5861.t4 ib.t0 vss.t9 vss.t8 nfet_03v3 w=1.4u l=1.5u ad=3.9200e-13 pd=1.9600e-06 as=6.1600e-13 ps=2.9800e-06 nf=1 m=4 par=4
XMpar2 ib.t1 ib.t0 vss.t9 vss.t8 nfet_03v3 w=1.4u l=1.5u ad=3.9200e-13 pd=1.9600e-06 as=3.9200e-13 ps=1.9600e-06 nf=1 m=2 par=2
XMpar3 out.t2 a_4756_7904.t0 vss.t3 vss.t2 nfet_03v3 w=0.84u l=1.44u ad=2.3520e-13 pd=1.4000e-06 as=3.6960e-13 ps=2.1400e-06 nf=1 m=4 par=4
XMpar4 a_1247_5563.t0 inp.t0 a_5402_5861.t0 vss.t0 nfet_03v3 w=2.34u l=0.78u ad=6.5520e-13 pd=2.9000e-06 as=1.4040e-12 ps=5.8800e-06 nf=1 m=2 par=2
XMpar5 a_1247_5563.t3 a_1247_5563.t2 vdd.t1 vdd.t0 pfet_03v3 w=3.58u l=1.44u ad=1.0024e-12 pd=4.1400e-06 as=1.0024e-12 ps=4.1400e-06 nf=1 m=2 par=2
XMpar6 a_4756_7904.t1 a_4756_7904.t0 vss.t3 vss.t2 nfet_03v3 w=0.84u l=1.44u ad=2.3520e-13 pd=1.4000e-06 as=2.3520e-13 ps=1.4000e-06 nf=1 m=4 par=4
XMpar7 out.t0 a_1247_5563.t2 vdd.t1 vdd.t0 pfet_03v3 w=3.58u l=1.44u ad=1.0024e-12 pd=4.1400e-06 as=1.5752e-12 ps=6.2500e-06 nf=1 m=4 par=4
XMpar8 a_5402_5861.t0 inn.t0 a_6530_5861.t0 vss.t0 nfet_03v3 w=2.34u l=0.78u ad=1.4040e-12 pd=5.8800e-06 as=6.5520e-13 ps=2.9000e-06 nf=1 m=2 par=2
XMpar9 a_6530_5861.t3 a_6530_5861.t2 vdd.t1 vdd.t0 pfet_03v3 w=3.58u l=1.44u ad=1.0024e-12 pd=4.1400e-06 as=1.0024e-12 ps=4.1400e-06 nf=1 m=2 par=2
X15 out.t8 vss.t28 cap_mim_2f0fF c_width=14.37u c_length=14.36u
Rpar0 a_1247_5563.t0 a_1247_5563.t2 125.5992
Rpar1 a_1247_5563.t0 a_1247_5563.t3 72.1201
Rpar2 a_1247_5563.t2 a_1247_5563.t3 24.0288
Rpar3 a_4756_7904.t0 a_4756_7904.t1 20.3160
Rpar4 a_4756_7904.t0 a_4756_7904.t8 242.3572
Rpar5 a_4756_7904.t1 a_4756_7904.t8 110.6833
Rpar6 a_5402_5861.t0 a_5402_5861.t4 60.1867
Rpar7 a_6530_5861.t0 a_6530_5861.t2 125.5901
Rpar8 a_6530_5861.t0 a_6530_5861.t3 72.1241
Rpar9 a_6530_5861.t2 a_6530_5861.t3 24.0301
Rpar10 ib ib.t0 15.9214
Rpar11 ib ib.t1 14.2547
Rpar12 ib.t0 ib.t1 163.1251
Rpar13 inn inn.t0 15.8056
Rpar14 inp inp.t0 15.8542
Rpar15 out out.t0 58.5582
Rpar16 out out.t2 173.4642
Rpar17 out out.t8 15.5013
Rpar18 out.t0 out.t2 175.4271
Rpar19 out.t0 out.t8 567.0793
Rpar20 out.t2 out.t8 1679.8337
Rpar21 vdd vdd.t0 102.9751
Rpar22 vdd vdd.t1 132.0373
Rpar23 vdd.t0 vdd.t1 3.3466
Rpar24 vss vss.t0 261.4726
Rpar25 vss vss.t8 94.8023
Rpar26 vss vss.t9 162.9161
Rpar27 vss vss.t2 327.9768
Rpar28 vss vss.t3 695.8930
Rpar29 vss vss.t28 76.0604
Rpar30 vss.t0 vss.t8 90.6675
Rpar31 vss.t0 vss.t9 180.6585
Rpar32 vss.t0 vss.t2 4.1870
Rpar33 vss.t0 vss.t3 9.4068
Rpar34 vss.t0 vss.t28 602.0357
Rpar35 vss.t8 vss.t9 8.3722
Rpar36 vss.t8 vss.t2 92.2984
Rpar37 vss.t8 vss.t3 374.2119
Rpar38 vss.t8 vss.t28 218.2806
Rpar39 vss.t9 vss.t2 185.8963
Rpar40 vss.t9 vss.t3 723.0187
Rpar41 vss.t9 vss.t28 375.1112
Rpar42 vss.t2 vss.t3 13.5970
Rpar43 vss.t2 vss.t28 755.1603
Rpar44 vss.t3 vss.t28 1602.2804
Cpar0 a_1247_5563.t0 vss 2.60484e-15
Cpar1 a_1247_5563.t2 vss 9.19181e-15
Cpar2 a_1247_5563.t3 vss 3.46898e-15
Cpar3 a_4756_7904.t0 vss 6.62955e-15
Cpar4 a_4756_7904.t1 vss 3.55732e-15
Cpar5 a_4756_7904.t8 vss 5.49282e-15
Cpar6 a_5402_5861.t0 vss 3.61938e-15
Cpar7 a_5402_5861.t4 vss 2.20802e-15
Cpar8 a_6530_5861.t0 vss 2.57983e-15
Cpar9 a_6530_5861.t2 vss 9.10361e-15
Cpar10 a_6530_5861.t3 vss 3.43547e-15
Cpar11 ib vss 9.26527e-15
Cpar12 ib.t0 vss 1.36542e-15
Cpar13 ib.t1 vss 6.10541e-17
Cpar14 inn inp 5.20400e-17
Cpar15 inn vdd 4.44900e-17
Cpar16 inn vss 1.60691e-15
Cpar17 inn.t0 vss 2.86855e-16
Cpar18 inp out 1.55400e-17
Cpar19 inp vdd 3.05700e-17
Cpar20 inp vss 1.61669e-15
Cpar21 inp.t0 vss 2.88250e-16
Cpar22 out vdd 6.73231e-15
Cpar23 out vss 1.55610e-14
Cpar24 out.t0 vss 1.22475e-15
Cpar25 out.t2 vss 1.23253e-15
Cpar26 out.t8 vss 1.36619e-14
Cpar27 vdd vss 6.04854e-14
Cpar28 vdd.t0 vss 1.45960e-14
Cpar29 vdd.t1 vss 1.07941e-14
.ends opamp_dut

Vdd vdd 0 3.300000
Vss vss 0 0
Ibias vdd ib 2.166700e-06
Vinp inp 0 DC 1.645000 AC 1 PWL(0 1.645000 6.005404e-09 1.645000 6.605945e-09 1.655000)
Rfb out inn 1m
Cload out 0 2.000000e-13
Xdut vdd vss inp inn out ib opamp_dut
.end
