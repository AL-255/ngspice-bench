* opa1000[0456]: 200f/nmos_miller_3v3_i500u_subth (nmos_miller, VDD=3.3V, CL=0.2pF, Iref=50.0uA)
.include "pdk_opa.inc"
.temp 27
.option gmin=1e-12 rshunt=1e12 reltol=1e-3 abstol=1e-12 vntol=1e-5 method=gear
* Post-PEX R+C extracted netlist for nmos_miller_3v3_i500u_subth
.subckt opamp_dut vdd vss inp inn out ib
XMpar0 a_6702_8249.t0 inp.t0 a_880_6864.t0 vss.t0 nfet_03v3 w=1.97u l=0.28u ad=8.9213e-13 pd=3.0164e-06 as=8.7712e-13 ps=2.9543e-06 nf=1 m=84 par=84
XMpar1 out a_880_6864.t101 vdd.t1 vdd.t0 pfet_03v3 w=10u l=0.35u ad=2.8000e-12 pd=1.0560e-05 as=2.8800e-12 ps=1.0826e-05 nf=1 m=80 par=80
XMpar2 a_6702_8249.t0 inn.t0 a_8084_4461.t32 vss.t0 nfet_03v3 w=1.97u l=0.28u ad=8.9213e-13 pd=3.0164e-06 as=8.7712e-13 ps=2.9543e-06 nf=1 m=84 par=84
XMpar3 a_6702_8249.t84 ib.t0 vss.t34 vss.t0 nfet_03v3 w=2.73u l=0.36u ad=7.6440e-13 pd=3.2900e-06 as=8.7360e-13 ps=3.7112e-06 nf=1 m=32 par=32
XMpar4 a_8084_4461.t1 a_8084_4461.t0 vdd.t1 vdd.t0 pfet_03v3 w=10u l=0.35u ad=2.8000e-12 pd=1.0560e-05 as=2.8000e-12 ps=1.0560e-05 nf=1 m=16 par=16
XMpar5 out.t2 ib.t0 vss.t34 vss.t0 nfet_03v3 w=2.73u l=0.36u ad=7.6440e-13 pd=3.2900e-06 as=7.6440e-13 ps=3.2900e-06 nf=1 m=80 par=80
XMpar6 ib ib.t0 vss.t34 vss.t0 nfet_03v3 w=2.73u l=0.36u ad=7.6440e-13 pd=3.2900e-06 as=8.7360e-13 ps=3.7112e-06 nf=1 m=16 par=16
XMpar7 a_880_6864.t84 a_8084_4461.t0 vdd.t1 vdd.t0 pfet_03v3 w=10u l=0.35u ad=2.8000e-12 pd=1.0560e-05 as=3.2000e-12 ps=1.1890e-05 nf=1 m=16 par=16
X184 a_1212_6864.t1 out.t69 cap_mim_2f0fF c_width=19.63u c_length=19.62u
X392 a_880_6864.t100 a_1212_6864.t0 vss.t233 ppolyf_u_1k r_width=1u r_length=1u
Rpar0 a_1212_6864.t0 a_1212_6864.t1 47.6764
Rpar1 a_6702_8249.t0 a_6702_8249.t84 55.4669
Rpar2 a_8084_4461.t0 a_8084_4461.t1 18.2131
Rpar3 a_8084_4461.t0 a_8084_4461.t32 1915.0746
Rpar4 a_8084_4461.t1 a_8084_4461.t32 37.6441
Rpar5 a_880_6864.t0 a_880_6864.t100 154.9217
Rpar6 a_880_6864.t0 a_880_6864.t101 242.0006
Rpar7 a_880_6864.t0 a_880_6864.t84 120.3006
Rpar8 a_880_6864.t100 a_880_6864.t101 239.5428
Rpar9 a_880_6864.t100 a_880_6864.t84 119.0788
Rpar10 a_880_6864.t101 a_880_6864.t84 105.8883
Rpar11 ib ib.t0 9.6502
Rpar12 inn inn.t0 2.5715
Rpar13 inp inp.t0 2.5715
Rpar14 out out.t2 133.1231
Rpar15 out out.t69 58.8808
Rpar16 out.t2 out.t69 217.7395
Rpar17 vdd vdd.t0 58.6907
Rpar18 vdd vdd.t1 725.6107
Rpar19 vdd.t0 vdd.t1 1.5252
Rpar20 vss vss.t0 82.6426
Rpar21 vss vss.t34 350.9240
Rpar22 vss vss.t233 553.7496
Rpar23 vss.t0 vss.t34 2.1906
Rpar24 vss.t0 vss.t233 63.6358
Rpar25 vss.t34 vss.t233 341.3832
Cpar0 a_1212_6864.t0 vss 3.36000e-17
Cpar1 a_1212_6864.t1 vss 2.54338e-15
Cpar2 a_6702_8249.t0 vss 8.88556e-14
Cpar3 a_6702_8249.t84 vss 2.72088e-14
Cpar4 a_8084_4461.t0 vss 2.89755e-14
Cpar5 a_8084_4461.t1 vss 3.50349e-14
Cpar6 a_8084_4461.t32 vss 5.28578e-14
Cpar7 a_880_6864.t0 vss 5.10316e-14
Cpar8 a_880_6864.t100 vss 3.21288e-15
Cpar9 a_880_6864.t101 vss 7.51121e-14
Cpar10 a_880_6864.t84 vss 3.12722e-14
Cpar11 ib out 6.58849e-15
Cpar12 ib vdd 1.02650e-16
Cpar13 ib vss 7.97072e-14
Cpar14 ib.t0 vss 6.79512e-15
Cpar15 inn inp 2.22980e-16
Cpar16 inn vdd 5.28000e-17
Cpar17 inn vss 3.42529e-14
Cpar18 inn.t0 vss 1.66143e-14
Cpar19 inp out 3.39800e-17
Cpar20 inp vdd 5.44600e-17
Cpar21 inp vss 3.42889e-14
Cpar22 inp.t0 vss 1.66088e-14
Cpar23 out vdd 1.77800e-13
Cpar24 out vss 2.16964e-13
Cpar25 out.t2 vss 5.85506e-14
Cpar26 out.t69 vss 1.94343e-14
Cpar27 vdd vss 2.49069e-13
Cpar28 vdd.t0 vss 1.92375e-13
Cpar29 vdd.t1 vss 9.81099e-14
.ends opamp_dut

Vdd vdd 0 3.300000
Vss vss 0 0
Ibias vdd ib 5.000000e-05
Vinp inp 0 DC 1.645000 AC 1 PWL(0 1.645000 3.000000e-09 1.645000 3.300000e-09 1.655000)
Rfb out inn 1m
Cload out 0 2.000000e-13
Xdut vdd vss inp inn out ib opamp_dut
.end
