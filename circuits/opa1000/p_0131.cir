* opa1000[0131]: 2p/current_reuse_1v8_0p1u_1u_weak (current_reuse, VDD=1.8V, CL=2.0pF, Iref=0.0929uA)
.include "pdk_opa.inc"
.temp 27
.option gmin=1e-12 rshunt=1e12 reltol=1e-3 abstol=1e-12 vntol=1e-5 method=gear
* Post-PEX R+C extracted netlist for current_reuse_1v8_0p1u_1u_weak
.subckt opamp_dut vdd vss inp inn out ib
XMpar0 a_3324_1294.t2 ib.t0 vss.t5 vss.t4 nfet_03v3 w=0.4u l=3u ad=2.4000e-13 pd=2.0000e-06 as=1.1200e-13 ps=9.6000e-07 nf=1 m=4 par=4
XMpar1 a_1018_4471.t0 inp.t0 a_3324_1294.t0 vss.t1 nfet_03v3 w=1.52u l=6.5u ad=4.2560e-13 pd=2.0800e-06 as=9.1200e-13 ps=4.2400e-06 nf=1 m=2 par=2
XMpar2 ib.t1 ib.t0 vss.t5 vss.t4 nfet_03v3 w=0.4u l=3u ad=2.4000e-13 pd=2.0000e-06 as=1.1200e-13 ps=9.6000e-07 nf=1 m=2 par=2
XMpar3 a_1018_4471.t2 inp.t2 a_3490_13781.t0 vdd.t4 pfet_03v3 w=1.47u l=6.5u ad=4.1160e-13 pd=2.0300e-06 as=6.4680e-13 ps=3.0850e-06 nf=1 m=4 par=4
XMpar4 a_3490_13781.t0 inn.t2 a_8944_9900.t0 vdd.t4 pfet_03v3 w=1.47u l=6.5u ad=6.4680e-13 pd=3.0850e-06 as=4.1160e-13 ps=2.0300e-06 nf=1 m=4 par=4
XMpar5 out.t5 ib.t0 vss.t5 vss.t4 nfet_03v3 w=0.4u l=3u ad=1.8880e-13 pd=1.5840e-06 as=1.6320e-13 ps=1.3760e-06 nf=1 m=10 par=10
XMpar6 out.t0 a_1018_4471.t8 vdd.t1 vdd.t0 pfet_03v3 w=0.94u l=2.5u ad=2.6320e-13 pd=1.5000e-06 as=3.2336e-13 ps=1.8160e-06 nf=1 m=10 par=10
XMpar7 a_1018_4471.t6 a_8944_9900.t6 vdd.t1 vdd.t0 pfet_03v3 w=0.94u l=2.5u ad=5.6400e-13 pd=3.0800e-06 as=2.6320e-13 ps=1.5000e-06 nf=1 m=1
XMpar8 a_3490_13781.t8 a_8944_9900.t6 vdd.t1 vdd.t0 pfet_03v3 w=0.94u l=2.5u ad=2.6320e-13 pd=1.5000e-06 as=5.6400e-13 ps=3.0800e-06 nf=1 m=2 par=2
XMpar9 a_8944_9900.t7 a_8944_9900.t6 vdd.t1 vdd.t0 pfet_03v3 w=0.94u l=2.5u ad=5.6400e-13 pd=3.0800e-06 as=2.6320e-13 ps=1.5000e-06 nf=1 m=1
XMpar10 a_3324_1294.t0 inn.t0 a_8944_9900.t2 vss.t1 nfet_03v3 w=1.52u l=6.5u ad=9.1200e-13 pd=4.2400e-06 as=4.2560e-13 ps=2.0800e-06 nf=1 m=2 par=2
X0 a_1215_6848.t0 a_5099_6328.t0 vss.t0 ppolyf_u_1k r_width=1u r_length=18.76u
X6 a_1215_8928.t0 a_5099_9448.t0 vss.t0 ppolyf_u_1k r_width=1u r_length=18.76u
X8 a_1018_4471.t7 a_5099_6328.t0 vss.t0 ppolyf_u_1k r_width=1u r_length=18.76u
X12 a_1215_8928.t0 a_5099_8408.t0 vss.t0 ppolyf_u_1k r_width=1u r_length=18.76u
X19 a_1215_7888.t0 a_5099_8408.t0 vss.t0 ppolyf_u_1k r_width=1u r_length=18.76u
X26 a_1215_9968.t1 out.t3 cap_mim_2f0fF c_width=17.1u c_length=17.11u
X32 a_1215_7888.t0 a_5099_7368.t0 vss.t0 ppolyf_u_1k r_width=1u r_length=18.76u
X38 a_1215_9968.t1 out.t3 cap_mim_2f0fF c_width=17.1u c_length=17.11u
X46 a_1215_6848.t0 a_5099_7368.t0 vss.t0 ppolyf_u_1k r_width=1u r_length=18.76u
X49 a_1215_9968.t1 out.t3 cap_mim_2f0fF c_width=17.1u c_length=17.11u
X50 a_1215_9968.t0 a_5099_9448.t0 vss.t0 ppolyf_u_1k r_width=1u r_length=18.76u
Rpar0 a_1018_4471.t0 a_1018_4471.t8 409.9163
Rpar1 a_1018_4471.t0 a_1018_4471.t2 107.5592
Rpar2 a_1018_4471.t0 a_1018_4471.t6 197.6199
Rpar3 a_1018_4471.t0 a_1018_4471.t7 197.7100
Rpar4 a_1018_4471.t8 a_1018_4471.t2 542.3871
Rpar5 a_1018_4471.t8 a_1018_4471.t6 345.5321
Rpar6 a_1018_4471.t8 a_1018_4471.t7 165.0213
Rpar7 a_1018_4471.t2 a_1018_4471.t6 261.4838
Rpar8 a_1018_4471.t2 a_1018_4471.t7 261.6030
Rpar9 a_1018_4471.t6 a_1018_4471.t7 166.6563
Rpar10 a_1215_9968.t0 a_1215_9968.t1 82.8217
Rpar11 a_3324_1294.t0 a_3324_1294.t2 88.5858
Rpar12 a_3490_13781.t0 a_3490_13781.t8 55.4602
Rpar13 a_8944_9900.t0 a_8944_9900.t6 107.4809
Rpar14 a_8944_9900.t0 a_8944_9900.t2 176.8948
Rpar15 a_8944_9900.t0 a_8944_9900.t7 551.4341
Rpar16 a_8944_9900.t6 a_8944_9900.t2 64.7698
Rpar17 a_8944_9900.t6 a_8944_9900.t7 28.5239
Rpar18 a_8944_9900.t2 a_8944_9900.t7 212.0689
Rpar19 ib ib.t0 13.8487
Rpar20 ib ib.t1 14.4742
Rpar21 ib.t0 ib.t1 34.3584
Rpar22 inn inn.t0 3.5360
Rpar23 inn inn.t2 53.7658
Rpar24 inp inp.t0 3.5847
Rpar25 inp inp.t2 43.1728
Rpar26 out out.t0 4.0545
Rpar27 out out.t5 147.1567
Rpar28 out out.t3 545.3670
Rpar29 out.t0 out.t5 94.1649
Rpar30 out.t0 out.t3 348.9779
Rpar31 out.t5 out.t3 85.5694
Rpar32 vdd vdd.t0 317.7587
Rpar33 vdd vdd.t1 188.0887
Rpar34 vdd vdd.t4 23.8150
Rpar35 vdd.t0 vdd.t1 4.5536
Rpar36 vdd.t0 vdd.t4 158.2997
Rpar37 vdd.t1 vdd.t4 93.7012
Rpar38 vss vss.t0 407.3821
Rpar39 vss vss.t1 243.2069
Rpar40 vss vss.t4 398.5230
Rpar41 vss vss.t5 49.4492
Rpar42 vss.t0 vss.t1 154.6831
Rpar43 vss.t0 vss.t4 55.3057
Rpar44 vss.t0 vss.t5 176.1241
Rpar45 vss.t1 vss.t4 35.9104
Rpar46 vss.t1 vss.t5 101.3573
Rpar47 vss.t4 vss.t5 13.9424
Cpar0 a_1018_4471.t0 vss 3.84393e-15
Cpar1 a_1018_4471.t2 vss 5.02200e-15
Cpar2 a_1018_4471.t6 vss 3.19090e-15
Cpar3 a_1018_4471.t7 vss 4.38655e-15
Cpar4 a_1018_4471.t8 vss 1.57467e-14
Cpar5 a_1215_6848.t0 vss 3.94200e-17
Cpar6 a_1215_7888.t0 vss 3.67600e-17
Cpar7 a_1215_8928.t0 vss 4.04600e-17
Cpar8 a_1215_9968.t0 vss 1.09950e-16
Cpar9 a_1215_9968.t1 vss 7.95828e-15
Cpar10 a_3324_1294.t0 vss 8.11017e-15
Cpar11 a_3324_1294.t2 vss 1.16752e-14
Cpar12 a_3490_13781.t0 vss 1.12906e-14
Cpar13 a_3490_13781.t8 vss 2.87855e-15
Cpar14 a_5099_6328.t0 vss 3.43800e-17
Cpar15 a_5099_7368.t0 vss 3.48000e-17
Cpar16 a_5099_8408.t0 vss 3.48000e-17
Cpar17 a_5099_9448.t0 vss 3.89400e-17
Cpar18 a_8944_9900.t0 vss 6.50543e-15
Cpar19 a_8944_9900.t2 vss 4.45945e-15
Cpar20 a_8944_9900.t6 vss 1.20544e-14
Cpar21 a_8944_9900.t7 vss 2.81714e-15
Cpar22 ib out 2.17581e-15
Cpar23 ib vdd 1.21800e-17
Cpar24 ib vss 3.93245e-14
Cpar25 ib.t0 vss 6.84774e-15
Cpar26 ib.t1 vss 5.91876e-16
Cpar27 inn inp 1.03750e-16
Cpar28 inn vdd 1.37239e-14
Cpar29 inn vss 1.16152e-14
Cpar30 inn.t0 vss 3.65667e-15
Cpar31 inn.t2 vss 1.26568e-14
Cpar32 inp vdd 1.22331e-14
Cpar33 inp vss 1.09393e-14
Cpar34 inp.t0 vss 3.27348e-15
Cpar35 inp.t2 vss 1.10365e-14
Cpar36 out vdd 7.99420e-15
Cpar37 out vss 2.48728e-14
Cpar38 out.t0 vss 1.42515e-15
Cpar39 out.t3 vss 1.77063e-14
Cpar40 out.t5 vss 5.06845e-15
Cpar41 vdd vss 1.30780e-13
Cpar42 vdd.t0 vss 1.78534e-14
Cpar43 vdd.t1 vss 1.47692e-14
Cpar44 vdd.t4 vss 2.97253e-14
.ends opamp_dut

Vdd vdd 0 1.800000
Vss vss 0 0
Ibias vdd ib 9.290000e-08
Vinp inp 0 DC 0.895000 AC 1 PWL(0 0.895000 4.700236e-07 0.895000 5.170260e-07 0.905000)
Rfb out inn 1m
Cload out 0 2.000000e-12
Xdut vdd vss inp inn out ib opamp_dut
.end
