* opa1000[0632]: 2p/pmos_miller_1v8_i1u_weak (pmos_miller, VDD=1.8V, CL=2.0pF, Iref=0.1437uA)
.include "pdk_opa.inc"
.temp 27
.option gmin=1e-12 rshunt=1e12 reltol=1e-3 abstol=1e-12 vntol=1e-5 method=gear
* Post-PEX R+C extracted netlist for pmos_miller_1v8_i1u_weak
.subckt opamp_dut vdd vss inp inn out ib
XMpar0 out.t0 a_1876_4689.t0 vdd.t1 vdd.t0 pfet_03v3 w=1u l=3.5u ad=4.7200e-13 pd=2.5440e-06 as=4.0800e-13 ps=2.2160e-06 nf=1 m=10 par=10
XMpar1 ib.t1 ib.t0 vss.t9 vss.t8 nfet_03v3 w=0.4u l=3.5u ad=2.4000e-13 pd=2.0000e-06 as=1.1200e-13 ps=9.6000e-07 nf=1 m=2 par=2
XMpar2 a_3388_4897.t2 a_1876_4689.t0 vdd.t1 vdd.t0 pfet_03v3 w=1u l=3.5u ad=6.0000e-13 pd=3.2000e-06 as=2.8000e-13 ps=1.5600e-06 nf=1 m=4 par=4
XMpar3 out.t1 a_6634_1294.t5 vss.t2 vss.t1 nfet_03v3 w=0.4u l=1.8u ad=1.3760e-13 pd=1.1680e-06 as=1.3760e-13 ps=1.1680e-06 nf=1 m=10 par=10
XMpar4 a_3388_4897.t0 inp.t0 a_6634_1294.t1 vdd.t4 pfet_03v3 w=2.38u l=4u ad=1.4280e-12 pd=5.9600e-06 as=6.6640e-13 ps=2.9400e-06 nf=1 m=2 par=2
XMpar5 a_7012_3027.t3 a_7012_3027.t2 vss.t2 vss.t1 nfet_03v3 w=0.4u l=1.8u ad=1.1200e-13 pd=9.6000e-07 as=1.1200e-13 ps=9.6000e-07 nf=1 m=2 par=2
XMpar6 a_3388_4897.t0 inn.t0 a_7012_3027.t0 vdd.t4 pfet_03v3 w=2.38u l=4u ad=1.4280e-12 pd=5.9600e-06 as=6.6640e-13 ps=2.9400e-06 nf=1 m=2 par=2
XMpar7 a_1876_4689.t1 a_1876_4689.t0 vdd.t1 vdd.t0 pfet_03v3 w=1u l=3.5u ad=6.0000e-13 pd=3.2000e-06 as=2.8000e-13 ps=1.5600e-06 nf=1 m=2 par=2
XMpar8 a_1876_4689.t4 ib.t0 vss.t9 vss.t8 nfet_03v3 w=0.4u l=3.5u ad=1.1200e-13 pd=9.6000e-07 as=1.1200e-13 ps=9.6000e-07 nf=1 m=2 par=2
XMpar9 a_6634_1294.t3 a_7012_3027.t2 vss.t2 vss.t1 nfet_03v3 w=0.4u l=1.8u ad=2.4000e-13 pd=2.0000e-06 as=1.1200e-13 ps=9.6000e-07 nf=1 m=2 par=2
X3 a_8594_9036.t0 a_12162_9556.t0 vss.t0 ppolyf_u_1k r_width=1u r_length=17.18u
X6 a_8594_11116.t0 a_12162_10596.t0 vss.t0 ppolyf_u_1k r_width=1u r_length=17.18u
X8 a_8594_9036.t0 a_12162_8516.t0 vss.t0 ppolyf_u_1k r_width=1u r_length=17.18u
X16 a_6634_1294.t0 a_12162_8516.t0 vss.t0 ppolyf_u_1k r_width=1u r_length=17.18u
X24 a_8594_10076.t0 a_12162_10596.t0 vss.t0 ppolyf_u_1k r_width=1u r_length=17.18u
X29 a_8594_10076.t0 a_12162_9556.t0 vss.t0 ppolyf_u_1k r_width=1u r_length=17.18u
X37 a_8594_11116.t1 out.t8 cap_mim_2f0fF c_width=14.37u c_length=14.36u
X45 a_8594_11116.t1 out.t8 cap_mim_2f0fF c_width=14.37u c_length=14.36u
Rpar0 a_1876_4689.t0 a_1876_4689.t1 15.1054
Rpar1 a_1876_4689.t0 a_1876_4689.t4 118.2681
Rpar2 a_1876_4689.t1 a_1876_4689.t4 92.5592
Rpar3 a_3388_4897.t0 a_3388_4897.t2 53.8072
Rpar4 a_6634_1294.t0 a_6634_1294.t1 1052.1166
Rpar5 a_6634_1294.t0 a_6634_1294.t5 170.8338
Rpar6 a_6634_1294.t0 a_6634_1294.t3 377.1410
Rpar7 a_6634_1294.t1 a_6634_1294.t5 236.2027
Rpar8 a_6634_1294.t1 a_6634_1294.t3 92.5383
Rpar9 a_6634_1294.t5 a_6634_1294.t3 84.6690
Rpar10 a_7012_3027.t0 a_7012_3027.t2 108.1464
Rpar11 a_7012_3027.t0 a_7012_3027.t3 111.4427
Rpar12 a_7012_3027.t2 a_7012_3027.t3 30.2865
Rpar13 a_8594_11116.t0 a_8594_11116.t1 57.1314
Rpar14 ib ib.t0 16.8673
Rpar15 ib ib.t1 9.1722
Rpar16 ib.t0 ib.t1 89.7381
Rpar17 inn inn.t0 4.2033
Rpar18 inp inp.t0 4.2519
Rpar19 out out.t0 5.4684
Rpar20 out out.t1 144.8275
Rpar21 out out.t8 734.0903
Rpar22 out.t0 out.t1 55.8360
Rpar23 out.t0 out.t8 283.0174
Rpar24 out.t1 out.t8 216.1464
Rpar25 vdd vdd.t0 39.3690
Rpar26 vdd vdd.t1 740.1510
Rpar27 vdd vdd.t4 180.5067
Rpar28 vdd.t0 vdd.t1 11.8548
Rpar29 vdd.t0 vdd.t4 142.5651
Rpar30 vdd.t1 vdd.t4 2680.2716
Rpar31 vss vss.t0 913.2790
Rpar32 vss vss.t1 65.1900
Rpar33 vss vss.t8 360.6298
Rpar34 vss vss.t9 868.5193
Rpar35 vss vss.t2 127.1825
Rpar36 vss.t0 vss.t1 15.1831
Rpar37 vss.t0 vss.t8 42.4279
Rpar38 vss.t0 vss.t9 174.7592
Rpar39 vss.t0 vss.t2 200.2827
Rpar40 vss.t1 vss.t8 2.9153
Rpar41 vss.t1 vss.t9 13.5997
Rpar42 vss.t1 vss.t2 7.6039
Rpar43 vss.t8 vss.t9 46.8789
Rpar44 vss.t8 vss.t2 52.3316
Rpar45 vss.t9 vss.t2 255.7026
Cpar0 a_12162_10596.t0 vss 3.59000e-17
Cpar1 a_12162_8516.t0 vss 3.48400e-17
Cpar2 a_12162_9556.t0 vss 3.71400e-17
Cpar3 a_1876_4689.t0 vss 4.32193e-14
Cpar4 a_1876_4689.t1 vss 7.70373e-15
Cpar5 a_1876_4689.t4 vss 3.68356e-15
Cpar6 a_3388_4897.t0 vss 9.92749e-15
Cpar7 a_3388_4897.t2 vss 1.57016e-14
Cpar8 a_6634_1294.t0 vss 3.63037e-15
Cpar9 a_6634_1294.t1 vss 1.93806e-15
Cpar10 a_6634_1294.t3 vss 2.22576e-15
Cpar11 a_6634_1294.t5 vss 6.50445e-15
Cpar12 a_7012_3027.t0 vss 1.45205e-15
Cpar13 a_7012_3027.t2 vss 2.49436e-15
Cpar14 a_7012_3027.t3 vss 7.66023e-16
Cpar15 a_8594_10076.t0 vss 4.32800e-17
Cpar16 a_8594_11116.t0 vss 1.16990e-16
Cpar17 a_8594_11116.t1 vss 5.41178e-15
Cpar18 a_8594_9036.t0 vss 4.30400e-17
Cpar19 ib vss 1.13993e-14
Cpar20 ib.t0 vss 1.27892e-15
Cpar21 ib.t1 vss 8.44259e-17
Cpar22 inn inp 5.19700e-17
Cpar23 inn vdd 3.93946e-15
Cpar24 inn vss 2.04511e-15
Cpar25 inn.t0 vss 3.23831e-15
Cpar26 inp vdd 3.99242e-15
Cpar27 inp vss 2.02228e-15
Cpar28 inp.t0 vss 3.29452e-15
Cpar29 out vdd 1.47055e-14
Cpar30 out vss 2.13238e-14
Cpar31 out.t0 vss 6.80506e-15
Cpar32 out.t1 vss 5.36674e-15
Cpar33 out.t8 vss 2.05475e-14
Cpar34 vdd vss 1.31891e-13
Cpar35 vdd.t0 vss 4.74715e-14
Cpar36 vdd.t1 vss 5.12056e-15
Cpar37 vdd.t4 vss 1.37642e-14
.ends opamp_dut

Vdd vdd 0 1.800000
Vss vss 0 0
Ibias vdd ib 1.437000e-07
Vinp inp 0 DC 0.805000 AC 1 PWL(0 0.805000 2.640212e-07 0.805000 2.904233e-07 0.815000)
Rfb out inn 1m
Cload out 0 2.000000e-12
Xdut vdd vss inp inn out ib opamp_dut
.end
