* opa1000[0387]: 2p/nmos_5t_1v8_1u_10u_weak (nmos_5t, VDD=1.8V, CL=2.0pF, Iref=1.625uA)
.include "pdk_opa.inc"
.temp 27
.option gmin=1e-12 rshunt=1e12 reltol=1e-3 abstol=1e-12 vntol=1e-5 method=gear
* Post-PEX R+C extracted netlist for nmos_5t_1v8_1u_10u_weak
.subckt opamp_dut vdd vss inp inn out ib
XMpar0 a_1970_5855.t0 inn.t0 out.t0 vss.t0 nfet_03v3 w=1.83u l=3.2u ad=8.0520e-13 pd=3.6250e-06 as=5.1240e-13 ps=2.3900e-06 nf=1 m=12 par=12
XMpar1 out.t12 a_1300_9487.t12 vdd.t1 vdd.t0 pfet_03v3 w=1.97u l=2u ad=5.5160e-13 pd=2.5300e-06 as=6.3040e-13 ps=2.8562e-06 nf=1 m=8 par=8
XMpar2 a_1300_9487.t0 inp.t0 a_1970_5855.t0 vss.t0 nfet_03v3 w=1.83u l=3.2u ad=5.1240e-13 pd=2.3900e-06 as=8.0520e-13 ps=3.6250e-06 nf=1 m=12 par=12
XMpar3 a_1970_5855.t12 ib.t0 vss.t5 vss.t4 nfet_03v3 w=2.59u l=3u ad=7.2520e-13 pd=3.1500e-06 as=1.3468e-12 ps=5.5725e-06 nf=1 m=8 par=8
XMpar4 a_1300_9487.t13 a_1300_9487.t12 vdd.t1 vdd.t0 pfet_03v3 w=1.97u l=2u ad=5.5160e-13 pd=2.5300e-06 as=6.3040e-13 ps=2.8562e-06 nf=1 m=8 par=8
XMpar5 ib.t1 ib.t0 vss.t5 vss.t4 nfet_03v3 w=2.59u l=3u ad=1.5540e-12 pd=6.3800e-06 as=7.2520e-13 ps=3.1500e-06 nf=1 m=2 par=2
X2 out.t20 vss.t19 cap_mim_2f0fF c_width=15u c_length=15u
Rpar0 a_1300_9487.t0 a_1300_9487.t12 132.8654
Rpar1 a_1300_9487.t0 a_1300_9487.t13 52.6700
Rpar2 a_1300_9487.t12 a_1300_9487.t13 16.4597
Rpar3 a_1970_5855.t0 a_1970_5855.t12 38.5679
Rpar4 ib ib.t0 12.2045
Rpar5 ib ib.t1 9.5614
Rpar6 ib.t0 ib.t1 22.3813
Rpar7 inn inn.t0 2.0161
Rpar8 inp inp.t0 2.0161
Rpar9 out out.t0 54.2440
Rpar10 out out.t12 4.0940
Rpar11 out out.t20 117.4616
Rpar12 out.t0 out.t20 125.9222
Rpar13 vdd vdd.t0 24.5995
Rpar14 vdd vdd.t1 96.3122
Rpar15 vdd.t0 vdd.t1 4.6238
Rpar16 vss vss.t0 145.3083
Rpar17 vss vss.t4 202.7637
Rpar18 vss vss.t5 64.4215
Rpar19 vss vss.t19 103.0652
Rpar20 vss.t0 vss.t4 2.3372
Rpar21 vss.t0 vss.t5 19.3070
Rpar22 vss.t0 vss.t19 213.9753
Rpar23 vss.t4 vss.t5 22.4766
Rpar24 vss.t4 vss.t19 298.5818
Rpar25 vss.t5 vss.t19 94.8646
Cpar0 a_1300_9487.t0 vss 9.36874e-15
Cpar1 a_1300_9487.t12 vss 2.64153e-14
Cpar2 a_1300_9487.t13 vss 8.05312e-15
Cpar3 a_1970_5855.t0 vss 1.82456e-14
Cpar4 a_1970_5855.t12 vss 1.05687e-14
Cpar5 ib out 7.09500e-17
Cpar6 ib vss 2.77184e-14
Cpar7 ib.t0 vss 4.70431e-15
Cpar8 ib.t1 vss 7.88042e-16
Cpar9 inn inp 1.54210e-16
Cpar10 inn out 4.87171e-15
Cpar11 inn vdd 1.43100e-17
Cpar12 inn vss 1.77628e-14
Cpar13 inn.t0 vss 7.36403e-15
Cpar14 inp out 9.28000e-17
Cpar15 inp vdd 1.43100e-17
Cpar16 inp vss 1.77988e-14
Cpar17 inp.t0 vss 7.31085e-15
Cpar18 out vdd 6.36485e-15
Cpar19 out vss 1.58954e-14
Cpar20 out.t0 vss 2.24776e-15
Cpar21 out.t12 vss 1.01596e-15
Cpar22 out.t20 vss 2.03372e-14
Cpar23 vdd vss 5.89574e-14
Cpar24 vdd.t0 vss 2.03806e-14
Cpar25 vdd.t1 vss 7.06337e-15
.ends opamp_dut

Vdd vdd 0 1.800000
Vss vss 0 0
Ibias vdd ib 1.625000e-06
Vinp inp 0 DC 0.895000 AC 1 PWL(0 0.895000 3.115165e-08 0.895000 3.426682e-08 0.905000)
Rfb out inn 1m
Cload out 0 2.000000e-12
Xdut vdd vss inp inn out ib opamp_dut
.end
