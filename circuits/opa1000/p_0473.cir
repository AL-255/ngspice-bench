* opa1000[0473]: 2p/nmos_miller_1v8_i20u_subth (nmos_miller, VDD=1.8V, CL=2.0pF, Iref=2.4286uA)
.include "pdk_opa.inc"
.temp 27
.option gmin=1e-12 rshunt=1e12 reltol=1e-3 abstol=1e-12 vntol=1e-5 method=gear
* Post-PEX R+C extracted netlist for nmos_miller_1v8_i20u_subth
.subckt opamp_dut vdd vss inp inn out ib
XMpar0 out.t0 ib.t0 vss.t9 vss.t0 nfet_03v3 w=4.81u l=1.5u ad=1.6546e-12 pd=6.4600e-06 as=1.3468e-12 ps=5.3700e-06 nf=1 m=10 par=10
XMpar1 a_3139_6689.t8 ib.t0 vss.t9 vss.t0 nfet_03v3 w=4.81u l=1.5u ad=1.3468e-12 pd=5.3700e-06 as=1.3468e-12 ps=5.3700e-06 nf=1 m=4 par=4
XMpar2 a_3139_6689.t0 inp.t0 a_3509_1290.t0 vss.t0 nfet_03v3 w=1.97u l=0.65u ad=7.0920e-13 pd=3.1825e-06 as=5.5160e-13 ps=2.5300e-06 nf=1 m=8 par=8
XMpar3 out.t2 a_3509_1290.t11 vdd.t1 vdd.t0 pfet_03v3 w=10u l=0.75u ad=2.8000e-12 pd=1.0560e-05 as=3.4400e-12 ps=1.2688e-05 nf=1 m=10 par=10
XMpar4 a_3139_6689.t0 inn.t0 a_6472_1041.t4 vss.t0 nfet_03v3 w=1.97u l=0.65u ad=7.0920e-13 pd=3.1825e-06 as=5.5160e-13 ps=2.5300e-06 nf=1 m=8 par=8
XMpar5 ib.t1 ib.t0 vss.t9 vss.t0 nfet_03v3 w=4.81u l=1.5u ad=1.3468e-12 pd=5.3700e-06 as=1.3468e-12 ps=5.3700e-06 nf=1 m=2 par=2
XMpar6 a_6472_1041.t1 a_6472_1041.t0 vdd.t1 vdd.t0 pfet_03v3 w=10u l=0.75u ad=2.8000e-12 pd=1.0560e-05 as=2.8000e-12 ps=1.0560e-05 nf=1 m=2 par=2
XMpar7 a_3509_1290.t8 a_6472_1041.t0 vdd.t1 vdd.t0 pfet_03v3 w=10u l=0.75u ad=6.0000e-12 pd=2.1200e-05 as=2.8000e-12 ps=1.0560e-05 nf=1 m=2 par=2
X0 a_4725_1290.t1 out.t9 cap_mim_2f0fF c_width=16.58u c_length=16.59u
X28 a_3509_1290.t10 a_4725_1290.t0 vss.t40 ppolyf_u_1k r_width=1u r_length=5.42u
X45 a_4725_1290.t1 out.t9 cap_mim_2f0fF c_width=16.58u c_length=16.59u
Rpar0 a_3139_6689.t0 a_3139_6689.t8 57.9651
Rpar1 a_3509_1290.t0 a_3509_1290.t10 87.9021
Rpar2 a_3509_1290.t0 a_3509_1290.t11 149.5412
Rpar3 a_3509_1290.t0 a_3509_1290.t8 71.4454
Rpar4 a_3509_1290.t10 a_3509_1290.t11 111.8844
Rpar5 a_3509_1290.t10 a_3509_1290.t8 122.4164
Rpar6 a_3509_1290.t11 a_3509_1290.t8 208.2579
Rpar7 a_4725_1290.t0 a_4725_1290.t1 79.6344
Rpar8 a_6472_1041.t0 a_6472_1041.t1 38.6364
Rpar9 a_6472_1041.t0 a_6472_1041.t4 347.7174
Rpar10 a_6472_1041.t1 a_6472_1041.t4 71.2752
Rpar11 ib ib.t0 25.6564
Rpar12 ib ib.t1 10.8307
Rpar13 ib.t0 ib.t1 55.2793
Rpar14 inn inn.t0 3.6906
Rpar15 inp inp.t0 4.0682
Rpar16 out out.t0 66.7425
Rpar17 out out.t2 239.8687
Rpar18 out out.t9 22.4775
Rpar19 out.t0 out.t2 69.6437
Rpar20 out.t0 out.t9 392.4035
Rpar21 out.t2 out.t9 1410.2748
Rpar22 vdd vdd.t0 92.4730
Rpar23 vdd vdd.t1 227.6146
Rpar24 vdd.t0 vdd.t1 3.5839
Rpar25 vss vss.t0 45.4632
Rpar26 vss vss.t9 429.7303
Rpar27 vss vss.t40 28.5061
Rpar28 vss.t0 vss.t9 4.2474
Rpar29 vss.t0 vss.t40 114.9194
Rpar30 vss.t9 vss.t40 1235.6397
Cpar0 a_3139_6689.t0 vss 1.07967e-14
Cpar1 a_3139_6689.t8 vss 8.00782e-15
Cpar2 a_3509_1290.t0 vss 3.89431e-15
Cpar3 a_3509_1290.t10 vss 1.81347e-15
Cpar4 a_3509_1290.t11 vss 1.23377e-14
Cpar5 a_3509_1290.t8 vss 5.51415e-15
Cpar6 a_4725_1290.t0 vss 1.55282e-16
Cpar7 a_4725_1290.t1 vss 5.87132e-15
Cpar8 a_6472_1041.t0 vss 5.64251e-15
Cpar9 a_6472_1041.t1 vss 5.68948e-15
Cpar10 a_6472_1041.t4 vss 4.75826e-15
Cpar11 ib out 2.65006e-15
Cpar12 ib vss 2.44007e-14
Cpar13 ib.t0 vss 5.80247e-15
Cpar14 ib.t1 vss 4.54889e-16
Cpar15 inn inp 5.24300e-17
Cpar16 inn out 2.19200e-17
Cpar17 inn vdd 1.48100e-17
Cpar18 inn vss 5.16863e-15
Cpar19 inn.t0 vss 7.51055e-16
Cpar20 inp vdd 1.33200e-17
Cpar21 inp vss 5.12369e-15
Cpar22 inp.t0 vss 8.30951e-16
Cpar23 out vdd 1.74968e-14
Cpar24 out vss 1.92484e-14
Cpar25 out.t0 vss 7.27378e-15
Cpar26 out.t2 vss 9.20581e-15
Cpar27 out.t9 vss 1.41670e-14
Cpar28 vdd vss 7.20432e-14
Cpar29 vdd.t0 vss 2.21583e-14
Cpar30 vdd.t1 vss 1.23536e-14
.ends opamp_dut

Vdd vdd 0 1.800000
Vss vss 0 0
Ibias vdd ib 2.428600e-06
Vinp inp 0 DC 0.895000 AC 1 PWL(0 0.895000 1.533956e-08 0.895000 1.687351e-08 0.905000)
Rfb out inn 1m
Cload out 0 2.000000e-12
Xdut vdd vss inp inn out ib opamp_dut
.end
