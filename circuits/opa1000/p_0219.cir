* opa1000[0219]: 2p/folded_cascode_nmos_1v8_1u_10u_weak (folded_cascode_nmos, VDD=1.8V, CL=2.0pF, Iref=1.2778uA)
.include "pdk_opa.inc"
.temp 27
.option gmin=1e-12 rshunt=1e12 reltol=1e-3 abstol=1e-12 vntol=1e-5 method=gear
* Post-PEX R+C extracted netlist for folded_cascode_nmos_1v8_1u_10u_weak
.subckt opamp_dut vdd vss inp inn out ib
XMpar0 a_2458_1249.t16 a_1242_3940.t0 vdd.t1 vdd.t0 pfet_03v3 w=5.84u l=3.13u ad=1.6352e-12 pd=6.4000e-06 as=2.5696e-12 ps=9.6400e-06 nf=1 m=4 par=4
XMpar1 a_1698_1249.t0 inn.t0 a_5774_1249.t9 vss.t0 nfet_03v3 w=1.93u l=3.2u ad=6.6392e-13 pd=3.0040e-06 as=6.6392e-13 ps=3.0040e-06 nf=1 m=10 par=10
XMpar2 a_1242_3940.t1 a_1242_3940.t0 vdd.t1 vdd.t0 pfet_03v3 w=5.84u l=3.13u ad=1.6352e-12 pd=6.4000e-06 as=3.5040e-12 ps=1.2880e-05 nf=1 m=2 par=2
XMpar3 a_1242_3940.t4 ib.t0 vss.t6 vss.t0 nfet_03v3 w=1.53u l=2.5u ad=4.2840e-13 pd=2.0900e-06 as=4.2840e-13 ps=2.0900e-06 nf=1 m=2 par=2
XMpar4 a_1698_1249.t0 inp.t0 a_2458_1249.t0 vss.t0 nfet_03v3 w=1.93u l=3.2u ad=6.6392e-13 pd=3.0040e-06 as=6.6392e-13 ps=3.0040e-06 nf=1 m=10 par=10
XMpar5 a_2458_1249.t10 ib.t10 a_3906_7856.t4 vdd.t4 pfet_03v3 w=1.62u l=1u ad=6.2640e-13 pd=2.9333e-06 as=4.5360e-13 ps=2.1800e-06 nf=1 m=6 par=6
XMpar6 a_1698_1249.t10 ib.t0 vss.t6 vss.t0 nfet_03v3 w=1.53u l=2.5u ad=4.2840e-13 pd=2.0900e-06 as=4.2840e-13 ps=2.0900e-06 nf=1 m=4 par=4
XMpar7 out.t3 a_3906_7856.t0 vss.t6 vss.t0 nfet_03v3 w=1.53u l=2.5u ad=4.2840e-13 pd=2.0900e-06 as=4.2840e-13 ps=2.0900e-06 nf=1 m=2 par=2
XMpar8 ib.t1 ib.t0 vss.t6 vss.t0 nfet_03v3 w=1.53u l=2.5u ad=9.1800e-13 pd=4.2600e-06 as=4.2840e-13 ps=2.0900e-06 nf=1 m=2 par=2
XMpar9 a_3906_7856.t1 a_3906_7856.t0 vss.t6 vss.t0 nfet_03v3 w=1.53u l=2.5u ad=9.1800e-13 pd=4.2600e-06 as=4.2840e-13 ps=2.0900e-06 nf=1 m=2 par=2
XMpar10 a_5774_1249.t0 a_1242_3940.t0 vdd.t1 vdd.t0 pfet_03v3 w=5.84u l=3.13u ad=1.6352e-12 pd=6.4000e-06 as=2.5696e-12 ps=9.6400e-06 nf=1 m=4 par=4
XMpar11 a_5774_1249.t1 ib.t10 out.t0 vdd.t4 pfet_03v3 w=1.62u l=1u ad=6.2640e-13 pd=2.9333e-06 as=4.5360e-13 ps=2.1800e-06 nf=1 m=6 par=6
Rpar0 a_1242_3940.t0 a_1242_3940.t1 22.3518
Rpar1 a_1242_3940.t0 a_1242_3940.t4 63.8764
Rpar2 a_1242_3940.t1 a_1242_3940.t4 80.3204
Rpar3 a_1698_1249.t0 a_1698_1249.t10 59.2109
Rpar4 a_2458_1249.t0 a_2458_1249.t10 63.8038
Rpar5 a_2458_1249.t0 a_2458_1249.t16 184.1252
Rpar6 a_2458_1249.t10 a_2458_1249.t16 58.8558
Rpar7 a_3906_7856.t0 a_3906_7856.t1 18.4194
Rpar8 a_3906_7856.t0 a_3906_7856.t4 190.5378
Rpar9 a_3906_7856.t1 a_3906_7856.t4 80.4748
Rpar10 a_5774_1249.t0 a_5774_1249.t1 58.8558
Rpar11 a_5774_1249.t0 a_5774_1249.t9 184.1252
Rpar12 a_5774_1249.t1 a_5774_1249.t9 63.8038
Rpar13 ib ib.t0 21.7067
Rpar14 ib ib.t1 6.1173
Rpar15 ib ib.t10 112.7009
Rpar16 ib.t0 ib.t1 45.6031
Rpar17 ib.t0 ib.t10 285.0383
Rpar18 ib.t1 ib.t10 236.7700
Rpar19 inn inn.t0 1.9758
Rpar20 inp inp.t0 1.9758
Rpar21 out out.t0 62.0838
Rpar22 out out.t3 10.2025
Rpar23 out.t0 out.t3 468.4443
Rpar24 vdd vdd.t0 29.9247
Rpar25 vdd vdd.t1 85.3911
Rpar26 vdd vdd.t4 306.4270
Rpar27 vdd.t0 vdd.t1 4.3577
Rpar28 vdd.t0 vdd.t4 116.5291
Rpar29 vdd.t1 vdd.t4 177.7535
Rpar30 vss vss.t0 73.0372
Rpar31 vss vss.t6 302.8413
Rpar32 vss.t0 vss.t6 3.2218
Cpar0 a_1242_3940.t0 vss 2.72616e-14
Cpar1 a_1242_3940.t1 vss 2.67537e-15
Cpar2 a_1242_3940.t4 vss 2.10136e-15
Cpar3 a_1698_1249.t0 vss 1.83074e-14
Cpar4 a_1698_1249.t10 vss 4.47249e-15
Cpar5 a_2458_1249.t0 vss 1.21196e-14
Cpar6 a_2458_1249.t10 vss 5.19406e-15
Cpar7 a_2458_1249.t16 vss 7.68532e-15
Cpar8 a_3906_7856.t0 vss 4.34564e-15
Cpar9 a_3906_7856.t1 vss 1.73792e-15
Cpar10 a_3906_7856.t4 vss 1.91354e-15
Cpar11 a_5774_1249.t0 vss 6.32451e-15
Cpar12 a_5774_1249.t1 vss 4.27435e-15
Cpar13 a_5774_1249.t9 vss 9.97366e-15
Cpar14 ib inn 2.59300e-17
Cpar15 ib inp 1.84300e-17
Cpar16 ib out 5.44220e-16
Cpar17 ib vdd 1.21549e-14
Cpar18 ib vss 2.11620e-14
Cpar19 ib.t0 vss 9.32966e-15
Cpar20 ib.t1 vss 1.21724e-15
Cpar21 ib.t10 vss 7.91874e-15
Cpar22 inn inp 1.03640e-16
Cpar23 inn vss 1.58300e-14
Cpar24 inn.t0 vss 4.96370e-15
Cpar25 inp vdd 5.89400e-17
Cpar26 inp vss 1.55938e-14
Cpar27 inp.t0 vss 5.00614e-15
Cpar28 out vdd 1.75050e-15
Cpar29 out vss 5.74900e-15
Cpar30 out.t0 vss 3.42867e-15
Cpar31 out.t3 vss 5.65909e-16
Cpar32 vdd vss 1.02187e-13
Cpar33 vdd.t0 vss 2.24012e-14
Cpar34 vdd.t1 vss 1.31444e-14
Cpar35 vdd.t4 vss 1.12107e-14
.ends opamp_dut

Vdd vdd 0 1.800000
Vss vss 0 0
Ibias vdd ib 1.277800e-06
Vinp inp 0 DC 0.985000 AC 1 PWL(0 0.985000 5.710051e-08 0.985000 6.281056e-08 0.995000)
Rfb out inn 1m
Cload out 0 2.000000e-12
Xdut vdd vss inp inn out ib opamp_dut
.end
