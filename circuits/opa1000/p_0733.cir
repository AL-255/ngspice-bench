* opa1000[0733]: 2p/rail_to_rail_3v3_0p1u_1u_subth (rail_to_rail, VDD=3.3V, CL=2.0pF, Iref=0.0719uA)
.include "pdk_opa.inc"
.temp 27
.option gmin=1e-12 rshunt=1e12 reltol=1e-3 abstol=1e-12 vntol=1e-5 method=gear
* Post-PEX R+C extracted netlist for rail_to_rail_3v3_0p1u_1u_subth
.subckt opamp_dut vdd vss inp inn out ib
XMpar0 out.t0 a_1433_10716.t7 vdd.t1 vdd.t0 pfet_03v3 w=2.61u l=2.5u ad=7.3080e-13 pd=3.1700e-06 as=1.1484e-12 ps=4.7950e-06 nf=1 m=8 par=8
XMpar1 a_6547_1204.t0 inn.t0 a_8972_17013.t0 vss.t5 nfet_03v3 w=0.98u l=2.5u ad=5.8800e-13 pd=3.1600e-06 as=2.7440e-13 ps=1.5400e-06 nf=1 m=2 par=2
XMpar2 a_1714_4818.t4 ib.t0 vss.t24 vss.t23 nfet_03v3 w=0.92u l=7.5u ad=5.5200e-13 pd=3.0400e-06 as=2.5760e-13 ps=1.4800e-06 nf=1 m=2 par=2
XMpar3 a_8972_17013.t5 a_8972_17013.t4 vdd.t1 vdd.t0 pfet_03v3 w=2.61u l=2.5u ad=7.3080e-13 pd=3.1700e-06 as=7.3080e-13 ps=3.1700e-06 nf=1 m=2 par=2
XMpar4 ib.t1 ib.t0 vss.t24 vss.t23 nfet_03v3 w=0.92u l=7.5u ad=5.5200e-13 pd=3.0400e-06 as=2.5760e-13 ps=1.4800e-06 nf=1 m=2 par=2
XMpar5 a_1594_5026.t0 inp.t2 a_7252_10879.t0 vdd.t2 pfet_03v3 w=1.68u l=2.5u ad=7.3920e-13 pd=3.4000e-06 as=4.7040e-13 ps=2.2400e-06 nf=1 m=8 par=8
XMpar6 a_1594_5026.t0 inn.t2 a_7372_4774.t0 vdd.t2 pfet_03v3 w=1.68u l=2.5u ad=7.3920e-13 pd=3.4000e-06 as=4.7040e-13 ps=2.2400e-06 nf=1 m=8 par=8
XMpar7 a_1714_4818.t1 a_1714_4818.t0 vdd.t7 vdd.t6 pfet_03v3 w=3.76u l=7.5u ad=2.2560e-12 pd=8.7200e-06 as=1.0528e-12 ps=4.3200e-06 nf=1 m=2 par=2
XMpar8 a_8972_17013.t2 a_7252_10879.t8 vss.t2 vss.t1 nfet_03v3 w=0.4u l=6.5u ad=1.1200e-13 pd=9.6000e-07 as=1.1200e-13 ps=9.6000e-07 nf=1 m=2 par=2
XMpar9 a_1594_5026.t8 a_1714_4818.t0 vdd.t7 vdd.t6 pfet_03v3 w=3.76u l=7.5u ad=2.2560e-12 pd=8.7200e-06 as=1.0528e-12 ps=4.3200e-06 nf=1 m=2 par=2
XMpar10 out.t8 ib.t0 vss.t24 vss.t23 nfet_03v3 w=0.92u l=7.5u ad=2.5760e-13 pd=1.4800e-06 as=4.7840e-13 ps=2.6500e-06 nf=1 m=8 par=8
XMpar11 a_6547_1204.t4 ib.t0 vss.t24 vss.t23 nfet_03v3 w=0.92u l=7.5u ad=5.5200e-13 pd=3.0400e-06 as=2.5760e-13 ps=1.4800e-06 nf=1 m=2 par=2
XMpar12 a_7252_10879.t9 a_7252_10879.t8 vss.t2 vss.t1 nfet_03v3 w=0.4u l=6.5u ad=2.4000e-13 pd=2.0000e-06 as=1.1200e-13 ps=9.6000e-07 nf=1 m=2 par=2
XMpar13 a_1433_10716.t3 a_7372_4774.t8 vss.t2 vss.t1 nfet_03v3 w=0.4u l=6.5u ad=2.4000e-13 pd=2.0000e-06 as=1.1200e-13 ps=9.6000e-07 nf=1 m=2 par=2
XMpar14 a_1433_10716.t2 a_8972_17013.t4 vdd.t1 vdd.t0 pfet_03v3 w=2.61u l=2.5u ad=1.5660e-12 pd=6.4200e-06 as=7.3080e-13 ps=3.1700e-06 nf=1 m=2 par=2
XMpar15 a_1433_10716.t0 inp.t0 a_6547_1204.t0 vss.t5 nfet_03v3 w=0.98u l=2.5u ad=2.7440e-13 pd=1.5400e-06 as=5.8800e-13 ps=3.1600e-06 nf=1 m=2 par=2
XMpar16 a_7372_4774.t9 a_7372_4774.t8 vss.t2 vss.t1 nfet_03v3 w=0.4u l=6.5u ad=1.1200e-13 pd=9.6000e-07 as=1.1200e-13 ps=9.6000e-07 nf=1 m=2 par=2
X0 a_15130_8051.t0 a_19116_8571.t0 vss.t0 ppolyf_u_1k r_width=1u r_length=19.27u
X1 a_15130_4931.t0 a_19116_5451.t0 vss.t0 ppolyf_u_1k r_width=1u r_length=19.27u
X4 a_15130_1811.t0 a_19116_2331.t0 vss.t0 ppolyf_u_1k r_width=1u r_length=19.27u
X5 a_19116_8571.t1 out.t3 cap_mim_2f0fF c_width=15.62u c_length=15.61u
X9 a_15130_8051.t0 a_19116_7531.t0 vss.t0 ppolyf_u_1k r_width=1u r_length=19.27u
X10 a_15130_4931.t0 a_19116_4411.t0 vss.t0 ppolyf_u_1k r_width=1u r_length=19.27u
X12 a_15130_1811.t0 a_19116_1291.t0 vss.t0 ppolyf_u_1k r_width=1u r_length=19.27u
X15 a_15130_7011.t0 a_19116_7531.t0 vss.t0 ppolyf_u_1k r_width=1u r_length=19.27u
X16 a_15130_3891.t0 a_19116_4411.t0 vss.t0 ppolyf_u_1k r_width=1u r_length=19.27u
X27 a_15130_7011.t0 a_19116_6491.t0 vss.t0 ppolyf_u_1k r_width=1u r_length=19.27u
X38 a_1433_10716.t6 a_19116_1291.t0 vss.t0 ppolyf_u_1k r_width=1u r_length=19.27u
X45 a_15130_3891.t0 a_19116_3371.t0 vss.t0 ppolyf_u_1k r_width=1u r_length=19.27u
X54 a_19116_8571.t1 out.t3 cap_mim_2f0fF c_width=15.62u c_length=15.61u
X59 a_15130_5971.t0 a_19116_6491.t0 vss.t0 ppolyf_u_1k r_width=1u r_length=19.27u
X62 a_15130_2851.t0 a_19116_3371.t0 vss.t0 ppolyf_u_1k r_width=1u r_length=19.27u
X68 a_15130_5971.t0 a_19116_5451.t0 vss.t0 ppolyf_u_1k r_width=1u r_length=19.27u
X71 a_15130_2851.t0 a_19116_2331.t0 vss.t0 ppolyf_u_1k r_width=1u r_length=19.27u
Rpar0 a_1433_10716.t0 a_1433_10716.t7 214.6685
Rpar1 a_1433_10716.t0 a_1433_10716.t2 821.3432
Rpar2 a_1433_10716.t0 a_1433_10716.t3 81.1000
Rpar3 a_1433_10716.t0 a_1433_10716.t6 4485.4589
Rpar4 a_1433_10716.t7 a_1433_10716.t2 67.8726
Rpar5 a_1433_10716.t7 a_1433_10716.t3 132.3077
Rpar6 a_1433_10716.t7 a_1433_10716.t6 370.6608
Rpar7 a_1433_10716.t2 a_1433_10716.t3 506.2225
Rpar8 a_1433_10716.t2 a_1433_10716.t6 183.2479
Rpar9 a_1433_10716.t3 a_1433_10716.t6 2764.5451
Rpar10 a_1594_5026.t0 a_1594_5026.t8 40.1854
Rpar11 a_1714_4818.t0 a_1714_4818.t1 12.9346
Rpar12 a_1714_4818.t0 a_1714_4818.t4 124.9963
Rpar13 a_1714_4818.t1 a_1714_4818.t4 85.5426
Rpar14 a_19116_8571.t0 a_19116_8571.t1 86.9394
Rpar15 a_6547_1204.t0 a_6547_1204.t4 62.1959
Rpar16 a_7252_10879.t0 a_7252_10879.t8 88.2689
Rpar17 a_7252_10879.t0 a_7252_10879.t9 68.7173
Rpar18 a_7252_10879.t8 a_7252_10879.t9 23.2662
Rpar19 a_7372_4774.t0 a_7372_4774.t8 134.7143
Rpar20 a_7372_4774.t0 a_7372_4774.t9 126.4891
Rpar21 a_7372_4774.t8 a_7372_4774.t9 31.2259
Rpar22 a_8972_17013.t0 a_8972_17013.t2 148.0316
Rpar23 a_8972_17013.t0 a_8972_17013.t4 719.3258
Rpar24 a_8972_17013.t0 a_8972_17013.t5 347.2645
Rpar25 a_8972_17013.t2 a_8972_17013.t4 246.5627
Rpar26 a_8972_17013.t2 a_8972_17013.t5 119.0316
Rpar27 a_8972_17013.t4 a_8972_17013.t5 22.9398
Rpar28 ib ib.t0 19.8341
Rpar29 ib ib.t1 16.1236
Rpar30 ib.t0 ib.t1 25.6508
Rpar31 inn inn.t0 4.3007
Rpar32 inn inn.t2 63.5927
Rpar33 inp inp.t0 4.3493
Rpar34 inp inp.t2 43.5281
Rpar35 out out.t0 3.6088
Rpar36 out out.t8 881.1342
Rpar37 out out.t3 246.1936
Rpar38 out.t0 out.t8 391.8272
Rpar39 out.t0 out.t3 109.4786
Rpar40 out.t8 out.t3 579.3320
Rpar41 vdd vdd.t0 88.4630
Rpar42 vdd vdd.t1 56.2338
Rpar43 vdd vdd.t7 1103.0074
Rpar44 vdd vdd.t6 5279.7362
Rpar45 vdd vdd.t2 635.5687
Rpar46 vdd.t0 vdd.t1 6.1881
Rpar47 vdd.t0 vdd.t7 1841.0287
Rpar48 vdd.t0 vdd.t2 1060.8271
Rpar49 vdd.t1 vdd.t7 346.6960
Rpar50 vdd.t1 vdd.t6 1659.5206
Rpar51 vdd.t1 vdd.t2 199.7712
Rpar52 vdd.t7 vdd.t6 17.2989
Rpar53 vdd.t7 vdd.t2 91.7208
Rpar54 vdd.t6 vdd.t2 439.0373
Rpar55 vss vss.t0 33.5028
Rpar56 vss vss.t1 129.6933
Rpar57 vss vss.t5 828.6532
Rpar58 vss vss.t2 506.6874
Rpar59 vss vss.t23 483.2452
Rpar60 vss.t0 vss.t1 244.8371
Rpar61 vss.t0 vss.t5 1122.6771
Rpar62 vss.t0 vss.t2 1017.2361
Rpar63 vss.t0 vss.t23 698.8323
Rpar64 vss.t1 vss.t5 5.6707
Rpar65 vss.t1 vss.t2 8.7161
Rpar66 vss.t1 vss.t23 3.6053
Rpar67 vss.t1 vss.t24 35.3572
Rpar68 vss.t5 vss.t2 45.8758
Rpar69 vss.t5 vss.t23 5.2277
Rpar70 vss.t5 vss.t24 46.5383
Rpar71 vss.t2 vss.t23 23.1415
Rpar72 vss.t2 vss.t24 311.2168
Rpar73 vss.t23 vss.t24 32.0703
Cpar0 a_1433_10716.t0 vss 2.50917e-15
Cpar1 a_1433_10716.t2 vss 8.01769e-15
Cpar2 a_1433_10716.t3 vss 4.70274e-15
Cpar3 a_1433_10716.t6 vss 7.67117e-15
Cpar4 a_1433_10716.t7 vss 1.98412e-14
Cpar5 a_15130_1811.t0 vss 4.26800e-17
Cpar6 a_15130_2851.t0 vss 4.01200e-17
Cpar7 a_15130_3891.t0 vss 3.82400e-17
Cpar8 a_15130_4931.t0 vss 3.76400e-17
Cpar9 a_15130_5971.t0 vss 3.74600e-17
Cpar10 a_15130_7011.t0 vss 3.91000e-17
Cpar11 a_15130_8051.t0 vss 3.16400e-17
Cpar12 a_1594_5026.t0 vss 1.63102e-14
Cpar13 a_1594_5026.t8 vss 1.25250e-14
Cpar14 a_1714_4818.t0 vss 2.39772e-14
Cpar15 a_1714_4818.t1 vss 7.11745e-15
Cpar16 a_1714_4818.t4 vss 9.70393e-15
Cpar17 a_19116_1291.t0 vss 3.10400e-17
Cpar18 a_19116_2331.t0 vss 3.07800e-17
Cpar19 a_19116_3371.t0 vss 3.00600e-17
Cpar20 a_19116_4411.t0 vss 3.00600e-17
Cpar21 a_19116_5451.t0 vss 3.00600e-17
Cpar22 a_19116_6491.t0 vss 3.00600e-17
Cpar23 a_19116_7531.t0 vss 3.27200e-17
Cpar24 a_19116_8571.t0 vss 2.10613e-16
Cpar25 a_19116_8571.t1 vss 6.89980e-15
Cpar26 a_6547_1204.t0 vss 9.13166e-15
Cpar27 a_6547_1204.t4 vss 2.00733e-14
Cpar28 a_7252_10879.t0 vss 3.65117e-15
Cpar29 a_7252_10879.t8 vss 7.79001e-15
Cpar30 a_7252_10879.t9 vss 1.91500e-15
Cpar31 a_7372_4774.t0 vss 4.74581e-15
Cpar32 a_7372_4774.t8 vss 8.61717e-15
Cpar33 a_7372_4774.t9 vss 1.80346e-15
Cpar34 a_8972_17013.t0 vss 3.52303e-15
Cpar35 a_8972_17013.t2 vss 4.60647e-15
Cpar36 a_8972_17013.t4 vss 8.68338e-15
Cpar37 a_8972_17013.t5 vss 4.11725e-15
Cpar38 ib out 2.69629e-15
Cpar39 ib vss 6.18564e-14
Cpar40 ib.t0 vss 2.12380e-14
Cpar41 ib.t1 vss 1.56902e-15
Cpar42 inn inp 1.55870e-16
Cpar43 inn vdd 9.81157e-15
Cpar44 inn vss 8.42004e-15
Cpar45 inn.t0 vss 1.23471e-15
Cpar46 inn.t2 vss 1.36787e-14
Cpar47 inp vdd 1.03673e-14
Cpar48 inp vss 6.24303e-15
Cpar49 inp.t0 vss 1.29261e-15
Cpar50 inp.t2 vss 1.37548e-14
Cpar51 out vdd 1.51874e-14
Cpar52 out vss 5.17306e-14
Cpar53 out.t0 vss 6.60955e-15
Cpar54 out.t3 vss 1.65906e-14
Cpar55 out.t8 vss 1.53980e-14
Cpar56 vdd vss 1.91178e-13
Cpar57 vdd.t0 vss 2.16860e-14
Cpar58 vdd.t1 vss 1.28281e-14
Cpar59 vdd.t2 vss 2.97825e-14
Cpar60 vdd.t6 vss 2.47995e-14
Cpar61 vdd.t7 vss 7.73194e-15
.ends opamp_dut

Vdd vdd 0 3.300000
Vss vss 0 0
Ibias vdd ib 7.190000e-08
Vinp inp 0 DC 1.645000 AC 1 PWL(0 1.645000 4.162742e-07 1.645000 4.579016e-07 1.655000)
Rfb out inn 1m
Cload out 0 2.000000e-12
Xdut vdd vss inp inn out ib opamp_dut
.end
