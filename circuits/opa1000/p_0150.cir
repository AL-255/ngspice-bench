* opa1000[0150]: 2p/current_reuse_3v3_0p1u_1u_subth (current_reuse, VDD=3.3V, CL=2.0pF, Iref=0.05uA)
.include "pdk_opa.inc"
.temp 27
.option gmin=1e-12 rshunt=1e12 reltol=1e-3 abstol=1e-12 vntol=1e-5 method=gear
* Post-PEX R+C extracted netlist for current_reuse_3v3_0p1u_1u_subth
.subckt opamp_dut vdd vss inp inn out ib
XMpar0 a_3650_10162.t0 inn.t0 a_8854_17996.t12 vss.t2 nfet_03v3 w=2.11u l=6.5u ad=9.2840e-13 pd=4.0450e-06 as=5.9080e-13 ps=2.6700e-06 nf=1 m=4 par=4
XMpar1 ib.t1 ib.t0 vss.t14 vss.t13 nfet_03v3 w=0.4u l=5u ad=2.4000e-13 pd=2.0000e-06 as=1.1200e-13 ps=9.6000e-07 nf=1 m=2 par=2
XMpar2 a_3650_12139.t1 inn.t4 a_8854_17996.t0 vdd.t4 pfet_03v3 w=1.95u l=6.5u ad=8.5800e-13 pd=3.8050e-06 as=5.4600e-13 ps=2.5100e-06 nf=1 m=12 par=12
XMpar3 out.t0 a_1302_1291.t18 vdd.t1 vdd.t0 pfet_03v3 w=2.32u l=3.75u ad=6.4960e-13 pd=2.8800e-06 as=7.9808e-13 ps=3.4720e-06 nf=1 m=10 par=10
XMpar4 a_1302_1291.t0 inp.t4 a_3650_12139.t1 vdd.t4 pfet_03v3 w=1.95u l=6.5u ad=5.4600e-13 pd=2.5100e-06 as=8.5800e-13 ps=3.8050e-06 nf=1 m=12 par=12
XMpar5 a_3650_10162.t8 ib.t0 vss.t14 vss.t13 nfet_03v3 w=0.4u l=5u ad=2.4000e-13 pd=2.0000e-06 as=1.1200e-13 ps=9.6000e-07 nf=1 m=4 par=4
XMpar6 a_3650_12139.t0 a_8854_17996.t16 vdd.t1 vdd.t0 pfet_03v3 w=2.32u l=3.75u ad=6.4960e-13 pd=2.8800e-06 as=1.3920e-12 ps=5.8400e-06 nf=1 m=2 par=2
XMpar7 out.t11 ib.t0 vss.t14 vss.t13 nfet_03v3 w=0.4u l=5u ad=1.8880e-13 pd=1.5840e-06 as=1.6320e-13 ps=1.3760e-06 nf=1 m=10 par=10
XMpar8 a_1302_1291.t12 inp.t0 a_3650_10162.t0 vss.t2 nfet_03v3 w=2.11u l=6.5u ad=5.9080e-13 pd=2.6700e-06 as=9.2840e-13 ps=4.0450e-06 nf=1 m=4 par=4
XMpar9 a_1302_1291.t16 a_8854_17996.t16 vdd.t1 vdd.t0 pfet_03v3 w=2.32u l=3.75u ad=1.3920e-12 pd=5.8400e-06 as=6.4960e-13 ps=2.8800e-06 nf=1 m=1
XMpar10 a_8854_17996.t17 a_8854_17996.t16 vdd.t1 vdd.t0 pfet_03v3 w=2.32u l=3.75u ad=1.3920e-12 pd=5.8400e-06 as=6.4960e-13 ps=2.8800e-06 nf=1 m=1
X1 a_1302_3891.t0 a_5224_3371.t0 vss.t0 ppolyf_u_1k r_width=1u r_length=18.95u
X12 a_1302_5971.t0 a_5224_6491.t0 vss.t0 ppolyf_u_1k r_width=1u r_length=18.95u
X15 a_1302_2851.t0 a_5224_3371.t0 vss.t0 ppolyf_u_1k r_width=1u r_length=18.95u
X26 a_1302_5971.t0 a_5224_5451.t0 vss.t0 ppolyf_u_1k r_width=1u r_length=18.95u
X27 a_1302_2851.t0 a_5224_2331.t0 vss.t0 ppolyf_u_1k r_width=1u r_length=18.95u
X31 a_1302_8051.t0 a_5224_8571.t0 vss.t0 ppolyf_u_1k r_width=1u r_length=18.95u
X34 a_1302_4931.t0 a_5224_5451.t0 vss.t0 ppolyf_u_1k r_width=1u r_length=18.95u
X36 a_1302_1811.t0 a_5224_2331.t0 vss.t0 ppolyf_u_1k r_width=1u r_length=18.95u
X41 a_1302_4931.t0 a_5224_4411.t0 vss.t0 ppolyf_u_1k r_width=1u r_length=18.95u
X44 a_1302_8051.t0 a_5224_7531.t0 vss.t0 ppolyf_u_1k r_width=1u r_length=18.95u
X45 a_1302_1811.t0 a_5224_1291.t0 vss.t0 ppolyf_u_1k r_width=1u r_length=18.95u
X49 a_1302_7011.t0 a_5224_7531.t0 vss.t0 ppolyf_u_1k r_width=1u r_length=18.95u
X53 a_1302_3891.t0 a_5224_4411.t0 vss.t0 ppolyf_u_1k r_width=1u r_length=18.95u
X59 a_5224_8571.t1 out.t1 cap_mim_2f0fF c_width=18.03u c_length=18.03u
X60 a_1302_7011.t0 a_5224_6491.t0 vss.t0 ppolyf_u_1k r_width=1u r_length=18.95u
X63 a_5224_8571.t1 out.t1 cap_mim_2f0fF c_width=18.03u c_length=18.03u
X76 a_1302_1291.t17 a_5224_1291.t0 vss.t0 ppolyf_u_1k r_width=1u r_length=18.95u
Rpar0 a_1302_1291.t0 a_1302_1291.t12 81.0674
Rpar1 a_1302_1291.t0 a_1302_1291.t16 230.5585
Rpar2 a_1302_1291.t0 a_1302_1291.t17 284.7344
Rpar3 a_1302_1291.t0 a_1302_1291.t18 100.9924
Rpar4 a_1302_1291.t12 a_1302_1291.t16 434.5385
Rpar5 a_1302_1291.t12 a_1302_1291.t17 160.2740
Rpar6 a_1302_1291.t12 a_1302_1291.t18 190.3424
Rpar7 a_1302_1291.t16 a_1302_1291.t17 1526.2370
Rpar8 a_1302_1291.t16 a_1302_1291.t18 97.3068
Rpar9 a_1302_1291.t17 a_1302_1291.t18 668.5429
Rpar10 a_3650_10162.t0 a_3650_10162.t8 53.6678
Rpar11 a_3650_12139.t0 a_3650_12139.t1 63.0788
Rpar12 a_5224_8571.t0 a_5224_8571.t1 60.2032
Rpar13 a_8854_17996.t0 a_8854_17996.t12 80.4999
Rpar14 a_8854_17996.t0 a_8854_17996.t16 72.5938
Rpar15 a_8854_17996.t0 a_8854_17996.t17 218.4997
Rpar16 a_8854_17996.t12 a_8854_17996.t16 244.4762
Rpar17 a_8854_17996.t12 a_8854_17996.t17 735.8476
Rpar18 a_8854_17996.t16 a_8854_17996.t17 21.6215
Rpar19 ib ib.t0 16.4435
Rpar20 ib ib.t1 15.2949
Rpar21 ib.t0 ib.t1 34.2091
Rpar22 inn inn.t0 2.0514
Rpar23 inn inn.t4 33.0886
Rpar24 inp inp.t0 2.1001
Rpar25 inp inp.t4 33.0400
Rpar26 out out.t0 3.6124
Rpar27 out out.t1 1854.2293
Rpar28 out out.t11 1005.7899
Rpar29 out.t0 out.t1 441.5297
Rpar30 out.t0 out.t11 239.4990
Rpar31 out.t1 out.t11 83.5070
Rpar32 vdd vdd.t0 48.7288
Rpar33 vdd vdd.t1 47.5440
Rpar34 vdd vdd.t4 277.1305
Rpar35 vdd.t0 vdd.t1 3.7192
Rpar36 vdd.t0 vdd.t4 62.0481
Rpar37 vdd.t1 vdd.t4 75.7387
Rpar38 vss vss.t0 39.9461
Rpar39 vss vss.t14 161.2211
Rpar40 vss vss.t2 230.9283
Rpar41 vss.t0 vss.t13 4.5915
Rpar42 vss.t0 vss.t14 17.0055
Rpar43 vss.t0 vss.t2 86.6604
Rpar44 vss.t13 vss.t14 161.1262
Rpar45 vss.t13 vss.t2 4551.3612
Rpar46 vss.t14 vss.t2 120.3197
Cpar0 a_1302_1291.t0 vss 1.36912e-14
Cpar1 a_1302_1291.t12 vss 7.01766e-15
Cpar2 a_1302_1291.t16 vss 3.75532e-15
Cpar3 a_1302_1291.t17 vss 4.62759e-15
Cpar4 a_1302_1291.t18 vss 2.51371e-14
Cpar5 a_1302_1811.t0 vss 4.00400e-17
Cpar6 a_1302_2851.t0 vss 3.61600e-17
Cpar7 a_1302_3891.t0 vss 3.61600e-17
Cpar8 a_1302_4931.t0 vss 3.61600e-17
Cpar9 a_1302_5971.t0 vss 3.61600e-17
Cpar10 a_1302_7011.t0 vss 3.69000e-17
Cpar11 a_1302_8051.t0 vss 3.32400e-17
Cpar12 a_3650_10162.t0 vss 1.43798e-14
Cpar13 a_3650_10162.t8 vss 1.55468e-14
Cpar14 a_3650_12139.t0 vss 4.61917e-15
Cpar15 a_3650_12139.t1 vss 3.87783e-14
Cpar16 a_5224_1291.t0 vss 3.70600e-17
Cpar17 a_5224_2331.t0 vss 3.47600e-17
Cpar18 a_5224_3371.t0 vss 3.40200e-17
Cpar19 a_5224_4411.t0 vss 3.40200e-17
Cpar20 a_5224_5451.t0 vss 3.61200e-17
Cpar21 a_5224_6491.t0 vss 3.78800e-17
Cpar22 a_5224_7531.t0 vss 4.14400e-17
Cpar23 a_5224_8571.t0 vss 9.07604e-17
Cpar24 a_5224_8571.t1 vss 4.97414e-15
Cpar25 a_8854_17996.t0 vss 1.90515e-14
Cpar26 a_8854_17996.t12 vss 6.86076e-15
Cpar27 a_8854_17996.t16 vss 1.72449e-14
Cpar28 a_8854_17996.t17 vss 3.94494e-15
Cpar29 ib out 2.49418e-15
Cpar30 ib vss 5.72155e-14
Cpar31 ib.t0 vss 9.56425e-15
Cpar32 ib.t1 vss 7.29720e-16
Cpar33 inn inp 2.08480e-16
Cpar34 inn out 7.02980e-16
Cpar35 inn vdd 2.85200e-14
Cpar36 inn vss 1.77251e-14
Cpar37 inn.t0 vss 7.67700e-15
Cpar38 inn.t4 vss 3.34399e-14
Cpar39 inp out 1.21800e-16
Cpar40 inp vdd 2.84924e-14
Cpar41 inp vss 1.76580e-14
Cpar42 inp.t0 vss 7.60328e-15
Cpar43 inp.t4 vss 3.27832e-14
Cpar44 out vdd 1.11069e-14
Cpar45 out vss 3.71282e-14
Cpar46 out.t0 vss 5.50977e-15
Cpar47 out.t1 vss 1.73127e-14
Cpar48 out.t11 vss 9.49505e-15
Cpar49 vdd vss 2.50309e-13
Cpar50 vdd.t0 vss 2.44960e-14
Cpar51 vdd.t1 vss 1.83277e-14
Cpar52 vdd.t4 vss 7.10367e-14
.ends opamp_dut

Vdd vdd 0 3.300000
Vss vss 0 0
Ibias vdd ib 5.000000e-08
Vinp inp 0 DC 1.645000 AC 1 PWL(0 1.645000 5.395061e-07 1.645000 5.934568e-07 1.655000)
Rfb out inn 1m
Cload out 0 2.000000e-12
Xdut vdd vss inp inn out ib opamp_dut
.end
