* opa1000[0151]: 2p/current_reuse_3v3_0p1u_1u_weak (current_reuse, VDD=3.3V, CL=2.0pF, Iref=0.0714uA)
.include "pdk_opa.inc"
.temp 27
.option gmin=1e-12 rshunt=1e12 reltol=1e-3 abstol=1e-12 vntol=1e-5 method=gear
* Post-PEX R+C extracted netlist for current_reuse_3v3_0p1u_1u_weak
.subckt opamp_dut vdd vss inp inn out ib
XMpar0 a_1576_5996.t5 a_6578_5951.t4 vdd.t1 vdd.t0 pfet_03v3 w=0.58u l=3.13u ad=3.4800e-13 pd=2.3600e-06 as=1.6240e-13 ps=1.1400e-06 nf=1 m=1
XMpar1 out.t3 ib.t0 vss.t12 vss.t11 nfet_03v3 w=0.4u l=3u ad=1.3760e-13 pd=1.1680e-06 as=1.1200e-13 ps=9.6000e-07 nf=1 m=10 par=10
XMpar2 a_4674_4591.t0 a_6578_5951.t4 vdd.t1 vdd.t0 pfet_03v3 w=0.58u l=3.13u ad=1.6240e-13 pd=1.1400e-06 as=3.4800e-13 ps=2.3600e-06 nf=1 m=2 par=2
XMpar3 out.t0 a_1576_5996.t6 vdd.t1 vdd.t0 pfet_03v3 w=0.58u l=3.13u ad=1.9952e-13 pd=1.3840e-06 as=2.3664e-13 ps=1.6280e-06 nf=1 m=10 par=10
XMpar4 a_4044_1249.t4 ib.t0 vss.t12 vss.t11 nfet_03v3 w=0.4u l=3u ad=1.1200e-13 pd=9.6000e-07 as=1.1200e-13 ps=9.6000e-07 nf=1 m=4 par=4
XMpar5 ib.t1 ib.t0 vss.t12 vss.t11 nfet_03v3 w=0.4u l=3u ad=1.1200e-13 pd=9.6000e-07 as=1.1200e-13 ps=9.6000e-07 nf=1 m=2 par=2
XMpar6 a_1576_5996.t2 inp.t0 a_4044_1249.t0 vss.t1 nfet_03v3 w=0.5u l=5u ad=1.4000e-13 pd=1.0600e-06 as=3.0000e-13 ps=2.2000e-06 nf=1 m=2 par=2
XMpar7 a_1576_5996.t0 inp.t2 a_4674_4591.t1 vdd.t2 pfet_03v3 w=0.74u l=5u ad=2.0720e-13 pd=1.3000e-06 as=4.4400e-13 ps=2.6800e-06 nf=1 m=2 par=2
XMpar8 a_4044_1249.t0 inn.t0 a_6578_5951.t2 vss.t1 nfet_03v3 w=0.5u l=5u ad=3.0000e-13 pd=2.2000e-06 as=1.4000e-13 ps=1.0600e-06 nf=1 m=2 par=2
XMpar9 a_6578_5951.t5 a_6578_5951.t4 vdd.t1 vdd.t0 pfet_03v3 w=0.58u l=3.13u ad=3.4800e-13 pd=2.3600e-06 as=1.6240e-13 ps=1.1400e-06 nf=1 m=1
XMpar10 a_4674_4591.t1 inn.t2 a_6578_5951.t0 vdd.t2 pfet_03v3 w=0.74u l=5u ad=4.4400e-13 pd=2.6800e-06 as=2.0720e-13 ps=1.3000e-06 nf=1 m=2 par=2
X0 a_8642_11537.t0 a_12774_11017.t0 vss.t0 ppolyf_u_1k r_width=1u r_length=20u
X1 a_8642_8417.t0 a_12774_7897.t0 vss.t0 ppolyf_u_1k r_width=1u r_length=20u
X6 a_8642_13617.t0 a_12774_14137.t0 vss.t0 ppolyf_u_1k r_width=1u r_length=20u
X11 a_8642_10497.t0 a_12774_11017.t0 vss.t0 ppolyf_u_1k r_width=1u r_length=20u
X14 a_8642_13617.t0 a_12774_13097.t0 vss.t0 ppolyf_u_1k r_width=1u r_length=20u
X20 a_1576_5996.t4 a_12774_7897.t0 vss.t0 ppolyf_u_1k r_width=1u r_length=20u
X24 a_8642_14657.t1 out.t13 cap_mim_2f0fF c_width=15.62u c_length=15.61u
X25 a_8642_10497.t0 a_12774_9977.t0 vss.t0 ppolyf_u_1k r_width=1u r_length=20u
X28 a_8642_9457.t0 a_12774_9977.t0 vss.t0 ppolyf_u_1k r_width=1u r_length=20u
X34 a_8642_12577.t0 a_12774_13097.t0 vss.t0 ppolyf_u_1k r_width=1u r_length=20u
X38 a_8642_12577.t0 a_12774_12057.t0 vss.t0 ppolyf_u_1k r_width=1u r_length=20u
X39 a_8642_9457.t0 a_12774_8937.t0 vss.t0 ppolyf_u_1k r_width=1u r_length=20u
X46 a_8642_14657.t1 out.t13 cap_mim_2f0fF c_width=15.62u c_length=15.61u
X47 a_8642_8417.t0 a_12774_8937.t0 vss.t0 ppolyf_u_1k r_width=1u r_length=20u
X48 a_8642_11537.t0 a_12774_12057.t0 vss.t0 ppolyf_u_1k r_width=1u r_length=20u
X52 a_8642_14657.t0 a_12774_14137.t0 vss.t0 ppolyf_u_1k r_width=1u r_length=20u
Rpar0 a_1576_5996.t0 a_1576_5996.t6 158.9154
Rpar1 a_1576_5996.t0 a_1576_5996.t2 97.3497
Rpar2 a_1576_5996.t0 a_1576_5996.t4 323.7763
Rpar3 a_1576_5996.t0 a_1576_5996.t5 174.5671
Rpar4 a_1576_5996.t6 a_1576_5996.t2 315.3043
Rpar5 a_1576_5996.t6 a_1576_5996.t4 129.1304
Rpar6 a_1576_5996.t6 a_1576_5996.t5 69.6219
Rpar7 a_1576_5996.t2 a_1576_5996.t4 642.4052
Rpar8 a_1576_5996.t2 a_1576_5996.t5 346.3589
Rpar9 a_1576_5996.t4 a_1576_5996.t5 141.8486
Rpar10 a_4044_1249.t0 a_4044_1249.t4 56.6247
Rpar11 a_4674_4591.t0 a_4674_4591.t1 55.1268
Rpar12 a_6578_5951.t0 a_6578_5951.t2 129.9074
Rpar13 a_6578_5951.t0 a_6578_5951.t4 75.4274
Rpar14 a_6578_5951.t0 a_6578_5951.t5 173.7937
Rpar15 a_6578_5951.t2 a_6578_5951.t4 91.2310
Rpar16 a_6578_5951.t2 a_6578_5951.t5 417.5221
Rpar17 a_6578_5951.t4 a_6578_5951.t5 30.7593
Rpar18 a_8642_14657.t0 a_8642_14657.t1 57.8255
Rpar19 ib ib.t0 10.8689
Rpar20 ib ib.t1 18.8985
Rpar21 inn inn.t0 3.1409
Rpar22 inn inn.t2 42.2057
Rpar23 inp inp.t0 3.1896
Rpar24 inp inp.t2 41.3794
Rpar25 out out.t0 43.9719
Rpar26 out out.t3 53.4795
Rpar27 out out.t13 20.9990
Rpar28 out.t0 out.t3 112.6793
Rpar29 vdd vdd.t0 146.1282
Rpar30 vdd vdd.t1 106.0704
Rpar31 vdd vdd.t2 188.4507
Rpar32 vdd.t0 vdd.t1 5.7336
Rpar33 vdd.t0 vdd.t2 66.9376
Rpar34 vdd.t1 vdd.t2 48.0988
Rpar35 vss vss.t0 1094.8875
Rpar36 vss vss.t1 81.5832
Rpar37 vss vss.t11 31.7060
Rpar38 vss vss.t12 149.1602
Rpar39 vss.t0 vss.t1 561.5842
Rpar40 vss.t0 vss.t11 206.3156
Rpar41 vss.t0 vss.t12 1465.8079
Rpar42 vss.t1 vss.t11 3.3390
Rpar43 vss.t1 vss.t12 20.8313
Rpar44 vss.t11 vss.t12 8.1317
Cpar0 a_12774_11017.t0 vss 2.93600e-17
Cpar1 a_12774_12057.t0 vss 2.93600e-17
Cpar2 a_12774_13097.t0 vss 3.00800e-17
Cpar3 a_12774_14137.t0 vss 2.81600e-17
Cpar4 a_12774_7897.t0 vss 2.64400e-17
Cpar5 a_12774_8937.t0 vss 3.00800e-17
Cpar6 a_12774_9977.t0 vss 2.93600e-17
Cpar7 a_1576_5996.t0 vss 2.81847e-15
Cpar8 a_1576_5996.t2 vss 2.48464e-15
Cpar9 a_1576_5996.t4 vss 3.71806e-15
Cpar10 a_1576_5996.t5 vss 2.53664e-15
Cpar11 a_1576_5996.t6 vss 1.92170e-14
Cpar12 a_4044_1249.t0 vss 6.25734e-15
Cpar13 a_4044_1249.t4 vss 8.45141e-15
Cpar14 a_4674_4591.t0 vss 2.55145e-15
Cpar15 a_4674_4591.t1 vss 6.00431e-15
Cpar16 a_6578_5951.t0 vss 3.00019e-15
Cpar17 a_6578_5951.t2 vss 2.69785e-15
Cpar18 a_6578_5951.t4 vss 1.04452e-14
Cpar19 a_6578_5951.t5 vss 1.97786e-15
Cpar20 a_8642_10497.t0 vss 4.08600e-17
Cpar21 a_8642_11537.t0 vss 4.12600e-17
Cpar22 a_8642_12577.t0 vss 4.12600e-17
Cpar23 a_8642_13617.t0 vss 4.28800e-17
Cpar24 a_8642_14657.t0 vss 9.33287e-17
Cpar25 a_8642_14657.t1 vss 4.57122e-15
Cpar26 a_8642_8417.t0 vss 3.20200e-17
Cpar27 a_8642_9457.t0 vss 3.65200e-17
Cpar28 ib inn 2.12100e-17
Cpar29 ib inp 1.79300e-17
Cpar30 ib out 1.04585e-15
Cpar31 ib vss 3.58019e-14
Cpar32 ib.t0 vss 4.77564e-15
Cpar33 ib.t1 vss 3.15969e-16
Cpar34 inn inp 1.02520e-16
Cpar35 inn vdd 4.85333e-15
Cpar36 inn vss 8.79791e-15
Cpar37 inn.t0 vss 1.51711e-15
Cpar38 inn.t2 vss 3.74118e-15
Cpar39 inp vdd 4.85459e-15
Cpar40 inp vss 7.90265e-15
Cpar41 inp.t0 vss 1.56323e-15
Cpar42 inp.t2 vss 3.64840e-15
Cpar43 out vdd 1.42939e-14
Cpar44 out vss 2.37215e-14
Cpar45 out.t0 vss 4.41980e-15
Cpar46 out.t13 vss 1.33736e-14
Cpar47 out.t3 vss 4.00924e-15
Cpar48 vdd vss 1.08548e-13
Cpar49 vdd.t0 vss 3.34457e-14
Cpar50 vdd.t1 vss 1.22677e-14
Cpar51 vdd.t2 vss 1.01948e-14
.ends opamp_dut

Vdd vdd 0 3.300000
Vss vss 0 0
Ibias vdd ib 7.140000e-08
Vinp inp 0 DC 1.645000 AC 1 PWL(0 1.645000 4.243806e-07 1.645000 4.668186e-07 1.655000)
Rfb out inn 1m
Cload out 0 2.000000e-12
Xdut vdd vss inp inn out ib opamp_dut
.end
