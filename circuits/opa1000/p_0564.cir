* opa1000[0564]: 2p/pmos_5t_3v3_i50n_weak (pmos_5t, VDD=3.3V, CL=2.0pF, Iref=0.0115uA)
.include "pdk_opa.inc"
.temp 27
.option gmin=1e-12 rshunt=1e12 reltol=1e-3 abstol=1e-12 vntol=1e-5 method=gear
* Post-PEX R+C extracted netlist for pmos_5t_3v3_i50n_weak
.subckt opamp_dut vdd vss inp inn out ib
XMpar0 a_2120_1204.t3 a_2120_1204.t2 vss.t1 vss.t0 nfet_03v3 w=0.4u l=8.13u ad=2.4000e-13 pd=2.0000e-06 as=1.1200e-13 ps=9.6000e-07 nf=1 m=2 par=2
XMpar1 a_1174_5768.t0 a_1654_7223.t0 vdd.t1 vdd.t0 pfet_03v3 w=0.4u l=7.5u ad=1.1200e-13 pd=9.6000e-07 as=2.0800e-13 ps=1.7400e-06 nf=1 m=8 par=8
XMpar2 a_1654_7223.t4 ib.t0 vss.t7 vss.t6 nfet_03v3 w=0.4u l=7.5u ad=1.1200e-13 pd=9.6000e-07 as=1.1200e-13 ps=9.6000e-07 nf=1 m=2 par=2
XMpar3 ib.t1 ib.t0 vss.t7 vss.t6 nfet_03v3 w=0.4u l=7.5u ad=2.4000e-13 pd=2.0000e-06 as=1.1200e-13 ps=9.6000e-07 nf=1 m=2 par=2
XMpar4 a_1174_5768.t5 inn.t0 out.t0 vdd.t12 pfet_03v3 w=1.66u l=9.75u ad=9.9600e-13 pd=4.5200e-06 as=4.6480e-13 ps=2.2200e-06 nf=1 m=2 par=2
XMpar5 out.t2 a_2120_1204.t2 vss.t1 vss.t0 nfet_03v3 w=0.4u l=8.13u ad=1.1200e-13 pd=9.6000e-07 as=1.1200e-13 ps=9.6000e-07 nf=1 m=2 par=2
XMpar6 a_1174_5768.t5 inp.t0 a_2120_1204.t0 vdd.t12 pfet_03v3 w=1.66u l=9.75u ad=9.9600e-13 pd=4.5200e-06 as=4.6480e-13 ps=2.2200e-06 nf=1 m=2 par=2
XMpar7 a_1654_7223.t1 a_1654_7223.t0 vdd.t1 vdd.t0 pfet_03v3 w=0.4u l=7.5u ad=2.4000e-13 pd=2.0000e-06 as=1.1200e-13 ps=9.6000e-07 nf=1 m=2 par=2
X20 out.t4 vss.t14 cap_mim_2f0fF c_width=6.71u c_length=6.71u
Rpar0 a_1174_5768.t0 a_1174_5768.t5 49.1618
Rpar1 a_1654_7223.t0 a_1654_7223.t1 16.4817
Rpar2 a_1654_7223.t0 a_1654_7223.t4 105.4409
Rpar3 a_1654_7223.t1 a_1654_7223.t4 182.4779
Rpar4 a_2120_1204.t0 a_2120_1204.t2 153.4349
Rpar5 a_2120_1204.t0 a_2120_1204.t3 120.8549
Rpar6 a_2120_1204.t2 a_2120_1204.t3 22.2810
Rpar7 ib ib.t0 11.5882
Rpar8 ib ib.t1 9.0001
Rpar9 inn inn.t0 3.7509
Rpar10 inp inp.t0 3.7994
Rpar11 out out.t0 79.7889
Rpar12 out out.t2 16.6971
Rpar13 out out.t4 63.1357
Rpar14 out.t0 out.t4 85.8657
Rpar15 vdd vdd.t0 23.3583
Rpar16 vdd vdd.t1 230.6301
Rpar17 vdd vdd.t12 94.3192
Rpar18 vdd.t0 vdd.t1 13.3100
Rpar19 vdd.t0 vdd.t12 326.6155
Rpar20 vdd.t1 vdd.t12 3224.8664
Rpar21 vss vss.t0 111.7533
Rpar22 vss vss.t1 351.4604
Rpar23 vss vss.t6 70.7315
Rpar24 vss vss.t7 409.6351
Rpar25 vss vss.t14 160.3194
Rpar26 vss.t0 vss.t1 30.4243
Rpar27 vss.t0 vss.t6 5.9545
Rpar28 vss.t0 vss.t7 35.9395
Rpar29 vss.t0 vss.t14 173.7389
Rpar30 vss.t1 vss.t6 20.8726
Rpar31 vss.t1 vss.t7 139.0033
Rpar32 vss.t1 vss.t14 610.6434
Rpar33 vss.t6 vss.t7 18.5800
Rpar34 vss.t6 vss.t14 98.1414
Rpar35 vss.t7 vss.t14 487.1092
Cpar0 a_1174_5768.t0 vss 1.91123e-14
Cpar1 a_1174_5768.t5 vss 1.10086e-14
Cpar2 a_1654_7223.t0 vss 4.78156e-14
Cpar3 a_1654_7223.t1 vss 8.64988e-15
Cpar4 a_1654_7223.t4 vss 6.67950e-15
Cpar5 a_2120_1204.t0 vss 1.86694e-15
Cpar6 a_2120_1204.t2 vss 6.54315e-15
Cpar7 a_2120_1204.t3 vss 1.90608e-15
Cpar8 ib out 1.30100e-17
Cpar9 ib vss 2.09598e-14
Cpar10 ib.t0 vss 2.36699e-15
Cpar11 ib.t1 vss 1.30270e-16
Cpar12 inn inp 5.14300e-17
Cpar13 inn out 4.15710e-16
Cpar14 inn vdd 8.88634e-15
Cpar15 inn vss 3.80892e-15
Cpar16 inn.t0 vss 6.92485e-15
Cpar17 inp vdd 8.67875e-15
Cpar18 inp vss 3.65143e-15
Cpar19 inp.t0 vss 6.79645e-15
Cpar20 out vdd 3.84087e-15
Cpar21 out vss 1.08210e-14
Cpar22 out.t0 vss 1.05726e-15
Cpar23 out.t2 vss 2.05811e-16
Cpar24 out.t4 vss 6.63880e-15
Cpar25 vdd vss 1.36682e-13
Cpar26 vdd.t0 vss 4.41169e-14
Cpar27 vdd.t1 vss 7.18140e-15
Cpar28 vdd.t12 vss 2.49851e-14
.ends opamp_dut

Vdd vdd 0 3.300000
Vss vss 0 0
Ibias vdd ib 1.150000e-08
Vinp inp 0 DC 1.480000 AC 1 PWL(0 1.480000 3.020725e-06 1.480000 3.322797e-06 1.490000)
Rfb out inn 1m
Cload out 0 2.000000e-12
Xdut vdd vss inp inn out ib opamp_dut
.end
