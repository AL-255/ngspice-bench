* opa1000[0334]: 200f/nmos_5t_1v8_ulp_lt0p1uw_weak (nmos_5t, VDD=1.8V, CL=0.2pF, Iref=0.0016uA)
.include "pdk_opa.inc"
.temp 27
.option gmin=1e-12 rshunt=1e12 reltol=1e-3 abstol=1e-12 vntol=1e-5 method=gear
* Post-PEX R+C extracted netlist for nmos_5t_1v8_ulp_lt0p1uw_weak
.subckt opamp_dut vdd vss inp inn out ib
XMpar0 out.t0 a_1212_5680.t2 vdd.t1 vdd.t0 pfet_03v3 w=0.4u l=10u ad=1.1200e-13 pd=9.6000e-07 as=1.1200e-13 ps=9.6000e-07 nf=1 m=2 par=2
XMpar1 a_1114_4179.t0 inp.t0 a_1212_5680.t0 vss.t0 nfet_03v3 w=0.4u l=9.5u ad=2.4000e-13 pd=2.0000e-06 as=1.1200e-13 ps=9.6000e-07 nf=1 m=2 par=2
XMpar2 a_1114_4179.t4 ib.t0 vss.t7 vss.t6 nfet_03v3 w=0.4u l=5u ad=1.1200e-13 pd=9.6000e-07 as=2.0800e-13 ps=1.7400e-06 nf=1 m=8 par=8
XMpar3 ib.t1 ib.t0 vss.t7 vss.t6 nfet_03v3 w=0.4u l=5u ad=2.4000e-13 pd=2.0000e-06 as=1.1200e-13 ps=9.6000e-07 nf=1 m=2 par=2
XMpar4 a_1212_5680.t3 a_1212_5680.t2 vdd.t1 vdd.t0 pfet_03v3 w=0.4u l=10u ad=2.4000e-13 pd=2.0000e-06 as=1.1200e-13 ps=9.6000e-07 nf=1 m=2 par=2
XMpar5 a_1114_4179.t0 inn.t0 out.t1 vss.t0 nfet_03v3 w=0.4u l=9.5u ad=2.4000e-13 pd=2.0000e-06 as=1.1200e-13 ps=9.6000e-07 nf=1 m=2 par=2
X0 out.t4 vss.t4 cap_mim_2f0fF c_width=16.59u c_length=16.58u
X16 out.t4 vss.t4 cap_mim_2f0fF c_width=16.59u c_length=16.58u
Rpar0 a_1114_4179.t0 a_1114_4179.t4 41.2960
Rpar1 a_1212_5680.t0 a_1212_5680.t2 159.9830
Rpar2 a_1212_5680.t0 a_1212_5680.t3 122.4740
Rpar3 a_1212_5680.t2 a_1212_5680.t3 22.3697
Rpar4 ib ib.t0 13.2767
Rpar5 ib ib.t1 14.2348
Rpar6 ib.t0 ib.t1 33.8818
Rpar7 inn inn.t0 3.5826
Rpar8 inp inp.t0 3.6311
Rpar9 out out.t0 115.0738
Rpar10 out out.t1 156.5448
Rpar11 out out.t4 17.6353
Rpar12 out.t0 out.t1 84.7808
Rpar13 out.t0 out.t4 513.9468
Rpar14 out.t1 out.t4 699.1659
Rpar15 vdd vdd.t0 73.8992
Rpar16 vdd vdd.t1 123.4793
Rpar17 vdd.t0 vdd.t1 16.7932
Rpar18 vss vss.t0 384.5988
Rpar19 vss vss.t6 80.6574
Rpar20 vss vss.t7 38.8744
Rpar21 vss vss.t4 423.8574
Rpar22 vss.t0 vss.t6 3.7598
Rpar23 vss.t0 vss.t7 69.9918
Rpar24 vss.t0 vss.t4 549.7753
Rpar25 vss.t6 vss.t7 14.1004
Rpar26 vss.t6 vss.t4 116.4587
Rpar27 vss.t7 vss.t4 357.4615
Cpar0 a_1114_4179.t0 vss 5.12668e-15
Cpar1 a_1114_4179.t4 vss 7.74704e-15
Cpar2 a_1212_5680.t0 vss 4.07950e-15
Cpar3 a_1212_5680.t2 vss 2.24101e-14
Cpar4 a_1212_5680.t3 vss 5.94513e-15
Cpar5 ib inn 1.99500e-17
Cpar6 ib inp 3.60000e-17
Cpar7 ib vss 3.75106e-14
Cpar8 ib.t0 vss 5.29519e-15
Cpar9 ib.t1 vss 4.39056e-16
Cpar10 inn inp 5.23500e-17
Cpar11 inn out 1.79600e-16
Cpar12 inn vdd 1.52300e-17
Cpar13 inn vss 9.64155e-15
Cpar14 inn.t0 vss 6.15946e-16
Cpar15 inp vdd 1.55600e-17
Cpar16 inp vss 9.49136e-15
Cpar17 inp.t0 vss 6.46122e-16
Cpar18 out vdd 5.81419e-15
Cpar19 out vss 2.13553e-14
Cpar20 out.t0 vss 2.65698e-16
Cpar21 out.t1 vss 1.92916e-16
Cpar22 out.t4 vss 1.12518e-14
Cpar23 vdd vss 5.92161e-14
Cpar24 vdd.t0 vss 1.49473e-14
Cpar25 vdd.t1 vss 8.84561e-15
.ends opamp_dut

Vdd vdd 0 1.800000
Vss vss 0 0
Ibias vdd ib 1.600000e-09
Vinp inp 0 DC 0.895000 AC 1 PWL(0 0.895000 1.167681e-05 0.895000 1.284449e-05 0.905000)
Rfb out inn 1m
Cload out 0 2.000000e-13
Xdut vdd vss inp inn out ib opamp_dut
.end
