* opa1000[0442]: 200f/nmos_miller_3v3_0p1u_1u_weak (nmos_miller, VDD=3.3V, CL=0.2pF, Iref=0.0714uA)
.include "pdk_opa.inc"
.temp 27
.option gmin=1e-12 rshunt=1e12 reltol=1e-3 abstol=1e-12 vntol=1e-5 method=gear
* Post-PEX R+C extracted netlist for nmos_miller_3v3_0p1u_1u_weak
.subckt opamp_dut vdd vss inp inn out ib
XMpar0 out.t8 ib.t0 vss.t6 vss.t5 nfet_03v3 w=0.4u l=7.5u ad=1.8880e-13 pd=1.5840e-06 as=1.6320e-13 ps=1.3760e-06 nf=1 m=10 par=10
XMpar1 out.t0 a_1006_8007.t5 vdd.t1 vdd.t0 pfet_03v3 w=1.18u l=3.75u ad=4.0592e-13 pd=2.1040e-06 as=4.8144e-13 ps=2.4680e-06 nf=1 m=10 par=10
XMpar2 a_5006_3065.t4 ib.t0 vss.t6 vss.t5 nfet_03v3 w=0.4u l=7.5u ad=2.4000e-13 pd=2.0000e-06 as=1.1200e-13 ps=9.6000e-07 nf=1 m=4 par=4
XMpar3 a_7032_1041.t3 a_7032_1041.t2 vdd.t1 vdd.t0 pfet_03v3 w=1.18u l=3.75u ad=3.3040e-13 pd=1.7400e-06 as=3.3040e-13 ps=1.7400e-06 nf=1 m=2 par=2
XMpar4 a_5006_3065.t0 inn.t0 a_7032_1041.t0 vss.t1 nfet_03v3 w=0.7u l=4u ad=4.2000e-13 pd=2.6000e-06 as=1.9600e-13 ps=1.2600e-06 nf=1 m=2 par=2
XMpar5 ib.t1 ib.t0 vss.t6 vss.t5 nfet_03v3 w=0.4u l=7.5u ad=2.4000e-13 pd=2.0000e-06 as=1.1200e-13 ps=9.6000e-07 nf=1 m=2 par=2
XMpar6 a_1006_8007.t3 a_7032_1041.t2 vdd.t1 vdd.t0 pfet_03v3 w=1.18u l=3.75u ad=7.0800e-13 pd=3.5600e-06 as=3.3040e-13 ps=1.7400e-06 nf=1 m=2 par=2
XMpar7 a_1006_8007.t0 inp.t0 a_5006_3065.t0 vss.t1 nfet_03v3 w=0.7u l=4u ad=1.9600e-13 pd=1.2600e-06 as=4.2000e-13 ps=2.6000e-06 nf=1 m=2 par=2
X0 a_1006_10607.t0 a_5124_11127.t0 vss.t0 ppolyf_u_1k r_width=1u r_length=19.93u
X2 a_1006_13727.t0 a_5124_13207.t0 vss.t0 ppolyf_u_1k r_width=1u r_length=19.93u
X5 a_1006_10607.t0 a_5124_10087.t0 vss.t0 ppolyf_u_1k r_width=1u r_length=19.93u
X11 a_1006_15807.t0 a_5124_16327.t0 vss.t0 ppolyf_u_1k r_width=1u r_length=19.93u
X12 a_1006_12687.t0 a_5124_13207.t0 vss.t0 ppolyf_u_1k r_width=1u r_length=19.93u
X16 a_1006_15807.t0 a_5124_15287.t0 vss.t0 ppolyf_u_1k r_width=1u r_length=19.93u
X17 a_1006_9567.t0 a_5124_9047.t0 vss.t0 ppolyf_u_1k r_width=1u r_length=19.93u
X21 a_1006_9567.t0 a_5124_10087.t0 vss.t0 ppolyf_u_1k r_width=1u r_length=19.93u
X22 a_5124_16327.t1 out.t4 cap_mim_2f0fF c_width=11.46u c_length=11.46u
X23 a_1006_8527.t0 a_5124_9047.t0 vss.t0 ppolyf_u_1k r_width=1u r_length=19.93u
X26 a_1006_12687.t0 a_5124_12167.t0 vss.t0 ppolyf_u_1k r_width=1u r_length=19.93u
X28 a_1006_8527.t0 a_5124_8007.t0 vss.t0 ppolyf_u_1k r_width=1u r_length=19.93u
X30 a_1006_14767.t0 a_5124_15287.t0 vss.t0 ppolyf_u_1k r_width=1u r_length=19.93u
X31 a_1006_11647.t0 a_5124_12167.t0 vss.t0 ppolyf_u_1k r_width=1u r_length=19.93u
X36 a_1006_14767.t0 a_5124_14247.t0 vss.t0 ppolyf_u_1k r_width=1u r_length=19.93u
X37 a_1006_8007.t2 a_5124_8007.t0 vss.t0 ppolyf_u_1k r_width=1u r_length=19.93u
X40 a_1006_11647.t0 a_5124_11127.t0 vss.t0 ppolyf_u_1k r_width=1u r_length=19.93u
X49 a_1006_13727.t0 a_5124_14247.t0 vss.t0 ppolyf_u_1k r_width=1u r_length=19.93u
Rpar0 a_1006_8007.t0 a_1006_8007.t5 51.6806
Rpar1 a_1006_8007.t0 a_1006_8007.t2 135.6303
Rpar2 a_1006_8007.t0 a_1006_8007.t3 212.5903
Rpar3 a_1006_8007.t5 a_1006_8007.t2 73.5295
Rpar4 a_1006_8007.t5 a_1006_8007.t3 132.3077
Rpar5 a_1006_8007.t2 a_1006_8007.t3 347.2274
Rpar6 a_5006_3065.t0 a_5006_3065.t4 56.4979
Rpar7 a_5124_16327.t0 a_5124_16327.t1 55.8661
Rpar8 a_7032_1041.t0 a_7032_1041.t2 183.7182
Rpar9 a_7032_1041.t0 a_7032_1041.t3 148.6274
Rpar10 a_7032_1041.t2 a_7032_1041.t3 26.8461
Rpar11 ib ib.t0 19.8246
Rpar12 ib ib.t1 16.2335
Rpar13 ib.t0 ib.t1 34.4697
Rpar14 inn inn.t0 3.4342
Rpar15 inp inp.t0 3.4828
Rpar16 out out.t0 59.2778
Rpar17 out out.t8 135.5523
Rpar18 out out.t4 19.7052
Rpar19 out.t0 out.t8 132.5204
Rpar20 out.t0 out.t4 973.7252
Rpar21 out.t8 out.t4 2226.6444
Rpar22 vdd vdd.t0 59.4950
Rpar23 vdd vdd.t1 257.6394
Rpar24 vdd.t0 vdd.t1 6.0315
Rpar25 vss vss.t0 389.7346
Rpar26 vss vss.t1 223.6013
Rpar27 vss vss.t6 1383.5333
Rpar28 vss vss.t5 134.0674
Rpar29 vss.t0 vss.t1 12.2682
Rpar30 vss.t0 vss.t6 72.1781
Rpar31 vss.t0 vss.t5 5.8165
Rpar32 vss.t1 vss.t6 39.7735
Rpar33 vss.t1 vss.t5 4.0749
Rpar34 vss.t6 vss.t5 24.2507
Cpar0 a_1006_10607.t0 vss 2.93600e-17
Cpar1 a_1006_11647.t0 vss 2.93600e-17
Cpar2 a_1006_12687.t0 vss 2.93600e-17
Cpar3 a_1006_13727.t0 vss 2.93600e-17
Cpar4 a_1006_14767.t0 vss 3.00800e-17
Cpar5 a_1006_15807.t0 vss 2.81800e-17
Cpar6 a_1006_8007.t0 vss 2.80040e-15
Cpar7 a_1006_8007.t2 vss 3.00419e-15
Cpar8 a_1006_8007.t3 vss 5.13013e-15
Cpar9 a_1006_8007.t5 vss 2.30570e-14
Cpar10 a_1006_8527.t0 vss 3.28000e-17
Cpar11 a_1006_9567.t0 vss 2.93600e-17
Cpar12 a_5006_3065.t0 vss 8.01037e-15
Cpar13 a_5006_3065.t4 vss 2.32748e-14
Cpar14 a_5124_10087.t0 vss 3.83800e-17
Cpar15 a_5124_11127.t0 vss 4.01600e-17
Cpar16 a_5124_12167.t0 vss 3.53600e-17
Cpar17 a_5124_13207.t0 vss 3.89600e-17
Cpar18 a_5124_14247.t0 vss 3.88200e-17
Cpar19 a_5124_15287.t0 vss 4.31600e-17
Cpar20 a_5124_16327.t0 vss 9.04800e-17
Cpar21 a_5124_16327.t1 vss 1.43330e-15
Cpar22 a_5124_8007.t0 vss 4.31400e-17
Cpar23 a_5124_9047.t0 vss 4.44000e-17
Cpar24 a_7032_1041.t0 vss 3.89398e-15
Cpar25 a_7032_1041.t2 vss 8.83689e-15
Cpar26 a_7032_1041.t3 vss 3.26550e-15
Cpar27 ib inn 1.30800e-17
Cpar28 ib inp 1.45900e-17
Cpar29 ib out 2.48065e-15
Cpar30 ib vdd 4.94580e-16
Cpar31 ib vss 8.03560e-14
Cpar32 ib.t0 vss 1.29931e-14
Cpar33 ib.t1 vss 9.44172e-16
Cpar34 inn inp 5.19700e-17
Cpar35 inn vdd 6.24100e-17
Cpar36 inn vss 4.56853e-15
Cpar37 inn.t0 vss 4.27881e-16
Cpar38 inp vss 4.59253e-15
Cpar39 inp.t0 vss 4.17897e-16
Cpar40 out vdd 1.57758e-14
Cpar41 out vss 2.95837e-14
Cpar42 out.t0 vss 9.22118e-15
Cpar43 out.t4 vss 7.81690e-15
Cpar44 out.t8 vss 1.60234e-14
Cpar45 vdd vss 1.05409e-13
Cpar46 vdd.t0 vss 3.68463e-14
Cpar47 vdd.t1 vss 8.61470e-15
.ends opamp_dut

Vdd vdd 0 3.300000
Vss vss 0 0
Ibias vdd ib 7.140000e-08
Vinp inp 0 DC 1.645000 AC 1 PWL(0 1.645000 1.359006e-07 1.645000 1.494906e-07 1.655000)
Rfb out inn 1m
Cload out 0 2.000000e-13
Xdut vdd vss inp inn out ib opamp_dut
.end
