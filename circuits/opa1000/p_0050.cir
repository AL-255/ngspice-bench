* opa1000[0050]: 2p/cherry_hooper_1v8_i2u_weak (cherry_hooper, VDD=1.8V, CL=2.0pF, Iref=0.1uA)
.include "pdk_opa.inc"
.temp 27
.option gmin=1e-12 rshunt=1e12 reltol=1e-3 abstol=1e-12 vntol=1e-5 method=gear
* Post-PEX R+C extracted netlist for cherry_hooper_1v8_i2u_weak
.subckt opamp_dut vdd vss inp inn out ib
XMpar0 a_1277_11039.t0 a_1397_10831.t1 a_1397_10831.t2 vdd.t2 pfet_03v3 w=10u l=1u ad=3.2000e-12 pd=1.1890e-05 as=2.8000e-12 ps=1.0560e-05 nf=1 m=16 par=16
XMpar1 a_1202_3053.t7 a_1202_3053.t6 vdd.t1 vdd.t0 pfet_03v3 w=1.71u l=1.3u ad=6.6120e-13 pd=3.0533e-06 as=6.6120e-13 ps=3.0533e-06 nf=1 m=3 par=3
XMpar2 a_1202_3053.t0 a_8210_7579.t8 a_2849_6078.t0 vss.t1 nfet_03v3 w=5.41u l=1.8u ad=1.5148e-12 pd=5.9700e-06 as=3.2460e-12 ps=1.2020e-05 nf=1 m=2 par=2
XMpar3 a_8068_1085.t3 a_8068_1085.t2 vdd.t1 vdd.t0 pfet_03v3 w=1.71u l=1.3u ad=4.7880e-13 pd=2.2700e-06 as=7.5240e-13 ps=3.4450e-06 nf=1 m=4 par=4
XMpar4 a_1577_6078.t0 inp.t0 a_8210_7579.t1 vss.t0 nfet_03v3 w=0.4u l=1.8u ad=2.4000e-13 pd=2.0000e-06 as=1.1200e-13 ps=9.6000e-07 nf=1 m=2 par=2
XMpar5 a_8194_3216.t0 a_9454_7579.t12 out.t4 vss.t0 nfet_03v3 w=7.21u l=1.8u ad=4.3260e-12 pd=1.5620e-05 as=2.0188e-12 ps=7.7700e-06 nf=1 m=2 par=2
XMpar6 a_8194_3216.t2 ib.t0 vss.t7 vss.t6 nfet_03v3 w=0.4u l=2.6u ad=1.4400e-13 pd=1.2200e-06 as=1.7600e-13 ps=1.4800e-06 nf=1 m=8 par=8
XMpar7 a_1577_6078.t4 ib.t0 vss.t7 vss.t6 nfet_03v3 w=0.4u l=2.6u ad=2.4000e-13 pd=2.0000e-06 as=1.7600e-13 ps=1.4800e-06 nf=1 m=4 par=4
XMpar8 a_2849_6078.t0 a_9574_10318.t8 a_9454_7579.t2 vss.t1 nfet_03v3 w=5.41u l=1.8u ad=3.2460e-12 pd=1.2020e-05 as=1.5148e-12 ps=5.9700e-06 nf=1 m=2 par=2
XMpar9 out.t0 a_8068_1085.t2 vdd.t1 vdd.t0 pfet_03v3 w=1.71u l=1.3u ad=4.7880e-13 pd=2.2700e-06 as=4.7880e-13 ps=2.2700e-06 nf=1 m=4 par=4
XMpar10 a_2849_6078.t2 ib.t0 vss.t7 vss.t6 nfet_03v3 w=0.4u l=2.6u ad=1.5467e-13 pd=1.3067e-06 as=1.1200e-13 ps=9.6000e-07 nf=1 m=6 par=6
XMpar11 a_9454_7579.t0 a_1397_10831.t33 a_9574_10318.t0 vdd.t7 pfet_03v3 w=7.63u l=1u ad=3.3572e-12 pd=1.2325e-05 as=2.1364e-12 ps=8.1900e-06 nf=1 m=4 par=4
XMpar12 a_9574_10318.t2 a_4490_9143.t1 vdd.t4 vdd.t3 pfet_03v3 w=0.84u l=2.6u ad=2.3520e-13 pd=1.4000e-06 as=5.0400e-13 ps=2.8800e-06 nf=1 m=2 par=2
XMpar13 a_1202_3053.t1 a_1397_10831.t33 a_8210_7579.t3 vdd.t7 pfet_03v3 w=7.63u l=1u ad=3.3572e-12 pd=1.2325e-05 as=2.1364e-12 ps=8.1900e-06 nf=1 m=4 par=4
XMpar14 a_9454_7579.t7 a_9454_7579.t6 vdd.t1 vdd.t0 pfet_03v3 w=1.71u l=1.3u ad=6.6120e-13 pd=3.0533e-06 as=6.6120e-13 ps=3.0533e-06 nf=1 m=3 par=3
XMpar15 a_1577_6078.t0 inn.t0 a_9574_10318.t4 vss.t0 nfet_03v3 w=0.4u l=1.8u ad=2.4000e-13 pd=2.0000e-06 as=1.1200e-13 ps=9.6000e-07 nf=1 m=2 par=2
XMpar16 a_8210_7579.t0 a_4490_9143.t1 vdd.t4 vdd.t3 pfet_03v3 w=0.84u l=2.6u ad=2.3520e-13 pd=1.4000e-06 as=5.0400e-13 ps=2.8800e-06 nf=1 m=2 par=2
XMpar17 ib.t1 ib.t0 vss.t7 vss.t6 nfet_03v3 w=0.4u l=2.6u ad=2.4000e-13 pd=2.0000e-06 as=1.1200e-13 ps=9.6000e-07 nf=1 m=1
XMpar18 a_8068_1085.t0 a_1202_3053.t12 a_8194_3216.t0 vss.t0 nfet_03v3 w=7.21u l=1.8u ad=2.0188e-12 pd=7.7700e-06 as=4.3260e-12 ps=1.5620e-05 nf=1 m=2 par=2
XMpar19 a_4490_9143.t2 a_4490_9143.t1 vdd.t4 vdd.t3 pfet_03v3 w=0.84u l=2.6u ad=5.0400e-13 pd=2.8800e-06 as=5.0400e-13 ps=2.8800e-06 nf=1 m=1
XMpar20 a_1397_10831.t0 ib.t0 vss.t7 vss.t6 nfet_03v3 w=0.4u l=2.6u ad=2.4000e-13 pd=2.0000e-06 as=2.4000e-13 ps=2.0000e-06 nf=1 m=1
XMpar21 a_1277_11039.t6 a_1277_11039.t5 vdd.t1 vdd.t0 pfet_03v3 w=1.71u l=1.3u ad=1.0260e-12 pd=4.6200e-06 as=1.0260e-12 ps=4.6200e-06 nf=1 m=1
XMpar22 a_4490_9143.t0 ib.t0 vss.t7 vss.t6 nfet_03v3 w=0.4u l=2.6u ad=2.4000e-13 pd=2.0000e-06 as=1.1200e-13 ps=9.6000e-07 nf=1 m=1
X29 out.t6 vss.t42 cap_mim_2f0fF c_width=15u c_length=15u
Rpar0 a_1202_3053.t0 a_1202_3053.t1 71.7759
Rpar1 a_1202_3053.t0 a_1202_3053.t6 2875.3481
Rpar2 a_1202_3053.t0 a_1202_3053.t7 709.9714
Rpar3 a_1202_3053.t0 a_1202_3053.t12 474.9603
Rpar4 a_1202_3053.t1 a_1202_3053.t6 729.6346
Rpar5 a_1202_3053.t1 a_1202_3053.t7 180.1590
Rpar6 a_1202_3053.t1 a_1202_3053.t12 120.5236
Rpar7 a_1202_3053.t6 a_1202_3053.t7 21.9680
Rpar8 a_1202_3053.t6 a_1202_3053.t12 403.3399
Rpar9 a_1202_3053.t7 a_1202_3053.t12 99.5914
Rpar10 a_1277_11039.t0 a_1277_11039.t5 177.0069
Rpar11 a_1277_11039.t0 a_1277_11039.t6 51.8568
Rpar12 a_1277_11039.t5 a_1277_11039.t6 50.4076
Rpar13 a_1397_10831.t0 a_1397_10831.t1 5955.6901
Rpar14 a_1397_10831.t0 a_1397_10831.t2 114.1377
Rpar15 a_1397_10831.t0 a_1397_10831.t33 157.9869
Rpar16 a_1397_10831.t1 a_1397_10831.t2 16.7963
Rpar17 a_1397_10831.t1 a_1397_10831.t33 4041.2583
Rpar18 a_1397_10831.t2 a_1397_10831.t33 77.4486
Rpar19 a_1577_6078.t0 a_1577_6078.t4 52.8355
Rpar20 a_2849_6078.t0 a_2849_6078.t2 58.7628
Rpar21 a_4490_9143.t0 a_4490_9143.t1 53.3537
Rpar22 a_4490_9143.t0 a_4490_9143.t2 647.4256
Rpar23 a_4490_9143.t1 a_4490_9143.t2 29.9418
Rpar24 a_8068_1085.t0 a_8068_1085.t2 134.4952
Rpar25 a_8068_1085.t0 a_8068_1085.t3 58.7321
Rpar26 a_8068_1085.t2 a_8068_1085.t3 18.6176
Rpar27 a_8194_3216.t0 a_8194_3216.t2 36.4179
Rpar28 a_8210_7579.t0 a_8210_7579.t1 652.3401
Rpar29 a_8210_7579.t0 a_8210_7579.t3 134.1369
Rpar30 a_8210_7579.t0 a_8210_7579.t8 101.9663
Rpar31 a_8210_7579.t1 a_8210_7579.t3 111.9734
Rpar32 a_8210_7579.t1 a_8210_7579.t8 285.8224
Rpar33 a_8210_7579.t3 a_8210_7579.t8 58.7720
Rpar34 a_9454_7579.t0 a_9454_7579.t6 686.7341
Rpar35 a_9454_7579.t0 a_9454_7579.t7 169.5661
Rpar36 a_9454_7579.t0 a_9454_7579.t12 69.7630
Rpar37 a_9454_7579.t0 a_9454_7579.t2 79.9135
Rpar38 a_9454_7579.t6 a_9454_7579.t7 21.5972
Rpar39 a_9454_7579.t6 a_9454_7579.t12 721.2709
Rpar40 a_9454_7579.t6 a_9454_7579.t2 2626.9009
Rpar41 a_9454_7579.t7 a_9454_7579.t12 178.0938
Rpar42 a_9454_7579.t7 a_9454_7579.t2 648.6257
Rpar43 a_9454_7579.t12 a_9454_7579.t2 266.8581
Rpar44 a_9574_10318.t0 a_9574_10318.t2 55.5382
Rpar45 a_9574_10318.t0 a_9574_10318.t4 102.9315
Rpar46 a_9574_10318.t0 a_9574_10318.t8 65.0939
Rpar47 a_9574_10318.t2 a_9574_10318.t4 192.9338
Rpar48 a_9574_10318.t2 a_9574_10318.t8 122.0114
Rpar49 a_9574_10318.t4 a_9574_10318.t8 226.1291
Rpar50 ib ib.t0 9.9550
Rpar51 ib ib.t1 15.6646
Rpar52 inn inn.t0 4.6229
Rpar53 inp inp.t0 4.6715
Rpar54 out out.t0 94.5777
Rpar55 out out.t4 89.9138
Rpar56 out out.t6 15.4964
Rpar57 out.t0 out.t4 57.7523
Rpar58 out.t0 out.t6 904.8681
Rpar59 out.t4 out.t6 860.2473
Rpar60 vdd vdd.t0 1181.4719
Rpar61 vdd vdd.t1 945.0889
Rpar62 vdd vdd.t7 714.4104
Rpar63 vdd vdd.t2 228.6962
Rpar64 vdd vdd.t3 46.3030
Rpar65 vdd vdd.t4 75.0594
Rpar66 vdd.t0 vdd.t1 2.7363
Rpar67 vdd.t0 vdd.t7 327.9972
Rpar68 vdd.t0 vdd.t2 233.6094
Rpar69 vdd.t0 vdd.t3 572.2842
Rpar70 vdd.t0 vdd.t4 1024.4037
Rpar71 vdd.t1 vdd.t7 262.3731
Rpar72 vdd.t1 vdd.t2 186.8700
Rpar73 vdd.t1 vdd.t3 457.7844
Rpar74 vdd.t1 vdd.t4 819.4461
Rpar75 vdd.t7 vdd.t2 141.2585
Rpar76 vdd.t7 vdd.t3 346.0478
Rpar77 vdd.t7 vdd.t4 619.4346
Rpar78 vdd.t2 vdd.t3 110.7764
Rpar79 vdd.t2 vdd.t4 198.2927
Rpar80 vdd.t3 vdd.t4 8.8545
Rpar81 vss vss.t0 71.9585
Rpar82 vss vss.t1 676.6187
Rpar83 vss vss.t6 394.9112
Rpar84 vss vss.t7 143.0337
Rpar85 vss vss.t42 390.3596
Rpar86 vss.t0 vss.t1 280.7779
Rpar87 vss.t0 vss.t6 163.5908
Rpar88 vss.t0 vss.t7 64.2734
Rpar89 vss.t0 vss.t42 176.2222
Rpar90 vss.t1 vss.t6 94.4766
Rpar91 vss.t1 vss.t7 67.3581
Rpar92 vss.t1 vss.t42 278.1704
Rpar93 vss.t6 vss.t7 4.1631
Rpar94 vss.t6 vss.t42 297.1397
Rpar95 vss.t7 vss.t42 121.2342
Cpar0 a_1202_3053.t0 vss 3.44557e-15
Cpar1 a_1202_3053.t1 vss 9.48225e-15
Cpar2 a_1202_3053.t12 vss 6.97703e-15
Cpar3 a_1202_3053.t6 vss 2.99202e-15
Cpar4 a_1202_3053.t7 vss 3.33100e-15
Cpar5 a_1277_11039.t0 vss 2.59716e-14
Cpar6 a_1277_11039.t5 vss 1.00053e-15
Cpar7 a_1277_11039.t6 vss 1.43509e-15
Cpar8 a_1397_10831.t0 vss 2.35279e-15
Cpar9 a_1397_10831.t1 vss 2.31319e-14
Cpar10 a_1397_10831.t2 vss 2.12674e-14
Cpar11 a_1397_10831.t33 vss 1.10292e-14
Cpar12 a_1577_6078.t0 vss 3.28333e-15
Cpar13 a_1577_6078.t4 vss 6.18674e-15
Cpar14 a_2849_6078.t0 vss 7.68440e-15
Cpar15 a_2849_6078.t2 vss 5.80023e-15
Cpar16 a_4490_9143.t0 vss 2.94813e-15
Cpar17 a_4490_9143.t1 vss 1.39951e-14
Cpar18 a_4490_9143.t2 vss 2.74628e-15
Cpar19 a_8068_1085.t0 vss 4.06041e-15
Cpar20 a_8068_1085.t2 vss 8.95603e-15
Cpar21 a_8068_1085.t3 vss 3.23683e-15
Cpar22 a_8194_3216.t0 vss 3.60381e-15
Cpar23 a_8194_3216.t2 vss 2.09258e-15
Cpar24 a_8210_7579.t0 vss 2.26701e-15
Cpar25 a_8210_7579.t1 vss 2.11922e-15
Cpar26 a_8210_7579.t3 vss 7.70613e-15
Cpar27 a_8210_7579.t8 vss 6.13607e-15
Cpar28 a_9454_7579.t0 vss 9.40388e-15
Cpar29 a_9454_7579.t12 vss 6.28598e-15
Cpar30 a_9454_7579.t2 vss 3.35535e-15
Cpar31 a_9454_7579.t6 vss 2.75376e-15
Cpar32 a_9454_7579.t7 vss 2.82966e-15
Cpar33 a_9574_10318.t0 vss 6.42064e-15
Cpar34 a_9574_10318.t2 vss 1.72735e-15
Cpar35 a_9574_10318.t4 vss 1.66597e-15
Cpar36 a_9574_10318.t8 vss 4.81229e-15
Cpar37 ib out 2.52300e-17
Cpar38 ib vdd 1.76660e-15
Cpar39 ib vss 4.80486e-14
Cpar40 ib.t0 vss 6.78677e-15
Cpar41 ib.t1 vss 1.77500e-17
Cpar42 inn inp 5.12600e-17
Cpar43 inn vss 2.44125e-15
Cpar44 inn.t0 vss 2.64610e-16
Cpar45 inp vdd 1.71400e-17
Cpar46 inp vss 2.42494e-15
Cpar47 inp.t0 vss 2.82139e-16
Cpar48 out vdd 3.23516e-15
Cpar49 out vss 1.36006e-14
Cpar50 out.t0 vss 3.45567e-16
Cpar51 out.t4 vss 4.05555e-16
Cpar52 out.t6 vss 8.14572e-15
Cpar53 vdd vss 1.84722e-13
Cpar54 vdd.t0 vss 1.60376e-14
Cpar55 vdd.t1 vss 1.18972e-14
Cpar56 vdd.t2 vss 2.67328e-14
Cpar57 vdd.t3 vss 7.17366e-15
Cpar58 vdd.t4 vss 4.97555e-15
Cpar59 vdd.t7 vss 1.42213e-14
.ends opamp_dut

Vdd vdd 0 1.800000
Vss vss 0 0
Ibias vdd ib 1.000000e-07
Vinp inp 0 DC 1.204600 AC 1 PWL(0 1.204600 7.250387e-08 1.204600 7.975425e-08 1.214600)
Rfb out inn 1m
Cload out 0 2.000000e-12
Xdut vdd vss inp inn out ib opamp_dut
.end
