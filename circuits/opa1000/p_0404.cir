* opa1000[0404]: 2p/nmos_5t_3v3_i2u_subth (nmos_5t, VDD=3.3V, CL=2.0pF, Iref=0.65uA)
.include "pdk_opa.inc"
.temp 27
.option gmin=1e-12 rshunt=1e12 reltol=1e-3 abstol=1e-12 vntol=1e-5 method=gear
* Post-PEX R+C extracted netlist for nmos_5t_3v3_i2u_subth
.subckt opamp_dut vdd vss inp inn out ib
XMpar0 a_1654_4949.t8 inp.t0 a_2250_4949.t36 vss.t0 nfet_03v3 w=8u l=2.38u ad=2.4800e-12 pd=9.3700e-06 as=2.4000e-12 ps=9.1000e-06 nf=1 m=64 par=64
XMpar1 a_1654_4949.t0 ib.t0 vss.t1 vss.t0 nfet_03v3 w=3.09u l=3.25u ad=8.6520e-13 pd=3.6500e-06 as=1.1124e-12 ps=4.5825e-06 nf=1 m=8 par=8
XMpar2 a_1654_4949.t8 inn.t0 out.t17 vss.t0 nfet_03v3 w=8u l=2.38u ad=2.4800e-12 pd=9.3700e-06 as=2.4000e-12 ps=9.1000e-06 nf=1 m=64 par=64
XMpar3 out.t0 a_2250_4949.t0 vdd.t1 vdd.t0 pfet_03v3 w=1.87u l=2.04u ad=5.9009e-13 pd=2.7089e-06 as=5.9009e-13 ps=2.7089e-06 nf=1 m=18 par=18
XMpar4 a_2250_4949.t1 a_2250_4949.t0 vdd.t1 vdd.t0 pfet_03v3 w=1.87u l=2.04u ad=5.9009e-13 pd=2.7089e-06 as=5.9009e-13 ps=2.7089e-06 nf=1 m=18 par=18
XMpar5 ib.t1 ib.t0 vss.t1 vss.t0 nfet_03v3 w=3.09u l=3.25u ad=8.6520e-13 pd=3.6500e-06 as=8.6520e-13 ps=3.6500e-06 nf=1 m=2 par=2
X109 out.t82 vss.t70 cap_mim_2f0fF c_width=10.25u c_length=10.25u
Rpar0 a_1654_4949.t0 a_1654_4949.t8 42.0527
Rpar1 a_2250_4949.t0 a_2250_4949.t1 7.8650
Rpar2 a_2250_4949.t0 a_2250_4949.t36 149.9387
Rpar3 a_2250_4949.t1 a_2250_4949.t36 57.3047
Rpar4 ib ib.t0 11.7334
Rpar5 ib ib.t1 10.3356
Rpar6 inn inn.t0 1.7091
Rpar7 inp inp.t0 1.7091
Rpar8 out out.t0 145.1292
Rpar9 out out.t17 53.3871
Rpar10 out out.t82 14.6594
Rpar11 out.t0 out.t17 56.0081
Rpar12 vdd vdd.t0 20.3077
Rpar13 vdd vdd.t1 428.6272
Rpar14 vdd.t0 vdd.t1 10.7569
Rpar15 vss vss.t0 32.6159
Rpar16 vss vss.t1 1072.8572
Rpar17 vss vss.t70 117.2582
Rpar18 vss.t0 vss.t1 3.9953
Rpar19 vss.t0 vss.t70 48.8399
Rpar20 vss.t1 vss.t70 1606.5224
Cpar0 a_1654_4949.t0 vss 7.04685e-15
Cpar1 a_1654_4949.t8 vss 1.54645e-13
Cpar2 a_2250_4949.t0 vss 5.00420e-14
Cpar3 a_2250_4949.t1 vss 1.69531e-14
Cpar4 a_2250_4949.t36 vss 9.84033e-14
Cpar5 ib out 1.10800e-17
Cpar6 ib vss 2.55067e-14
Cpar7 ib.t0 vss 4.52988e-15
Cpar8 ib.t1 vss 2.85024e-16
Cpar9 inn inp 2.19930e-16
Cpar10 inn out 4.32271e-14
Cpar11 inn vdd 1.90500e-17
Cpar12 inn vss 6.84990e-14
Cpar13 inn.t0 vss 7.32843e-14
Cpar14 inp vdd 1.99100e-17
Cpar15 inp vss 6.84642e-14
Cpar16 inp.t0 vss 7.28258e-14
Cpar17 out vdd 1.56844e-14
Cpar18 out vss 3.05393e-14
Cpar19 out.t0 vss 1.45448e-14
Cpar20 out.t17 vss 7.36981e-14
Cpar21 out.t82 vss 2.67660e-14
Cpar22 vdd vss 1.27326e-13
Cpar23 vdd.t0 vss 5.92857e-14
Cpar24 vdd.t1 vss 8.49081e-15
.ends opamp_dut

Vdd vdd 0 3.300000
Vss vss 0 0
Ibias vdd ib 6.500000e-07
Vinp inp 0 DC 1.645000 AC 1 PWL(0 1.645000 5.184226e-08 1.645000 5.702649e-08 1.655000)
Rfb out inn 1m
Cload out 0 2.000000e-12
Xdut vdd vss inp inn out ib opamp_dut
.end
