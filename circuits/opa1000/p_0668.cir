* opa1000[0668]: 200f/rail_to_rail_1v8_ulp_lt0p1uw_weak (rail_to_rail, VDD=1.8V, CL=0.2pF, Iref=0.0005uA)
.include "pdk_opa.inc"
.temp 27
.option gmin=1e-12 rshunt=1e12 reltol=1e-3 abstol=1e-12 vntol=1e-5 method=gear
* Post-PEX R+C extracted netlist for rail_to_rail_1v8_ulp_lt0p1uw_weak
.subckt opamp_dut vdd vss inp inn out ib
XMpar0 a_6972_10295.t6 inn.t0 a_7146_14862.t0 vss.t9 nfet_03v3 w=0.4u l=9.5u ad=2.4000e-13 pd=2.0000e-06 as=2.4000e-13 ps=2.0000e-06 nf=1 m=2 par=2
XMpar1 out.t1 ib.t0 vss.t1 vss.t0 nfet_03v3 w=0.4u l=8u ad=1.1200e-13 pd=9.6000e-07 as=2.0800e-13 ps=1.7400e-06 nf=1 m=8 par=8
XMpar2 a_6852_10503.t4 a_6972_10295.t2 vdd.t3 vdd.t2 pfet_03v3 w=0.4u l=9.5u ad=2.4000e-13 pd=2.0000e-06 as=1.1200e-13 ps=9.6000e-07 nf=1 m=2 par=2
XMpar3 a_9390_1041.t1 a_9390_1041.t0 vss.t1 vss.t0 nfet_03v3 w=0.4u l=8u ad=2.4000e-13 pd=2.0000e-06 as=1.1200e-13 ps=9.6000e-07 nf=1 m=2 par=2
XMpar4 out.t0 a_6852_10503.t7 vdd.t3 vdd.t2 pfet_03v3 w=0.4u l=9.5u ad=1.1200e-13 pd=9.6000e-07 as=1.7600e-13 ps=1.4800e-06 nf=1 m=8 par=8
XMpar5 a_1669_6556.t0 a_1789_6348.t2 vdd.t1 vdd.t0 pfet_03v3 w=0.4u l=8u ad=2.4000e-13 pd=2.0000e-06 as=1.1200e-13 ps=9.6000e-07 nf=1 m=2 par=2
XMpar6 a_6852_10503.t0 a_9390_1041.t0 vss.t1 vss.t0 nfet_03v3 w=0.4u l=8u ad=2.4000e-13 pd=2.0000e-06 as=1.1200e-13 ps=9.6000e-07 nf=1 m=2 par=2
XMpar7 ib.t1 ib.t0 vss.t1 vss.t0 nfet_03v3 w=0.4u l=8u ad=2.4000e-13 pd=2.0000e-06 as=1.1200e-13 ps=9.6000e-07 nf=1 m=2 par=2
XMpar8 a_7452_8843.t3 a_7452_8843.t2 vss.t1 vss.t0 nfet_03v3 w=0.4u l=8u ad=2.4000e-13 pd=2.0000e-06 as=1.1200e-13 ps=9.6000e-07 nf=1 m=2 par=2
XMpar9 a_1789_6348.t3 a_1789_6348.t2 vdd.t1 vdd.t0 pfet_03v3 w=0.4u l=8u ad=2.4000e-13 pd=2.0000e-06 as=1.1200e-13 ps=9.6000e-07 nf=1 m=2 par=2
XMpar10 a_1669_6556.t1 inn.t2 a_9390_1041.t4 vdd.t2 pfet_03v3 w=0.4u l=9.5u ad=2.4000e-13 pd=2.0000e-06 as=2.4000e-13 ps=2.0000e-06 nf=1 m=2 par=2
XMpar11 a_6972_10295.t3 a_6972_10295.t2 vdd.t3 vdd.t2 pfet_03v3 w=0.4u l=9.5u ad=1.1200e-13 pd=9.6000e-07 as=1.1200e-13 ps=9.6000e-07 nf=1 m=2 par=2
XMpar12 a_6852_10503.t2 inp.t0 a_7146_14862.t0 vss.t9 nfet_03v3 w=0.4u l=9.5u ad=2.4000e-13 pd=2.0000e-06 as=2.4000e-13 ps=2.0000e-06 nf=1 m=2 par=2
XMpar13 a_6972_10295.t0 a_7452_8843.t2 vss.t1 vss.t0 nfet_03v3 w=0.4u l=8u ad=1.1200e-13 pd=9.6000e-07 as=1.1200e-13 ps=9.6000e-07 nf=1 m=2 par=2
XMpar14 a_1789_6348.t0 ib.t0 vss.t1 vss.t0 nfet_03v3 w=0.4u l=8u ad=2.4000e-13 pd=2.0000e-06 as=1.1200e-13 ps=9.6000e-07 nf=1 m=2 par=2
XMpar15 a_7146_14862.t4 ib.t0 vss.t1 vss.t0 nfet_03v3 w=0.4u l=8u ad=2.4000e-13 pd=2.0000e-06 as=1.1200e-13 ps=9.6000e-07 nf=1 m=2 par=2
XMpar16 a_1669_6556.t1 inp.t2 a_7452_8843.t0 vdd.t2 pfet_03v3 w=0.4u l=9.5u ad=2.4000e-13 pd=2.0000e-06 as=2.4000e-13 ps=2.0000e-06 nf=1 m=2 par=2
X4 a_6852_10503.t6 a_20319_1290.t0 vss.t6 ppolyf_u_1k r_width=1u r_length=19.23u
X10 a_16341_3890.t0 a_20319_3370.t0 vss.t6 ppolyf_u_1k r_width=1u r_length=19.23u
X16 a_16341_5970.t0 a_20319_6490.t0 vss.t6 ppolyf_u_1k r_width=1u r_length=19.23u
X18 a_16341_2850.t0 a_20319_3370.t0 vss.t6 ppolyf_u_1k r_width=1u r_length=19.23u
X21 a_20319_7530.t1 out.t13 cap_mim_2f0fF c_width=19.85u c_length=19.84u
X22 a_16341_5970.t0 a_20319_5450.t0 vss.t6 ppolyf_u_1k r_width=1u r_length=19.23u
X26 a_16341_2850.t0 a_20319_2330.t0 vss.t6 ppolyf_u_1k r_width=1u r_length=19.23u
X33 a_16341_4930.t0 a_20319_5450.t0 vss.t6 ppolyf_u_1k r_width=1u r_length=19.23u
X38 a_16341_1810.t0 a_20319_2330.t0 vss.t6 ppolyf_u_1k r_width=1u r_length=19.23u
X41 a_16341_4930.t0 a_20319_4410.t0 vss.t6 ppolyf_u_1k r_width=1u r_length=19.23u
X42 a_16341_1810.t0 a_20319_1290.t0 vss.t6 ppolyf_u_1k r_width=1u r_length=19.23u
X50 a_16341_7010.t0 a_20319_7530.t0 vss.t6 ppolyf_u_1k r_width=1u r_length=19.23u
X53 a_16341_3890.t0 a_20319_4410.t0 vss.t6 ppolyf_u_1k r_width=1u r_length=19.23u
X59 a_16341_7010.t0 a_20319_6490.t0 vss.t6 ppolyf_u_1k r_width=1u r_length=19.23u
Rpar0 a_1669_6556.t0 a_1669_6556.t1 57.9834
Rpar1 a_1789_6348.t0 a_1789_6348.t2 96.0241
Rpar2 a_1789_6348.t0 a_1789_6348.t3 134.8375
Rpar3 a_1789_6348.t2 a_1789_6348.t3 16.9934
Rpar4 a_20319_7530.t0 a_20319_7530.t1 60.6720
Rpar5 a_6852_10503.t0 a_6852_10503.t7 399.1603
Rpar6 a_6852_10503.t0 a_6852_10503.t2 67.0119
Rpar7 a_6852_10503.t0 a_6852_10503.t4 884.3918
Rpar8 a_6852_10503.t0 a_6852_10503.t6 186.6058
Rpar9 a_6852_10503.t7 a_6852_10503.t2 432.4577
Rpar10 a_6852_10503.t7 a_6852_10503.t4 49.2748
Rpar11 a_6852_10503.t7 a_6852_10503.t6 135.4444
Rpar12 a_6852_10503.t2 a_6852_10503.t4 958.1664
Rpar13 a_6852_10503.t2 a_6852_10503.t6 202.1722
Rpar14 a_6852_10503.t4 a_6852_10503.t6 300.0947
Rpar15 a_6972_10295.t0 a_6972_10295.t2 209.9587
Rpar16 a_6972_10295.t0 a_6972_10295.t3 168.6073
Rpar17 a_6972_10295.t0 a_6972_10295.t6 95.9686
Rpar18 a_6972_10295.t2 a_6972_10295.t3 32.3488
Rpar19 a_6972_10295.t2 a_6972_10295.t6 336.3224
Rpar20 a_6972_10295.t3 a_6972_10295.t6 270.0837
Rpar21 a_7146_14862.t0 a_7146_14862.t4 81.6268
Rpar22 a_7452_8843.t0 a_7452_8843.t2 103.3733
Rpar23 a_7452_8843.t0 a_7452_8843.t3 81.9572
Rpar24 a_7452_8843.t2 a_7452_8843.t3 23.0435
Rpar25 a_9390_1041.t0 a_9390_1041.t1 17.1447
Rpar26 a_9390_1041.t0 a_9390_1041.t4 140.2912
Rpar27 a_9390_1041.t1 a_9390_1041.t4 133.1430
Rpar28 ib ib.t0 19.5107
Rpar29 ib ib.t1 18.4308
Rpar30 ib.t0 ib.t1 28.6778
Rpar31 inn inn.t0 4.0662
Rpar32 inn inn.t2 43.3994
Rpar33 inp inp.t0 4.0672
Rpar34 inp inp.t2 43.6710
Rpar35 out out.t0 6.5136
Rpar36 out out.t1 224.0916
Rpar37 out out.t13 385.1347
Rpar38 out.t0 out.t1 87.5979
Rpar39 out.t0 out.t13 150.5499
Rpar40 out.t1 out.t13 228.2015
Rpar41 vdd vdd.t0 3039.5055
Rpar42 vdd vdd.t1 1410.9461
Rpar43 vdd vdd.t2 184.5055
Rpar44 vdd vdd.t3 129.9946
Rpar45 vdd.t0 vdd.t1 21.2047
Rpar46 vdd.t0 vdd.t2 156.1093
Rpar47 vdd.t0 vdd.t3 542.7447
Rpar48 vdd.t1 vdd.t2 72.4663
Rpar49 vdd.t1 vdd.t3 251.9435
Rpar50 vdd.t2 vdd.t3 6.8713
Rpar51 vss vss.t0 62.8914
Rpar52 vss vss.t1 337.7078
Rpar53 vss vss.t6 1073.4578
Rpar54 vss vss.t9 130.7813
Rpar55 vss.t0 vss.t1 6.1118
Rpar56 vss.t0 vss.t6 41.4909
Rpar57 vss.t0 vss.t9 9.1598
Rpar58 vss.t1 vss.t6 84.0133
Rpar59 vss.t1 vss.t9 50.9463
Rpar60 vss.t6 vss.t9 152.7390
Cpar0 a_16341_1810.t0 vss 3.54800e-17
Cpar1 a_16341_2850.t0 vss 3.28000e-17
Cpar2 a_16341_3890.t0 vss 3.28000e-17
Cpar3 a_16341_4930.t0 vss 3.28800e-17
Cpar4 a_16341_5970.t0 vss 3.38200e-17
Cpar5 a_16341_7010.t0 vss 3.18800e-17
Cpar6 a_1669_6556.t0 vss 9.80468e-15
Cpar7 a_1669_6556.t1 vss 1.31330e-14
Cpar8 a_1789_6348.t0 vss 1.60569e-14
Cpar9 a_1789_6348.t2 vss 2.02490e-14
Cpar10 a_1789_6348.t3 vss 6.31609e-15
Cpar11 a_20319_1290.t0 vss 2.64400e-17
Cpar12 a_20319_2330.t0 vss 3.00800e-17
Cpar13 a_20319_3370.t0 vss 2.93600e-17
Cpar14 a_20319_4410.t0 vss 2.93600e-17
Cpar15 a_20319_5450.t0 vss 2.93600e-17
Cpar16 a_20319_6490.t0 vss 3.20200e-17
Cpar17 a_20319_7530.t0 vss 8.84500e-17
Cpar18 a_20319_7530.t1 vss 3.06309e-15
Cpar19 a_6852_10503.t0 vss 8.17384e-15
Cpar20 a_6852_10503.t2 vss 6.65688e-15
Cpar21 a_6852_10503.t4 vss 5.93528e-15
Cpar22 a_6852_10503.t6 vss 6.41154e-15
Cpar23 a_6852_10503.t7 vss 3.55239e-14
Cpar24 a_6972_10295.t0 vss 5.91352e-15
Cpar25 a_6972_10295.t2 vss 2.11182e-14
Cpar26 a_6972_10295.t3 vss 4.57507e-15
Cpar27 a_6972_10295.t6 vss 6.56059e-15
Cpar28 a_7146_14862.t0 vss 1.55628e-14
Cpar29 a_7146_14862.t4 vss 2.15471e-14
Cpar30 a_7452_8843.t0 vss 2.22860e-15
Cpar31 a_7452_8843.t2 vss 7.83520e-15
Cpar32 a_7452_8843.t3 vss 2.02244e-15
Cpar33 a_9390_1041.t0 vss 8.26686e-15
Cpar34 a_9390_1041.t1 vss 2.33791e-15
Cpar35 a_9390_1041.t4 vss 2.71207e-15
Cpar36 ib out 1.91777e-15
Cpar37 ib vdd 5.14550e-16
Cpar38 ib vss 6.56743e-14
Cpar39 ib.t0 vss 2.10706e-14
Cpar40 ib.t1 vss 1.64736e-15
Cpar41 inn inp 2.06850e-16
Cpar42 inn vdd 8.08754e-15
Cpar43 inn vss 1.34259e-14
Cpar44 inn.t0 vss 3.55824e-15
Cpar45 inn.t2 vss 6.87845e-15
Cpar46 inp vdd 8.15208e-15
Cpar47 inp vss 1.36447e-14
Cpar48 inp.t0 vss 3.60623e-15
Cpar49 inp.t2 vss 7.01344e-15
Cpar50 out vdd 1.90198e-14
Cpar51 out vss 2.71716e-14
Cpar52 out.t0 vss 5.59561e-15
Cpar53 out.t1 vss 1.30087e-14
Cpar54 out.t13 vss 1.57021e-14
Cpar55 vdd vss 2.19457e-13
Cpar56 vdd.t0 vss 2.29986e-14
Cpar57 vdd.t1 vss 7.07608e-15
Cpar58 vdd.t2 vss 7.67758e-14
Cpar59 vdd.t3 vss 2.08210e-14
.ends opamp_dut

Vdd vdd 0 1.800000
Vss vss 0 0
Ibias vdd ib 5.000000e-10
Vinp inp 0 DC 0.895000 AC 1 PWL(0 0.895000 3.472850e-05 0.895000 3.820135e-05 0.905000)
Rfb out inn 1m
Cload out 0 2.000000e-13
Xdut vdd vss inp inn out ib opamp_dut
.end
