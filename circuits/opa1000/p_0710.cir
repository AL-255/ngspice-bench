* opa1000[0710]: 2p/rail_to_rail_1v8_i50n_weak (rail_to_rail, VDD=1.8V, CL=2.0pF, Iref=0.0081uA)
.include "pdk_opa.inc"
.temp 27
.option gmin=1e-12 rshunt=1e12 reltol=1e-3 abstol=1e-12 vntol=1e-5 method=gear
* Post-PEX R+C extracted netlist for rail_to_rail_1v8_i50n_weak
.subckt opamp_dut vdd vss inp inn out ib
XMpar0 a_8848_6703.t3 a_8848_6703.t2 vss.t2 vss.t1 nfet_03v3 w=0.4u l=3.9u ad=2.4000e-13 pd=2.0000e-06 as=1.1200e-13 ps=9.6000e-07 nf=1 m=2 par=2
XMpar1 out.t10 ib.t0 vss.t32 vss.t31 nfet_03v3 w=0.4u l=7.5u ad=1.1200e-13 pd=9.6000e-07 as=2.0800e-13 ps=1.7400e-06 nf=1 m=8 par=8
XMpar2 out.t0 a_1108_1290.t7 vdd.t1 vdd.t0 pfet_03v3 w=0.4u l=5u ad=1.4400e-13 pd=1.2200e-06 as=1.7600e-13 ps=1.4800e-06 nf=1 m=8 par=8
XMpar3 a_8772_11156.t2 a_8848_6703.t2 vss.t2 vss.t1 nfet_03v3 w=0.4u l=3.9u ad=1.1200e-13 pd=9.6000e-07 as=1.1200e-13 ps=9.6000e-07 nf=1 m=2 par=2
XMpar4 a_9212_1041.t3 a_9212_1041.t2 vss.t2 vss.t1 nfet_03v3 w=0.4u l=3.9u ad=1.1200e-13 pd=9.6000e-07 as=1.1200e-13 ps=9.6000e-07 nf=1 m=2 par=2
XMpar5 a_10363_12772.t1 a_10363_12772.t0 vdd.t7 vdd.t6 pfet_03v3 w=0.4u l=7.5u ad=2.4000e-13 pd=2.0000e-06 as=1.1200e-13 ps=9.6000e-07 nf=1 m=2 par=2
XMpar6 a_1108_1290.t5 a_8772_11156.t4 vdd.t1 vdd.t0 pfet_03v3 w=0.4u l=5u ad=2.4000e-13 pd=2.0000e-06 as=1.1200e-13 ps=9.6000e-07 nf=1 m=2 par=2
XMpar7 a_1108_1290.t0 inp.t2 a_7102_8248.t0 vss.t5 nfet_03v3 w=0.4u l=8.13u ad=1.1200e-13 pd=9.6000e-07 as=2.4000e-13 ps=2.0000e-06 nf=1 m=2 par=2
XMpar8 a_10363_12772.t4 ib.t0 vss.t32 vss.t31 nfet_03v3 w=0.4u l=7.5u ad=2.4000e-13 pd=2.0000e-06 as=1.1200e-13 ps=9.6000e-07 nf=1 m=2 par=2
XMpar9 a_7102_6703.t2 a_10363_12772.t0 vdd.t7 vdd.t6 pfet_03v3 w=0.4u l=7.5u ad=2.4000e-13 pd=2.0000e-06 as=1.1200e-13 ps=9.6000e-07 nf=1 m=2 par=2
XMpar10 a_7102_6703.t0 inp.t0 a_8848_6703.t0 vdd.t2 pfet_03v3 w=0.4u l=8.13u ad=2.4000e-13 pd=2.0000e-06 as=1.1200e-13 ps=9.6000e-07 nf=1 m=2 par=2
XMpar11 a_7102_8248.t0 inn.t2 a_8772_11156.t0 vss.t5 nfet_03v3 w=0.4u l=8.13u ad=2.4000e-13 pd=2.0000e-06 as=1.1200e-13 ps=9.6000e-07 nf=1 m=2 par=2
XMpar12 a_1108_1290.t3 a_9212_1041.t2 vss.t2 vss.t1 nfet_03v3 w=0.4u l=3.9u ad=2.4000e-13 pd=2.0000e-06 as=1.1200e-13 ps=9.6000e-07 nf=1 m=2 par=2
XMpar13 a_7102_6703.t0 inn.t0 a_9212_1041.t0 vdd.t2 pfet_03v3 w=0.4u l=8.13u ad=2.4000e-13 pd=2.0000e-06 as=1.1200e-13 ps=9.6000e-07 nf=1 m=2 par=2
XMpar14 ib.t1 ib.t0 vss.t32 vss.t31 nfet_03v3 w=0.4u l=7.5u ad=2.4000e-13 pd=2.0000e-06 as=1.1200e-13 ps=9.6000e-07 nf=1 m=2 par=2
XMpar15 a_8772_11156.t5 a_8772_11156.t4 vdd.t1 vdd.t0 pfet_03v3 w=0.4u l=5u ad=1.1200e-13 pd=9.6000e-07 as=1.1200e-13 ps=9.6000e-07 nf=1 m=2 par=2
XMpar16 a_7102_8248.t4 ib.t0 vss.t32 vss.t31 nfet_03v3 w=0.4u l=7.5u ad=2.4000e-13 pd=2.0000e-06 as=1.1200e-13 ps=9.6000e-07 nf=1 m=2 par=2
X1 a_1108_5970.t0 a_5086_6490.t0 vss.t0 ppolyf_u_1k r_width=1u r_length=19.23u
X3 a_1108_2850.t0 a_5086_3370.t0 vss.t0 ppolyf_u_1k r_width=1u r_length=19.23u
X10 a_1108_5970.t0 a_5086_5450.t0 vss.t0 ppolyf_u_1k r_width=1u r_length=19.23u
X17 a_1108_2850.t0 a_5086_2330.t0 vss.t0 ppolyf_u_1k r_width=1u r_length=19.23u
X18 a_5086_7530.t1 out.t4 cap_mim_2f0fF c_width=17.1u c_length=17.11u
X20 a_5086_7530.t1 out.t4 cap_mim_2f0fF c_width=17.1u c_length=17.11u
X25 a_1108_4930.t0 a_5086_5450.t0 vss.t0 ppolyf_u_1k r_width=1u r_length=19.23u
X26 a_1108_1810.t0 a_5086_2330.t0 vss.t0 ppolyf_u_1k r_width=1u r_length=19.23u
X30 a_1108_4930.t0 a_5086_4410.t0 vss.t0 ppolyf_u_1k r_width=1u r_length=19.23u
X31 a_1108_1810.t0 a_5086_1290.t0 vss.t0 ppolyf_u_1k r_width=1u r_length=19.23u
X36 a_1108_7010.t0 a_5086_7530.t0 vss.t0 ppolyf_u_1k r_width=1u r_length=19.23u
X39 a_1108_3890.t0 a_5086_4410.t0 vss.t0 ppolyf_u_1k r_width=1u r_length=19.23u
X40 a_5086_7530.t1 out.t4 cap_mim_2f0fF c_width=17.1u c_length=17.11u
X45 a_1108_7010.t0 a_5086_6490.t0 vss.t0 ppolyf_u_1k r_width=1u r_length=19.23u
X51 a_1108_1290.t2 a_5086_1290.t0 vss.t0 ppolyf_u_1k r_width=1u r_length=19.23u
X56 a_1108_3890.t0 a_5086_3370.t0 vss.t0 ppolyf_u_1k r_width=1u r_length=19.23u
Rpar0 a_10363_12772.t0 a_10363_12772.t1 16.1962
Rpar1 a_10363_12772.t0 a_10363_12772.t4 201.1360
Rpar2 a_10363_12772.t1 a_10363_12772.t4 282.5541
Rpar3 a_1108_1290.t0 a_1108_1290.t7 73.9958
Rpar4 a_1108_1290.t0 a_1108_1290.t2 209.2672
Rpar5 a_1108_1290.t0 a_1108_1290.t3 238.7399
Rpar6 a_1108_1290.t0 a_1108_1290.t5 199.0321
Rpar7 a_1108_1290.t7 a_1108_1290.t2 205.2962
Rpar8 a_1108_1290.t7 a_1108_1290.t3 234.2096
Rpar9 a_1108_1290.t7 a_1108_1290.t5 96.4815
Rpar10 a_1108_1290.t2 a_1108_1290.t3 98.6149
Rpar11 a_1108_1290.t2 a_1108_1290.t5 552.2005
Rpar12 a_1108_1290.t3 a_1108_1290.t5 629.9711
Rpar13 a_5086_7530.t0 a_5086_7530.t1 62.4546
Rpar14 a_7102_6703.t0 a_7102_6703.t2 81.5687
Rpar15 a_7102_8248.t0 a_7102_8248.t4 69.0323
Rpar16 a_8772_11156.t0 a_8772_11156.t2 121.9026
Rpar17 a_8772_11156.t0 a_8772_11156.t4 156.2468
Rpar18 a_8772_11156.t0 a_8772_11156.t5 143.9738
Rpar19 a_8772_11156.t2 a_8772_11156.t4 193.3678
Rpar20 a_8772_11156.t2 a_8772_11156.t5 178.1790
Rpar21 a_8772_11156.t4 a_8772_11156.t5 31.3677
Rpar22 a_8848_6703.t0 a_8848_6703.t2 185.2380
Rpar23 a_8848_6703.t0 a_8848_6703.t3 138.5097
Rpar24 a_8848_6703.t2 a_8848_6703.t3 21.1800
Rpar25 a_9212_1041.t0 a_9212_1041.t2 170.7010
Rpar26 a_9212_1041.t0 a_9212_1041.t3 171.6752
Rpar27 a_9212_1041.t2 a_9212_1041.t3 29.2369
Rpar28 ib ib.t0 18.7334
Rpar29 ib ib.t1 18.1856
Rpar30 ib.t0 ib.t1 28.5723
Rpar31 inn inn.t0 60.3141
Rpar32 inn inn.t2 3.3504
Rpar33 inp inp.t0 41.9775
Rpar34 inp inp.t2 3.3990
Rpar35 out out.t0 576.6070
Rpar36 out out.t10 6.9841
Rpar37 out out.t4 1310.4120
Rpar38 out.t0 out.t10 190.6658
Rpar39 out.t0 out.t4 79.4717
Rpar40 out.t10 out.t4 433.3120
Rpar41 vdd vdd.t0 127.9246
Rpar42 vdd vdd.t1 224.1139
Rpar43 vdd vdd.t6 229.4628
Rpar44 vdd vdd.t7 127.2673
Rpar45 vdd vdd.t2 1058.7269
Rpar46 vdd.t0 vdd.t1 6.2124
Rpar47 vdd.t0 vdd.t6 333.9878
Rpar48 vdd.t0 vdd.t7 185.2402
Rpar49 vdd.t0 vdd.t2 162.9914
Rpar50 vdd.t1 vdd.t6 585.1205
Rpar51 vdd.t1 vdd.t7 324.5262
Rpar52 vdd.t1 vdd.t2 156.7893
Rpar53 vdd.t6 vdd.t7 22.7522
Rpar54 vdd.t6 vdd.t2 2764.1427
Rpar55 vdd.t7 vdd.t2 1533.0805
Rpar56 vss vss.t0 62.3109
Rpar57 vss vss.t1 152.1868
Rpar58 vss vss.t2 412.9281
Rpar59 vss vss.t5 1178.8813
Rpar60 vss vss.t31 173.7606
Rpar61 vss vss.t32 208.0123
Rpar62 vss.t0 vss.t1 150.6395
Rpar63 vss.t0 vss.t2 416.8911
Rpar64 vss.t0 vss.t5 1000.9402
Rpar65 vss.t0 vss.t31 178.2874
Rpar66 vss.t0 vss.t32 220.7299
Rpar67 vss.t1 vss.t2 10.2784
Rpar68 vss.t1 vss.t5 8.8975
Rpar69 vss.t1 vss.t31 7.7112
Rpar70 vss.t1 vss.t32 30.8647
Rpar71 vss.t2 vss.t5 32.5220
Rpar72 vss.t2 vss.t31 22.9687
Rpar73 vss.t2 vss.t32 94.3040
Rpar74 vss.t5 vss.t31 866.7783
Rpar75 vss.t5 vss.t32 483.7353
Rpar76 vss.t31 vss.t32 25.8952
Cpar0 a_10363_12772.t0 vss 2.06112e-14
Cpar1 a_10363_12772.t1 vss 7.42532e-15
Cpar2 a_10363_12772.t4 vss 1.99970e-14
Cpar3 a_1108_1290.t0 vss 3.80359e-15
Cpar4 a_1108_1290.t2 vss 4.56940e-15
Cpar5 a_1108_1290.t3 vss 4.75466e-15
Cpar6 a_1108_1290.t5 vss 4.65381e-15
Cpar7 a_1108_1290.t7 vss 2.28501e-14
Cpar8 a_1108_1810.t0 vss 3.20200e-17
Cpar9 a_1108_2850.t0 vss 2.93600e-17
Cpar10 a_1108_3890.t0 vss 2.93600e-17
Cpar11 a_1108_4930.t0 vss 2.93600e-17
Cpar12 a_1108_5970.t0 vss 3.00800e-17
Cpar13 a_1108_7010.t0 vss 2.66000e-17
Cpar14 a_5086_1290.t0 vss 3.22200e-17
Cpar15 a_5086_2330.t0 vss 3.06600e-17
Cpar16 a_5086_3370.t0 vss 3.53600e-17
Cpar17 a_5086_4410.t0 vss 3.66000e-17
Cpar18 a_5086_5450.t0 vss 3.32200e-17
Cpar19 a_5086_6490.t0 vss 4.51200e-17
Cpar20 a_5086_7530.t0 vss 1.65160e-16
Cpar21 a_5086_7530.t1 vss 8.88814e-15
Cpar22 a_7102_6703.t0 vss 1.08718e-14
Cpar23 a_7102_6703.t2 vss 1.16663e-14
Cpar24 a_7102_8248.t0 vss 1.16756e-14
Cpar25 a_7102_8248.t4 vss 2.13008e-14
Cpar26 a_8772_11156.t0 vss 3.70618e-15
Cpar27 a_8772_11156.t2 vss 3.54671e-15
Cpar28 a_8772_11156.t4 vss 1.23176e-14
Cpar29 a_8772_11156.t5 vss 3.02366e-15
Cpar30 a_8848_6703.t0 vss 2.55774e-15
Cpar31 a_8848_6703.t2 vss 6.30451e-15
Cpar32 a_8848_6703.t3 vss 2.40448e-15
Cpar33 a_9212_1041.t0 vss 2.23010e-15
Cpar34 a_9212_1041.t2 vss 3.81645e-15
Cpar35 a_9212_1041.t3 vss 1.51652e-15
Cpar36 ib out 1.98127e-15
Cpar37 ib vdd 1.11500e-17
Cpar38 ib vss 6.24478e-14
Cpar39 ib.t0 vss 1.99277e-14
Cpar40 ib.t1 vss 1.54573e-15
Cpar41 inn inp 1.03000e-16
Cpar42 inn vdd 7.80152e-15
Cpar43 inn vss 1.24366e-14
Cpar44 inn.t0 vss 5.50455e-15
Cpar45 inn.t2 vss 2.44846e-15
Cpar46 inp vdd 7.48684e-15
Cpar47 inp vss 1.18745e-14
Cpar48 inp.t0 vss 5.22568e-15
Cpar49 inp.t2 vss 2.45534e-15
Cpar50 out vdd 1.57347e-14
Cpar51 out vss 3.10068e-14
Cpar52 out.t0 vss 7.19891e-15
Cpar53 out.t10 vss 5.22027e-15
Cpar54 out.t4 vss 2.52273e-14
Cpar55 vdd vss 1.72466e-13
Cpar56 vdd.t0 vss 4.09419e-14
Cpar57 vdd.t1 vss 1.05263e-14
Cpar58 vdd.t2 vss 1.99838e-14
Cpar59 vdd.t6 vss 1.95655e-14
Cpar60 vdd.t7 vss 5.90036e-15
.ends opamp_dut

Vdd vdd 0 1.800000
Vss vss 0 0
Ibias vdd ib 8.100000e-09
Vinp inp 0 DC 0.895000 AC 1 PWL(0 0.895000 6.707474e-06 0.895000 7.378221e-06 0.905000)
Rfb out inn 1m
Cload out 0 2.000000e-12
Xdut vdd vss inp inn out ib opamp_dut
.end
