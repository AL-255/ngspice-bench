* opa1000[0845]: 200f/telescopic_nmos_1v8_1u_10u_subth (telescopic_nmos, VDD=1.8V, CL=0.2pF, Iref=1.625uA)
.include "pdk_opa.inc"
.temp 27
.option gmin=1e-12 rshunt=1e12 reltol=1e-3 abstol=1e-12 vntol=1e-5 method=gear
* Post-PEX R+C extracted netlist for telescopic_nmos_1v8_1u_10u_subth
.subckt opamp_dut vdd vss inp inn out ib
XMpar0 a_2793_7673.t0 a_2093_7465.t0 out.t0 vdd.t0 pfet_03v3 w=2.09u l=0.8u ad=7.9420e-13 pd=3.5031e-06 as=7.5240e-13 ps=3.3325e-06 nf=1 m=64 par=64
XMpar1 a_9774_4025.t28 vdd.t146 out.t3 vss.t0 nfet_03v3 w=1.85u l=0.8u ad=6.1667e-13 pd=2.8250e-06 as=5.1800e-13 ps=2.4100e-06 nf=1 m=12 par=12
XMpar2 a_2793_7673.t3 a_2093_7465.t204 vdd.t13 vdd.t12 pfet_03v3 w=1.87u l=1.6u ad=5.2360e-13 pd=2.4300e-06 as=5.2360e-13 ps=2.4300e-06 nf=1 m=20 par=20
XMpar3 a_1973_7673.t0 a_2093_7465.t0 a_2093_7465.t1 vdd.t0 pfet_03v3 w=2.09u l=0.8u ad=7.9420e-13 pd=3.5031e-06 as=7.3150e-13 ps=3.2472e-06 nf=1 m=64 par=64
XMpar4 a_1844_11688.t0 inn.t0 a_9774_4025.t0 vss.t0 nfet_03v3 w=1.96u l=1u ad=6.3840e-13 pd=2.8914e-06 as=5.4880e-13 ps=2.5200e-06 nf=1 m=28 par=28
XMpar5 a_1973_7673.t9 a_2093_7465.t204 vdd.t13 vdd.t12 pfet_03v3 w=1.87u l=1.6u ad=6.4328e-13 pd=2.9320e-06 as=5.2360e-13 ps=2.4300e-06 nf=1 m=20 par=20
XMpar6 a_1844_11688.t56 ib.t0 vss.t29 vss.t28 nfet_03v3 w=7.6u l=3u ad=2.1280e-12 pd=8.1600e-06 as=2.7360e-12 ps=1.0220e-05 nf=1 m=8 par=8
XMpar7 a_1844_11688.t0 inp.t0 a_5410_1204.t0 vss.t0 nfet_03v3 w=1.96u l=1u ad=6.3840e-13 pd=2.8914e-06 as=5.4880e-13 ps=2.5200e-06 nf=1 m=28 par=28
XMpar8 a_2093_7465.t128 vdd.t146 a_5410_1204.t28 vss.t0 nfet_03v3 w=1.85u l=0.8u ad=5.1800e-13 pd=2.4100e-06 as=6.1667e-13 ps=2.8250e-06 nf=1 m=12 par=12
XMpar9 ib.t1 ib.t0 vss.t29 vss.t28 nfet_03v3 w=7.6u l=3u ad=2.1280e-12 pd=8.1600e-06 as=2.1280e-12 ps=8.1600e-06 nf=1 m=2 par=2
Rpar0 a_1844_11688.t0 a_1844_11688.t56 55.4534
Rpar1 a_1973_7673.t0 a_1973_7673.t9 63.7343
Rpar2 a_2093_7465.t0 a_2093_7465.t1 5.3896
Rpar3 a_2093_7465.t0 a_2093_7465.t128 231.1940
Rpar4 a_2093_7465.t0 a_2093_7465.t204 397.0076
Rpar5 a_2093_7465.t1 a_2093_7465.t128 59.4116
Rpar6 a_2093_7465.t1 a_2093_7465.t204 102.0219
Rpar7 a_2093_7465.t128 a_2093_7465.t204 197.1640
Rpar8 a_2793_7673.t0 a_2793_7673.t3 50.2889
Rpar9 a_5410_1204.t0 a_5410_1204.t28 35.4184
Rpar10 a_9774_4025.t0 a_9774_4025.t28 35.4184
Rpar11 ib ib.t0 28.2988
Rpar12 ib ib.t1 10.4661
Rpar13 ib.t0 ib.t1 53.0672
Rpar14 inn inn.t0 1.6755
Rpar15 inp inp.t0 1.6755
Rpar16 out out.t0 3.0595
Rpar17 out.t0 out.t3 50.8435
Rpar18 vdd vdd.t0 133.0317
Rpar19 vdd vdd.t12 26.4127
Rpar20 vdd vdd.t13 714.2324
Rpar21 vdd vdd.t146 1466.9135
Rpar22 vdd.t0 vdd.t12 69.9953
Rpar23 vdd.t0 vdd.t13 1892.7624
Rpar24 vdd.t0 vdd.t146 76.3787
Rpar25 vdd.t12 vdd.t13 10.8231
Rpar26 vdd.t12 vdd.t146 771.8242
Rpar27 vss vss.t0 41.5871
Rpar28 vss vss.t28 1744.1769
Rpar29 vss vss.t29 5430.6926
Rpar30 vss.t0 vss.t28 78.6600
Rpar31 vss.t0 vss.t29 244.9716
Rpar32 vss.t28 vss.t29 5.7657
Cpar0 a_1844_11688.t0 vss 2.87234e-14
Cpar1 a_1844_11688.t56 vss 1.50440e-14
Cpar2 a_1973_7673.t0 vss 7.54564e-14
Cpar3 a_1973_7673.t9 vss 2.85880e-14
Cpar4 a_2093_7465.t0 vss 1.04544e-13
Cpar5 a_2093_7465.t1 vss 6.76917e-14
Cpar6 a_2093_7465.t128 vss 1.01369e-14
Cpar7 a_2093_7465.t204 vss 5.94649e-14
Cpar8 a_2793_7673.t0 vss 8.11497e-14
Cpar9 a_2793_7673.t3 vss 2.80083e-14
Cpar10 a_5410_1204.t0 vss 1.67044e-14
Cpar11 a_5410_1204.t28 vss 7.27878e-15
Cpar12 a_9774_4025.t0 vss 1.59298e-14
Cpar13 a_9774_4025.t28 vss 6.94122e-15
Cpar14 ib out 1.19700e-17
Cpar15 ib vdd 8.66430e-16
Cpar16 ib vss 2.66650e-14
Cpar17 ib.t0 vss 7.28348e-15
Cpar18 ib.t1 vss 4.98420e-16
Cpar19 inn inp 1.04240e-16
Cpar20 inn vdd 2.13300e-17
Cpar21 inn vss 1.82145e-14
Cpar22 inn.t0 vss 7.12956e-15
Cpar23 inp vdd 2.62700e-17
Cpar24 inp vss 1.83096e-14
Cpar25 inp.t0 vss 7.13291e-15
Cpar26 out vdd 2.84460e-14
Cpar27 out vss 1.45212e-14
Cpar28 out.t0 vss 8.04857e-14
Cpar29 out.t3 vss 1.09177e-14
Cpar30 vdd vss 4.17153e-13
Cpar31 vdd.t0 vss 1.51358e-13
Cpar32 vdd.t12 vss 5.14810e-14
Cpar33 vdd.t13 vss 6.96455e-15
Cpar34 vdd.t146 vss 5.47945e-15
.ends opamp_dut

Vdd vdd 0 1.800000
Vss vss 0 0
Ibias vdd ib 1.625000e-06
Vinp inp 0 DC 0.931000 AC 1 PWL(0 0.931000 7.162788e-09 0.931000 7.879066e-09 0.941000)
Rfb out inn 1m
Cload out 0 2.000000e-13
Xdut vdd vss inp inn out ib opamp_dut
.end
