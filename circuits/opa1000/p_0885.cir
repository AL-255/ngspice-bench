* opa1000[0885]: 2p/telescopic_nmos_1v8_i2u_weak (telescopic_nmos, VDD=1.8V, CL=2.0pF, Iref=0.65uA)
.include "pdk_opa.inc"
.temp 27
.option gmin=1e-12 rshunt=1e12 reltol=1e-3 abstol=1e-12 vntol=1e-5 method=gear
* Post-PEX R+C extracted netlist for telescopic_nmos_1v8_i2u_weak
.subckt opamp_dut vdd vss inp inn out ib
XMpar0 a_2016_12343.t0 inn.t0 a_8174_1205.t0 vss.t0 nfet_03v3 w=2.04u l=4.5u ad=7.5771e-13 pd=3.3657e-06 as=6.6446e-13 ps=2.9829e-06 nf=1 m=14 par=14
XMpar1 a_4856_4404.t1 a_2980_6017.t22 vdd.t2 vdd.t1 pfet_03v3 w=1.65u l=3.4u ad=4.6200e-13 pd=2.2100e-06 as=4.6200e-13 ps=2.2100e-06 nf=1 m=6 par=6
XMpar2 a_2016_12343.t0 inp.t0 a_3818_8330.t0 vss.t0 nfet_03v3 w=2.04u l=4.5u ad=7.5771e-13 pd=3.3657e-06 as=6.6446e-13 ps=2.9829e-06 nf=1 m=14 par=14
XMpar3 a_4856_4404.t0 a_2980_6017.t2 out.t0 vdd.t0 pfet_03v3 w=2.05u l=1.95u ad=7.0520e-13 pd=3.1480e-06 as=5.7400e-13 ps=2.6100e-06 nf=1 m=10 par=10
XMpar4 a_2860_6225.t0 a_2980_6017.t2 a_2980_6017.t3 vdd.t0 pfet_03v3 w=2.05u l=1.95u ad=7.0520e-13 pd=3.1480e-06 as=7.0520e-13 ps=3.1480e-06 nf=1 m=10 par=10
XMpar5 a_2980_6017.t0 vdd.t44 a_3818_8330.t14 vss.t18 nfet_03v3 w=2.35u l=1.95u ad=6.5800e-13 pd=2.9100e-06 as=1.4100e-12 ps=5.9000e-06 nf=1 m=2 par=2
XMpar6 a_2016_12343.t28 ib.t0 vss.t23 vss.t0 nfet_03v3 w=1.29u l=3.9u ad=3.6120e-13 pd=1.8500e-06 as=4.6440e-13 ps=2.3325e-06 nf=1 m=8 par=8
XMpar7 a_2860_6225.t1 a_2980_6017.t22 vdd.t2 vdd.t1 pfet_03v3 w=1.65u l=3.4u ad=6.3800e-13 pd=2.9733e-06 as=4.6200e-13 ps=2.2100e-06 nf=1 m=6 par=6
XMpar8 ib.t1 ib.t0 vss.t23 vss.t0 nfet_03v3 w=1.29u l=3.9u ad=3.6120e-13 pd=1.8500e-06 as=3.6120e-13 ps=1.8500e-06 nf=1 m=2 par=2
XMpar9 a_8174_1205.t14 vdd.t44 out.t5 vss.t18 nfet_03v3 w=2.35u l=1.95u ad=1.4100e-12 pd=5.9000e-06 as=6.5800e-13 ps=2.9100e-06 nf=1 m=2 par=2
X34 out.t12 vss.t42 cap_mim_2f0fF c_width=7.75u c_length=7.75u
Rpar0 a_2016_12343.t0 a_2016_12343.t28 57.9592
Rpar1 a_2860_6225.t0 a_2860_6225.t1 45.9430
Rpar2 a_2980_6017.t0 a_2980_6017.t2 693.0465
Rpar3 a_2980_6017.t0 a_2980_6017.t3 203.1997
Rpar4 a_2980_6017.t0 a_2980_6017.t22 127.2541
Rpar5 a_2980_6017.t2 a_2980_6017.t3 15.8044
Rpar6 a_2980_6017.t2 a_2980_6017.t22 175.7141
Rpar7 a_2980_6017.t3 a_2980_6017.t22 51.5190
Rpar8 a_3818_8330.t0 a_3818_8330.t14 70.2489
Rpar9 a_4856_4404.t0 a_4856_4404.t1 60.2171
Rpar10 a_8174_1205.t0 a_8174_1205.t14 70.2489
Rpar11 ib ib.t0 11.1731
Rpar12 ib ib.t1 16.1962
Rpar13 inn inn.t0 1.7506
Rpar14 inp inp.t0 1.7506
Rpar15 out out.t0 207.0138
Rpar16 out out.t5 71.2372
Rpar17 out out.t12 14.7702
Rpar18 out.t0 out.t5 93.5733
Rpar19 out.t0 out.t12 3240.2508
Rpar20 out.t5 out.t12 1115.0288
Rpar21 vdd vdd.t0 103.5697
Rpar22 vdd vdd.t1 134.4183
Rpar23 vdd vdd.t2 586.1405
Rpar24 vdd vdd.t44 480.7511
Rpar25 vdd.t0 vdd.t1 56.9503
Rpar26 vdd.t0 vdd.t2 248.3358
Rpar27 vdd.t0 vdd.t44 203.6845
Rpar28 vdd.t1 vdd.t2 5.9054
Rpar29 vdd.t1 vdd.t44 104.1000
Rpar30 vdd.t2 vdd.t44 453.9354
Rpar31 vss vss.t0 209.8785
Rpar32 vss vss.t18 79.8223
Rpar33 vss vss.t23 3072.2049
Rpar34 vss vss.t42 62.5369
Rpar35 vss.t0 vss.t18 129.8202
Rpar36 vss.t0 vss.t23 5.2681
Rpar37 vss.t0 vss.t42 705.8757
Rpar38 vss.t18 vss.t23 1893.2193
Rpar39 vss.t18 vss.t42 268.4630
Cpar0 a_2016_12343.t0 vss 2.90968e-14
Cpar1 a_2016_12343.t28 vss 6.41403e-15
Cpar2 a_2860_6225.t0 vss 1.58198e-14
Cpar3 a_2860_6225.t1 vss 9.86850e-15
Cpar4 a_2980_6017.t0 vss 4.17059e-15
Cpar5 a_2980_6017.t2 vss 2.89079e-14
Cpar6 a_2980_6017.t22 vss 2.82443e-14
Cpar7 a_2980_6017.t3 vss 1.16121e-14
Cpar8 a_3818_8330.t0 vss 1.68669e-14
Cpar9 a_3818_8330.t14 vss 5.61663e-15
Cpar10 a_4856_4404.t0 vss 1.81698e-14
Cpar11 a_4856_4404.t1 vss 1.12689e-14
Cpar12 a_8174_1205.t0 vss 1.53320e-14
Cpar13 a_8174_1205.t14 vss 5.10548e-15
Cpar14 ib inp 1.80000e-17
Cpar15 ib vdd 1.83870e-16
Cpar16 ib vss 2.81197e-14
Cpar17 ib.t0 vss 4.36579e-15
Cpar18 ib.t1 vss 1.89466e-16
Cpar19 inn inp 1.12650e-16
Cpar20 inn vdd 1.97390e-16
Cpar21 inn vss 2.66602e-14
Cpar22 inn.t0 vss 1.04476e-14
Cpar23 inp vdd 8.67400e-17
Cpar24 inp vss 2.67143e-14
Cpar25 inp.t0 vss 1.03699e-14
Cpar26 out vdd 8.00561e-15
Cpar27 out vss 1.24956e-14
Cpar28 out.t0 vss 5.09224e-15
Cpar29 out.t12 vss 9.42460e-15
Cpar30 out.t5 vss 2.05540e-15
Cpar31 vdd vss 1.50198e-13
Cpar32 vdd.t0 vss 3.40336e-14
Cpar33 vdd.t1 vss 2.28612e-14
Cpar34 vdd.t2 vss 6.12005e-15
Cpar35 vdd.t44 vss 2.92755e-15
.ends opamp_dut

Vdd vdd 0 1.800000
Vss vss 0 0
Ibias vdd ib 6.500000e-07
Vinp inp 0 DC 0.931000 AC 1 PWL(0 0.931000 5.935846e-08 0.931000 6.529430e-08 0.941000)
Rfb out inn 1m
Cload out 0 2.000000e-12
Xdut vdd vss inp inn out ib opamp_dut
.end
