* opa1000[0441]: 200f/nmos_miller_3v3_i200n_weak (nmos_miller, VDD=3.3V, CL=0.2pF, Iref=0.0371uA)
.include "pdk_opa.inc"
.temp 27
.option gmin=1e-12 rshunt=1e12 reltol=1e-3 abstol=1e-12 vntol=1e-5 method=gear
* Post-PEX R+C extracted netlist for nmos_miller_3v3_i200n_weak
.subckt opamp_dut vdd vss inp inn out ib
XMpar0 a_4086_4349.t4 ib.t0 vss.t6 vss.t5 nfet_03v3 w=0.4u l=5u ad=2.4000e-13 pd=2.0000e-06 as=1.1200e-13 ps=9.6000e-07 nf=1 m=4 par=4
XMpar1 a_6190_1041.t3 a_6190_1041.t2 vdd.t1 vdd.t0 pfet_03v3 w=0.49u l=3.2u ad=2.9400e-13 pd=2.1800e-06 as=1.3720e-13 ps=1.0500e-06 nf=1 m=2 par=2
XMpar2 out.t0 a_1041_9275.t5 vdd.t1 vdd.t0 pfet_03v3 w=0.49u l=3.2u ad=1.6856e-13 pd=1.2760e-06 as=1.6856e-13 ps=1.2760e-06 nf=1 m=10 par=10
XMpar3 ib.t1 ib.t0 vss.t6 vss.t5 nfet_03v3 w=0.4u l=5u ad=2.4000e-13 pd=2.0000e-06 as=1.1200e-13 ps=9.6000e-07 nf=1 m=2 par=2
XMpar4 out.t10 ib.t0 vss.t6 vss.t5 nfet_03v3 w=0.4u l=5u ad=1.8880e-13 pd=1.5840e-06 as=1.6320e-13 ps=1.3760e-06 nf=1 m=10 par=10
XMpar5 a_4086_4349.t0 inn.t0 a_6190_1041.t0 vss.t0 nfet_03v3 w=0.4u l=3.9u ad=2.4000e-13 pd=2.0000e-06 as=1.1200e-13 ps=9.6000e-07 nf=1 m=2 par=2
XMpar6 a_1041_9275.t3 a_6190_1041.t2 vdd.t1 vdd.t0 pfet_03v3 w=0.49u l=3.2u ad=2.9400e-13 pd=2.1800e-06 as=1.3720e-13 ps=1.0500e-06 nf=1 m=2 par=2
XMpar7 a_1041_9275.t0 inp.t0 a_4086_4349.t0 vss.t0 nfet_03v3 w=0.4u l=3.9u ad=1.1200e-13 pd=9.6000e-07 as=2.4000e-13 ps=2.0000e-06 nf=1 m=2 par=2
X3 a_1041_11875.t0 a_5019_12395.t0 vss.t2 ppolyf_u_1k r_width=1u r_length=19.23u
X6 a_1041_14995.t0 a_5019_14475.t0 vss.t2 ppolyf_u_1k r_width=1u r_length=19.23u
X7 a_1041_11875.t0 a_5019_11355.t0 vss.t2 ppolyf_u_1k r_width=1u r_length=19.23u
X12 a_1041_9795.t0 a_5019_9275.t0 vss.t2 ppolyf_u_1k r_width=1u r_length=19.23u
X17 a_1041_13955.t0 a_5019_14475.t0 vss.t2 ppolyf_u_1k r_width=1u r_length=19.23u
X19 a_1041_10835.t0 a_5019_11355.t0 vss.t2 ppolyf_u_1k r_width=1u r_length=19.23u
X24 a_5019_15515.t1 out.t20 cap_mim_2f0fF c_width=11.46u c_length=11.46u
X25 a_1041_13955.t0 a_5019_13435.t0 vss.t2 ppolyf_u_1k r_width=1u r_length=19.23u
X26 a_1041_9275.t2 a_5019_9275.t0 vss.t2 ppolyf_u_1k r_width=1u r_length=19.23u
X30 a_1041_10835.t0 a_5019_10315.t0 vss.t2 ppolyf_u_1k r_width=1u r_length=19.23u
X34 a_1041_12915.t0 a_5019_13435.t0 vss.t2 ppolyf_u_1k r_width=1u r_length=19.23u
X36 a_1041_9795.t0 a_5019_10315.t0 vss.t2 ppolyf_u_1k r_width=1u r_length=19.23u
X40 a_1041_12915.t0 a_5019_12395.t0 vss.t2 ppolyf_u_1k r_width=1u r_length=19.23u
X42 a_1041_14995.t0 a_5019_15515.t0 vss.t2 ppolyf_u_1k r_width=1u r_length=19.23u
Rpar0 a_1041_9275.t0 a_1041_9275.t5 268.7841
Rpar1 a_1041_9275.t0 a_1041_9275.t2 335.8604
Rpar2 a_1041_9275.t0 a_1041_9275.t3 145.4895
Rpar3 a_1041_9275.t5 a_1041_9275.t2 53.8060
Rpar4 a_1041_9275.t5 a_1041_9275.t3 327.8354
Rpar5 a_1041_9275.t2 a_1041_9275.t3 409.6482
Rpar6 a_4086_4349.t0 a_4086_4349.t4 44.7600
Rpar7 a_5019_15515.t0 a_5019_15515.t1 56.1928
Rpar8 a_6190_1041.t0 a_6190_1041.t2 158.1740
Rpar9 a_6190_1041.t0 a_6190_1041.t3 151.5289
Rpar10 a_6190_1041.t2 a_6190_1041.t3 15.2365
Rpar11 ib ib.t0 16.4427
Rpar12 ib ib.t1 15.2951
Rpar13 ib.t0 ib.t1 34.2074
Rpar14 inn inn.t0 3.2588
Rpar15 inp inp.t0 3.3074
Rpar16 out out.t0 90.5993
Rpar17 out out.t10 106.0263
Rpar18 out out.t20 19.6837
Rpar19 out.t0 out.t10 70.4430
Rpar20 out.t0 out.t20 1431.7787
Rpar21 out.t10 out.t20 1675.5780
Rpar22 vdd vdd.t0 120.8612
Rpar23 vdd vdd.t1 69.5738
Rpar24 vdd.t0 vdd.t1 7.8660
Rpar25 vss vss.t0 361.1583
Rpar26 vss vss.t6 1490.7580
Rpar27 vss vss.t5 101.9189
Rpar28 vss vss.t2 359.2951
Rpar29 vss.t0 vss.t6 67.3249
Rpar30 vss.t0 vss.t5 3.0033
Rpar31 vss.t0 vss.t2 16.3330
Rpar32 vss.t6 vss.t5 18.5873
Rpar33 vss.t6 vss.t2 67.4556
Rpar34 vss.t5 vss.t2 4.3121
Cpar0 a_1041_10835.t0 vss 3.68600e-17
Cpar1 a_1041_11875.t0 vss 3.68600e-17
Cpar2 a_1041_12915.t0 vss 3.68600e-17
Cpar3 a_1041_13955.t0 vss 3.75800e-17
Cpar4 a_1041_14995.t0 vss 3.83200e-17
Cpar5 a_1041_9275.t0 vss 4.75775e-15
Cpar6 a_1041_9275.t2 vss 4.49822e-15
Cpar7 a_1041_9275.t3 vss 6.81342e-15
Cpar8 a_1041_9275.t5 vss 1.57544e-14
Cpar9 a_1041_9795.t0 vss 3.98200e-17
Cpar10 a_4086_4349.t0 vss 6.41882e-15
Cpar11 a_4086_4349.t4 vss 1.58799e-14
Cpar12 a_5019_10315.t0 vss 3.99200e-17
Cpar13 a_5019_11355.t0 vss 3.85200e-17
Cpar14 a_5019_12395.t0 vss 4.14800e-17
Cpar15 a_5019_13435.t0 vss 4.14800e-17
Cpar16 a_5019_14475.t0 vss 4.30600e-17
Cpar17 a_5019_15515.t0 vss 1.64530e-16
Cpar18 a_5019_15515.t1 vss 2.63809e-15
Cpar19 a_5019_9275.t0 vss 3.72000e-17
Cpar20 a_6190_1041.t0 vss 4.74517e-15
Cpar21 a_6190_1041.t2 vss 1.01443e-14
Cpar22 a_6190_1041.t3 vss 4.68892e-15
Cpar23 ib inn 1.05600e-17
Cpar24 ib inp 1.36500e-17
Cpar25 ib out 2.25366e-15
Cpar26 ib vdd 1.58590e-16
Cpar27 ib vss 5.72224e-14
Cpar28 ib.t0 vss 9.46329e-15
Cpar29 ib.t1 vss 7.22019e-16
Cpar30 inn inp 5.23500e-17
Cpar31 inn vss 4.40254e-15
Cpar32 inn.t0 vss 3.62561e-16
Cpar33 inp vss 4.51124e-15
Cpar34 inp.t0 vss 3.59720e-16
Cpar35 out vdd 1.62916e-14
Cpar36 out vss 2.23959e-14
Cpar37 out.t0 vss 7.09420e-15
Cpar38 out.t10 vss 1.21690e-14
Cpar39 out.t20 vss 7.92802e-15
Cpar40 vdd vss 8.08355e-14
Cpar41 vdd.t0 vss 3.67090e-14
Cpar42 vdd.t1 vss 1.00369e-14
.ends opamp_dut

Vdd vdd 0 3.300000
Vss vss 0 0
Ibias vdd ib 3.710000e-08
Vinp inp 0 DC 1.645000 AC 1 PWL(0 1.645000 2.536055e-07 1.645000 2.789660e-07 1.655000)
Rfb out inn 1m
Cload out 0 2.000000e-13
Xdut vdd vss inp inn out ib opamp_dut
.end
