* opa1000[0450]: 200f/nmos_miller_3v3_i10u_weak (nmos_miller, VDD=3.3V, CL=0.2pF, Iref=1.8571uA)
.include "pdk_opa.inc"
.temp 27
.option gmin=1e-12 rshunt=1e12 reltol=1e-3 abstol=1e-12 vntol=1e-5 method=gear
* Post-PEX R+C extracted netlist for nmos_miller_3v3_i10u_weak
.subckt opamp_dut vdd vss inp inn out ib
XMpar0 out.t0 a_885_6909.t7 vdd.t1 vdd.t0 pfet_03v3 w=3.2u l=0.75u ad=8.9600e-13 pd=3.7600e-06 as=1.1008e-12 ps=4.5280e-06 nf=1 m=10 par=10
XMpar1 a_4706_5192.t8 ib.t0 vss.t10 vss.t0 nfet_03v3 w=1.2u l=1.5u ad=7.2000e-13 pd=3.6000e-06 as=3.3600e-13 ps=1.7600e-06 nf=1 m=4 par=4
XMpar2 out.t8 ib.t0 vss.t10 vss.t0 nfet_03v3 w=1.2u l=1.5u ad=5.6640e-13 pd=2.8640e-06 as=4.8960e-13 ps=2.4960e-06 nf=1 m=10 par=10
XMpar3 a_4706_5192.t0 inp.t0 a_885_6909.t0 vss.t0 nfet_03v3 w=1.28u l=0.78u ad=5.6320e-13 pd=2.8000e-06 as=3.5840e-13 ps=1.8400e-06 nf=1 m=4 par=4
XMpar4 a_4706_5192.t0 inn.t0 a_5672_8200.t0 vss.t0 nfet_03v3 w=1.28u l=0.78u ad=5.6320e-13 pd=2.8000e-06 as=3.5840e-13 ps=1.8400e-06 nf=1 m=4 par=4
XMpar5 ib.t1 ib.t0 vss.t10 vss.t0 nfet_03v3 w=1.2u l=1.5u ad=7.2000e-13 pd=3.6000e-06 as=3.3600e-13 ps=1.7600e-06 nf=1 m=2 par=2
XMpar6 a_885_6909.t5 a_5672_8200.t4 vdd.t1 vdd.t0 pfet_03v3 w=3.2u l=0.75u ad=1.9200e-12 pd=7.6000e-06 as=8.9600e-13 ps=3.7600e-06 nf=1 m=2 par=2
XMpar7 a_5672_8200.t5 a_5672_8200.t4 vdd.t1 vdd.t0 pfet_03v3 w=3.2u l=0.75u ad=8.9600e-13 pd=3.7600e-06 as=8.9600e-13 ps=3.7600e-06 nf=1 m=2 par=2
X18 a_3903_6909.t1 out.t20 cap_mim_2f0fF c_width=11.46u c_length=11.46u
X34 a_885_6909.t4 a_3903_6909.t0 vss.t8 ppolyf_u_1k r_width=1u r_length=14.43u
Rpar0 a_3903_6909.t0 a_3903_6909.t1 59.8418
Rpar1 a_4706_5192.t0 a_4706_5192.t8 48.0633
Rpar2 a_5672_8200.t0 a_5672_8200.t4 174.6067
Rpar3 a_5672_8200.t0 a_5672_8200.t5 58.1056
Rpar4 a_5672_8200.t4 a_5672_8200.t5 29.8625
Rpar5 a_885_6909.t0 a_885_6909.t7 80.5559
Rpar6 a_885_6909.t0 a_885_6909.t4 634.7560
Rpar7 a_885_6909.t0 a_885_6909.t5 373.0930
Rpar8 a_885_6909.t7 a_885_6909.t4 169.0395
Rpar9 a_885_6909.t7 a_885_6909.t5 99.3570
Rpar10 a_885_6909.t4 a_885_6909.t5 65.2778
Rpar11 ib ib.t0 13.0618
Rpar12 ib ib.t1 11.6166
Rpar13 ib.t0 ib.t1 31.3846
Rpar14 inn inn.t0 6.3742
Rpar15 inp inp.t0 6.4228
Rpar16 out out.t0 554.1724
Rpar17 out out.t8 3.6850
Rpar18 out out.t20 476.0918
Rpar19 out.t0 out.t8 107.7536
Rpar20 out.t0 out.t20 324.0642
Rpar21 out.t8 out.t20 92.5716
Rpar22 vdd vdd.t0 43.4834
Rpar23 vdd vdd.t1 58.0286
Rpar24 vdd.t0 vdd.t1 3.5446
Rpar25 vss vss.t0 91.7398
Rpar26 vss vss.t10 35.2259
Rpar27 vss vss.t8 147.2811
Rpar28 vss.t0 vss.t10 12.1030
Rpar29 vss.t0 vss.t8 40.9280
Rpar30 vss.t10 vss.t8 183.9376
Cpar0 a_3903_6909.t0 vss 1.33410e-16
Cpar1 a_3903_6909.t1 vss 2.16237e-15
Cpar2 a_4706_5192.t0 vss 4.81537e-15
Cpar3 a_4706_5192.t8 vss 9.02272e-15
Cpar4 a_5672_8200.t0 vss 2.53982e-15
Cpar5 a_5672_8200.t4 vss 3.98151e-15
Cpar6 a_5672_8200.t5 vss 3.67394e-15
Cpar7 a_885_6909.t0 vss 2.81789e-15
Cpar8 a_885_6909.t4 vss 2.45376e-15
Cpar9 a_885_6909.t5 vss 4.03738e-15
Cpar10 a_885_6909.t7 vss 8.35619e-15
Cpar11 ib out 2.57421e-15
Cpar12 ib vss 2.59872e-14
Cpar13 ib.t0 vss 5.20577e-15
Cpar14 ib.t1 vss 6.02808e-16
Cpar15 inn inp 5.15300e-17
Cpar16 inn out 4.75200e-17
Cpar17 inn vss 2.87635e-15
Cpar18 inn.t0 vss 3.85339e-16
Cpar19 inp out 3.07500e-17
Cpar20 inp vss 2.88435e-15
Cpar21 inp.t0 vss 3.88235e-16
Cpar22 out vdd 8.78575e-15
Cpar23 out vss 1.99712e-14
Cpar24 out.t0 vss 6.50090e-15
Cpar25 out.t20 vss 7.61934e-15
Cpar26 out.t8 vss 5.27715e-15
Cpar27 vdd vss 4.46749e-14
Cpar28 vdd.t0 vss 1.15379e-14
Cpar29 vdd.t1 vss 7.76048e-15
.ends opamp_dut

Vdd vdd 0 3.300000
Vss vss 0 0
Ibias vdd ib 1.857100e-06
Vinp inp 0 DC 1.645000 AC 1 PWL(0 1.645000 5.137756e-09 1.645000 5.651531e-09 1.655000)
Rfb out inn 1m
Cload out 0 2.000000e-13
Xdut vdd vss inp inn out ib opamp_dut
.end
