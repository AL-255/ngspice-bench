* opa1000[0318]: 2p/folded_cascode_pmos_3v3_i1u_subth (folded_cascode_pmos, VDD=3.3V, CL=2.0pF, Iref=0.2889uA)
.include "pdk_opa.inc"
.temp 27
.option gmin=1e-12 rshunt=1e12 reltol=1e-3 abstol=1e-12 vntol=1e-5 method=gear
* Post-PEX R+C extracted netlist for folded_cascode_pmos_3v3_i1u_subth
.subckt opamp_dut vdd vss inp inn out ib
XMpar0 a_1406_8608.t4 inp.t0 a_2306_8608.t2 vdd.t6 pfet_03v3 w=8u l=3.9u ad=2.5600e-12 pd=9.6400e-06 as=2.4000e-12 ps=9.1000e-06 nf=1 m=64 par=64
XMpar1 a_11534_4488.t2 inn.t0 a_1406_8608.t4 vdd.t6 pfet_03v3 w=8u l=3.9u ad=2.4000e-12 pd=9.1000e-06 as=2.5600e-12 ps=9.6400e-06 nf=1 m=64 par=64
XMpar2 a_1406_8608.t0 a_1100_5964.t0 vdd.t1 vdd.t0 pfet_03v3 w=4.73u l=4.5u ad=1.3244e-12 pd=5.2900e-06 as=2.0812e-12 ps=7.9750e-06 nf=1 m=4 par=4
XMpar3 out.t1 a_9492_6071.t2 vdd.t1 vdd.t0 pfet_03v3 w=4.73u l=4.5u ad=1.3244e-12 pd=5.2900e-06 as=1.3244e-12 ps=5.2900e-06 nf=1 m=2 par=2
XMpar4 a_2306_8608.t66 ib vss.t5 vss.t4 nfet_03v3 w=1.15u l=2.8u ad=3.2200e-13 pd=1.7100e-06 as=5.0600e-13 ps=2.6050e-06 nf=1 m=4 par=4
XMpar5 a_1100_5964.t4 ib vss.t5 vss.t4 nfet_03v3 w=1.15u l=2.8u ad=3.2200e-13 pd=1.7100e-06 as=3.2200e-13 ps=1.7100e-06 nf=1 m=2 par=2
XMpar6 a_1100_5964.t1 a_1100_5964.t0 vdd.t1 vdd.t0 pfet_03v3 w=4.73u l=4.5u ad=1.3244e-12 pd=5.2900e-06 as=1.3244e-12 ps=5.2900e-06 nf=1 m=2 par=2
XMpar7 ib.t1 ib vss.t5 vss.t4 nfet_03v3 w=1.15u l=2.8u ad=6.9000e-13 pd=3.5000e-06 as=3.2200e-13 ps=1.7100e-06 nf=1 m=2 par=2
XMpar8 a_9492_6071.t3 a_9492_6071.t2 vdd.t1 vdd.t0 pfet_03v3 w=4.73u l=4.5u ad=2.8380e-12 pd=1.0660e-05 as=1.3244e-12 ps=5.2900e-06 nf=1 m=2 par=2
XMpar9 a_11534_4488.t66 ib vss.t5 vss.t4 nfet_03v3 w=1.15u l=2.8u ad=3.2200e-13 pd=1.7100e-06 as=5.0600e-13 ps=2.6050e-06 nf=1 m=4 par=4
XMpar10 a_11534_4488.t0 a_1100_5964.t6 out.t0 vss.t1 nfet_03v3 w=1.26u l=1.02u ad=7.5600e-13 pd=3.7200e-06 as=3.5280e-13 ps=1.8200e-06 nf=1 m=2 par=2
XMpar11 a_2306_8608.t0 a_1100_5964.t6 a_9492_6071.t0 vss.t1 nfet_03v3 w=1.26u l=1.02u ad=7.5600e-13 pd=3.7200e-06 as=3.5280e-13 ps=1.8200e-06 nf=1 m=2 par=2
X40 out.t4 vss.t0 cap_mim_2f0fF c_width=16.58u c_length=16.59u
Rpar0 a_1100_5964.t0 a_1100_5964.t1 23.7135
Rpar1 a_1100_5964.t0 a_1100_5964.t4 313.1358
Rpar2 a_1100_5964.t0 a_1100_5964.t6 449.6199
Rpar3 a_1100_5964.t1 a_1100_5964.t4 126.3640
Rpar4 a_1100_5964.t1 a_1100_5964.t6 181.4413
Rpar5 a_1100_5964.t4 a_1100_5964.t6 85.2096
Rpar6 a_11534_4488.t0 a_11534_4488.t2 118.3817
Rpar7 a_11534_4488.t0 a_11534_4488.t66 55.0466
Rpar8 a_11534_4488.t2 a_11534_4488.t66 109.0290
Rpar9 a_1406_8608.t0 a_1406_8608.t4 34.8554
Rpar10 a_2306_8608.t0 a_2306_8608.t2 306.5137
Rpar11 a_2306_8608.t0 a_2306_8608.t66 61.3600
Rpar12 a_2306_8608.t2 a_2306_8608.t66 136.4781
Rpar13 a_9492_6071.t0 a_9492_6071.t2 244.4809
Rpar14 a_9492_6071.t0 a_9492_6071.t3 72.1524
Rpar15 a_9492_6071.t2 a_9492_6071.t3 17.8712
Rpar16 ib ib.t1 16.4727
Rpar17 inn inn.t0 1.5794
Rpar18 inp inp.t0 1.5794
Rpar19 out out.t0 120.3251
Rpar20 out out.t1 8.3867
Rpar21 out out.t4 126.5134
Rpar22 out.t0 out.t1 399.1426
Rpar23 out.t0 out.t4 176.2512
Rpar24 out.t1 out.t4 419.6705
Rpar25 vdd vdd.t0 263.1063
Rpar26 vdd vdd.t1 467.7431
Rpar27 vdd vdd.t6 20.1966
Rpar28 vdd.t0 vdd.t1 4.0435
Rpar29 vdd.t0 vdd.t6 269.6551
Rpar30 vdd.t1 vdd.t6 479.3853
Rpar31 vss vss.t0 53.5189
Rpar32 vss vss.t1 136.4092
Rpar33 vss vss.t4 65.4801
Rpar34 vss vss.t5 97.7327
Rpar35 vss.t0 vss.t1 705.1674
Rpar36 vss.t0 vss.t4 338.4995
Rpar37 vss.t0 vss.t5 505.2290
Rpar38 vss.t1 vss.t4 2.8101
Rpar39 vss.t1 vss.t5 23.5086
Rpar40 vss.t4 vss.t5 4.6233
Cpar0 a_1100_5964.t0 vss 2.09575e-14
Cpar1 a_1100_5964.t1 vss 3.45388e-15
Cpar2 a_1100_5964.t4 vss 2.18340e-15
Cpar3 a_1100_5964.t6 vss 3.01890e-15
Cpar4 a_11534_4488.t0 vss 3.91082e-15
Cpar5 a_11534_4488.t2 vss 1.17403e-13
Cpar6 a_11534_4488.t66 vss 4.76742e-15
Cpar7 a_1406_8608.t0 vss 7.18579e-15
Cpar8 a_1406_8608.t4 vss 2.08310e-13
Cpar9 a_2306_8608.t0 vss 3.66461e-15
Cpar10 a_2306_8608.t2 vss 1.16797e-13
Cpar11 a_2306_8608.t66 vss 6.89350e-15
Cpar12 a_9492_6071.t0 vss 1.18048e-15
Cpar13 a_9492_6071.t2 vss 1.52372e-14
Cpar14 a_9492_6071.t3 vss 4.83948e-15
Cpar15 ib vss 2.81600e-14
Cpar16 ib.t1 vss 3.52793e-16
Cpar17 inn inp 2.29020e-16
Cpar18 inn vdd 8.95349e-14
Cpar19 inn vss 1.23709e-14
Cpar20 inn.t0 vss 1.78561e-13
Cpar21 inp out 1.21100e-17
Cpar22 inp vdd 8.90793e-14
Cpar23 inp vss 1.22178e-14
Cpar24 inp.t0 vss 1.78222e-13
Cpar25 out vdd 4.35655e-15
Cpar26 out vss 1.08233e-14
Cpar27 out.t0 vss 3.17116e-16
Cpar28 out.t1 vss 2.59424e-16
Cpar29 out.t4 vss 1.11635e-14
Cpar30 vdd vss 1.05159e-12
Cpar31 vdd.t0 vss 1.70863e-14
Cpar32 vdd.t1 vss 1.07408e-14
Cpar33 vdd.t6 vss 2.45545e-13
.ends opamp_dut

Vdd vdd 0 3.300000
Vss vss 0 0
Ibias vdd ib 2.889000e-07
Vinp inp 0 DC 1.381000 AC 1 PWL(0 1.381000 2.301847e-07 1.381000 2.532032e-07 1.391000)
Rfb out inn 1m
Cload out 0 2.000000e-12
Xdut vdd vss inp inn out ib opamp_dut
.end
