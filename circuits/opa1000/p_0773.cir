* opa1000[0773]: 200f/symmetrical_ota_3v3_i50n_weak (symmetrical_ota, VDD=3.3V, CL=0.2pF, Iref=0.0108uA)
.include "pdk_opa.inc"
.temp 27
.option gmin=1e-12 rshunt=1e12 reltol=1e-3 abstol=1e-12 vntol=1e-5 method=gear
* Post-PEX R+C extracted netlist for symmetrical_ota_3v3_i50n_weak
.subckt opamp_dut vdd vss inp inn out ib
XMpar0 out.t0 a_2148_7042.t0 vss.t1 vss.t0 nfet_03v3 w=0.4u l=3.9u ad=1.1200e-13 pd=9.6000e-07 as=1.7600e-13 ps=1.4800e-06 nf=1 m=4 par=4
XMpar1 a_1701_2616.t0 ib.t0 vss.t3 vss.t2 nfet_03v3 w=0.4u l=3u ad=1.1200e-13 pd=9.6000e-07 as=1.7600e-13 ps=1.4800e-06 nf=1 m=4 par=4
XMpar2 a_6490_4023.t3 a_6490_4023.t2 vdd.t1 vdd.t0 pfet_03v3 w=0.4u l=3.9u ad=2.4000e-13 pd=2.0000e-06 as=1.1200e-13 ps=9.6000e-07 nf=1 m=2 par=2
XMpar3 a_1701_2616.t4 inp.t0 a_1710_4023.t0 vss.t16 nfet_03v3 w=0.4u l=6.5u ad=2.4000e-13 pd=2.0000e-06 as=1.1200e-13 ps=9.6000e-07 nf=1 m=2 par=2
XMpar4 a_1701_2616.t4 inn.t0 a_6490_4023.t0 vss.t16 nfet_03v3 w=0.4u l=6.5u ad=2.4000e-13 pd=2.0000e-06 as=1.1200e-13 ps=9.6000e-07 nf=1 m=2 par=2
XMpar5 a_2148_7042.t8 a_6490_4023.t2 vdd.t1 vdd.t0 pfet_03v3 w=0.4u l=3.9u ad=2.4000e-13 pd=2.0000e-06 as=1.7600e-13 ps=1.4800e-06 nf=1 m=4 par=4
XMpar6 ib.t1 ib.t0 vss.t3 vss.t2 nfet_03v3 w=0.4u l=3u ad=1.1200e-13 pd=9.6000e-07 as=1.1200e-13 ps=9.6000e-07 nf=1 m=2 par=2
XMpar7 a_1710_4023.t3 a_1710_4023.t2 vdd.t1 vdd.t0 pfet_03v3 w=0.4u l=3.9u ad=2.4000e-13 pd=2.0000e-06 as=1.1200e-13 ps=9.6000e-07 nf=1 m=2 par=2
XMpar8 out.t1 a_1710_4023.t2 vdd.t1 vdd.t0 pfet_03v3 w=0.4u l=3.9u ad=2.4000e-13 pd=2.0000e-06 as=1.7600e-13 ps=1.4800e-06 nf=1 m=4 par=4
XMpar9 a_2148_7042.t1 a_2148_7042.t0 vss.t1 vss.t0 nfet_03v3 w=0.4u l=3.9u ad=1.1200e-13 pd=9.6000e-07 as=1.1200e-13 ps=9.6000e-07 nf=1 m=4 par=4
Rpar0 a_1701_2616.t0 a_1701_2616.t4 53.7826
Rpar1 a_1710_4023.t0 a_1710_4023.t2 107.7013
Rpar2 a_1710_4023.t0 a_1710_4023.t3 152.7120
Rpar3 a_1710_4023.t2 a_1710_4023.t3 15.3623
Rpar4 a_2148_7042.t0 a_2148_7042.t1 22.2613
Rpar5 a_2148_7042.t0 a_2148_7042.t8 205.1339
Rpar6 a_2148_7042.t1 a_2148_7042.t8 91.2467
Rpar7 a_6490_4023.t0 a_6490_4023.t2 107.7010
Rpar8 a_6490_4023.t0 a_6490_4023.t3 152.7126
Rpar9 a_6490_4023.t2 a_6490_4023.t3 15.3623
Rpar10 ib ib.t0 17.2395
Rpar11 ib ib.t1 17.5055
Rpar12 ib.t0 ib.t1 117.3571
Rpar13 inn inn.t0 3.2172
Rpar14 inp inp.t0 3.2658
Rpar15 out out.t0 134.7218
Rpar16 out out.t1 6.2900
Rpar17 out.t0 out.t1 118.7754
Rpar18 vdd vdd.t0 203.9675
Rpar19 vdd vdd.t1 75.3042
Rpar20 vdd.t0 vdd.t1 7.5602
Rpar21 vss vss.t0 367.9667
Rpar22 vss vss.t1 430.5924
Rpar23 vss vss.t2 48.2455
Rpar24 vss vss.t3 187.8786
Rpar25 vss vss.t16 140.3334
Rpar26 vss.t0 vss.t1 10.1346
Rpar27 vss.t0 vss.t2 108.1579
Rpar28 vss.t0 vss.t3 388.4593
Rpar29 vss.t0 vss.t16 327.8573
Rpar30 vss.t1 vss.t2 126.6471
Rpar31 vss.t1 vss.t3 454.8866
Rpar32 vss.t1 vss.t16 383.8927
Rpar33 vss.t2 vss.t3 9.3728
Rpar34 vss.t2 vss.t16 8.2115
Rpar35 vss.t3 vss.t16 31.9387
Cpar0 a_1701_2616.t0 vss 3.57862e-15
Cpar1 a_1701_2616.t4 vss 4.52860e-15
Cpar2 a_1710_4023.t0 vss 4.36770e-15
Cpar3 a_1710_4023.t2 vss 1.80031e-14
Cpar4 a_1710_4023.t3 vss 5.06698e-15
Cpar5 a_2148_7042.t0 vss 9.02068e-15
Cpar6 a_2148_7042.t1 vss 2.42881e-15
Cpar7 a_2148_7042.t8 vss 4.26859e-15
Cpar8 a_6490_4023.t0 vss 4.12693e-15
Cpar9 a_6490_4023.t2 vss 1.70108e-14
Cpar10 a_6490_4023.t3 vss 4.78765e-15
Cpar11 ib inp 1.56700e-17
Cpar12 ib vdd 1.54900e-17
Cpar13 ib vss 1.40724e-14
Cpar14 ib.t0 vss 1.97625e-15
Cpar15 ib.t1 vss 8.92285e-17
Cpar16 inn inp 5.16000e-17
Cpar17 inn vss 6.88539e-15
Cpar18 inn.t0 vss 4.50380e-16
Cpar19 inp vss 6.75853e-15
Cpar20 inp.t0 vss 4.72282e-16
Cpar21 out vdd 6.62181e-15
Cpar22 out vss 1.17014e-14
Cpar23 out.t0 vss 6.69321e-15
Cpar24 out.t1 vss 4.18662e-15
Cpar25 vdd vss 8.42416e-14
Cpar26 vdd.t0 vss 3.51656e-14
Cpar27 vdd.t1 vss 8.25185e-15
.ends opamp_dut

Vdd vdd 0 3.300000
Vss vss 0 0
Ibias vdd ib 1.080000e-08
Vinp inp 0 DC 1.645000 AC 1 PWL(0 1.645000 3.346826e-07 1.645000 3.681508e-07 1.655000)
Rfb out inn 1m
Cload out 0 2.000000e-13
Xdut vdd vss inp inn out ib opamp_dut
.end
