* opa1000[0691]: 200f/rail_to_rail_3v3_i200n_subth (rail_to_rail, VDD=3.3V, CL=0.2pF, Iref=0.0325uA)
.include "pdk_opa.inc"
.temp 27
.option gmin=1e-12 rshunt=1e12 reltol=1e-3 abstol=1e-12 vntol=1e-5 method=gear
* Post-PEX R+C extracted netlist for rail_to_rail_3v3_i200n_subth
.subckt opamp_dut vdd vss inp inn out ib
XMpar0 out.t0 a_9800_6430.t7 vdd.t5 vdd.t4 pfet_03v3 w=2.34u l=4u ad=6.5520e-13 pd=2.9000e-06 as=1.0296e-12 ps=4.3900e-06 nf=1 m=8 par=8
XMpar1 a_1513_8866.t4 ib.t0 vss.t18 vss.t17 nfet_03v3 w=0.4u l=6.25u ad=2.4000e-13 pd=2.0000e-06 as=1.1200e-13 ps=9.6000e-07 nf=1 m=2 par=2
XMpar2 out.t9 ib.t0 vss.t18 vss.t17 nfet_03v3 w=0.4u l=6.25u ad=1.1200e-13 pd=9.6000e-07 as=2.0800e-13 ps=1.7400e-06 nf=1 m=8 par=8
XMpar3 ib.t1 ib.t0 vss.t18 vss.t17 nfet_03v3 w=0.4u l=6.25u ad=2.4000e-13 pd=2.0000e-06 as=1.1200e-13 ps=9.6000e-07 nf=1 m=2 par=2
XMpar4 a_11572_14866.t2 a_9800_13413.t0 vss.t3 vss.t2 nfet_03v3 w=0.4u l=8.13u ad=1.1200e-13 pd=9.6000e-07 as=1.1200e-13 ps=9.6000e-07 nf=1 m=2 par=2
XMpar5 a_6384_1294.t0 inp.t0 a_9800_6430.t3 vss.t1 nfet_03v3 w=0.46u l=3.84u ad=2.7600e-13 pd=2.1200e-06 as=2.7600e-13 ps=2.1200e-06 nf=1 m=2 par=2
XMpar6 a_9800_6430.t0 a_9920_6222.t0 vss.t3 vss.t2 nfet_03v3 w=0.4u l=8.13u ad=2.4000e-13 pd=2.0000e-06 as=1.1200e-13 ps=9.6000e-07 nf=1 m=2 par=2
XMpar7 a_9800_13413.t1 a_9800_13413.t0 vss.t3 vss.t2 nfet_03v3 w=0.4u l=8.13u ad=2.4000e-13 pd=2.0000e-06 as=1.1200e-13 ps=9.6000e-07 nf=1 m=2 par=2
XMpar8 a_6384_1294.t4 ib.t0 vss.t18 vss.t17 nfet_03v3 w=0.4u l=6.25u ad=2.4000e-13 pd=2.0000e-06 as=1.1200e-13 ps=9.6000e-07 nf=1 m=2 par=2
XMpar9 a_9800_6430.t2 a_11572_14866.t4 vdd.t5 vdd.t4 pfet_03v3 w=2.34u l=4u ad=1.4040e-12 pd=5.8800e-06 as=6.5520e-13 ps=2.9000e-06 nf=1 m=2 par=2
XMpar10 a_1393_9074.t0 inp.t2 a_9800_13413.t4 vdd.t10 pfet_03v3 w=2.37u l=3.84u ad=1.4220e-12 pd=5.9400e-06 as=6.6360e-13 ps=2.9300e-06 nf=1 m=2 par=2
XMpar11 a_1393_9074.t0 inn.t2 a_9920_6222.t4 vdd.t10 pfet_03v3 w=2.37u l=3.84u ad=1.4220e-12 pd=5.9400e-06 as=6.6360e-13 ps=2.9300e-06 nf=1 m=2 par=2
XMpar12 a_1393_9074.t4 a_1513_8866.t0 vdd.t1 vdd.t0 pfet_03v3 w=1.31u l=6.25u ad=7.8600e-13 pd=3.8200e-06 as=3.6680e-13 ps=1.8700e-06 nf=1 m=2 par=2
XMpar13 a_9920_6222.t1 a_9920_6222.t0 vss.t3 vss.t2 nfet_03v3 w=0.4u l=8.13u ad=1.1200e-13 pd=9.6000e-07 as=1.1200e-13 ps=9.6000e-07 nf=1 m=2 par=2
XMpar14 a_11572_14866.t5 a_11572_14866.t4 vdd.t5 vdd.t4 pfet_03v3 w=2.34u l=4u ad=6.5520e-13 pd=2.9000e-06 as=6.5520e-13 ps=2.9000e-06 nf=1 m=2 par=2
XMpar15 a_11572_14866.t0 inn.t0 a_6384_1294.t0 vss.t1 nfet_03v3 w=0.46u l=3.84u ad=2.7600e-13 pd=2.1200e-06 as=2.7600e-13 ps=2.1200e-06 nf=1 m=2 par=2
XMpar16 a_1513_8866.t1 a_1513_8866.t0 vdd.t1 vdd.t0 pfet_03v3 w=1.31u l=6.25u ad=3.6680e-13 pd=1.8700e-06 as=3.6680e-13 ps=1.8700e-06 nf=1 m=2 par=2
X4 a_19359_5970.t0 a_23337_5450.t0 vss.t0 ppolyf_u_1k r_width=1u r_length=19.23u
X7 a_19359_2850.t0 a_23337_2330.t0 vss.t0 ppolyf_u_1k r_width=1u r_length=19.23u
X10 a_19359_4930.t0 a_23337_5450.t0 vss.t0 ppolyf_u_1k r_width=1u r_length=19.23u
X14 a_19359_1810.t0 a_23337_2330.t0 vss.t0 ppolyf_u_1k r_width=1u r_length=19.23u
X20 a_19359_4930.t0 a_23337_4410.t0 vss.t0 ppolyf_u_1k r_width=1u r_length=19.23u
X24 a_19359_1810.t0 a_23337_1290.t0 vss.t0 ppolyf_u_1k r_width=1u r_length=19.23u
X28 a_19359_7010.t0 a_23337_7530.t0 vss.t0 ppolyf_u_1k r_width=1u r_length=19.23u
X31 a_19359_3890.t0 a_23337_4410.t0 vss.t0 ppolyf_u_1k r_width=1u r_length=19.23u
X41 a_19359_7010.t0 a_23337_6490.t0 vss.t0 ppolyf_u_1k r_width=1u r_length=19.23u
X42 a_23337_7530.t1 out.t7 cap_mim_2f0fF c_width=17.43u c_length=17.43u
X49 a_9800_6430.t6 a_23337_1290.t0 vss.t0 ppolyf_u_1k r_width=1u r_length=19.23u
X55 a_19359_3890.t0 a_23337_3370.t0 vss.t0 ppolyf_u_1k r_width=1u r_length=19.23u
X58 a_19359_5970.t0 a_23337_6490.t0 vss.t0 ppolyf_u_1k r_width=1u r_length=19.23u
X59 a_19359_2850.t0 a_23337_3370.t0 vss.t0 ppolyf_u_1k r_width=1u r_length=19.23u
Rpar0 a_11572_14866.t0 a_11572_14866.t2 110.2730
Rpar1 a_11572_14866.t0 a_11572_14866.t4 352.3026
Rpar2 a_11572_14866.t0 a_11572_14866.t5 180.8475
Rpar3 a_11572_14866.t2 a_11572_14866.t4 210.3036
Rpar4 a_11572_14866.t2 a_11572_14866.t5 107.9551
Rpar5 a_11572_14866.t4 a_11572_14866.t5 24.2660
Rpar6 a_1393_9074.t0 a_1393_9074.t4 52.5695
Rpar7 a_1513_8866.t0 a_1513_8866.t1 28.5988
Rpar8 a_1513_8866.t0 a_1513_8866.t4 116.6421
Rpar9 a_1513_8866.t1 a_1513_8866.t4 135.3876
Rpar10 a_23337_7530.t0 a_23337_7530.t1 60.7071
Rpar11 a_6384_1294.t0 a_6384_1294.t4 97.6624
Rpar12 a_9800_13413.t0 a_9800_13413.t1 22.7848
Rpar13 a_9800_13413.t0 a_9800_13413.t4 120.6085
Rpar14 a_9800_13413.t1 a_9800_13413.t4 94.9988
Rpar15 a_9800_6430.t0 a_9800_6430.t7 105.6712
Rpar16 a_9800_6430.t0 a_9800_6430.t2 440.1249
Rpar17 a_9800_6430.t0 a_9800_6430.t3 232.2685
Rpar18 a_9800_6430.t0 a_9800_6430.t6 154.6355
Rpar19 a_9800_6430.t7 a_9800_6430.t2 424.3208
Rpar20 a_9800_6430.t7 a_9800_6430.t3 223.9281
Rpar21 a_9800_6430.t7 a_9800_6430.t6 200.6045
Rpar22 a_9800_6430.t2 a_9800_6430.t3 98.1592
Rpar23 a_9800_6430.t2 a_9800_6430.t6 835.5256
Rpar24 a_9800_6430.t3 a_9800_6430.t6 440.9345
Rpar25 a_9920_6222.t0 a_9920_6222.t1 31.8083
Rpar26 a_9920_6222.t0 a_9920_6222.t4 150.3483
Rpar27 a_9920_6222.t1 a_9920_6222.t4 134.4321
Rpar28 ib ib.t0 17.1320
Rpar29 ib ib.t1 17.4433
Rpar30 ib.t0 ib.t1 28.8473
Rpar31 inn inn.t0 4.6481
Rpar32 inn inn.t2 42.6008
Rpar33 inp inp.t0 4.6487
Rpar34 inp inp.t2 33.6944
Rpar35 out out.t0 228.6769
Rpar36 out out.t9 9.9717
Rpar37 out out.t7 220.7937
Rpar38 out.t0 out.t9 140.6995
Rpar39 out.t0 out.t7 202.8549
Rpar40 out.t9 out.t7 135.8491
Rpar41 vdd vdd.t0 457.2095
Rpar42 vdd vdd.t1 735.8748
Rpar43 vdd vdd.t10 99.2991
Rpar44 vdd vdd.t5 72.5395
Rpar45 vdd vdd.t4 47.8365
Rpar46 vdd.t0 vdd.t1 14.1540
Rpar47 vdd.t0 vdd.t10 134.2400
Rpar48 vdd.t0 vdd.t5 447.6825
Rpar49 vdd.t0 vdd.t4 748.9228
Rpar50 vdd.t1 vdd.t10 216.0581
Rpar51 vdd.t1 vdd.t5 720.5412
Rpar52 vdd.t1 vdd.t4 1205.3848
Rpar53 vdd.t10 vdd.t5 73.0596
Rpar54 vdd.t10 vdd.t4 148.9675
Rpar55 vdd.t5 vdd.t4 5.8601
Rpar56 vss vss.t0 2285.3766
Rpar57 vss vss.t1 832.1593
Rpar58 vss vss.t2 223.3671
Rpar59 vss vss.t3 1016.2695
Rpar60 vss vss.t17 196.2242
Rpar61 vss vss.t18 49.1162
Rpar62 vss.t0 vss.t1 331.3331
Rpar63 vss.t0 vss.t2 90.2680
Rpar64 vss.t0 vss.t3 442.0452
Rpar65 vss.t0 vss.t17 98.8833
Rpar66 vss.t0 vss.t18 786.1817
Rpar67 vss.t1 vss.t2 11.7824
Rpar68 vss.t1 vss.t3 89.8588
Rpar69 vss.t1 vss.t17 12.9140
Rpar70 vss.t1 vss.t18 142.5548
Rpar71 vss.t2 vss.t3 9.9034
Rpar72 vss.t2 vss.t17 3.0051
Rpar73 vss.t2 vss.t18 31.9837
Rpar74 vss.t3 vss.t17 22.2171
Rpar75 vss.t3 vss.t18 231.4390
Rpar76 vss.t17 vss.t18 19.4625
Cpar0 a_11572_14866.t0 vss 3.94297e-15
Cpar1 a_11572_14866.t2 vss 4.04373e-15
Cpar2 a_11572_14866.t4 vss 1.22071e-14
Cpar3 a_11572_14866.t5 vss 3.85417e-15
Cpar4 a_1393_9074.t0 vss 7.90350e-15
Cpar5 a_1393_9074.t4 vss 5.73194e-15
Cpar6 a_1513_8866.t0 vss 1.64544e-14
Cpar7 a_1513_8866.t1 vss 3.62805e-15
Cpar8 a_1513_8866.t4 vss 1.22760e-14
Cpar9 a_19359_1810.t0 vss 4.25600e-17
Cpar10 a_19359_2850.t0 vss 3.99000e-17
Cpar11 a_19359_3890.t0 vss 3.99000e-17
Cpar12 a_19359_4930.t0 vss 4.09400e-17
Cpar13 a_19359_5970.t0 vss 3.77600e-17
Cpar14 a_19359_7010.t0 vss 3.32200e-17
Cpar15 a_23337_1290.t0 vss 2.64400e-17
Cpar16 a_23337_2330.t0 vss 3.00800e-17
Cpar17 a_23337_3370.t0 vss 2.93600e-17
Cpar18 a_23337_4410.t0 vss 2.93600e-17
Cpar19 a_23337_5450.t0 vss 2.93600e-17
Cpar20 a_23337_6490.t0 vss 3.20200e-17
Cpar21 a_23337_7530.t0 vss 1.07540e-16
Cpar22 a_23337_7530.t1 vss 3.60993e-15
Cpar23 a_6384_1294.t0 vss 1.18504e-14
Cpar24 a_6384_1294.t4 vss 1.87963e-14
Cpar25 a_9800_13413.t0 vss 5.61927e-15
Cpar26 a_9800_13413.t1 vss 1.43870e-15
Cpar27 a_9800_13413.t4 vss 1.17435e-15
Cpar28 a_9800_6430.t0 vss 5.06444e-15
Cpar29 a_9800_6430.t2 vss 5.84216e-15
Cpar30 a_9800_6430.t3 vss 4.87010e-15
Cpar31 a_9800_6430.t6 vss 3.97576e-15
Cpar32 a_9800_6430.t7 vss 2.19045e-14
Cpar33 a_9920_6222.t0 vss 6.49478e-15
Cpar34 a_9920_6222.t1 vss 1.43834e-15
Cpar35 a_9920_6222.t4 vss 1.67449e-15
Cpar36 ib out 1.87563e-15
Cpar37 ib vss 5.37187e-14
Cpar38 ib.t0 vss 1.69799e-14
Cpar39 ib.t1 vss 1.33749e-15
Cpar40 inn inp 1.56230e-16
Cpar41 inn vdd 4.07028e-15
Cpar42 inn vss 7.09108e-15
Cpar43 inn.t0 vss 1.53311e-15
Cpar44 inn.t2 vss 4.24415e-15
Cpar45 inp vdd 4.79029e-15
Cpar46 inp vss 7.08993e-15
Cpar47 inp.t0 vss 1.67429e-15
Cpar48 inp.t2 vss 4.65949e-15
Cpar49 out vdd 1.08375e-14
Cpar50 out vss 2.61920e-14
Cpar51 out.t0 vss 7.80292e-15
Cpar52 out.t7 vss 1.07504e-14
Cpar53 out.t9 vss 6.28779e-15
Cpar54 vdd vss 1.61307e-13
Cpar55 vdd.t0 vss 1.11293e-14
Cpar56 vdd.t1 vss 6.54168e-15
Cpar57 vdd.t10 vss 1.13203e-14
Cpar58 vdd.t4 vss 2.99286e-14
Cpar59 vdd.t5 vss 1.20404e-14
.ends opamp_dut

Vdd vdd 0 3.300000
Vss vss 0 0
Ibias vdd ib 3.250000e-08
Vinp inp 0 DC 1.645000 AC 1 PWL(0 1.645000 5.314625e-07 1.645000 5.846087e-07 1.655000)
Rfb out inn 1m
Cload out 0 2.000000e-13
Xdut vdd vss inp inn out ib opamp_dut
.end
