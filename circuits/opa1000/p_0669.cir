* opa1000[0669]: 200f/rail_to_rail_1v8_i50n_subth (rail_to_rail, VDD=1.8V, CL=0.2pF, Iref=0.0066uA)
.include "pdk_opa.inc"
.temp 27
.option gmin=1e-12 rshunt=1e12 reltol=1e-3 abstol=1e-12 vntol=1e-5 method=gear
* Post-PEX R+C extracted netlist for rail_to_rail_1v8_i50n_subth
.subckt opamp_dut vdd vss inp inn out ib
XMpar0 out.t0 ib.t0 vss.t18 vss.t17 nfet_03v3 w=0.4u l=5u ad=1.1200e-13 pd=9.6000e-07 as=2.0800e-13 ps=1.7400e-06 nf=1 m=8 par=8
XMpar1 a_7252_8498.t0 a_7040_7045.t4 vss.t2 vss.t1 nfet_03v3 w=0.4u l=4.23u ad=1.1200e-13 pd=9.6000e-07 as=1.1200e-13 ps=9.6000e-07 nf=1 m=2 par=2
XMpar2 out.t1 a_1163_7366.t7 vdd.t5 vdd.t4 pfet_03v3 w=0.47u l=4u ad=1.6920e-13 pd=1.3075e-06 as=2.0680e-13 ps=1.5850e-06 nf=1 m=8 par=8
XMpar3 a_6674_2910.t1 inn.t0 a_7160_1041.t0 vdd.t12 pfet_03v3 w=1.27u l=4.4u ad=7.6200e-13 pd=3.7400e-06 as=3.5560e-13 ps=1.8300e-06 nf=1 m=4 par=4
XMpar4 a_1163_7366.t0 inp.t4 a_6674_5545.t0 vss.t9 nfet_03v3 w=0.4u l=4.4u ad=1.1200e-13 pd=9.6000e-07 as=2.4000e-13 ps=2.0000e-06 nf=1 m=2 par=2
XMpar5 a_7252_8498.t3 a_7252_8498.t2 vdd.t5 vdd.t4 pfet_03v3 w=0.47u l=4u ad=1.3160e-13 pd=1.0300e-06 as=1.3160e-13 ps=1.0300e-06 nf=1 m=2 par=2
XMpar6 a_7160_1041.t5 a_7160_1041.t4 vss.t2 vss.t1 nfet_03v3 w=0.4u l=4.23u ad=1.1200e-13 pd=9.6000e-07 as=1.1200e-13 ps=9.6000e-07 nf=1 m=2 par=2
XMpar7 a_6674_5545.t2 ib.t0 vss.t18 vss.t17 nfet_03v3 w=0.4u l=5u ad=2.4000e-13 pd=2.0000e-06 as=1.1200e-13 ps=9.6000e-07 nf=1 m=2 par=2
XMpar8 a_6674_2910.t1 inp.t0 a_7040_7045.t0 vdd.t12 pfet_03v3 w=1.27u l=4.4u ad=7.6200e-13 pd=3.7400e-06 as=3.5560e-13 ps=1.8300e-06 nf=1 m=4 par=4
XMpar9 ib.t1 ib.t0 vss.t18 vss.t17 nfet_03v3 w=0.4u l=5u ad=2.4000e-13 pd=2.0000e-06 as=1.1200e-13 ps=9.6000e-07 nf=1 m=2 par=2
XMpar10 a_7032_13831.t0 ib.t0 vss.t18 vss.t17 nfet_03v3 w=0.4u l=5u ad=2.4000e-13 pd=2.0000e-06 as=1.1200e-13 ps=9.6000e-07 nf=1 m=2 par=2
XMpar11 a_1163_7366.t3 a_7252_8498.t2 vdd.t5 vdd.t4 pfet_03v3 w=0.47u l=4u ad=2.8200e-13 pd=2.1400e-06 as=1.3160e-13 ps=1.0300e-06 nf=1 m=2 par=2
XMpar12 a_1163_7366.t5 a_7160_1041.t4 vss.t2 vss.t1 nfet_03v3 w=0.4u l=4.23u ad=2.4000e-13 pd=2.0000e-06 as=1.1200e-13 ps=9.6000e-07 nf=1 m=2 par=2
XMpar13 a_7040_7045.t5 a_7040_7045.t4 vss.t2 vss.t1 nfet_03v3 w=0.4u l=4.23u ad=2.4000e-13 pd=2.0000e-06 as=1.1200e-13 ps=9.6000e-07 nf=1 m=2 par=2
XMpar14 a_6674_5545.t0 inn.t4 a_7252_8498.t6 vss.t9 nfet_03v3 w=0.4u l=4.4u ad=2.4000e-13 pd=2.0000e-06 as=1.1200e-13 ps=9.6000e-07 nf=1 m=2 par=2
XMpar15 a_6674_2910.t0 a_7032_13831.t2 vdd.t1 vdd.t0 pfet_03v3 w=0.4u l=5u ad=2.4000e-13 pd=2.0000e-06 as=1.1200e-13 ps=9.6000e-07 nf=1 m=2 par=2
XMpar16 a_7032_13831.t3 a_7032_13831.t2 vdd.t1 vdd.t0 pfet_03v3 w=0.4u l=5u ad=1.1200e-13 pd=9.6000e-07 as=1.1200e-13 ps=9.6000e-07 nf=1 m=2 par=2
X4 a_1163_13086.t0 a_5141_13606.t0 vss.t0 ppolyf_u_1k r_width=1u r_length=19.23u
X16 a_1163_9966.t0 a_5141_10486.t0 vss.t0 ppolyf_u_1k r_width=1u r_length=19.23u
X18 a_1163_7886.t0 a_5141_7366.t0 vss.t0 ppolyf_u_1k r_width=1u r_length=19.23u
X22 a_1163_13086.t0 a_5141_12566.t0 vss.t0 ppolyf_u_1k r_width=1u r_length=19.23u
X27 a_1163_7366.t2 a_5141_7366.t0 vss.t0 ppolyf_u_1k r_width=1u r_length=19.23u
X29 a_1163_12046.t0 a_5141_12566.t0 vss.t0 ppolyf_u_1k r_width=1u r_length=19.23u
X30 a_1163_9966.t0 a_5141_9446.t0 vss.t0 ppolyf_u_1k r_width=1u r_length=19.23u
X38 a_1163_12046.t0 a_5141_11526.t0 vss.t0 ppolyf_u_1k r_width=1u r_length=19.23u
X39 a_1163_8926.t0 a_5141_9446.t0 vss.t0 ppolyf_u_1k r_width=1u r_length=19.23u
X47 a_1163_11006.t0 a_5141_11526.t0 vss.t0 ppolyf_u_1k r_width=1u r_length=19.23u
X49 a_1163_8926.t0 a_5141_8406.t0 vss.t0 ppolyf_u_1k r_width=1u r_length=19.23u
X58 a_1163_11006.t0 a_5141_10486.t0 vss.t0 ppolyf_u_1k r_width=1u r_length=19.23u
X60 a_1163_7886.t0 a_5141_8406.t0 vss.t0 ppolyf_u_1k r_width=1u r_length=19.23u
X63 a_5141_13606.t1 out.t3 cap_mim_2f0fF c_width=13.83u c_length=13.83u
Rpar0 a_1163_7366.t0 a_1163_7366.t7 224.2667
Rpar1 a_1163_7366.t0 a_1163_7366.t2 116.2301
Rpar2 a_1163_7366.t0 a_1163_7366.t3 113.1830
Rpar3 a_1163_7366.t0 a_1163_7366.t5 157.5050
Rpar4 a_1163_7366.t7 a_1163_7366.t2 297.3284
Rpar5 a_1163_7366.t7 a_1163_7366.t3 87.1368
Rpar6 a_1163_7366.t7 a_1163_7366.t5 479.7521
Rpar7 a_1163_7366.t2 a_1163_7366.t3 150.0559
Rpar8 a_1163_7366.t2 a_1163_7366.t5 248.6398
Rpar9 a_1163_7366.t3 a_1163_7366.t5 242.1216
Rpar10 a_5141_13606.t0 a_5141_13606.t1 65.0736
Rpar11 a_6674_2910.t0 a_6674_2910.t1 77.4845
Rpar12 a_6674_5545.t0 a_6674_5545.t2 50.1492
Rpar13 a_7032_13831.t0 a_7032_13831.t2 86.5343
Rpar14 a_7032_13831.t0 a_7032_13831.t3 113.3268
Rpar15 a_7032_13831.t2 a_7032_13831.t3 30.3939
Rpar16 a_7040_7045.t0 a_7040_7045.t4 102.9224
Rpar17 a_7040_7045.t0 a_7040_7045.t5 77.5173
Rpar18 a_7040_7045.t4 a_7040_7045.t5 22.3799
Rpar19 a_7160_1041.t0 a_7160_1041.t4 136.2400
Rpar20 a_7160_1041.t0 a_7160_1041.t5 135.9923
Rpar21 a_7160_1041.t4 a_7160_1041.t5 30.0194
Rpar22 a_7252_8498.t0 a_7252_8498.t2 120.8529
Rpar23 a_7252_8498.t0 a_7252_8498.t3 109.8249
Rpar24 a_7252_8498.t0 a_7252_8498.t6 103.4867
Rpar25 a_7252_8498.t2 a_7252_8498.t3 31.9709
Rpar26 a_7252_8498.t2 a_7252_8498.t6 168.4214
Rpar27 a_7252_8498.t3 a_7252_8498.t6 153.0527
Rpar28 ib ib.t0 15.6429
Rpar29 ib ib.t1 16.6348
Rpar30 ib.t0 ib.t1 29.4327
Rpar31 inn inn.t0 52.0252
Rpar32 inn inn.t4 3.1426
Rpar33 inp inp.t0 42.4870
Rpar34 inp inp.t4 3.1912
Rpar35 out out.t0 6.5440
Rpar36 out out.t1 535.6212
Rpar37 out out.t3 635.4918
Rpar38 out.t0 out.t1 204.8491
Rpar39 out.t0 out.t3 243.0447
Rpar40 out.t1 out.t3 383.0449
Rpar41 vdd vdd.t0 33.9785
Rpar42 vdd vdd.t1 78.5309
Rpar43 vdd vdd.t4 208.5940
Rpar44 vdd vdd.t5 159.6110
Rpar45 vdd vdd.t12 213.8747
Rpar46 vdd.t0 vdd.t1 14.2924
Rpar47 vdd.t0 vdd.t4 1045.9381
Rpar48 vdd.t0 vdd.t5 800.3259
Rpar49 vdd.t0 vdd.t12 1072.4165
Rpar50 vdd.t1 vdd.t5 1849.7081
Rpar51 vdd.t1 vdd.t12 2478.5623
Rpar52 vdd.t4 vdd.t5 6.4074
Rpar53 vdd.t4 vdd.t12 237.2305
Rpar54 vdd.t5 vdd.t12 181.5229
Rpar55 vss vss.t0 278.2342
Rpar56 vss vss.t1 55.4552
Rpar57 vss vss.t9 269.1435
Rpar58 vss vss.t2 36.9486
Rpar59 vss vss.t17 948.1277
Rpar60 vss vss.t18 266.5146
Rpar61 vss.t0 vss.t1 97.0701
Rpar62 vss.t0 vss.t9 82.5667
Rpar63 vss.t0 vss.t2 71.8213
Rpar64 vss.t0 vss.t17 604.6689
Rpar65 vss.t0 vss.t18 977.3707
Rpar66 vss.t1 vss.t9 13.2678
Rpar67 vss.t1 vss.t2 15.6663
Rpar68 vss.t1 vss.t17 2321.2037
Rpar69 vss.t1 vss.t18 1088.7859
Rpar70 vss.t9 vss.t2 29.7008
Rpar71 vss.t9 vss.t17 2637.2084
Rpar72 vss.t9 vss.t18 1482.8134
Rpar73 vss.t2 vss.t17 1784.2261
Rpar74 vss.t2 vss.t18 792.4444
Rpar75 vss.t17 vss.t18 14.5393
Cpar0 a_1163_11006.t0 vss 3.78600e-17
Cpar1 a_1163_12046.t0 vss 3.85800e-17
Cpar2 a_1163_13086.t0 vss 3.83000e-17
Cpar3 a_1163_7366.t0 vss 3.33368e-15
Cpar4 a_1163_7366.t2 vss 3.68405e-15
Cpar5 a_1163_7366.t3 vss 4.90966e-15
Cpar6 a_1163_7366.t5 vss 4.36045e-15
Cpar7 a_1163_7366.t7 vss 1.82748e-14
Cpar8 a_1163_7886.t0 vss 4.05200e-17
Cpar9 a_1163_8926.t0 vss 3.78600e-17
Cpar10 a_1163_9966.t0 vss 3.78600e-17
Cpar11 a_5141_10486.t0 vss 3.07400e-17
Cpar12 a_5141_11526.t0 vss 2.96200e-17
Cpar13 a_5141_12566.t0 vss 4.01800e-17
Cpar14 a_5141_13606.t0 vss 3.09220e-16
Cpar15 a_5141_13606.t1 vss 4.81602e-15
Cpar16 a_5141_7366.t0 vss 3.61800e-17
Cpar17 a_5141_8406.t0 vss 3.82800e-17
Cpar18 a_5141_9446.t0 vss 3.47400e-17
Cpar19 a_6674_2910.t0 vss 8.73842e-15
Cpar20 a_6674_2910.t1 vss 1.38018e-14
Cpar21 a_6674_5545.t0 vss 8.85253e-15
Cpar22 a_6674_5545.t2 vss 1.39134e-14
Cpar23 a_7032_13831.t0 vss 1.08770e-14
Cpar24 a_7032_13831.t2 vss 1.19272e-14
Cpar25 a_7032_13831.t3 vss 3.02749e-15
Cpar26 a_7040_7045.t0 vss 3.04837e-15
Cpar27 a_7040_7045.t4 vss 5.54014e-15
Cpar28 a_7040_7045.t5 vss 1.77795e-15
Cpar29 a_7160_1041.t0 vss 3.98366e-15
Cpar30 a_7160_1041.t4 vss 6.50523e-15
Cpar31 a_7160_1041.t5 vss 1.65721e-15
Cpar32 a_7252_8498.t0 vss 3.07822e-15
Cpar33 a_7252_8498.t2 vss 1.01015e-14
Cpar34 a_7252_8498.t3 vss 2.53300e-15
Cpar35 a_7252_8498.t6 vss 2.57778e-15
Cpar36 ib out 2.09410e-15
Cpar37 ib vdd 2.20850e-16
Cpar38 ib vss 4.44542e-14
Cpar39 ib.t0 vss 1.47343e-14
Cpar40 ib.t1 vss 1.19357e-15
Cpar41 inn inp 1.55910e-16
Cpar42 inn vdd 8.38252e-15
Cpar43 inn vss 7.96249e-15
Cpar44 inn.t0 vss 9.24491e-15
Cpar45 inn.t4 vss 1.35728e-15
Cpar46 inp vdd 8.12898e-15
Cpar47 inp vss 8.48798e-15
Cpar48 inp.t0 vss 9.49975e-15
Cpar49 inp.t4 vss 1.44583e-15
Cpar50 out vdd 1.73409e-14
Cpar51 out vss 4.07143e-14
Cpar52 out.t0 vss 7.35073e-15
Cpar53 out.t1 vss 1.01266e-14
Cpar54 out.t3 vss 1.26818e-14
Cpar55 vdd vss 1.60588e-13
Cpar56 vdd.t0 vss 9.87695e-15
Cpar57 vdd.t1 vss 4.34754e-15
Cpar58 vdd.t12 vss 2.68172e-14
Cpar59 vdd.t4 vss 3.25864e-14
Cpar60 vdd.t5 vss 1.17617e-14
.ends opamp_dut

Vdd vdd 0 1.800000
Vss vss 0 0
Ibias vdd ib 6.600000e-09
Vinp inp 0 DC 0.895000 AC 1 PWL(0 0.895000 1.564089e-06 0.895000 1.720498e-06 0.905000)
Rfb out inn 1m
Cload out 0 2.000000e-13
Xdut vdd vss inp inn out ib opamp_dut
.end
