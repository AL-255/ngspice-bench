* opa1000[0712]: 2p/rail_to_rail_1v8_i200n_weak (rail_to_rail, VDD=1.8V, CL=2.0pF, Iref=0.0325uA)
.include "pdk_opa.inc"
.temp 27
.option gmin=1e-12 rshunt=1e12 reltol=1e-3 abstol=1e-12 vntol=1e-5 method=gear
* Post-PEX R+C extracted netlist for rail_to_rail_1v8_i200n_weak
.subckt opamp_dut vdd vss inp inn out ib
XMpar0 a_1548_11773.t0 inn.t2 a_9840_17924.t4 vdd.t2 pfet_03v3 w=0.82u l=5.2u ad=4.9200e-13 pd=2.8400e-06 as=4.9200e-13 ps=2.8400e-06 nf=1 m=2 par=2
XMpar1 out.t0 ib.t0 vss.t10 vss.t9 nfet_03v3 w=0.4u l=4u ad=1.1200e-13 pd=9.6000e-07 as=1.4400e-13 ps=1.2200e-06 nf=1 m=8 par=8
XMpar2 ib.t1 ib.t0 vss.t10 vss.t9 nfet_03v3 w=0.4u l=4u ad=2.4000e-13 pd=2.0000e-06 as=1.1200e-13 ps=9.6000e-07 nf=1 m=2 par=2
XMpar3 out.t2 a_841_4078.t7 vdd.t4 vdd.t3 pfet_03v3 w=0.4u l=1.92u ad=1.1200e-13 pd=9.6000e-07 as=1.7600e-13 ps=1.4800e-06 nf=1 m=8 par=8
XMpar4 a_10804_14583.t4 a_10804_14583.t3 vdd.t4 vdd.t3 pfet_03v3 w=0.4u l=1.92u ad=1.1200e-13 pd=9.6000e-07 as=1.1200e-13 ps=9.6000e-07 nf=1 m=2 par=2
XMpar5 a_841_4078.t2 inp.t0 a_9074_16542.t0 vss.t0 nfet_03v3 w=0.4u l=5.2u ad=1.1200e-13 pd=9.6000e-07 as=2.4000e-13 ps=2.0000e-06 nf=1 m=2 par=2
XMpar6 a_1548_11773.t0 inp.t2 a_7552_10063.t0 vdd.t2 pfet_03v3 w=0.82u l=5.2u ad=4.9200e-13 pd=2.8400e-06 as=4.9200e-13 ps=2.8400e-06 nf=1 m=2 par=2
XMpar7 a_841_4078.t4 a_9840_17924.t0 vss.t3 vss.t2 nfet_03v3 w=0.4u l=9.75u ad=2.4000e-13 pd=2.0000e-06 as=1.1200e-13 ps=9.6000e-07 nf=1 m=2 par=2
XMpar8 a_9074_16542.t2 ib.t0 vss.t10 vss.t9 nfet_03v3 w=0.4u l=4u ad=2.4000e-13 pd=2.0000e-06 as=1.1200e-13 ps=9.6000e-07 nf=1 m=2 par=2
XMpar9 a_1668_11565.t4 ib.t0 vss.t10 vss.t9 nfet_03v3 w=0.4u l=4u ad=1.1200e-13 pd=9.6000e-07 as=1.1200e-13 ps=9.6000e-07 nf=1 m=2 par=2
XMpar10 a_7552_10063.t3 a_7552_10063.t2 vss.t3 vss.t2 nfet_03v3 w=0.4u l=9.75u ad=2.4000e-13 pd=2.0000e-06 as=1.1200e-13 ps=9.6000e-07 nf=1 m=2 par=2
XMpar11 a_841_4078.t0 a_10804_14583.t3 vdd.t4 vdd.t3 pfet_03v3 w=0.4u l=1.92u ad=2.4000e-13 pd=2.0000e-06 as=1.1200e-13 ps=9.6000e-07 nf=1 m=2 par=2
XMpar12 a_1668_11565.t1 a_1668_11565.t0 vdd.t1 vdd.t0 pfet_03v3 w=0.4u l=4u ad=2.4000e-13 pd=2.0000e-06 as=1.1200e-13 ps=9.6000e-07 nf=1 m=2 par=2
XMpar13 a_1548_11773.t2 a_1668_11565.t0 vdd.t1 vdd.t0 pfet_03v3 w=0.4u l=4u ad=2.4000e-13 pd=2.0000e-06 as=1.1200e-13 ps=9.6000e-07 nf=1 m=2 par=2
XMpar14 a_10804_14583.t2 a_7552_10063.t2 vss.t3 vss.t2 nfet_03v3 w=0.4u l=9.75u ad=1.1200e-13 pd=9.6000e-07 as=1.1200e-13 ps=9.6000e-07 nf=1 m=2 par=2
XMpar15 a_10804_14583.t0 inn.t0 a_9074_16542.t0 vss.t0 nfet_03v3 w=0.4u l=5.2u ad=1.1200e-13 pd=9.6000e-07 as=2.4000e-13 ps=2.0000e-06 nf=1 m=2 par=2
XMpar16 a_9840_17924.t1 a_9840_17924.t0 vss.t3 vss.t2 nfet_03v3 w=0.4u l=9.75u ad=2.4000e-13 pd=2.0000e-06 as=1.1200e-13 ps=9.6000e-07 nf=1 m=2 par=2
X4 a_4819_10318.t1 out.t1 cap_mim_2f0fF c_width=17.1u c_length=17.11u
X6 a_841_8758.t0 a_4819_8238.t0 vss.t6 ppolyf_u_1k r_width=1u r_length=19.23u
X8 a_841_5638.t0 a_4819_5118.t0 vss.t6 ppolyf_u_1k r_width=1u r_length=19.23u
X15 a_841_7718.t0 a_4819_8238.t0 vss.t6 ppolyf_u_1k r_width=1u r_length=19.23u
X17 a_841_4598.t0 a_4819_5118.t0 vss.t6 ppolyf_u_1k r_width=1u r_length=19.23u
X20 a_841_7718.t0 a_4819_7198.t0 vss.t6 ppolyf_u_1k r_width=1u r_length=19.23u
X35 a_841_4598.t0 a_4819_4078.t0 vss.t6 ppolyf_u_1k r_width=1u r_length=19.23u
X47 a_841_6678.t0 a_4819_7198.t0 vss.t6 ppolyf_u_1k r_width=1u r_length=19.23u
X48 a_4819_10318.t1 out.t1 cap_mim_2f0fF c_width=17.1u c_length=17.11u
X49 a_841_4078.t6 a_4819_4078.t0 vss.t6 ppolyf_u_1k r_width=1u r_length=19.23u
X52 a_841_9798.t0 a_4819_9278.t0 vss.t6 ppolyf_u_1k r_width=1u r_length=19.23u
X55 a_841_6678.t0 a_4819_6158.t0 vss.t6 ppolyf_u_1k r_width=1u r_length=19.23u
X57 a_4819_10318.t1 out.t1 cap_mim_2f0fF c_width=17.1u c_length=17.11u
X59 a_841_8758.t0 a_4819_9278.t0 vss.t6 ppolyf_u_1k r_width=1u r_length=19.23u
X60 a_841_9798.t0 a_4819_10318.t0 vss.t6 ppolyf_u_1k r_width=1u r_length=19.23u
X61 a_841_5638.t0 a_4819_6158.t0 vss.t6 ppolyf_u_1k r_width=1u r_length=19.23u
Rpar0 a_10804_14583.t0 a_10804_14583.t2 131.3305
Rpar1 a_10804_14583.t0 a_10804_14583.t3 203.2190
Rpar2 a_10804_14583.t0 a_10804_14583.t4 235.9197
Rpar3 a_10804_14583.t2 a_10804_14583.t3 471.3974
Rpar4 a_10804_14583.t2 a_10804_14583.t4 547.2517
Rpar5 a_10804_14583.t3 a_10804_14583.t4 28.1478
Rpar6 a_1548_11773.t0 a_1548_11773.t2 65.8298
Rpar7 a_1668_11565.t0 a_1668_11565.t1 15.9649
Rpar8 a_1668_11565.t0 a_1668_11565.t4 132.5950
Rpar9 a_1668_11565.t1 a_1668_11565.t4 133.3213
Rpar10 a_4819_10318.t0 a_4819_10318.t1 57.9774
Rpar11 a_7552_10063.t0 a_7552_10063.t2 145.3409
Rpar12 a_7552_10063.t0 a_7552_10063.t3 115.6263
Rpar13 a_7552_10063.t2 a_7552_10063.t3 22.7610
Rpar14 a_841_4078.t0 a_841_4078.t7 264.9900
Rpar15 a_841_4078.t0 a_841_4078.t2 140.7058
Rpar16 a_841_4078.t0 a_841_4078.t4 120.3898
Rpar17 a_841_4078.t0 a_841_4078.t6 206.2346
Rpar18 a_841_4078.t7 a_841_4078.t2 647.8993
Rpar19 a_841_4078.t7 a_841_4078.t4 554.3518
Rpar20 a_841_4078.t7 a_841_4078.t6 73.6745
Rpar21 a_841_4078.t2 a_841_4078.t4 60.2616
Rpar22 a_841_4078.t2 a_841_4078.t6 504.2426
Rpar23 a_841_4078.t4 a_841_4078.t6 431.4371
Rpar24 a_9074_16542.t0 a_9074_16542.t2 58.7171
Rpar25 a_9840_17924.t0 a_9840_17924.t1 17.8605
Rpar26 a_9840_17924.t0 a_9840_17924.t4 114.0535
Rpar27 a_9840_17924.t1 a_9840_17924.t4 103.5783
Rpar28 ib ib.t0 36.3059
Rpar29 ib ib.t1 14.2208
Rpar30 ib.t0 ib.t1 43.4344
Rpar31 inn inn.t0 3.2827
Rpar32 inn inn.t2 57.3962
Rpar33 inp inp.t0 3.3314
Rpar34 inp inp.t2 75.0591
Rpar35 out out.t0 192.7163
Rpar36 out out.t1 98.3578
Rpar37 out out.t2 5.2754
Rpar38 out.t0 out.t1 144.4900
Rpar39 out.t0 out.t2 851.0266
Rpar40 out.t1 out.t2 434.3436
Rpar41 vdd vdd.t0 1163.3052
Rpar42 vdd vdd.t1 411.3560
Rpar43 vdd vdd.t3 432.3369
Rpar44 vdd vdd.t4 257.0479
Rpar45 vdd vdd.t2 48.3648
Rpar46 vdd.t0 vdd.t1 25.2327
Rpar47 vdd.t0 vdd.t3 725.7638
Rpar48 vdd.t0 vdd.t4 380.2588
Rpar49 vdd.t0 vdd.t2 1448.6572
Rpar50 vdd.t1 vdd.t3 256.6371
Rpar51 vdd.t1 vdd.t4 134.4632
Rpar52 vdd.t1 vdd.t2 512.2592
Rpar53 vdd.t3 vdd.t4 8.2254
Rpar54 vdd.t3 vdd.t2 538.3867
Rpar55 vdd.t4 vdd.t2 320.1003
Rpar56 vss vss.t0 1512.1733
Rpar57 vss vss.t10 483.3800
Rpar58 vss vss.t2 421.6761
Rpar59 vss vss.t6 95.3240
Rpar60 vss vss.t3 130.5348
Rpar61 vss vss.t9 2262.7926
Rpar62 vss.t0 vss.t10 220.2605
Rpar63 vss.t0 vss.t2 7.4567
Rpar64 vss.t0 vss.t6 266.7689
Rpar65 vss.t0 vss.t3 25.8340
Rpar66 vss.t0 vss.t9 1016.5191
Rpar67 vss.t10 vss.t2 336.4390
Rpar68 vss.t10 vss.t6 55.2799
Rpar69 vss.t10 vss.t3 227.1967
Rpar70 vss.t10 vss.t9 42.6409
Rpar71 vss.t2 vss.t6 20.8515
Rpar72 vss.t2 vss.t3 37.0887
Rpar73 vss.t2 vss.t9 1578.8753
Rpar74 vss.t6 vss.t3 23.5794
Rpar75 vss.t6 vss.t9 287.4093
Rpar76 vss.t3 vss.t9 1073.7003
Cpar0 a_10804_14583.t0 vss 4.60748e-15
Cpar1 a_10804_14583.t2 vss 5.92826e-15
Cpar2 a_10804_14583.t3 vss 4.52635e-15
Cpar3 a_10804_14583.t4 vss 2.12917e-15
Cpar4 a_1548_11773.t0 vss 9.76525e-15
Cpar5 a_1548_11773.t2 vss 8.58209e-15
Cpar6 a_1668_11565.t0 vss 1.16043e-14
Cpar7 a_1668_11565.t1 vss 4.60279e-15
Cpar8 a_1668_11565.t4 vss 7.41383e-15
Cpar9 a_4819_10318.t0 vss 9.12500e-17
Cpar10 a_4819_10318.t1 vss 7.93890e-15
Cpar11 a_4819_4078.t0 vss 4.25000e-17
Cpar12 a_4819_5118.t0 vss 3.71800e-17
Cpar13 a_4819_6158.t0 vss 3.62400e-17
Cpar14 a_4819_7198.t0 vss 3.62400e-17
Cpar15 a_4819_8238.t0 vss 3.62400e-17
Cpar16 a_4819_9278.t0 vss 4.15400e-17
Cpar17 a_7552_10063.t0 vss 2.57586e-15
Cpar18 a_7552_10063.t2 vss 8.37154e-15
Cpar19 a_7552_10063.t3 vss 2.79662e-15
Cpar20 a_841_4078.t0 vss 4.44742e-15
Cpar21 a_841_4078.t2 vss 3.05869e-15
Cpar22 a_841_4078.t4 vss 6.32278e-15
Cpar23 a_841_4078.t6 vss 4.41392e-15
Cpar24 a_841_4078.t7 vss 9.94539e-15
Cpar25 a_841_4598.t0 vss 4.08200e-17
Cpar26 a_841_5638.t0 vss 3.71200e-17
Cpar27 a_841_6678.t0 vss 3.71200e-17
Cpar28 a_841_7718.t0 vss 3.71200e-17
Cpar29 a_841_8758.t0 vss 3.78600e-17
Cpar30 a_841_9798.t0 vss 3.44600e-17
Cpar31 a_9074_16542.t0 vss 8.10194e-15
Cpar32 a_9074_16542.t2 vss 1.11079e-14
Cpar33 a_9840_17924.t0 vss 7.82288e-15
Cpar34 a_9840_17924.t1 vss 1.88784e-15
Cpar35 a_9840_17924.t4 vss 1.66512e-15
Cpar36 ib out 8.17970e-16
Cpar37 ib vss 3.49209e-14
Cpar38 ib.t0 vss 1.10389e-14
Cpar39 ib.t1 vss 9.12048e-16
Cpar40 inn inp 1.56510e-16
Cpar41 inn vdd 5.31579e-15
Cpar42 inn vss 1.06813e-14
Cpar43 inn.t0 vss 1.29913e-15
Cpar44 inn.t2 vss 5.01610e-15
Cpar45 inp vdd 6.93656e-15
Cpar46 inp vss 1.08697e-14
Cpar47 inp.t0 vss 1.60143e-15
Cpar48 inp.t2 vss 6.43676e-15
Cpar49 out vdd 7.74840e-15
Cpar50 out vss 3.09347e-14
Cpar51 out.t0 vss 5.15153e-15
Cpar52 out.t1 vss 1.53309e-14
Cpar53 out.t2 vss 9.31654e-16
Cpar54 vdd vss 1.29115e-13
Cpar55 vdd.t0 vss 1.06718e-14
Cpar56 vdd.t1 vss 5.81304e-15
Cpar57 vdd.t2 vss 1.55337e-14
Cpar58 vdd.t3 vss 1.45982e-14
Cpar59 vdd.t4 vss 1.00636e-14
.ends opamp_dut

Vdd vdd 0 1.800000
Vss vss 0 0
Ibias vdd ib 3.250000e-08
Vinp inp 0 DC 0.895000 AC 1 PWL(0 0.895000 1.890665e-06 0.895000 2.079732e-06 0.905000)
Rfb out inn 1m
Cload out 0 2.000000e-12
Xdut vdd vss inp inn out ib opamp_dut
.end
