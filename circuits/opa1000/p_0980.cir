* opa1000[0980]: 2p/telescopic_pmos_3v3_i50n_weak (telescopic_pmos, VDD=3.3V, CL=2.0pF, Iref=0.0115uA)
.include "pdk_opa.inc"
.temp 27
.option gmin=1e-12 rshunt=1e12 reltol=1e-3 abstol=1e-12 vntol=1e-5 method=gear
* Post-PEX R+C extracted netlist for telescopic_pmos_3v3_i50n_weak
.subckt opamp_dut vdd vss inp inn out ib
XMpar0 a_3968_6167.t2 a_1460_2657.t0 out.t1 vdd.t4 pfet_03v3 w=0.41u l=4.38u ad=2.4600e-13 pd=2.0200e-06 as=1.1480e-13 ps=9.7000e-07 nf=1 m=2 par=2
XMpar1 a_3968_4436.t1 a_1460_2657.t4 out.t0 vss.t2 nfet_03v3 w=0.4u l=4.38u ad=2.4000e-13 pd=2.0000e-06 as=1.1200e-13 ps=9.6000e-07 nf=1 m=2 par=2
XMpar2 a_1340_2865.t2 a_1460_2657.t4 a_1460_2657.t5 vss.t2 nfet_03v3 w=0.4u l=4.38u ad=2.4000e-13 pd=2.0000e-06 as=2.4000e-13 ps=2.0000e-06 nf=1 m=2 par=2
XMpar3 a_2354_7945.t2 a_1639_9242.t0 vdd.t3 vdd.t2 pfet_03v3 w=0.4u l=6.25u ad=1.1200e-13 pd=9.6000e-07 as=2.0800e-13 ps=1.7400e-06 nf=1 m=8 par=8
XMpar4 a_3968_4436.t0 a_1460_2657.t8 vss.t1 vss.t0 nfet_03v3 w=0.4u l=8.13u ad=1.1200e-13 pd=9.6000e-07 as=1.1200e-13 ps=9.6000e-07 nf=1 m=2 par=2
XMpar5 a_2354_7945.t0 inp.t0 a_2704_6167.t0 vdd.t0 pfet_03v3 w=0.65u l=5.2u ad=3.9000e-13 pd=2.5000e-06 as=1.8200e-13 ps=1.2100e-06 nf=1 m=2 par=2
XMpar6 a_1340_2865.t0 a_1460_2657.t8 vss.t1 vss.t0 nfet_03v3 w=0.4u l=8.13u ad=2.4000e-13 pd=2.0000e-06 as=1.1200e-13 ps=9.6000e-07 nf=1 m=2 par=2
XMpar7 a_1639_9242.t1 a_1639_9242.t0 vdd.t3 vdd.t2 pfet_03v3 w=0.4u l=6.25u ad=2.4000e-13 pd=2.0000e-06 as=1.1200e-13 ps=9.6000e-07 nf=1 m=2 par=2
XMpar8 a_2354_7945.t0 inn.t0 a_3968_6167.t0 vdd.t0 pfet_03v3 w=0.65u l=5.2u ad=3.9000e-13 pd=2.5000e-06 as=1.8200e-13 ps=1.2100e-06 nf=1 m=2 par=2
XMpar9 a_1460_2657.t1 a_1460_2657.t0 a_2704_6167.t2 vdd.t4 pfet_03v3 w=0.41u l=4.38u ad=2.4600e-13 pd=2.0200e-06 as=2.4600e-13 ps=2.0200e-06 nf=1 m=2 par=2
XMpar10 ib.t1 ib.t0 vss.t6 vss.t5 nfet_03v3 w=0.4u l=6.25u ad=2.4000e-13 pd=2.0000e-06 as=1.1200e-13 ps=9.6000e-07 nf=1 m=2 par=2
XMpar11 a_1639_9242.t4 ib.t0 vss.t6 vss.t5 nfet_03v3 w=0.4u l=6.25u ad=1.1200e-13 pd=9.6000e-07 as=1.1200e-13 ps=9.6000e-07 nf=1 m=2 par=2
Rpar0 a_1340_2865.t0 a_1340_2865.t2 67.4116
Rpar1 a_1460_2657.t0 a_1460_2657.t1 24.2450
Rpar2 a_1460_2657.t0 a_1460_2657.t8 704.9419
Rpar3 a_1460_2657.t0 a_1460_2657.t4 464.6858
Rpar4 a_1460_2657.t0 a_1460_2657.t5 226.5287
Rpar5 a_1460_2657.t1 a_1460_2657.t8 326.3585
Rpar6 a_1460_2657.t1 a_1460_2657.t4 215.1300
Rpar7 a_1460_2657.t1 a_1460_2657.t5 104.8733
Rpar8 a_1460_2657.t8 a_1460_2657.t4 404.4813
Rpar9 a_1460_2657.t8 a_1460_2657.t5 197.1797
Rpar10 a_1460_2657.t4 a_1460_2657.t5 25.1976
Rpar11 a_1639_9242.t0 a_1639_9242.t1 15.9349
Rpar12 a_1639_9242.t0 a_1639_9242.t4 124.4075
Rpar13 a_1639_9242.t1 a_1639_9242.t4 209.5232
Rpar14 a_2354_7945.t0 a_2354_7945.t2 51.2684
Rpar15 a_2704_6167.t0 a_2704_6167.t2 70.2548
Rpar16 a_3968_4436.t0 a_3968_4436.t1 66.1025
Rpar17 a_3968_6167.t0 a_3968_6167.t2 61.0672
Rpar18 ib ib.t0 11.5933
Rpar19 ib ib.t1 8.8363
Rpar20 inn inn.t0 3.3659
Rpar21 inp inp.t0 3.4144
Rpar22 out out.t0 15.7592
Rpar23 out out.t1 54.3528
Rpar24 vdd vdd.t0 146.5684
Rpar25 vdd vdd.t3 264.1156
Rpar26 vdd vdd.t2 25.3739
Rpar27 vdd vdd.t4 140.8577
Rpar28 vdd.t0 vdd.t3 1887.7156
Rpar29 vdd.t0 vdd.t2 181.3552
Rpar30 vdd.t0 vdd.t4 61.4169
Rpar31 vdd.t3 vdd.t2 13.1942
Rpar32 vdd.t3 vdd.t4 1814.1644
Rpar33 vdd.t2 vdd.t4 174.2890
Rpar34 vss vss.t0 95.1740
Rpar35 vss vss.t1 427.8049
Rpar36 vss vss.t6 514.9322
Rpar37 vss vss.t5 95.6442
Rpar38 vss vss.t2 172.5851
Rpar39 vss.t0 vss.t1 29.8193
Rpar40 vss.t0 vss.t6 27.3440
Rpar41 vss.t0 vss.t5 5.0994
Rpar42 vss.t0 vss.t2 8.3773
Rpar43 vss.t1 vss.t6 172.6613
Rpar44 vss.t1 vss.t5 28.6467
Rpar45 vss.t1 vss.t2 52.6573
Rpar46 vss.t6 vss.t5 28.3526
Rpar47 vss.t6 vss.t2 51.5742
Rpar48 vss.t5 vss.t2 5.5717
Cpar0 a_1340_2865.t0 vss 4.65419e-15
Cpar1 a_1340_2865.t2 vss 3.67466e-15
Cpar2 a_1460_2657.t0 vss 5.21115e-15
Cpar3 a_1460_2657.t1 vss 2.29726e-15
Cpar4 a_1460_2657.t4 vss 5.46221e-15
Cpar5 a_1460_2657.t5 vss 2.77376e-15
Cpar6 a_1460_2657.t8 vss 1.02246e-14
Cpar7 a_1639_9242.t0 vss 4.01041e-14
Cpar8 a_1639_9242.t1 vss 7.81567e-15
Cpar9 a_1639_9242.t4 vss 6.93598e-15
Cpar10 a_2354_7945.t0 vss 8.21192e-15
Cpar11 a_2354_7945.t2 vss 1.74935e-14
Cpar12 a_2704_6167.t0 vss 3.71073e-15
Cpar13 a_2704_6167.t2 vss 5.26122e-15
Cpar14 a_3968_4436.t0 vss 5.30251e-15
Cpar15 a_3968_4436.t1 vss 5.33976e-15
Cpar16 a_3968_6167.t0 vss 4.35516e-15
Cpar17 a_3968_6167.t2 vss 6.23035e-15
Cpar18 ib vss 1.81044e-14
Cpar19 ib.t0 vss 2.11459e-15
Cpar20 ib.t1 vss 1.13640e-16
Cpar21 inn inp 5.19900e-17
Cpar22 inn vdd 5.13049e-15
Cpar23 inn vss 3.05465e-15
Cpar24 inn.t0 vss 3.11420e-15
Cpar25 inp vdd 5.00352e-15
Cpar26 inp vss 2.95421e-15
Cpar27 inp.t0 vss 3.09102e-15
Cpar28 out vdd 2.93403e-15
Cpar29 out vss 8.68087e-15
Cpar30 out.t0 vss 4.74423e-16
Cpar31 out.t1 vss 3.29670e-15
Cpar32 vdd vss 1.29420e-13
Cpar33 vdd.t0 vss 1.36152e-14
Cpar34 vdd.t2 vss 3.86126e-14
Cpar35 vdd.t3 vss 6.07475e-15
Cpar36 vdd.t4 vss 1.62935e-14
.ends opamp_dut

Vdd vdd 0 3.300000
Vss vss 0 0
Ibias vdd ib 1.150000e-08
Vinp inp 0 DC 1.480000 AC 1 PWL(0 1.480000 3.083113e-06 1.480000 3.391425e-06 1.490000)
Rfb out inn 1m
Cload out 0 2.000000e-12
Xdut vdd vss inp inn out ib opamp_dut
.end
