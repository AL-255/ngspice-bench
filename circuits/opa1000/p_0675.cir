* opa1000[0675]: 200f/rail_to_rail_1v8_i1u_subth (rail_to_rail, VDD=1.8V, CL=0.2pF, Iref=0.1625uA)
.include "pdk_opa.inc"
.temp 27
.option gmin=1e-12 rshunt=1e12 reltol=1e-3 abstol=1e-12 vntol=1e-5 method=gear
* Post-PEX R+C extracted netlist for rail_to_rail_1v8_i1u_subth
.subckt opamp_dut vdd vss inp inn out ib
XMpar0 a_1229_3176.t3 a_1229_3176.t2 vdd.t7 vdd.t6 pfet_03v3 w=2.17u l=2.1u ad=6.0760e-13 pd=2.7300e-06 as=6.0760e-13 ps=2.7300e-06 nf=1 m=2 par=2
XMpar1 a_7490_1294.t2 ib.t0 vss.t18 vss.t17 nfet_03v3 w=0.47u l=2.1u ad=2.8200e-13 pd=2.1400e-06 as=1.3160e-13 ps=1.0300e-06 nf=1 m=2 par=2
XMpar2 out.t0 a_1083_1041.t7 vdd.t1 vdd.t0 pfet_03v3 w=3.8u l=1.08u ad=1.0640e-12 pd=4.3600e-06 as=1.3680e-12 ps=5.4700e-06 nf=1 m=8 par=8
XMpar3 a_6732_7351.t1 a_6732_7351.t0 vss.t2 vss.t1 nfet_03v3 w=0.55u l=4.5u ad=1.5400e-13 pd=1.1100e-06 as=1.5400e-13 ps=1.1100e-06 nf=1 m=2 par=2
XMpar4 a_1109_3384.t6 a_1229_3176.t2 vdd.t7 vdd.t6 pfet_03v3 w=2.17u l=2.1u ad=1.3020e-12 pd=5.5400e-06 as=6.0760e-13 ps=2.7300e-06 nf=1 m=2 par=2
XMpar5 a_1109_3384.t0 inp.t2 a_6226_9206.t0 vdd.t12 pfet_03v3 w=1.76u l=1.56u ad=6.8053e-13 pd=3.1200e-06 as=4.9280e-13 ps=2.3200e-06 nf=1 m=6 par=6
XMpar6 a_1109_3384.t0 inn.t2 a_6732_7351.t4 vdd.t12 pfet_03v3 w=1.76u l=1.56u ad=6.8053e-13 pd=3.1200e-06 as=4.9280e-13 ps=2.3200e-06 nf=1 m=6 par=6
XMpar7 a_1083_1041.t3 a_6732_7351.t0 vss.t2 vss.t1 nfet_03v3 w=0.55u l=4.5u ad=3.3000e-13 pd=2.3000e-06 as=1.5400e-13 ps=1.1100e-06 nf=1 m=2 par=2
XMpar8 out.t1 ib.t0 vss.t18 vss.t17 nfet_03v3 w=0.47u l=2.1u ad=1.3160e-13 pd=1.0300e-06 as=2.4440e-13 ps=1.8625e-06 nf=1 m=8 par=8
XMpar9 a_7490_1294.t0 inn.t0 a_8100_5100.t2 vss.t9 nfet_03v3 w=0.71u l=1.56u ad=4.2600e-13 pd=2.6200e-06 as=1.9880e-13 ps=1.2700e-06 nf=1 m=2 par=2
XMpar10 a_8100_5100.t5 a_8100_5100.t4 vdd.t1 vdd.t0 pfet_03v3 w=3.8u l=1.08u ad=1.0640e-12 pd=4.3600e-06 as=1.0640e-12 ps=4.3600e-06 nf=1 m=2 par=2
XMpar11 a_1083_1041.t1 inp.t0 a_7490_1294.t0 vss.t9 nfet_03v3 w=0.71u l=1.56u ad=1.9880e-13 pd=1.2700e-06 as=4.2600e-13 ps=2.6200e-06 nf=1 m=2 par=2
XMpar12 ib.t1 ib.t0 vss.t18 vss.t17 nfet_03v3 w=0.47u l=2.1u ad=2.8200e-13 pd=2.1400e-06 as=1.3160e-13 ps=1.0300e-06 nf=1 m=2 par=2
XMpar13 a_1083_1041.t5 a_8100_5100.t4 vdd.t1 vdd.t0 pfet_03v3 w=3.8u l=1.08u ad=2.2800e-12 pd=8.8000e-06 as=1.0640e-12 ps=4.3600e-06 nf=1 m=2 par=2
XMpar14 a_6226_9206.t7 a_6226_9206.t6 vss.t2 vss.t1 nfet_03v3 w=0.55u l=4.5u ad=3.3000e-13 pd=2.3000e-06 as=1.5400e-13 ps=1.1100e-06 nf=1 m=2 par=2
XMpar15 a_1229_3176.t0 ib.t0 vss.t18 vss.t17 nfet_03v3 w=0.47u l=2.1u ad=2.8200e-13 pd=2.1400e-06 as=1.3160e-13 ps=1.0300e-06 nf=1 m=2 par=2
XMpar16 a_8100_5100.t0 a_6226_9206.t6 vss.t2 vss.t1 nfet_03v3 w=0.55u l=4.5u ad=1.5400e-13 pd=1.1100e-06 as=1.5400e-13 ps=1.1100e-06 nf=1 m=2 par=2
X3 a_4752_12579.t0 a_8262_13099.t0 vss.t0 ppolyf_u_1k r_width=1u r_length=16.89u
X6 a_4752_12579.t0 a_8262_12059.t0 vss.t0 ppolyf_u_1k r_width=1u r_length=16.89u
X16 a_4752_11539.t0 a_8262_12059.t0 vss.t0 ppolyf_u_1k r_width=1u r_length=16.89u
X22 a_4752_11539.t0 a_8262_11019.t0 vss.t0 ppolyf_u_1k r_width=1u r_length=16.89u
X32 a_1083_1041.t0 a_8262_11019.t0 vss.t0 ppolyf_u_1k r_width=1u r_length=16.89u
X37 a_4752_13619.t0 a_8262_13099.t0 vss.t0 ppolyf_u_1k r_width=1u r_length=16.89u
X52 a_4752_13619.t1 out.t6 cap_mim_2f0fF c_width=12.99u c_length=12.99u
Rpar0 a_1083_1041.t0 a_1083_1041.t1 303.6901
Rpar1 a_1083_1041.t0 a_1083_1041.t7 338.4678
Rpar2 a_1083_1041.t0 a_1083_1041.t3 106.7036
Rpar3 a_1083_1041.t0 a_1083_1041.t5 221.0930
Rpar4 a_1083_1041.t1 a_1083_1041.t7 101.6360
Rpar5 a_1083_1041.t1 a_1083_1041.t3 175.3479
Rpar6 a_1083_1041.t1 a_1083_1041.t5 182.4028
Rpar7 a_1083_1041.t7 a_1083_1041.t3 195.4282
Rpar8 a_1083_1041.t7 a_1083_1041.t5 203.2910
Rpar9 a_1083_1041.t3 a_1083_1041.t5 127.6571
Rpar10 a_1109_3384.t0 a_1109_3384.t6 68.2881
Rpar11 a_1229_3176.t0 a_1229_3176.t2 287.1287
Rpar12 a_1229_3176.t0 a_1229_3176.t3 149.4090
Rpar13 a_1229_3176.t2 a_1229_3176.t3 22.5987
Rpar14 a_4752_13619.t0 a_4752_13619.t1 57.6028
Rpar15 a_6226_9206.t0 a_6226_9206.t6 172.2521
Rpar16 a_6226_9206.t0 a_6226_9206.t7 120.1328
Rpar17 a_6226_9206.t6 a_6226_9206.t7 20.8368
Rpar18 a_6732_7351.t0 a_6732_7351.t1 29.8928
Rpar19 a_6732_7351.t0 a_6732_7351.t4 126.5165
Rpar20 a_6732_7351.t1 a_6732_7351.t4 119.0596
Rpar21 a_7490_1294.t0 a_7490_1294.t2 84.3355
Rpar22 a_8100_5100.t0 a_8100_5100.t2 90.4637
Rpar23 a_8100_5100.t0 a_8100_5100.t4 355.0013
Rpar24 a_8100_5100.t0 a_8100_5100.t5 131.5877
Rpar25 a_8100_5100.t2 a_8100_5100.t4 635.2420
Rpar26 a_8100_5100.t2 a_8100_5100.t5 235.4640
Rpar27 a_8100_5100.t4 a_8100_5100.t5 25.7620
Rpar28 ib ib.t0 12.5561
Rpar29 ib ib.t1 14.0514
Rpar30 ib.t0 ib.t1 31.4252
Rpar31 inn inn.t0 5.0684
Rpar32 inn inn.t2 47.9790
Rpar33 inp inp.t0 5.1170
Rpar34 inp inp.t2 47.9304
Rpar35 out out.t0 66.5408
Rpar36 out out.t1 163.9150
Rpar37 out out.t6 19.9166
Rpar38 out.t0 out.t1 358.2936
Rpar39 out.t0 out.t6 930.0539
Rpar40 out.t1 out.t6 2291.0709
Rpar41 vdd vdd.t0 705.0734
Rpar42 vdd vdd.t1 1268.3142
Rpar43 vdd vdd.t6 1853.9253
Rpar44 vdd vdd.t7 2450.7201
Rpar45 vdd vdd.t12 55.6702
Rpar46 vdd.t0 vdd.t1 3.1929
Rpar47 vdd.t0 vdd.t6 153.6082
Rpar48 vdd.t0 vdd.t7 203.0560
Rpar49 vdd.t0 vdd.t12 109.3586
Rpar50 vdd.t1 vdd.t6 312.8635
Rpar51 vdd.t1 vdd.t7 413.5770
Rpar52 vdd.t1 vdd.t12 196.7186
Rpar53 vdd.t6 vdd.t7 10.3955
Rpar54 vdd.t6 vdd.t12 287.5483
Rpar55 vdd.t7 vdd.t12 380.1126
Rpar56 vss vss.t0 932.3316
Rpar57 vss vss.t1 64.7823
Rpar58 vss vss.t9 56.3806
Rpar59 vss vss.t2 184.3097
Rpar60 vss vss.t17 2192.1397
Rpar61 vss vss.t18 571.0935
Rpar62 vss.t0 vss.t1 603.0627
Rpar63 vss.t0 vss.t9 642.0984
Rpar64 vss.t0 vss.t2 1310.9245
Rpar65 vss.t0 vss.t17 297.3469
Rpar66 vss.t0 vss.t18 81.3536
Rpar67 vss.t1 vss.t9 1.8789
Rpar68 vss.t1 vss.t2 10.0606
Rpar69 vss.t1 vss.t17 1063.9878
Rpar70 vss.t1 vss.t18 373.7326
Rpar71 vss.t9 vss.t2 15.6599
Rpar72 vss.t9 vss.t17 1240.0359
Rpar73 vss.t9 vss.t18 396.3170
Rpar74 vss.t2 vss.t17 2094.3828
Rpar75 vss.t2 vss.t18 816.3550
Rpar76 vss.t17 vss.t18 13.7672
Cpar0 a_1083_1041.t0 vss 3.06173e-15
Cpar1 a_1083_1041.t1 vss 2.22042e-15
Cpar2 a_1083_1041.t3 vss 3.50712e-15
Cpar3 a_1083_1041.t5 vss 4.27626e-15
Cpar4 a_1083_1041.t7 vss 9.28709e-15
Cpar5 a_1109_3384.t0 vss 8.93244e-15
Cpar6 a_1109_3384.t6 vss 7.38630e-15
Cpar7 a_1229_3176.t0 vss 8.66894e-15
Cpar8 a_1229_3176.t2 vss 6.98690e-15
Cpar9 a_1229_3176.t3 vss 4.50720e-15
Cpar10 a_4752_11539.t0 vss 4.07000e-17
Cpar11 a_4752_12579.t0 vss 4.14600e-17
Cpar12 a_4752_13619.t0 vss 1.80850e-16
Cpar13 a_4752_13619.t1 vss 3.35294e-15
Cpar14 a_6226_9206.t0 vss 3.17303e-15
Cpar15 a_6226_9206.t6 vss 6.11766e-15
Cpar16 a_6226_9206.t7 vss 2.10780e-15
Cpar17 a_6732_7351.t0 vss 5.11129e-15
Cpar18 a_6732_7351.t1 vss 1.07683e-15
Cpar19 a_6732_7351.t4 vss 1.98791e-15
Cpar20 a_7490_1294.t0 vss 5.93097e-15
Cpar21 a_7490_1294.t2 vss 8.51021e-15
Cpar22 a_8100_5100.t0 vss 2.55325e-15
Cpar23 a_8100_5100.t2 vss 1.72699e-15
Cpar24 a_8100_5100.t4 vss 4.10261e-15
Cpar25 a_8100_5100.t5 vss 3.03941e-15
Cpar26 a_8262_11019.t0 vss 4.31800e-17
Cpar27 a_8262_12059.t0 vss 3.85200e-17
Cpar28 a_8262_13099.t0 vss 4.17600e-17
Cpar29 ib out 1.73216e-15
Cpar30 ib vdd 1.39900e-17
Cpar31 ib vss 2.43273e-14
Cpar32 ib.t0 vss 8.23213e-15
Cpar33 ib.t1 vss 8.82992e-16
Cpar34 inn inp 1.03420e-16
Cpar35 inn vdd 5.42543e-15
Cpar36 inn vss 8.42718e-15
Cpar37 inn.t0 vss 6.74616e-16
Cpar38 inn.t2 vss 7.79979e-15
Cpar39 inp vdd 7.52664e-15
Cpar40 inp vss 6.45605e-15
Cpar41 inp.t0 vss 7.86034e-16
Cpar42 inp.t2 vss 9.00273e-15
Cpar43 out vdd 1.14355e-14
Cpar44 out vss 2.11207e-14
Cpar45 out.t0 vss 5.94381e-15
Cpar46 out.t1 vss 7.65206e-15
Cpar47 out.t6 vss 6.60772e-15
Cpar48 vdd vss 1.06597e-13
Cpar49 vdd.t0 vss 1.59923e-14
Cpar50 vdd.t1 vss 8.03076e-15
Cpar51 vdd.t12 vss 1.76881e-14
Cpar52 vdd.t6 vss 6.45953e-15
Cpar53 vdd.t7 vss 4.33573e-15
.ends opamp_dut

Vdd vdd 0 1.800000
Vss vss 0 0
Ibias vdd ib 1.625000e-07
Vinp inp 0 DC 0.895000 AC 1 PWL(0 0.895000 6.645964e-08 0.895000 7.310560e-08 0.905000)
Rfb out inn 1m
Cload out 0 2.000000e-13
Xdut vdd vss inp inn out ib opamp_dut
.end
