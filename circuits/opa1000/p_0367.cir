* opa1000[0367]: 200f/nmos_5t_3v3_i10u_weak (nmos_5t, VDD=3.3V, CL=0.2pF, Iref=2.875uA)
.include "pdk_opa.inc"
.temp 27
.option gmin=1e-12 rshunt=1e12 reltol=1e-3 abstol=1e-12 vntol=1e-5 method=gear
* Post-PEX R+C extracted netlist for nmos_5t_3v3_i10u_weak
.subckt opamp_dut vdd vss inp inn out ib
XMpar0 out.t0 a_1972_6831.t0 vdd.t1 vdd.t0 pfet_03v3 w=1.93u l=1.08u ad=5.4040e-13 pd=2.4900e-06 as=6.1760e-13 ps=2.8112e-06 nf=1 m=8 par=8
XMpar1 a_1544_1205.t0 inp.t0 a_1972_6831.t16 vss.t0 nfet_03v3 w=2.05u l=1.63u ad=7.9267e-13 pd=3.5067e-06 as=5.7400e-13 ps=2.6100e-06 nf=1 m=18 par=18
XMpar2 a_1544_1205.t0 inn.t0 out.t5 vss.t0 nfet_03v3 w=2.05u l=1.63u ad=7.9267e-13 pd=3.5067e-06 as=5.7400e-13 ps=2.6100e-06 nf=1 m=18 par=18
XMpar3 a_1544_1205.t36 ib.t0 vss.t13 vss.t12 nfet_03v3 w=1.85u l=1.5u ad=5.1800e-13 pd=2.4100e-06 as=6.6600e-13 ps=3.0325e-06 nf=1 m=8 par=8
XMpar4 a_1972_6831.t1 a_1972_6831.t0 vdd.t1 vdd.t0 pfet_03v3 w=1.93u l=1.08u ad=5.4040e-13 pd=2.4900e-06 as=6.1760e-13 ps=2.8112e-06 nf=1 m=8 par=8
XMpar5 ib.t1 ib.t0 vss.t13 vss.t12 nfet_03v3 w=1.85u l=1.5u ad=5.1800e-13 pd=2.4100e-06 as=5.1800e-13 ps=2.4100e-06 nf=1 m=2 par=2
Rpar0 a_1544_1205.t0 a_1544_1205.t36 26.9554
Rpar1 a_1972_6831.t0 a_1972_6831.t1 16.1084
Rpar2 a_1972_6831.t0 a_1972_6831.t16 147.8660
Rpar3 a_1972_6831.t1 a_1972_6831.t16 48.7788
Rpar4 ib ib.t0 18.6429
Rpar5 ib ib.t1 11.9033
Rpar6 ib.t0 ib.t1 85.2919
Rpar7 inn inn.t0 2.0462
Rpar8 inp inp.t0 2.0462
Rpar9 out out.t0 3.4915
Rpar10 out out.t5 34.0386
Rpar11 vdd vdd.t0 24.4700
Rpar12 vdd vdd.t1 99.7764
Rpar13 vdd.t0 vdd.t1 4.2351
Rpar14 vss vss.t0 45.2894
Rpar15 vss vss.t12 48.9329
Rpar16 vss vss.t13 94.9077
Rpar17 vss.t0 vss.t12 1.7152
Rpar18 vss.t0 vss.t13 8.4707
Rpar19 vss.t12 vss.t13 9.0131
Cpar0 a_1544_1205.t0 vss 2.29892e-14
Cpar1 a_1544_1205.t36 vss 4.67621e-15
Cpar2 a_1972_6831.t0 vss 1.52862e-14
Cpar3 a_1972_6831.t1 vss 6.75765e-15
Cpar4 a_1972_6831.t16 vss 1.40848e-14
Cpar5 ib inp 2.45400e-17
Cpar6 ib vss 1.45275e-14
Cpar7 ib.t0 vss 2.44038e-15
Cpar8 ib.t1 vss 1.90639e-16
Cpar9 inn inp 1.55820e-16
Cpar10 inn out 5.17911e-15
Cpar11 inn vdd 1.01500e-17
Cpar12 inn vss 1.62637e-14
Cpar13 inn.t0 vss 7.64766e-15
Cpar14 inp vdd 1.15400e-17
Cpar15 inp vss 1.61955e-14
Cpar16 inp.t0 vss 7.70452e-15
Cpar17 out vdd 5.47851e-15
Cpar18 out vss 9.48248e-15
Cpar19 out.t0 vss 3.88562e-15
Cpar20 out.t5 vss 1.46736e-14
Cpar21 vdd vss 4.22993e-14
Cpar22 vdd.t0 vss 1.43484e-14
Cpar23 vdd.t1 vss 5.08896e-15
.ends opamp_dut

Vdd vdd 0 3.300000
Vss vss 0 0
Ibias vdd ib 2.875000e-06
Vinp inp 0 DC 1.645000 AC 1 PWL(0 1.645000 3.000000e-09 1.645000 3.300000e-09 1.655000)
Rfb out inn 1m
Cload out 0 2.000000e-13
Xdut vdd vss inp inn out ib opamp_dut
.end
