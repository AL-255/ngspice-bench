* opa1000[0968]: 2p/telescopic_pmos_1v8_i2u_weak (telescopic_pmos, VDD=1.8V, CL=2.0pF, Iref=0.4uA)
.include "pdk_opa.inc"
.temp 27
.option gmin=1e-12 rshunt=1e12 reltol=1e-3 abstol=1e-12 vntol=1e-5 method=gear
* Post-PEX R+C extracted netlist for telescopic_pmos_1v8_i2u_weak
.subckt opamp_dut vdd vss inp inn out ib
XMpar0 a_2122_4944.t0 inn.t0 a_8014_7155.t0 vdd.t5 pfet_03v3 w=1.86u l=2.4u ad=6.3984e-13 pd=2.9200e-06 as=6.3984e-13 ps=2.9200e-06 nf=1 m=20 par=20
XMpar1 a_5070_7155.t20 vss.t21 a_5516_7155.t4 vdd.t0 pfet_03v3 w=1.75u l=1.63u ad=6.7667e-13 pd=3.1067e-06 as=4.9000e-13 ps=2.3100e-06 nf=1 m=6 par=6
XMpar2 a_2122_4944.t0 inp.t0 a_5070_7155.t0 vdd.t5 pfet_03v3 w=1.86u l=2.4u ad=6.3984e-13 pd=2.9200e-06 as=6.3984e-13 ps=2.9200e-06 nf=1 m=20 par=20
XMpar3 a_8014_7155.t20 vss.t21 out.t0 vdd.t0 pfet_03v3 w=1.75u l=1.63u ad=6.7667e-13 pd=3.1067e-06 as=4.9000e-13 ps=2.3100e-06 nf=1 m=6 par=6
XMpar4 a_7558_3017.t1 a_5516_7155.t0 out.t4 vss.t3 nfet_03v3 w=1.16u l=1.63u ad=6.9600e-13 pd=3.5200e-06 as=3.2480e-13 ps=1.7200e-06 nf=1 m=2 par=2
XMpar5 a_7558_3017.t0 a_5516_7155.t10 vss.t2 vss.t1 nfet_03v3 w=1.16u l=4.25u ad=3.2480e-13 pd=1.7200e-06 as=3.2480e-13 ps=1.7200e-06 nf=1 m=2 par=2
XMpar6 ib.t1 ib.t0 vss.t12 vss.t11 nfet_03v3 w=0.8u l=3.9u ad=4.8000e-13 pd=2.8000e-06 as=2.2400e-13 ps=1.3600e-06 nf=1 m=2 par=2
XMpar7 a_1342_4736.t4 ib.t0 vss.t12 vss.t11 nfet_03v3 w=0.8u l=3.9u ad=2.2400e-13 pd=1.3600e-06 as=2.2400e-13 ps=1.3600e-06 nf=1 m=2 par=2
XMpar8 a_1342_4736.t1 a_1342_4736.t0 vdd.t2 vdd.t1 pfet_03v3 w=3.15u l=3.9u ad=8.8200e-13 pd=3.7100e-06 as=8.8200e-13 ps=3.7100e-06 nf=1 m=2 par=2
XMpar9 a_5932_1249.t2 a_5516_7155.t10 vss.t2 vss.t1 nfet_03v3 w=1.16u l=4.25u ad=6.9600e-13 pd=3.5200e-06 as=3.2480e-13 ps=1.7200e-06 nf=1 m=2 par=2
XMpar10 a_2122_4944.t20 a_1342_4736.t0 vdd.t2 vdd.t1 pfet_03v3 w=3.15u l=3.9u ad=8.8200e-13 pd=3.7100e-06 as=1.1340e-12 ps=4.6575e-06 nf=1 m=8 par=8
XMpar11 a_5516_7155.t1 a_5516_7155.t0 a_5932_1249.t0 vss.t3 nfet_03v3 w=1.16u l=1.63u ad=6.9600e-13 pd=3.5200e-06 as=6.9600e-13 ps=3.5200e-06 nf=1 m=2 par=2
X40 out.t8 vss.t0 cap_mim_2f0fF c_width=17.43u c_length=17.43u
Rpar0 a_1342_4736.t0 a_1342_4736.t1 24.7560
Rpar1 a_1342_4736.t0 a_1342_4736.t4 121.5531
Rpar2 a_1342_4736.t1 a_1342_4736.t4 115.6494
Rpar3 a_2122_4944.t0 a_2122_4944.t20 60.0014
Rpar4 a_5070_7155.t0 a_5070_7155.t20 48.4019
Rpar5 a_5516_7155.t0 a_5516_7155.t1 24.5801
Rpar6 a_5516_7155.t0 a_5516_7155.t10 160.5428
Rpar7 a_5516_7155.t0 a_5516_7155.t4 382.2982
Rpar8 a_5516_7155.t1 a_5516_7155.t10 86.5328
Rpar9 a_5516_7155.t1 a_5516_7155.t4 206.0593
Rpar10 a_5516_7155.t10 a_5516_7155.t4 125.9686
Rpar11 a_5932_1249.t0 a_5932_1249.t2 64.3187
Rpar12 a_7558_3017.t0 a_7558_3017.t1 61.1522
Rpar13 a_8014_7155.t0 a_8014_7155.t20 48.4019
Rpar14 ib ib.t0 11.7368
Rpar15 ib ib.t1 7.4113
Rpar16 inn inn.t0 1.8834
Rpar17 inp inp.t0 1.8834
Rpar18 out out.t0 75.5699
Rpar19 out out.t4 76.0014
Rpar20 out out.t8 15.8869
Rpar21 out.t0 out.t4 239.3632
Rpar22 out.t0 out.t8 635.4517
Rpar23 out.t4 out.t8 639.0806
Rpar24 vdd vdd.t0 172.0332
Rpar25 vdd vdd.t1 419.5121
Rpar26 vdd vdd.t2 1161.0223
Rpar27 vdd vdd.t5 25.5630
Rpar28 vdd.t0 vdd.t1 45.1049
Rpar29 vdd.t0 vdd.t2 124.8303
Rpar30 vdd.t0 vdd.t5 87.9731
Rpar31 vdd.t1 vdd.t2 5.6093
Rpar32 vdd.t1 vdd.t5 214.5270
Rpar33 vdd.t2 vdd.t5 593.7150
Rpar34 vss vss.t0 113.6753
Rpar35 vss vss.t1 55.0560
Rpar36 vss vss.t2 464.7346
Rpar37 vss vss.t11 119.0980
Rpar38 vss vss.t12 181.7383
Rpar39 vss vss.t21 127.6183
Rpar40 vss vss.t3 229.3729
Rpar41 vss.t0 vss.t1 153.0177
Rpar42 vss.t0 vss.t2 1108.2645
Rpar43 vss.t0 vss.t11 1599.5769
Rpar44 vss.t0 vss.t12 2440.9019
Rpar45 vss.t0 vss.t21 193.8628
Rpar46 vss.t0 vss.t3 660.6911
Rpar47 vss.t1 vss.t2 11.7657
Rpar48 vss.t1 vss.t11 122.8535
Rpar49 vss.t1 vss.t12 187.4792
Rpar50 vss.t1 vss.t21 171.7863
Rpar51 vss.t1 vss.t3 5.1930
Rpar52 vss.t2 vss.t11 1246.9817
Rpar53 vss.t2 vss.t12 1902.9903
Rpar54 vss.t2 vss.t21 1244.2001
Rpar55 vss.t2 vss.t3 51.2245
Rpar56 vss.t11 vss.t12 15.2753
Rpar57 vss.t11 vss.t21 1795.7750
Rpar58 vss.t11 vss.t3 494.2400
Rpar59 vss.t12 vss.t21 2740.2938
Rpar60 vss.t12 vss.t3 754.2266
Rpar61 vss.t21 vss.t3 741.7290
Cpar0 a_1342_4736.t0 vss 3.06517e-14
Cpar1 a_1342_4736.t1 vss 4.16764e-15
Cpar2 a_1342_4736.t4 vss 2.36152e-15
Cpar3 a_2122_4944.t0 vss 3.89325e-14
Cpar4 a_2122_4944.t20 vss 1.22548e-14
Cpar5 a_5070_7155.t0 vss 2.44770e-14
Cpar6 a_5070_7155.t20 vss 5.50272e-15
Cpar7 a_5516_7155.t0 vss 2.29657e-15
Cpar8 a_5516_7155.t1 vss 1.52606e-15
Cpar9 a_5516_7155.t10 vss 5.38117e-15
Cpar10 a_5516_7155.t4 vss 2.67319e-15
Cpar11 a_5932_1249.t0 vss 2.51338e-15
Cpar12 a_5932_1249.t2 vss 3.23363e-15
Cpar13 a_7558_3017.t0 vss 3.62317e-15
Cpar14 a_7558_3017.t1 vss 3.76699e-15
Cpar15 a_8014_7155.t0 vss 2.39362e-14
Cpar16 a_8014_7155.t20 vss 5.38113e-15
Cpar17 ib vss 1.24626e-14
Cpar18 ib.t0 vss 1.50504e-15
Cpar19 ib.t1 vss 9.02200e-17
Cpar20 inn inp 2.07280e-16
Cpar21 inn vdd 2.05878e-14
Cpar22 inn vss 4.24923e-15
Cpar23 inn.t0 vss 2.92932e-14
Cpar24 inp vdd 2.08514e-14
Cpar25 inp vss 4.28053e-15
Cpar26 inp.t0 vss 2.94630e-14
Cpar27 out vdd 2.36037e-15
Cpar28 out vss 1.30100e-14
Cpar29 out.t0 vss 2.03160e-16
Cpar30 out.t4 vss 1.56605e-16
Cpar31 out.t8 vss 7.77001e-15
Cpar32 vdd vss 2.35338e-13
Cpar33 vdd.t0 vss 1.45464e-14
Cpar34 vdd.t1 vss 2.03886e-14
Cpar35 vdd.t2 vss 9.04476e-15
Cpar36 vdd.t5 vss 4.93971e-14
.ends opamp_dut

Vdd vdd 0 1.800000
Vss vss 0 0
Ibias vdd ib 4.000000e-07
Vinp inp 0 DC 0.805000 AC 1 PWL(0 0.805000 1.115329e-07 0.805000 1.226862e-07 0.815000)
Rfb out inn 1m
Cload out 0 2.000000e-12
Xdut vdd vss inp inn out ib opamp_dut
.end
