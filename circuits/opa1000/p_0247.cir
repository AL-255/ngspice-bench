* opa1000[0247]: 2p/folded_cascode_nmos_3v3_i150u_weak (folded_cascode_nmos, VDD=3.3V, CL=2.0pF, Iref=43.3333uA)
.include "pdk_opa.inc"
.temp 27
.option gmin=1e-12 rshunt=1e12 reltol=1e-3 abstol=1e-12 vntol=1e-5 method=gear
* Post-PEX R+C extracted netlist for folded_cascode_nmos_3v3_i150u_weak
.subckt opamp_dut vdd vss inp inn out ib
XMpar0 a_3634_1294.t0 inp.t0 a_3866_1294.t2 vss.t2 nfet_03v3 w=2.01u l=0.56u ad=5.9343e-13 pd=2.6962e-06 as=5.9343e-13 ps=2.6962e-06 nf=1 m=42 par=42
XMpar1 a_3634_1294.t42 ib.t0 vss.t1 vss.t0 nfet_03v3 w=4.79u l=0.81u ad=1.3412e-12 pd=5.3500e-06 as=1.3412e-12 ps=5.3500e-06 nf=1 m=12 par=12
XMpar2 a_3866_1294.t52 ib.t12 a_4956_4225.t12 vdd.t54 pfet_03v3 w=2u l=0.57u ad=6.1053e-13 pd=2.7684e-06 as=5.9368e-13 ps=2.6989e-06 nf=1 m=76 par=76
XMpar3 a_8654_1294.t0 a_1244_10217.t0 vdd.t1 vdd.t0 pfet_03v3 w=10u l=1.05u ad=2.8000e-12 pd=1.0560e-05 as=3.3333e-12 ps=1.2333e-05 nf=1 m=12 par=12
XMpar4 a_8654_1294.t11 ib.t12 out.t0 vdd.t54 pfet_03v3 w=2u l=0.57u ad=6.1053e-13 pd=2.7684e-06 as=5.9368e-13 ps=2.6989e-06 nf=1 m=76 par=76
XMpar5 a_4956_4225.t1 a_4956_4225.t0 vss.t1 vss.t0 nfet_03v3 w=4.79u l=0.81u ad=1.8521e-12 pd=7.1600e-06 as=1.3412e-12 ps=5.3500e-06 nf=1 m=6 par=6
XMpar6 a_3866_1294.t0 a_1244_10217.t0 vdd.t1 vdd.t0 pfet_03v3 w=10u l=1.05u ad=2.8000e-12 pd=1.0560e-05 as=3.3333e-12 ps=1.2333e-05 nf=1 m=12 par=12
XMpar7 a_1244_10217.t12 ib.t0 vss.t1 vss.t0 nfet_03v3 w=4.79u l=0.81u ad=1.3412e-12 pd=5.3500e-06 as=1.3412e-12 ps=5.3500e-06 nf=1 m=6 par=6
XMpar8 ib.t1 ib.t0 vss.t1 vss.t0 nfet_03v3 w=4.79u l=0.81u ad=1.8521e-12 pd=7.1600e-06 as=1.3412e-12 ps=5.3500e-06 nf=1 m=6 par=6
XMpar9 a_1244_10217.t1 a_1244_10217.t0 vdd.t1 vdd.t0 pfet_03v3 w=10u l=1.05u ad=2.8000e-12 pd=1.0560e-05 as=3.8667e-12 ps=1.4107e-05 nf=1 m=6 par=6
XMpar10 out.t76 a_4956_4225.t0 vss.t1 vss.t0 nfet_03v3 w=4.79u l=0.81u ad=1.3412e-12 pd=5.3500e-06 as=1.3412e-12 ps=5.3500e-06 nf=1 m=6 par=6
XMpar11 a_3634_1294.t0 inn.t0 a_8654_1294.t87 vss.t2 nfet_03v3 w=2.01u l=0.56u ad=5.9343e-13 pd=2.6962e-06 as=5.9343e-13 ps=2.6962e-06 nf=1 m=42 par=42
X90 out.t82 vss.t23 cap_mim_2f0fF c_width=17.43u c_length=17.43u
Rpar0 a_1244_10217.t0 a_1244_10217.t1 16.8500
Rpar1 a_1244_10217.t0 a_1244_10217.t12 74.5775
Rpar2 a_1244_10217.t1 a_1244_10217.t12 118.1163
Rpar3 a_3634_1294.t0 a_3634_1294.t42 71.5843
Rpar4 a_3866_1294.t0 a_3866_1294.t2 173.6003
Rpar5 a_3866_1294.t0 a_3866_1294.t52 80.3386
Rpar6 a_3866_1294.t2 a_3866_1294.t52 42.4049
Rpar7 a_4956_4225.t0 a_4956_4225.t1 16.1696
Rpar8 a_4956_4225.t0 a_4956_4225.t12 455.2561
Rpar9 a_4956_4225.t1 a_4956_4225.t12 77.4613
Rpar10 a_8654_1294.t0 a_8654_1294.t87 173.6003
Rpar11 a_8654_1294.t0 a_8654_1294.t11 80.3386
Rpar12 a_8654_1294.t87 a_8654_1294.t11 42.4049
Rpar13 ib ib.t0 12.0308
Rpar14 ib ib.t1 2.8437
Rpar15 ib ib.t12 62.8638
Rpar16 inn inn.t0 2.0312
Rpar17 inp inp.t0 2.0312
Rpar18 out out.t0 89.3822
Rpar19 out out.t76 63.8534
Rpar20 out out.t82 15.8992
Rpar21 out.t0 out.t76 132.1480
Rpar22 out.t0 out.t82 751.5971
Rpar23 out.t76 out.t82 536.9303
Rpar24 vdd vdd.t0 156.6719
Rpar25 vdd vdd.t1 59.7110
Rpar26 vdd vdd.t54 311.5816
Rpar27 vdd.t0 vdd.t1 2.8103
Rpar28 vdd.t0 vdd.t54 68.9076
Rpar29 vdd.t1 vdd.t54 105.2289
Rpar30 vss vss.t0 786.5140
Rpar31 vss vss.t1 2238.1390
Rpar32 vss vss.t2 45.1082
Rpar33 vss vss.t23 9696.5185
Rpar34 vss.t0 vss.t1 2.1599
Rpar35 vss.t0 vss.t2 109.5570
Rpar36 vss.t0 vss.t23 69.4371
Rpar37 vss.t1 vss.t2 314.7421
Rpar38 vss.t1 vss.t23 243.4505
Rpar39 vss.t2 vss.t23 1376.0000
Cpar0 a_1244_10217.t0 vss 4.12799e-14
Cpar1 a_1244_10217.t1 vss 8.23041e-15
Cpar2 a_1244_10217.t12 vss 6.11563e-15
Cpar3 a_3634_1294.t0 vss 4.50356e-14
Cpar4 a_3634_1294.t42 vss 1.65975e-14
Cpar5 a_3866_1294.t0 vss 2.85869e-14
Cpar6 a_3866_1294.t2 vss 2.72230e-14
Cpar7 a_3866_1294.t52 vss 4.72420e-14
Cpar8 a_4956_4225.t0 vss 1.31165e-14
Cpar9 a_4956_4225.t1 vss 1.21465e-14
Cpar10 a_4956_4225.t12 vss 4.24136e-14
Cpar11 a_8654_1294.t0 vss 2.77666e-14
Cpar12 a_8654_1294.t11 vss 4.58861e-14
Cpar13 a_8654_1294.t87 vss 2.64417e-14
Cpar14 ib inn 1.77400e-17
Cpar15 ib inp 1.77400e-17
Cpar16 ib out 1.34195e-14
Cpar17 ib vdd 5.91559e-14
Cpar18 ib vss 3.67205e-14
Cpar19 ib.t0 vss 2.23970e-14
Cpar20 ib.t1 vss 5.98816e-15
Cpar21 ib.t12 vss 7.81506e-14
Cpar22 inn inp 1.03960e-16
Cpar23 inn vdd 1.28300e-17
Cpar24 inn vss 2.01297e-14
Cpar25 inn.t0 vss 7.49469e-15
Cpar26 inp vdd 1.28300e-17
Cpar27 inp vss 1.99529e-14
Cpar28 inp.t0 vss 7.49766e-15
Cpar29 out vdd 8.52823e-15
Cpar30 out vss 2.10712e-14
Cpar31 out.t0 vss 1.66047e-14
Cpar32 out.t76 vss 3.31082e-15
Cpar33 out.t82 vss 4.41099e-14
Cpar34 vdd vss 3.05871e-13
Cpar35 vdd.t0 vss 5.00530e-14
Cpar36 vdd.t1 vss 2.11623e-14
Cpar37 vdd.t54 vss 8.00133e-14
.ends opamp_dut

Vdd vdd 0 3.300000
Vss vss 0 0
Ibias vdd ib 4.333330e-05
Vinp inp 0 DC 1.810000 AC 1 PWL(0 1.810000 3.000000e-09 1.810000 3.300000e-09 1.820000)
Rfb out inn 1m
Cload out 0 2.000000e-12
Xdut vdd vss inp inn out ib opamp_dut
.end
