* opa1000[0198]: 200f/folded_cascode_nmos_3v3_1u_10u_subth (folded_cascode_nmos, VDD=3.3V, CL=0.2pF, Iref=1.1667uA)
.include "pdk_opa.inc"
.temp 27
.option gmin=1e-12 rshunt=1e12 reltol=1e-3 abstol=1e-12 vntol=1e-5 method=gear
* Post-PEX R+C extracted netlist for folded_cascode_nmos_3v3_1u_10u_subth
.subckt opamp_dut vdd vss inp inn out ib
XMpar0 a_2326_1249.t0 inp.t0 a_2866_5858.t4 vss.t6 nfet_03v3 w=2.05u l=1u ad=6.4689e-13 pd=2.9089e-06 as=6.4689e-13 ps=2.9089e-06 nf=1 m=18 par=18
XMpar1 a_1292_7451.t1 a_1292_7451.t0 vdd.t1 vdd.t0 pfet_03v3 w=8.49u l=1.63u ad=2.3772e-12 pd=9.0500e-06 as=5.0940e-12 ps=1.8180e-05 nf=1 m=2 par=2
XMpar2 a_2326_1249.t36 ib.t0 vss.t1 vss.t0 nfet_03v3 w=3.22u l=2u ad=9.0160e-13 pd=3.7800e-06 as=9.0160e-13 ps=3.7800e-06 nf=1 m=4 par=4
XMpar3 a_2326_1249.t0 inn.t0 a_6894_5858.t4 vss.t6 nfet_03v3 w=2.05u l=1u ad=6.4689e-13 pd=2.9089e-06 as=6.4689e-13 ps=2.9089e-06 nf=1 m=18 par=18
XMpar4 a_2866_5858.t22 ib.t10 a_3106_5858.t0 vdd.t10 pfet_03v3 w=1.9u l=0.6u ad=6.0800e-13 pd=2.7775e-06 as=5.3200e-13 ps=2.4600e-06 nf=1 m=16 par=16
XMpar5 a_6894_5858.t22 ib.t10 out.t0 vdd.t10 pfet_03v3 w=1.9u l=0.6u ad=6.0800e-13 pd=2.7775e-06 as=5.3200e-13 ps=2.4600e-06 nf=1 m=16 par=16
XMpar6 ib.t1 ib.t0 vss.t1 vss.t0 nfet_03v3 w=3.22u l=2u ad=1.9320e-12 pd=7.6400e-06 as=9.0160e-13 ps=3.7800e-06 nf=1 m=2 par=2
XMpar7 a_6894_5858.t0 a_1292_7451.t0 vdd.t1 vdd.t0 pfet_03v3 w=8.49u l=1.63u ad=2.3772e-12 pd=9.0500e-06 as=3.7356e-12 ps=1.3615e-05 nf=1 m=4 par=4
XMpar8 a_2866_5858.t0 a_1292_7451.t0 vdd.t1 vdd.t0 pfet_03v3 w=8.49u l=1.63u ad=2.3772e-12 pd=9.0500e-06 as=3.7356e-12 ps=1.3615e-05 nf=1 m=4 par=4
XMpar9 a_3106_5858.t17 a_3106_5858.t16 vss.t1 vss.t0 nfet_03v3 w=3.22u l=2u ad=1.9320e-12 pd=7.6400e-06 as=9.0160e-13 ps=3.7800e-06 nf=1 m=2 par=2
XMpar10 out.t10 a_3106_5858.t16 vss.t1 vss.t0 nfet_03v3 w=3.22u l=2u ad=9.0160e-13 pd=3.7800e-06 as=9.0160e-13 ps=3.7800e-06 nf=1 m=2 par=2
XMpar11 a_1292_7451.t4 ib.t0 vss.t1 vss.t0 nfet_03v3 w=3.22u l=2u ad=9.0160e-13 pd=3.7800e-06 as=9.0160e-13 ps=3.7800e-06 nf=1 m=2 par=2
X72 out.t18 vss.t40 cap_mim_2f0fF c_width=12.2u c_length=12.2u
Rpar0 a_1292_7451.t0 a_1292_7451.t1 24.3691
Rpar1 a_1292_7451.t0 a_1292_7451.t4 87.6497
Rpar2 a_1292_7451.t1 a_1292_7451.t4 387.2243
Rpar3 a_2326_1249.t0 a_2326_1249.t36 64.8870
Rpar4 a_2866_5858.t0 a_2866_5858.t4 80.5531
Rpar5 a_2866_5858.t0 a_2866_5858.t22 80.1748
Rpar6 a_2866_5858.t4 a_2866_5858.t22 113.6996
Rpar7 a_3106_5858.t0 a_3106_5858.t16 302.9935
Rpar8 a_3106_5858.t0 a_3106_5858.t17 86.0445
Rpar9 a_3106_5858.t16 a_3106_5858.t17 18.2928
Rpar10 a_6894_5858.t0 a_6894_5858.t4 80.5531
Rpar11 a_6894_5858.t0 a_6894_5858.t22 80.1748
Rpar12 a_6894_5858.t4 a_6894_5858.t22 113.6996
Rpar13 ib ib.t0 247.2276
Rpar14 ib ib.t1 86.3883
Rpar15 ib ib.t10 1.5162
Rpar16 ib.t0 ib.t1 16.9853
Rpar17 inn inn.t0 2.2226
Rpar18 inp inp.t0 2.2226
Rpar19 out out.t0 65.3873
Rpar20 out out.t10 72.7616
Rpar21 out out.t18 15.3336
Rpar22 out.t0 out.t10 118.1198
Rpar23 out.t0 out.t18 743.6643
Rpar24 out.t10 out.t18 827.5335
Rpar25 vdd vdd.t0 299.2065
Rpar26 vdd vdd.t1 142.6018
Rpar27 vdd vdd.t10 170.1149
Rpar28 vdd.t0 vdd.t1 3.9732
Rpar29 vdd.t0 vdd.t10 127.5091
Rpar30 vdd.t1 vdd.t10 62.8623
Rpar31 vss vss.t0 46.9833
Rpar32 vss vss.t1 76.7894
Rpar33 vss vss.t6 346.9230
Rpar34 vss vss.t40 79.8650
Rpar35 vss.t0 vss.t1 4.0362
Rpar36 vss.t0 vss.t6 124.9434
Rpar37 vss.t0 vss.t40 191.1965
Rpar38 vss.t1 vss.t6 192.0851
Rpar39 vss.t1 vss.t40 312.4915
Rpar40 vss.t6 vss.t40 1411.7893
Cpar0 a_1292_7451.t0 vss 2.23214e-14
Cpar1 a_1292_7451.t1 vss 4.18496e-15
Cpar2 a_1292_7451.t4 vss 4.42575e-15
Cpar3 a_2326_1249.t0 vss 2.10135e-14
Cpar4 a_2326_1249.t36 vss 6.96348e-15
Cpar5 a_2866_5858.t0 vss 9.07997e-15
Cpar6 a_2866_5858.t22 vss 1.00495e-14
Cpar7 a_2866_5858.t4 vss 1.43174e-14
Cpar8 a_3106_5858.t0 vss 6.20234e-15
Cpar9 a_3106_5858.t16 vss 5.49607e-15
Cpar10 a_3106_5858.t17 vss 3.59072e-15
Cpar11 a_6894_5858.t0 vss 7.90492e-15
Cpar12 a_6894_5858.t22 vss 8.74895e-15
Cpar13 a_6894_5858.t4 vss 1.24645e-14
Cpar14 ib out 1.28000e-15
Cpar15 ib vdd 1.55978e-14
Cpar16 ib vss 2.35234e-14
Cpar17 ib.t0 vss 1.05218e-14
Cpar18 ib.t1 vss 3.66616e-15
Cpar19 ib.t10 vss 7.12774e-15
Cpar20 inn inp 1.03520e-16
Cpar21 inn vdd 6.57100e-17
Cpar22 inn vss 1.26095e-14
Cpar23 inn.t0 vss 4.63296e-15
Cpar24 inp vdd 7.69600e-17
Cpar25 inp vss 1.24994e-14
Cpar26 inp.t0 vss 4.64302e-15
Cpar27 out vdd 3.24963e-15
Cpar28 out vss 1.05514e-14
Cpar29 out.t0 vss 1.93883e-15
Cpar30 out.t10 vss 7.00460e-16
Cpar31 out.t18 vss 1.27762e-14
Cpar32 vdd vss 1.12587e-13
Cpar33 vdd.t0 vss 1.92201e-14
Cpar34 vdd.t1 vss 1.23215e-14
Cpar35 vdd.t10 vss 1.94342e-14
.ends opamp_dut

Vdd vdd 0 3.300000
Vss vss 0 0
Ibias vdd ib 1.166700e-06
Vinp inp 0 DC 1.810000 AC 1 PWL(0 1.810000 1.240346e-08 1.810000 1.364380e-08 1.820000)
Rfb out inn 1m
Cload out 0 2.000000e-13
Xdut vdd vss inp inn out ib opamp_dut
.end
