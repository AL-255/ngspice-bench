* opa1000[0326]: 2p/folded_cascode_pmos_3v3_i20u_subth (folded_cascode_pmos, VDD=3.3V, CL=2.0pF, Iref=5.7778uA)
.include "pdk_opa.inc"
.temp 27
.option gmin=1e-12 rshunt=1e12 reltol=1e-3 abstol=1e-12 vntol=1e-5 method=gear
* Post-PEX R+C extracted netlist for folded_cascode_pmos_3v3_i20u_subth
.subckt opamp_dut vdd vss inp inn out ib
XMpar0 a_1720_11360.t4 inp.t0 a_1976_14940.t20 vdd.t6 pfet_03v3 w=8u l=0.39u ad=2.4000e-12 pd=9.1000e-06 as=2.2400e-12 ps=8.5600e-06 nf=1 m=64 par=64
XMpar1 a_8174_1249.t0 a_1382_11152.t6 out.t0 vss.t0 nfet_03v3 w=1.82u l=0.6u ad=6.5520e-13 pd=2.9950e-06 as=5.0960e-13 ps=2.3800e-06 nf=1 m=16 par=16
XMpar2 out.t6 a_6242_1249.t14 vdd.t1 vdd.t0 pfet_03v3 w=10u l=1.69u ad=2.8000e-12 pd=1.0560e-05 as=2.8000e-12 ps=1.0560e-05 nf=1 m=2 par=2
XMpar3 a_1720_11360.t4 inn.t0 a_8174_1249.t20 vdd.t6 pfet_03v3 w=8u l=0.39u ad=2.4000e-12 pd=9.1000e-06 as=2.2400e-12 ps=8.5600e-06 nf=1 m=64 par=64
XMpar4 a_8174_1249.t16 ib.t0 vss.t4 vss.t3 nfet_03v3 w=10u l=1.5u ad=2.8000e-12 pd=1.0560e-05 as=4.4000e-12 ps=1.5880e-05 nf=1 m=4 par=4
XMpar5 a_1976_14940.t16 ib.t0 vss.t4 vss.t3 nfet_03v3 w=10u l=1.5u ad=2.8000e-12 pd=1.0560e-05 as=4.4000e-12 ps=1.5880e-05 nf=1 m=4 par=4
XMpar6 a_6242_1249.t15 a_6242_1249.t14 vdd.t1 vdd.t0 pfet_03v3 w=10u l=1.69u ad=6.0000e-12 pd=2.1200e-05 as=2.8000e-12 ps=1.0560e-05 nf=1 m=2 par=2
XMpar7 a_1382_11152.t4 ib.t0 vss.t4 vss.t3 nfet_03v3 w=10u l=1.5u ad=2.8000e-12 pd=1.0560e-05 as=2.8000e-12 ps=1.0560e-05 nf=1 m=2 par=2
XMpar8 a_1720_11360.t0 a_1382_11152.t0 vdd.t1 vdd.t0 pfet_03v3 w=10u l=1.69u ad=2.8000e-12 pd=1.0560e-05 as=4.4000e-12 ps=1.5880e-05 nf=1 m=4 par=4
XMpar9 a_1976_14940.t0 a_1382_11152.t6 a_6242_1249.t0 vss.t0 nfet_03v3 w=1.82u l=0.6u ad=6.5520e-13 pd=2.9950e-06 as=5.0960e-13 ps=2.3800e-06 nf=1 m=16 par=16
XMpar10 a_1382_11152.t1 a_1382_11152.t0 vdd.t1 vdd.t0 pfet_03v3 w=10u l=1.69u ad=2.8000e-12 pd=1.0560e-05 as=2.8000e-12 ps=1.0560e-05 nf=1 m=2 par=2
XMpar11 ib.t1 ib.t0 vss.t4 vss.t3 nfet_03v3 w=10u l=1.5u ad=6.0000e-12 pd=2.1200e-05 as=2.8000e-12 ps=1.0560e-05 nf=1 m=2 par=2
X181 out.t18 vss.t40 cap_mim_2f0fF c_width=7.75u c_length=7.75u
Rpar0 a_1382_11152.t0 a_1382_11152.t1 26.4955
Rpar1 a_1382_11152.t0 a_1382_11152.t6 398.6995
Rpar2 a_1382_11152.t0 a_1382_11152.t4 414.8829
Rpar3 a_1382_11152.t1 a_1382_11152.t6 132.4570
Rpar4 a_1382_11152.t1 a_1382_11152.t4 137.8335
Rpar5 a_1382_11152.t6 a_1382_11152.t4 87.0280
Rpar6 a_1720_11360.t0 a_1720_11360.t4 46.7812
Rpar7 a_1976_14940.t0 a_1976_14940.t16 62.5723
Rpar8 a_1976_14940.t0 a_1976_14940.t20 200.0708
Rpar9 a_1976_14940.t16 a_1976_14940.t20 69.1334
Rpar10 a_6242_1249.t0 a_6242_1249.t14 250.4047
Rpar11 a_6242_1249.t0 a_6242_1249.t15 45.2164
Rpar12 a_6242_1249.t14 a_6242_1249.t15 23.9274
Rpar13 a_8174_1249.t0 a_8174_1249.t16 62.5723
Rpar14 a_8174_1249.t0 a_8174_1249.t20 200.0708
Rpar15 a_8174_1249.t16 a_8174_1249.t20 69.1334
Rpar16 ib ib.t0 14.6747
Rpar17 ib ib.t1 3.4165
Rpar18 ib.t0 ib.t1 234.2308
Rpar19 inn inn.t0 3.0707
Rpar20 inp inp.t0 3.0707
Rpar21 out out.t0 74.5480
Rpar22 out out.t6 7.0152
Rpar23 out out.t18 139.3200
Rpar24 out.t0 out.t6 514.6238
Rpar25 out.t0 out.t18 93.0765
Rpar26 out.t6 out.t18 961.7619
Rpar27 vdd vdd.t0 110.6594
Rpar28 vdd vdd.t1 276.9803
Rpar29 vdd vdd.t6 23.0103
Rpar30 vdd.t0 vdd.t1 3.8446
Rpar31 vdd.t0 vdd.t6 324.4545
Rpar32 vdd.t1 vdd.t6 812.1091
Rpar33 vss vss.t0 244.5345
Rpar34 vss vss.t4 225.6482
Rpar35 vss vss.t3 68.9820
Rpar36 vss vss.t40 77.7348
Rpar37 vss.t0 vss.t4 136.5380
Rpar38 vss.t0 vss.t3 41.7502
Rpar39 vss.t0 vss.t40 510.2201
Rpar40 vss.t4 vss.t3 3.6914
Rpar41 vss.t4 vss.t40 470.8139
Rpar42 vss.t3 vss.t40 143.9306
Cpar0 a_1382_11152.t0 vss 1.23889e-14
Cpar1 a_1382_11152.t1 vss 4.34600e-15
Cpar2 a_1382_11152.t4 vss 3.36363e-15
Cpar3 a_1382_11152.t6 vss 1.16512e-14
Cpar4 a_1720_11360.t0 vss 1.16004e-14
Cpar5 a_1720_11360.t4 vss 2.33182e-13
Cpar6 a_1976_14940.t0 vss 1.05283e-14
Cpar7 a_1976_14940.t16 vss 1.62853e-14
Cpar8 a_1976_14940.t20 vss 1.17660e-13
Cpar9 a_6242_1249.t0 vss 5.37730e-15
Cpar10 a_6242_1249.t14 vss 1.21958e-14
Cpar11 a_6242_1249.t15 vss 8.87824e-15
Cpar12 a_8174_1249.t0 vss 1.00618e-14
Cpar13 a_8174_1249.t16 vss 1.55639e-14
Cpar14 a_8174_1249.t20 vss 1.12448e-13
Cpar15 ib out 6.88800e-17
Cpar16 ib vdd 9.07000e-17
Cpar17 ib vss 2.51437e-14
Cpar18 ib.t0 vss 5.30738e-15
Cpar19 ib.t1 vss 8.16691e-16
Cpar20 inn inp 1.05180e-16
Cpar21 inn vdd 2.24553e-14
Cpar22 inn vss 1.16860e-14
Cpar23 inn.t0 vss 3.55023e-14
Cpar24 inp vdd 2.25287e-14
Cpar25 inp vss 1.16576e-14
Cpar26 inp.t0 vss 3.55934e-14
Cpar27 out vdd 2.68784e-15
Cpar28 out vss 1.36425e-14
Cpar29 out.t0 vss 3.61082e-15
Cpar30 out.t18 vss 1.17047e-14
Cpar31 out.t6 vss 1.52877e-15
Cpar32 vdd vss 3.09834e-13
Cpar33 vdd.t0 vss 1.94149e-14
Cpar34 vdd.t1 vss 9.44514e-15
Cpar35 vdd.t6 vss 7.23498e-14
.ends opamp_dut

Vdd vdd 0 3.300000
Vss vss 0 0
Ibias vdd ib 5.777800e-06
Vinp inp 0 DC 1.381000 AC 1 PWL(0 1.381000 9.463198e-09 1.381000 1.040952e-08 1.391000)
Rfb out inn 1m
Cload out 0 2.000000e-12
Xdut vdd vss inp inn out ib opamp_dut
.end
