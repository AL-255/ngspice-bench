* opa1000[0015]: 200f/cherry_hooper_1v8_10u_100u_weak (cherry_hooper, VDD=1.8V, CL=0.2pF, Iref=3.5714uA)
.include "pdk_opa.inc"
.temp 27
.option gmin=1e-12 rshunt=1e12 reltol=1e-3 abstol=1e-12 vntol=1e-5 method=gear
* Post-PEX R+C extracted netlist for cherry_hooper_1v8_10u_100u_weak
.subckt opamp_dut vdd vss inp inn out ib
XMpar0 a_10684_11168.t4 a_10684_11168.t3 vdd.t0 vdd.t0 pfet_03v3 w=9.48u l=0.32u ad=2.7668e-12 pd=1.0415e-05 as=2.7668e-12 ps=1.0415e-05 nf=1 m=27 par=27
XMpar1 a_1129_4566.t18 a_1249_4358.t2 a_1249_4358.t3 vdd.t10 pfet_03v3 w=10u l=0.32u ad=3.2000e-12 pd=1.1890e-05 as=2.8000e-12 ps=1.0560e-05 nf=1 m=16 par=16
XMpar2 a_6366_11376.t0 ib.t0 vss.t1 vss.t0 nfet_03v3 w=8.95u l=0.5u ad=2.5060e-12 pd=9.5100e-06 as=3.2220e-12 ps=1.1907e-05 nf=1 m=8 par=8
XMpar3 ib.t1 ib.t0 vss.t1 vss.t0 nfet_03v3 w=8.95u l=0.5u ad=5.3700e-12 pd=1.9100e-05 as=3.9380e-12 ps=1.4305e-05 nf=1 m=2 par=2
XMpar4 a_5352_8050.t0 ib.t0 vss.t1 vss.t0 nfet_03v3 w=8.95u l=0.5u ad=2.5060e-12 pd=9.5100e-06 as=2.9833e-12 ps=1.1108e-05 nf=1 m=12 par=12
XMpar5 a_6366_11376.t8 a_10684_11168.t57 out.t5 vss.t60 nfet_03v3 w=8.08u l=0.4u ad=4.8480e-12 pd=1.7360e-05 as=4.8480e-12 ps=1.7360e-05 nf=1 m=1
XMpar6 a_1129_4566.t1 a_1129_4566.t0 vdd.t0 vdd.t0 pfet_03v3 w=9.48u l=0.32u ad=2.9915e-12 pd=1.1164e-05 as=2.9915e-12 ps=1.1164e-05 nf=1 m=9 par=9
XMpar7 a_6023_4566.t3 a_6023_4566.t2 vdd.t186 vdd.t185 pfet_03v3 w=3.95u l=0.5u ad=2.3700e-12 pd=9.1000e-06 as=2.3700e-12 ps=9.1000e-06 nf=1 m=1
XMpar8 a_2521_1041.t3 a_2521_1041.t2 vdd.t0 vdd.t0 pfet_03v3 w=9.48u l=0.32u ad=2.7668e-12 pd=1.0415e-05 as=2.7668e-12 ps=1.0415e-05 nf=1 m=27 par=27
XMpar9 a_6023_4566.t0 ib.t0 vss.t1 vss.t0 nfet_03v3 w=8.95u l=0.5u ad=5.3700e-12 pd=1.9100e-05 as=2.5060e-12 ps=9.5100e-06 nf=1 m=2 par=2
XMpar10 out.t0 a_7508_14377.t0 vdd.t0 vdd.t0 pfet_03v3 w=9.48u l=0.32u ad=2.9915e-12 pd=1.1164e-05 as=2.6544e-12 ps=1.0040e-05 nf=1 m=18 par=18
XMpar11 a_9994_8445.t3 a_6023_4566.t2 vdd.t186 vdd.t185 pfet_03v3 w=3.95u l=0.5u ad=2.3700e-12 pd=9.1000e-06 as=2.3700e-12 ps=9.1000e-06 nf=1 m=1
XMpar12 a_2521_1041.t56 a_1249_4358.t34 a_9994_8445.t2 vdd.t125 pfet_03v3 w=7.13u l=0.32u ad=4.2780e-12 pd=1.5460e-05 as=4.2780e-12 ps=1.5460e-05 nf=1 m=1
XMpar13 a_6366_11376.t8 a_2521_1041.t57 a_7508_14377.t36 vss.t60 nfet_03v3 w=8.08u l=0.4u ad=4.8480e-12 pd=1.7360e-05 as=4.8480e-12 ps=1.7360e-05 nf=1 m=1
XMpar14 a_7508_14377.t1 a_7508_14377.t0 vdd.t0 vdd.t0 pfet_03v3 w=9.48u l=0.32u ad=2.6544e-12 pd=1.0040e-05 as=2.6544e-12 ps=1.0040e-05 nf=1 m=18 par=18
XMpar15 a_5776_8050.t4 inp.t0 a_9994_8445.t0 vss.t63 nfet_03v3 w=2.28u l=0.48u ad=1.3680e-12 pd=5.7600e-06 as=6.3840e-13 ps=2.8400e-06 nf=1 m=2 par=2
XMpar16 a_10684_11168.t0 a_10574_1294.t4 a_5352_8050.t12 vss.t60 nfet_03v3 w=6.06u l=0.4u ad=1.6968e-12 pd=6.6200e-06 as=3.6360e-12 ps=1.3320e-05 nf=1 m=1
XMpar17 a_2521_1041.t0 a_9994_8445.t4 a_5352_8050.t12 vss.t60 nfet_03v3 w=6.06u l=0.4u ad=1.6968e-12 pd=6.6200e-06 as=3.6360e-12 ps=1.3320e-05 nf=1 m=1
XMpar18 a_1249_4358.t0 ib.t0 vss.t1 vss.t0 nfet_03v3 w=8.95u l=0.5u ad=2.5060e-12 pd=9.5100e-06 as=3.9380e-12 ps=1.4305e-05 nf=1 m=2 par=2
XMpar19 a_10574_1294.t0 inn.t0 a_5776_8050.t4 vss.t63 nfet_03v3 w=2.28u l=0.48u ad=6.3840e-13 pd=2.8400e-06 as=1.3680e-12 ps=5.7600e-06 nf=1 m=2 par=2
XMpar20 a_10574_1294.t3 a_6023_4566.t2 vdd.t186 vdd.t185 pfet_03v3 w=3.95u l=0.5u ad=2.3700e-12 pd=9.1000e-06 as=2.3700e-12 ps=9.1000e-06 nf=1 m=1
XMpar21 a_5776_8050.t0 ib.t0 vss.t1 vss.t0 nfet_03v3 w=8.95u l=0.5u ad=2.5060e-12 pd=9.5100e-06 as=2.5060e-12 ps=9.5100e-06 nf=1 m=4 par=4
XMpar22 a_10684_11168.t0 a_10574_1294.t4 a_5352_8050.t12 vss.t61 nfet_03v3 w=6.06u l=0.4u ad=1.6968e-12 pd=6.6200e-06 as=3.6360e-12 ps=1.3320e-05 nf=1 m=1
XMpar23 a_2521_1041.t0 a_9994_8445.t4 a_5352_8050.t12 vss.t61 nfet_03v3 w=6.06u l=0.4u ad=1.6968e-12 pd=6.6200e-06 as=3.6360e-12 ps=1.3320e-05 nf=1 m=1
XMpar24 a_10574_1294.t2 a_1249_4358.t34 a_10684_11168.t2 vdd.t125 pfet_03v3 w=7.13u l=0.32u ad=4.2780e-12 pd=1.5460e-05 as=4.2780e-12 ps=1.5460e-05 nf=1 m=1
X56 out.t19 vss.t67 cap_mim_2f0fF c_width=20u c_length=20u
X57 out.t19 vss.t67 cap_mim_2f0fF c_width=20u c_length=20u
X97 out.t19 vss.t67 cap_mim_2f0fF c_width=20u c_length=20u
X100 out.t19 vss.t67 cap_mim_2f0fF c_width=20u c_length=20u
X129 out.t19 vss.t67 cap_mim_2f0fF c_width=20u c_length=20u
X130 out.t19 vss.t67 cap_mim_2f0fF c_width=20u c_length=20u
Rpar0 a_10574_1294.t0 a_10574_1294.t2 118.4024
Rpar1 a_10574_1294.t0 a_10574_1294.t3 70.7833
Rpar2 a_10574_1294.t0 a_10574_1294.t4 124.6927
Rpar3 a_10574_1294.t2 a_10574_1294.t3 61.7357
Rpar4 a_10574_1294.t2 a_10574_1294.t4 407.2624
Rpar5 a_10574_1294.t3 a_10574_1294.t4 243.4697
Rpar6 a_10684_11168.t0 a_10684_11168.t4 155.9187
Rpar7 a_10684_11168.t0 a_10684_11168.t3 6352.8875
Rpar8 a_10684_11168.t0 a_10684_11168.t2 131.6905
Rpar9 a_10684_11168.t0 a_10684_11168.t57 173.8538
Rpar10 a_10684_11168.t4 a_10684_11168.t3 17.6897
Rpar11 a_10684_11168.t4 a_10684_11168.t2 73.4291
Rpar12 a_10684_11168.t4 a_10684_11168.t57 1197.9538
Rpar13 a_10684_11168.t3 a_10684_11168.t2 2991.8571
Rpar14 a_10684_11168.t2 a_10684_11168.t57 1011.8033
Rpar15 a_1129_4566.t0 a_1129_4566.t1 30.7668
Rpar16 a_1129_4566.t0 a_1129_4566.t18 423.8764
Rpar17 a_1129_4566.t1 a_1129_4566.t18 25.8911
Rpar18 a_1249_4358.t0 a_1249_4358.t2 1198.9066
Rpar19 a_1249_4358.t0 a_1249_4358.t3 41.6758
Rpar20 a_1249_4358.t0 a_1249_4358.t34 295.9704
Rpar21 a_1249_4358.t2 a_1249_4358.t3 22.2739
Rpar22 a_1249_4358.t2 a_1249_4358.t34 6360.5789
Rpar23 a_1249_4358.t3 a_1249_4358.t34 221.1035
Rpar24 a_2521_1041.t0 a_2521_1041.t2 12220.8983
Rpar25 a_2521_1041.t0 a_2521_1041.t3 299.9371
Rpar26 a_2521_1041.t0 a_2521_1041.t56 233.6535
Rpar27 a_2521_1041.t0 a_2521_1041.t57 160.7735
Rpar28 a_2521_1041.t2 a_2521_1041.t3 17.7037
Rpar29 a_2521_1041.t2 a_2521_1041.t56 2168.3318
Rpar30 a_2521_1041.t3 a_2521_1041.t56 53.2173
Rpar31 a_2521_1041.t3 a_2521_1041.t57 1647.8030
Rpar32 a_2521_1041.t56 a_2521_1041.t57 1283.6520
Rpar33 a_5352_8050.t0 a_5352_8050.t12 32.0831
Rpar34 a_5776_8050.t0 a_5776_8050.t4 47.0826
Rpar35 a_6023_4566.t0 a_6023_4566.t2 119.8578
Rpar36 a_6023_4566.t0 a_6023_4566.t3 119.6174
Rpar37 a_6023_4566.t2 a_6023_4566.t3 44.4961
Rpar38 a_6366_11376.t0 a_6366_11376.t8 43.9094
Rpar39 a_7508_14377.t0 a_7508_14377.t1 18.3440
Rpar40 a_7508_14377.t0 a_7508_14377.t36 542.9196
Rpar41 a_7508_14377.t1 a_7508_14377.t36 80.3824
Rpar42 a_9994_8445.t0 a_9994_8445.t2 135.9169
Rpar43 a_9994_8445.t0 a_9994_8445.t3 89.8593
Rpar44 a_9994_8445.t0 a_9994_8445.t4 112.4222
Rpar45 a_9994_8445.t2 a_9994_8445.t3 77.3860
Rpar46 a_9994_8445.t2 a_9994_8445.t4 461.0051
Rpar47 a_9994_8445.t3 a_9994_8445.t4 304.7864
Rpar48 ib ib.t0 9.3487
Rpar49 ib ib.t1 115.4945
Rpar50 ib.t0 ib.t1 21.4746
Rpar51 inn inn.t0 29.4362
Rpar52 inp inp.t0 29.4849
Rpar53 out out.t0 1.6591
Rpar54 out out.t19 98.2725
Rpar55 out out.t5 68.9878
Rpar56 out.t19 out.t5 302.7949
Rpar57 vdd vdd.t0 84.5966
Rpar58 vdd vdd.t185 1966.5710
Rpar59 vdd vdd.t186 791.3086
Rpar60 vdd.t0 vdd.t10 144.7343
Rpar61 vdd.t0 vdd.t125 106.6950
Rpar62 vdd.t0 vdd.t185 129.1795
Rpar63 vdd.t0 vdd.t186 44.3525
Rpar64 vdd.t10 vdd.t125 164.2532
Rpar65 vdd.t10 vdd.t185 776.1865
Rpar66 vdd.t10 vdd.t186 182.0327
Rpar67 vdd.t125 vdd.t185 572.1878
Rpar68 vdd.t125 vdd.t186 134.1905
Rpar69 vdd.t185 vdd.t186 13.1884
Rpar70 vss vss.t0 57.4839
Rpar71 vss vss.t1 114.5278
Rpar72 vss vss.t60 177.7209
Rpar73 vss vss.t61 476.5638
Rpar74 vss vss.t63 166.5194
Rpar75 vss vss.t67 6842.8497
Rpar76 vss.t0 vss.t1 2.0703
Rpar77 vss.t0 vss.t60 35.8367
Rpar78 vss.t0 vss.t61 96.1668
Rpar79 vss.t0 vss.t63 41.7331
Rpar80 vss.t0 vss.t67 162.2269
Rpar81 vss.t1 vss.t60 90.5936
Rpar82 vss.t1 vss.t61 243.0763
Rpar83 vss.t1 vss.t63 101.3818
Rpar84 vss.t1 vss.t67 367.2366
Rpar85 vss.t60 vss.t61 29.5064
Rpar86 vss.t60 vss.t63 1.6948
Rpar87 vss.t60 vss.t67 602.4473
Rpar88 vss.t61 vss.t63 5.0072
Rpar89 vss.t61 vss.t67 1616.1147
Rpar90 vss.t63 vss.t67 632.6175
Cpar0 a_10574_1294.t0 vss 2.34204e-15
Cpar1 a_10574_1294.t2 vss 3.28458e-15
Cpar2 a_10574_1294.t3 vss 2.68238e-15
Cpar3 a_10574_1294.t4 vss 1.32762e-15
Cpar4 a_10684_11168.t0 vss 6.35258e-15
Cpar5 a_10684_11168.t2 vss 5.43176e-15
Cpar6 a_10684_11168.t3 vss 2.22733e-14
Cpar7 a_10684_11168.t4 vss 5.51497e-14
Cpar8 a_10684_11168.t57 vss 1.22151e-15
Cpar9 a_1129_4566.t0 vss 7.70534e-15
Cpar10 a_1129_4566.t1 vss 2.37545e-14
Cpar11 a_1129_4566.t18 vss 3.78291e-14
Cpar12 a_1249_4358.t0 vss 6.51483e-15
Cpar13 a_1249_4358.t2 vss 1.21464e-14
Cpar14 a_1249_4358.t3 vss 3.35984e-14
Cpar15 a_1249_4358.t34 vss 2.88064e-15
Cpar16 a_2521_1041.t0 vss 8.18713e-15
Cpar17 a_2521_1041.t2 vss 2.12676e-14
Cpar18 a_2521_1041.t3 vss 5.39319e-14
Cpar19 a_2521_1041.t56 vss 6.95259e-15
Cpar20 a_2521_1041.t57 vss 1.67660e-15
Cpar21 a_5352_8050.t0 vss 7.45424e-15
Cpar22 a_5352_8050.t12 vss 3.53610e-15
Cpar23 a_5776_8050.t0 vss 4.75517e-15
Cpar24 a_5776_8050.t4 vss 2.83689e-15
Cpar25 a_6023_4566.t0 vss 6.22984e-15
Cpar26 a_6023_4566.t2 vss 2.30905e-15
Cpar27 a_6023_4566.t3 vss 3.19201e-15
Cpar28 a_6366_11376.t0 vss 4.08705e-15
Cpar29 a_6366_11376.t8 vss 2.00949e-15
Cpar30 a_7508_14377.t0 vss 2.89871e-14
Cpar31 a_7508_14377.t1 vss 3.67264e-14
Cpar32 a_7508_14377.t36 vss 5.15650e-15
Cpar33 a_9994_8445.t0 vss 2.63833e-15
Cpar34 a_9994_8445.t2 vss 3.87341e-15
Cpar35 a_9994_8445.t3 vss 3.05606e-15
Cpar36 a_9994_8445.t4 vss 1.45305e-15
Cpar37 ib vdd 4.70460e-16
Cpar38 ib vss 3.12447e-14
Cpar39 ib.t0 vss 5.60957e-15
Cpar40 ib.t1 vss 1.86606e-15
Cpar41 inn inp 5.16800e-17
Cpar42 inn vss 1.32282e-15
Cpar43 inn.t0 vss 2.13134e-16
Cpar44 inp vss 1.32014e-15
Cpar45 inp.t0 vss 2.12125e-16
Cpar46 out vdd 5.04461e-14
Cpar47 out vss 5.00741e-14
Cpar48 out.t0 vss 1.85432e-15
Cpar49 out.t19 vss 5.70246e-14
Cpar50 out.t5 vss 3.64057e-16
Cpar51 vdd vss 3.14226e-13
Cpar52 vdd.t0 vss 2.49100e-13
Cpar53 vdd.t10 vss 3.21878e-14
Cpar54 vdd.t125 vss 9.94618e-15
Cpar55 vdd.t185 vss 6.65432e-15
Cpar56 vdd.t186 vss 1.44219e-14
.ends opamp_dut

Vdd vdd 0 1.800000
Vss vss 0 0
Ibias vdd ib 3.571400e-06
Vinp inp 0 DC 1.262400 AC 1 PWL(0 1.262400 8.205080e-09 1.262400 9.025588e-09 1.272400)
Rfb out inn 1m
Cload out 0 2.000000e-13
Xdut vdd vss inp inn out ib opamp_dut
.end
