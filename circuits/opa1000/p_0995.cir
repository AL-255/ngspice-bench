* opa1000[0995]: 2p/telescopic_pmos_3v3_10u_100u_subth (telescopic_pmos, VDD=3.3V, CL=2.0pF, Iref=8.5uA)
.include "pdk_opa.inc"
.temp 27
.option gmin=1e-12 rshunt=1e12 reltol=1e-3 abstol=1e-12 vntol=1e-5 method=gear
* Post-PEX R+C extracted netlist for telescopic_pmos_3v3_10u_100u_subth
.subckt opamp_dut vdd vss inp inn out ib
XMpar0 a_1728_1204.t0 a_2291_11759.t52 a_2291_11759.t53 vdd.t0 pfet_03v3 w=3.4u l=0.35u ad=1.1560e-12 pd=4.7175e-06 as=1.0880e-12 ps=4.4650e-06 nf=1 m=64 par=64
XMpar1 a_1481_8386.t1 inn.t0 a_2644_11967.t13 vdd.t15 pfet_03v3 w=8u l=0.28u ad=3.6000e-12 pd=9.4000e-06 as=3.4400e-12 ps=8.8600e-06 nf=1 m=64 par=64
XMpar2 a_1481_8386.t1 inp.t0 a_1728_1204.t5 vdd.t15 pfet_03v3 w=8u l=0.28u ad=3.6000e-12 pd=9.4000e-06 as=3.4400e-12 ps=8.8600e-06 nf=1 m=64 par=64
XMpar3 a_2644_11967.t0 a_2291_11759.t52 out.t4 vdd.t0 pfet_03v3 w=3.4u l=0.35u ad=1.2240e-12 pd=4.9700e-06 as=9.5200e-13 ps=3.9600e-06 nf=1 m=64 par=64
XMpar4 a_2291_11759.t1 a_2291_11759.t0 a_4282_16461.t0 vss.t0 nfet_03v3 w=1.97u l=0.35u ad=6.0009e-13 pd=2.7308e-06 as=6.9708e-13 ps=3.1323e-06 nf=1 m=26 par=26
XMpar5 a_3278_16461.t0 a_2291_11759.t0 out.t0 vss.t0 nfet_03v3 w=1.97u l=0.35u ad=7.4557e-13 pd=3.3331e-06 as=6.0009e-13 ps=2.7308e-06 nf=1 m=26 par=26
XMpar6 a_1481_8386.t0 a_1351_8178.t0 vdd.t14 vdd.t13 pfet_03v3 w=10u l=0.65u ad=2.8000e-12 pd=1.0560e-05 as=3.6000e-12 ps=1.3220e-05 nf=1 m=8 par=8
XMpar7 a_4282_16461.t3 a_2291_11759.t180 vss.t8 vss.t7 nfet_03v3 w=2.05u l=0.6u ad=5.7400e-13 pd=2.6100e-06 as=6.5600e-13 ps=2.9462e-06 nf=1 m=8 par=8
XMpar8 a_3278_16461.t4 a_2291_11759.t180 vss.t8 vss.t7 nfet_03v3 w=2.05u l=0.6u ad=5.7400e-13 pd=2.6100e-06 as=6.5600e-13 ps=2.9462e-06 nf=1 m=8 par=8
XMpar9 a_1351_8178.t1 a_1351_8178.t0 vdd.t14 vdd.t13 pfet_03v3 w=10u l=0.65u ad=2.8000e-12 pd=1.0560e-05 as=2.8000e-12 ps=1.0560e-05 nf=1 m=2 par=2
XMpar10 a_1351_8178.t4 ib.t0 vss.t56 vss.t55 nfet_03v3 w=5.74u l=0.65u ad=1.6072e-12 pd=6.3000e-06 as=1.6072e-12 ps=6.3000e-06 nf=1 m=2 par=2
XMpar11 ib.t1 ib.t0 vss.t56 vss.t55 nfet_03v3 w=5.74u l=0.65u ad=3.4440e-12 pd=1.2680e-05 as=1.6072e-12 ps=6.3000e-06 nf=1 m=2 par=2
Rpar0 a_1351_8178.t0 a_1351_8178.t1 29.3806
Rpar1 a_1351_8178.t0 a_1351_8178.t4 225.9549
Rpar2 a_1351_8178.t1 a_1351_8178.t4 65.7664
Rpar3 a_1481_8386.t0 a_1481_8386.t1 46.8098
Rpar4 a_1728_1204.t0 a_1728_1204.t5 61.4724
Rpar5 a_2291_11759.t0 a_2291_11759.t1 15.8922
Rpar6 a_2291_11759.t0 a_2291_11759.t52 1812.5667
Rpar7 a_2291_11759.t0 a_2291_11759.t53 368.2217
Rpar8 a_2291_11759.t0 a_2291_11759.t180 1613.2946
Rpar9 a_2291_11759.t1 a_2291_11759.t52 359.3127
Rpar10 a_2291_11759.t1 a_2291_11759.t53 72.9941
Rpar11 a_2291_11759.t1 a_2291_11759.t180 319.8102
Rpar12 a_2291_11759.t52 a_2291_11759.t53 8.2315
Rpar13 a_2291_11759.t52 a_2291_11759.t180 577.6166
Rpar14 a_2291_11759.t53 a_2291_11759.t180 117.3424
Rpar15 a_2644_11967.t0 a_2644_11967.t13 38.6772
Rpar16 a_3278_16461.t0 a_3278_16461.t4 86.4789
Rpar17 a_4282_16461.t0 a_4282_16461.t3 114.7280
Rpar18 ib ib.t0 28.3757
Rpar19 ib ib.t1 3.3800
Rpar20 ib.t0 ib.t1 203.6300
Rpar21 inn inn.t0 3.7544
Rpar22 inp inp.t0 3.7544
Rpar23 out out.t0 6252.1189
Rpar24 out out.t4 2.4312
Rpar25 out.t0 out.t4 35.7818
Rpar26 vdd vdd.t0 53.5171
Rpar27 vdd vdd.t13 9660.4869
Rpar28 vdd vdd.t15 758.3167
Rpar29 vdd.t0 vdd.t13 1077.8933
Rpar30 vdd.t0 vdd.t14 3465.0170
Rpar31 vdd.t0 vdd.t15 84.6111
Rpar32 vdd.t13 vdd.t14 5.6970
Rpar33 vdd.t13 vdd.t15 73.7187
Rpar34 vdd.t14 vdd.t15 236.9774
Rpar35 vss vss.t0 365.8333
Rpar36 vss vss.t8 509.3785
Rpar37 vss vss.t7 125.3154
Rpar38 vss vss.t55 410.5892
Rpar39 vss vss.t56 480.8173
Rpar40 vss.t0 vss.t8 662.0405
Rpar41 vss.t0 vss.t7 163.4788
Rpar42 vss.t0 vss.t55 533.2470
Rpar43 vss.t0 vss.t56 624.4313
Rpar44 vss.t8 vss.t7 3.9164
Rpar45 vss.t8 vss.t55 516.9134
Rpar46 vss.t8 vss.t56 605.3270
Rpar47 vss.t7 vss.t55 137.1677
Rpar48 vss.t7 vss.t56 160.6290
Rpar49 vss.t55 vss.t56 10.6182
Cpar0 a_1351_8178.t0 vss 1.11482e-14
Cpar1 a_1351_8178.t1 vss 4.92051e-15
Cpar2 a_1351_8178.t4 vss 2.62603e-15
Cpar3 a_1481_8386.t0 vss 1.46199e-14
Cpar4 a_1481_8386.t1 vss 1.92652e-13
Cpar5 a_1728_1204.t0 vss 6.74557e-14
Cpar6 a_1728_1204.t5 vss 1.24946e-13
Cpar7 a_2291_11759.t0 vss 2.27184e-14
Cpar8 a_2291_11759.t1 vss 2.28051e-14
Cpar9 a_2291_11759.t180 vss 1.56658e-14
Cpar10 a_2291_11759.t52 vss 7.03703e-14
Cpar11 a_2291_11759.t53 vss 6.94262e-14
Cpar12 a_2644_11967.t0 vss 7.54190e-14
Cpar13 a_2644_11967.t13 vss 1.28487e-13
Cpar14 a_3278_16461.t0 vss 2.45422e-14
Cpar15 a_3278_16461.t4 vss 1.08223e-14
Cpar16 a_4282_16461.t0 vss 2.90798e-14
Cpar17 a_4282_16461.t3 vss 1.30324e-14
Cpar18 ib vdd 1.42650e-16
Cpar19 ib vss 7.65524e-15
Cpar20 ib.t0 vss 5.23572e-16
Cpar21 ib.t1 vss 4.97739e-16
Cpar22 inn inp 1.00830e-16
Cpar23 inn vdd 2.53754e-14
Cpar24 inn vss 1.50961e-14
Cpar25 inn.t0 vss 3.15796e-14
Cpar26 inp vdd 2.53756e-14
Cpar27 inp vss 1.49995e-14
Cpar28 inp.t0 vss 3.16095e-14
Cpar29 out vdd 2.15522e-14
Cpar30 out vss 1.05836e-14
Cpar31 out.t0 vss 3.02141e-14
Cpar32 out.t4 vss 8.95303e-14
Cpar33 vdd vss 5.23519e-13
Cpar34 vdd.t0 vss 8.09662e-14
Cpar35 vdd.t13 vss 1.20174e-14
Cpar36 vdd.t14 vss 6.29348e-15
Cpar37 vdd.t15 vss 9.64935e-14
.ends opamp_dut

Vdd vdd 0 3.300000
Vss vss 0 0
Ibias vdd ib 8.500000e-06
Vinp inp 0 DC 1.480000 AC 1 PWL(0 1.480000 3.696187e-09 1.480000 4.065806e-09 1.490000)
Rfb out inn 1m
Cload out 0 2.000000e-12
Xdut vdd vss inp inn out ib opamp_dut
.end
