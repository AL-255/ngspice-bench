* opa1000[0996]: 2p/telescopic_pmos_3v3_10u_100u_weak (telescopic_pmos, VDD=3.3V, CL=2.0pF, Iref=8.5uA)
.include "pdk_opa.inc"
.temp 27
.option gmin=1e-12 rshunt=1e12 reltol=1e-3 abstol=1e-12 vntol=1e-5 method=gear
* Post-PEX R+C extracted netlist for telescopic_pmos_3v3_10u_100u_weak
.subckt opamp_dut vdd vss inp inn out ib
XMpar0 a_1946_13372.t0 a_3168_7385.t0 a_3168_7385.t1 vdd.t0 pfet_03v3 w=2.01u l=0.8u ad=7.2360e-13 pd=3.2325e-06 as=5.6280e-13 ps=2.5700e-06 nf=1 m=48 par=48
XMpar1 a_1565_1294.t0 inn.t0 a_5500_7593.t48 vdd.t25 pfet_03v3 w=2.02u l=0.8u ad=6.0730e-13 pd=2.7516e-06 as=5.8645e-13 ps=2.6658e-06 nf=1 m=62 par=62
XMpar2 a_6044_5440.t0 a_3168_7385.t30 out.t48 vss.t0 nfet_03v3 w=1.84u l=0.8u ad=6.1333e-13 pd=2.8133e-06 as=5.1520e-13 ps=2.4000e-06 nf=1 m=12 par=12
XMpar3 a_1565_1294.t0 inp.t0 a_1946_13372.t48 vdd.t25 pfet_03v3 w=2.02u l=0.8u ad=6.0730e-13 pd=2.7516e-06 as=5.8645e-13 ps=2.6658e-06 nf=1 m=62 par=62
XMpar4 a_5500_7593.t0 a_3168_7385.t0 out.t0 vdd.t0 pfet_03v3 w=2.01u l=0.8u ad=6.4320e-13 pd=2.9012e-06 as=5.6280e-13 ps=2.5700e-06 nf=1 m=48 par=48
XMpar5 a_3168_7385.t31 a_3168_7385.t30 a_4136_5440.t0 vss.t0 nfet_03v3 w=1.84u l=0.8u ad=5.1520e-13 pd=2.4000e-06 as=7.1147e-13 ps=3.2267e-06 nf=1 m=12 par=12
XMpar6 a_1565_1294.t124 a_1405_1086.t2 vdd.t2 vdd.t1 pfet_03v3 w=10u l=0.8u ad=2.8000e-12 pd=1.0560e-05 as=3.6000e-12 ps=1.3220e-05 nf=1 m=8 par=8
XMpar7 a_1405_1086.t3 a_1405_1086.t2 vdd.t2 vdd.t1 pfet_03v3 w=10u l=0.8u ad=2.8000e-12 pd=1.0560e-05 as=2.8000e-12 ps=1.0560e-05 nf=1 m=2 par=2
XMpar8 a_6044_5440.t9 a_3168_7385.t120 vss.t30 vss.t29 nfet_03v3 w=2.36u l=0.6u ad=6.6080e-13 pd=2.9200e-06 as=6.6080e-13 ps=2.9200e-06 nf=1 m=2 par=2
XMpar9 a_4136_5440.t12 a_3168_7385.t120 vss.t30 vss.t29 nfet_03v3 w=2.36u l=0.6u ad=1.4160e-12 pd=5.9200e-06 as=6.6080e-13 ps=2.9200e-06 nf=1 m=2 par=2
XMpar10 ib.t1 ib.t0 vss.t4 vss.t3 nfet_03v3 w=2.79u l=0.8u ad=1.6740e-12 pd=6.7800e-06 as=7.8120e-13 ps=3.3500e-06 nf=1 m=2 par=2
XMpar11 a_1405_1086.t0 ib.t0 vss.t4 vss.t3 nfet_03v3 w=2.79u l=0.8u ad=7.8120e-13 pd=3.3500e-06 as=7.8120e-13 ps=3.3500e-06 nf=1 m=2 par=2
Rpar0 a_1405_1086.t0 a_1405_1086.t2 218.9491
Rpar1 a_1405_1086.t0 a_1405_1086.t3 69.5709
Rpar2 a_1405_1086.t2 a_1405_1086.t3 27.3186
Rpar3 a_1565_1294.t0 a_1565_1294.t124 33.3205
Rpar4 a_1946_13372.t0 a_1946_13372.t48 57.8074
Rpar5 a_3168_7385.t0 a_3168_7385.t1 4.7027
Rpar6 a_3168_7385.t0 a_3168_7385.t120 736.1377
Rpar7 a_3168_7385.t0 a_3168_7385.t30 1444.1788
Rpar8 a_3168_7385.t0 a_3168_7385.t31 379.5782
Rpar9 a_3168_7385.t1 a_3168_7385.t120 163.7346
Rpar10 a_3168_7385.t1 a_3168_7385.t30 321.2199
Rpar11 a_3168_7385.t1 a_3168_7385.t31 84.4273
Rpar12 a_3168_7385.t120 a_3168_7385.t30 591.6422
Rpar13 a_3168_7385.t120 a_3168_7385.t31 155.5033
Rpar14 a_3168_7385.t30 a_3168_7385.t31 15.4587
Rpar15 a_4136_5440.t0 a_4136_5440.t12 48.3353
Rpar16 a_5500_7593.t0 a_5500_7593.t48 36.9454
Rpar17 a_6044_5440.t0 a_6044_5440.t9 63.9600
Rpar18 ib ib.t0 17.2922
Rpar19 ib ib.t1 3.8656
Rpar20 inn inn.t0 1.4321
Rpar21 inp inp.t0 1.4321
Rpar22 out out.t0 62.7026
Rpar23 out out.t48 4.1559
Rpar24 vdd vdd.t0 127.1005
Rpar25 vdd vdd.t1 627.1240
Rpar26 vdd vdd.t25 35.5995
Rpar27 vdd vdd.t2 2210.1979
Rpar28 vdd.t0 vdd.t1 119.3885
Rpar29 vdd.t0 vdd.t25 137.5219
Rpar30 vdd.t0 vdd.t2 420.7657
Rpar31 vdd.t1 vdd.t25 678.5439
Rpar32 vdd.t1 vdd.t2 5.5973
Rpar33 vdd.t25 vdd.t2 2391.4193
Rpar34 vss vss.t0 35.3046
Rpar35 vss vss.t4 281.9434
Rpar36 vss vss.t29 224.7953
Rpar37 vss vss.t3 184.2656
Rpar38 vss vss.t30 311.8247
Rpar39 vss.t0 vss.t4 10.6184
Rpar40 vss.t0 vss.t29 4.6536
Rpar41 vss.t0 vss.t3 2.8362
Rpar42 vss.t0 vss.t30 9.9111
Rpar43 vss.t4 vss.t29 148.3602
Rpar44 vss.t4 vss.t3 24.1031
Rpar45 vss.t4 vss.t30 240.0822
Rpar46 vss.t29 vss.t3 50.6651
Rpar47 vss.t29 vss.t30 42.3126
Rpar48 vss.t3 vss.t30 92.8846
Cpar0 a_1405_1086.t0 vss 1.97098e-15
Cpar1 a_1405_1086.t2 vss 1.28301e-14
Cpar2 a_1405_1086.t3 vss 4.76107e-15
Cpar3 a_1565_1294.t0 vss 7.48209e-14
Cpar4 a_1565_1294.t124 vss 1.93624e-14
Cpar5 a_1946_13372.t0 vss 5.03158e-14
Cpar6 a_1946_13372.t48 vss 4.66912e-14
Cpar7 a_3168_7385.t0 vss 7.15303e-14
Cpar8 a_3168_7385.t1 vss 3.97687e-14
Cpar9 a_3168_7385.t120 vss 4.73870e-15
Cpar10 a_3168_7385.t30 vss 1.77675e-14
Cpar11 a_3168_7385.t31 vss 1.05229e-14
Cpar12 a_4136_5440.t0 vss 9.65758e-15
Cpar13 a_4136_5440.t12 vss 3.37689e-15
Cpar14 a_5500_7593.t0 vss 5.32270e-14
Cpar15 a_5500_7593.t48 vss 4.96706e-14
Cpar16 a_6044_5440.t0 vss 1.31579e-14
Cpar17 a_6044_5440.t9 vss 4.42583e-15
Cpar18 ib vdd 4.25500e-17
Cpar19 ib vss 6.30217e-15
Cpar20 ib.t0 vss 4.92281e-16
Cpar21 ib.t1 vss 2.58310e-16
Cpar22 inn inp 1.26170e-16
Cpar23 inn vdd 2.83539e-14
Cpar24 inn vss 6.22966e-15
Cpar25 inn.t0 vss 4.17478e-14
Cpar26 inp vdd 2.86386e-14
Cpar27 inp vss 6.28508e-15
Cpar28 inp.t0 vss 4.19815e-14
Cpar29 out vdd 2.19426e-14
Cpar30 out vss 1.89594e-14
Cpar31 out.t0 vss 5.23967e-14
Cpar32 out.t48 vss 7.98664e-15
Cpar33 vdd vss 3.84573e-13
Cpar34 vdd.t0 vss 9.68516e-14
Cpar35 vdd.t1 vss 1.71682e-14
Cpar36 vdd.t2 vss 8.25014e-15
Cpar37 vdd.t25 vss 7.66836e-14
.ends opamp_dut

Vdd vdd 0 3.300000
Vss vss 0 0
Ibias vdd ib 8.500000e-06
Vinp inp 0 DC 1.480000 AC 1 PWL(0 1.480000 4.918668e-09 1.480000 5.410535e-09 1.490000)
Rfb out inn 1m
Cload out 0 2.000000e-12
Xdut vdd vss inp inn out ib opamp_dut
.end
