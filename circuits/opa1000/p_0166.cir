* opa1000[0166]: 200f/folded_cascode_nmos_1v8_ulp_lt0p1uw_subth (folded_cascode_nmos, VDD=1.8V, CL=0.2pF, Iref=0.0014uA)
.include "pdk_opa.inc"
.temp 27
.option gmin=1e-12 rshunt=1e12 reltol=1e-3 abstol=1e-12 vntol=1e-5 method=gear
* Post-PEX R+C extracted netlist for folded_cascode_nmos_1v8_ulp_lt0p1uw_subth
.subckt opamp_dut vdd vss inp inn out ib
XMpar0 a_9660_7958.t4 ib.t10 out.t0 vdd.t9 pfet_03v3 w=0.4u l=8.5u ad=2.4000e-13 pd=2.0000e-06 as=2.4000e-13 ps=2.0000e-06 nf=1 m=2 par=2
XMpar1 a_6730_10199.t3 a_6730_10199.t2 vss.t1 vss.t0 nfet_03v3 w=0.4u l=9.5u ad=2.4000e-13 pd=2.0000e-06 as=1.1200e-13 ps=9.6000e-07 nf=1 m=2 par=2
XMpar2 a_5010_1249.t4 ib.t10 a_6730_10199.t0 vdd.t9 pfet_03v3 w=0.4u l=8.5u ad=2.4000e-13 pd=2.0000e-06 as=2.4000e-13 ps=2.0000e-06 nf=1 m=2 par=2
XMpar3 a_9660_7958.t0 a_1254_3668.t0 vdd.t1 vdd.t0 pfet_03v3 w=0.4u l=9.5u ad=1.7600e-13 pd=1.4800e-06 as=2.4000e-13 ps=2.0000e-06 nf=1 m=4 par=4
XMpar4 a_3890_1249.t4 inn.t0 a_9660_7958.t6 vss.t17 nfet_03v3 w=1.25u l=5u ad=5.5000e-13 pd=2.7550e-06 as=3.5000e-13 ps=1.8100e-06 nf=1 m=8 par=8
XMpar5 out.t1 a_6730_10199.t2 vss.t1 vss.t0 nfet_03v3 w=0.4u l=9.5u ad=2.4000e-13 pd=2.0000e-06 as=1.1200e-13 ps=9.6000e-07 nf=1 m=2 par=2
XMpar6 a_3890_1249.t0 ib.t0 vss.t1 vss.t0 nfet_03v3 w=0.4u l=9.5u ad=2.4000e-13 pd=2.0000e-06 as=1.1200e-13 ps=9.6000e-07 nf=1 m=4 par=4
XMpar7 a_1254_3668.t4 ib.t0 vss.t1 vss.t0 nfet_03v3 w=0.4u l=9.5u ad=2.4000e-13 pd=2.0000e-06 as=1.1200e-13 ps=9.6000e-07 nf=1 m=2 par=2
XMpar8 a_3890_1249.t4 inp.t0 a_5010_1249.t6 vss.t17 nfet_03v3 w=1.25u l=5u ad=5.5000e-13 pd=2.7550e-06 as=3.5000e-13 ps=1.8100e-06 nf=1 m=8 par=8
XMpar9 a_5010_1249.t0 a_1254_3668.t0 vdd.t1 vdd.t0 pfet_03v3 w=0.4u l=9.5u ad=1.7600e-13 pd=1.4800e-06 as=2.4000e-13 ps=2.0000e-06 nf=1 m=4 par=4
XMpar10 ib.t1 ib.t0 vss.t1 vss.t0 nfet_03v3 w=0.4u l=9.5u ad=2.4000e-13 pd=2.0000e-06 as=1.1200e-13 ps=9.6000e-07 nf=1 m=2 par=2
XMpar11 a_1254_3668.t1 a_1254_3668.t0 vdd.t1 vdd.t0 pfet_03v3 w=0.4u l=9.5u ad=1.1200e-13 pd=9.6000e-07 as=2.4000e-13 ps=2.0000e-06 nf=1 m=2 par=2
X32 out.t4 vss.t16 cap_mim_2f0fF c_width=17.5u c_length=17.5u
Rpar0 a_1254_3668.t0 a_1254_3668.t1 25.5954
Rpar1 a_1254_3668.t0 a_1254_3668.t4 150.2267
Rpar2 a_1254_3668.t1 a_1254_3668.t4 466.1255
Rpar3 a_3890_1249.t0 a_3890_1249.t4 61.4431
Rpar4 a_5010_1249.t0 a_5010_1249.t6 113.5433
Rpar5 a_5010_1249.t0 a_5010_1249.t4 132.3480
Rpar6 a_5010_1249.t6 a_5010_1249.t4 268.4831
Rpar7 a_6730_10199.t0 a_6730_10199.t2 105.0709
Rpar8 a_6730_10199.t0 a_6730_10199.t3 126.1216
Rpar9 a_6730_10199.t2 a_6730_10199.t3 15.5126
Rpar10 a_9660_7958.t0 a_9660_7958.t6 88.1310
Rpar11 a_9660_7958.t0 a_9660_7958.t4 114.7727
Rpar12 a_9660_7958.t6 a_9660_7958.t4 229.0199
Rpar13 ib ib.t0 11.4806
Rpar14 ib ib.t1 18.6259
Rpar15 ib ib.t10 85.8102
Rpar16 ib.t0 ib.t1 33.5714
Rpar17 inn inn.t0 1.9685
Rpar18 inp inp.t0 1.9685
Rpar19 out out.t0 169.5938
Rpar20 out out.t1 13.0284
Rpar21 out out.t4 98.1315
Rpar22 out.t0 out.t1 336.1419
Rpar23 out.t0 out.t4 146.8329
Rpar24 out.t1 out.t4 194.5008
Rpar25 vdd vdd.t0 406.5088
Rpar26 vdd vdd.t1 277.9424
Rpar27 vdd vdd.t9 31.6335
Rpar28 vdd.t0 vdd.t1 6.7261
Rpar29 vdd.t0 vdd.t9 384.6398
Rpar30 vdd.t1 vdd.t9 262.9899
Rpar31 vss vss.t0 108.9199
Rpar32 vss vss.t1 104.3364
Rpar33 vss vss.t16 645.0133
Rpar34 vss vss.t17 78.6977
Rpar35 vss.t0 vss.t1 14.8047
Rpar36 vss.t0 vss.t16 241.7740
Rpar37 vss.t0 vss.t17 3.3467
Rpar38 vss.t1 vss.t16 105.6302
Rpar39 vss.t1 vss.t17 25.0168
Rpar40 vss.t16 vss.t17 1482.2480
Cpar0 a_1254_3668.t0 vss 5.41548e-14
Cpar1 a_1254_3668.t1 vss 4.69526e-15
Cpar2 a_1254_3668.t4 vss 1.81270e-14
Cpar3 a_3890_1249.t0 vss 1.20227e-14
Cpar4 a_3890_1249.t4 vss 1.51004e-14
Cpar5 a_5010_1249.t0 vss 1.59499e-14
Cpar6 a_5010_1249.t4 vss 9.90514e-15
Cpar7 a_5010_1249.t6 vss 1.36891e-14
Cpar8 a_6730_10199.t0 vss 2.43619e-15
Cpar9 a_6730_10199.t2 vss 9.66920e-15
Cpar10 a_6730_10199.t3 vss 2.47633e-15
Cpar11 a_9660_7958.t0 vss 1.14842e-14
Cpar12 a_9660_7958.t4 vss 7.41485e-15
Cpar13 a_9660_7958.t6 vss 1.09000e-14
Cpar14 ib inn 3.76600e-17
Cpar15 ib inp 1.15500e-17
Cpar16 ib out 1.35647e-15
Cpar17 ib vdd 1.74530e-14
Cpar18 ib vss 5.42762e-14
Cpar19 ib.t0 vss 2.27669e-14
Cpar20 ib.t1 vss 2.74451e-15
Cpar21 ib.t10 vss 1.56938e-14
Cpar22 inn inp 1.02790e-16
Cpar23 inn vss 1.78839e-14
Cpar24 inn.t0 vss 4.59469e-15
Cpar25 inp vdd 1.24200e-17
Cpar26 inp vss 1.78203e-14
Cpar27 inp.t0 vss 4.63533e-15
Cpar28 out vdd 2.89430e-15
Cpar29 out vss 1.87246e-14
Cpar30 out.t0 vss 6.17315e-16
Cpar31 out.t1 vss 3.18418e-16
Cpar32 out.t4 vss 1.34708e-14
Cpar33 vdd vss 1.78941e-13
Cpar34 vdd.t0 vss 4.69390e-14
Cpar35 vdd.t1 vss 2.43621e-14
Cpar36 vdd.t9 vss 1.76266e-14
.ends opamp_dut

Vdd vdd 0 1.800000
Vss vss 0 0
Ibias vdd ib 1.400000e-09
Vinp inp 0 DC 0.985000 AC 1 PWL(0 0.985000 1.334689e-05 0.985000 1.468157e-05 0.995000)
Rfb out inn 1m
Cload out 0 2.000000e-13
Xdut vdd vss inp inn out ib opamp_dut
.end
