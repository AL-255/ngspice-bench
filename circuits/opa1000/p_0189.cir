* opa1000[0189]: 200f/folded_cascode_nmos_3v3_i50n_weak (folded_cascode_nmos, VDD=3.3V, CL=0.2pF, Iref=0.0128uA)
.include "pdk_opa.inc"
.temp 27
.option gmin=1e-12 rshunt=1e12 reltol=1e-3 abstol=1e-12 vntol=1e-5 method=gear
* Post-PEX R+C extracted netlist for folded_cascode_nmos_3v3_i50n_weak
.subckt opamp_dut vdd vss inp inn out ib
XMpar0 a_3314_2776.t4 ib.t0 vss.t5 vss.t4 nfet_03v3 w=0.4u l=5u ad=1.1200e-13 pd=9.6000e-07 as=1.1200e-13 ps=9.6000e-07 nf=1 m=4 par=4
XMpar1 a_5934_4187.t0 a_1188_7120.t0 vdd.t1 vdd.t0 pfet_03v3 w=0.4u l=9.75u ad=1.1200e-13 pd=9.6000e-07 as=2.4000e-13 ps=2.0000e-06 nf=1 m=4 par=4
XMpar2 a_3564_8739.t0 a_1188_7120.t0 vdd.t1 vdd.t0 pfet_03v3 w=0.4u l=9.75u ad=1.1200e-13 pd=9.6000e-07 as=2.4000e-13 ps=2.0000e-06 nf=1 m=4 par=4
XMpar3 a_3314_2776.t0 inn.t0 a_5934_4187.t3 vss.t0 nfet_03v3 w=0.4u l=5.2u ad=2.4000e-13 pd=2.0000e-06 as=1.1200e-13 ps=9.6000e-07 nf=1 m=2 par=2
XMpar4 ib.t1 ib.t0 vss.t5 vss.t4 nfet_03v3 w=0.4u l=5u ad=2.4000e-13 pd=2.0000e-06 as=1.1200e-13 ps=9.6000e-07 nf=1 m=2 par=2
XMpar5 a_5934_4187.t5 ib.t4 out.t0 vdd.t10 pfet_03v3 w=0.4u l=2.8u ad=2.4000e-13 pd=2.0000e-06 as=1.1200e-13 ps=9.6000e-07 nf=1 m=2 par=2
XMpar6 a_1188_7120.t1 a_1188_7120.t0 vdd.t1 vdd.t0 pfet_03v3 w=0.4u l=9.75u ad=1.1200e-13 pd=9.6000e-07 as=2.4000e-13 ps=2.0000e-06 nf=1 m=2 par=2
XMpar7 a_3314_2776.t0 inp.t0 a_3564_8739.t2 vss.t0 nfet_03v3 w=0.4u l=5.2u ad=2.4000e-13 pd=2.0000e-06 as=1.1200e-13 ps=9.6000e-07 nf=1 m=2 par=2
XMpar8 a_1188_7120.t4 ib.t0 vss.t5 vss.t4 nfet_03v3 w=0.4u l=5u ad=1.1200e-13 pd=9.6000e-07 as=1.1200e-13 ps=9.6000e-07 nf=1 m=2 par=2
XMpar9 out.t2 a_3692_1204.t2 vss.t5 vss.t4 nfet_03v3 w=0.4u l=5u ad=1.1200e-13 pd=9.6000e-07 as=1.1200e-13 ps=9.6000e-07 nf=1 m=2 par=2
XMpar10 a_3692_1204.t3 a_3692_1204.t2 vss.t5 vss.t4 nfet_03v3 w=0.4u l=5u ad=2.4000e-13 pd=2.0000e-06 as=1.1200e-13 ps=9.6000e-07 nf=1 m=2 par=2
XMpar11 a_3564_8739.t4 ib.t4 a_3692_1204.t0 vdd.t10 pfet_03v3 w=0.4u l=2.8u ad=2.4000e-13 pd=2.0000e-06 as=1.1200e-13 ps=9.6000e-07 nf=1 m=2 par=2
Rpar0 a_1188_7120.t0 a_1188_7120.t1 25.6764
Rpar1 a_1188_7120.t0 a_1188_7120.t4 45.4633
Rpar2 a_1188_7120.t1 a_1188_7120.t4 170.2604
Rpar3 a_3314_2776.t0 a_3314_2776.t4 66.3434
Rpar4 a_3564_8739.t0 a_3564_8739.t2 109.7490
Rpar5 a_3564_8739.t0 a_3564_8739.t4 120.2231
Rpar6 a_3564_8739.t2 a_3564_8739.t4 67.3643
Rpar7 a_3692_1204.t0 a_3692_1204.t2 158.1923
Rpar8 a_3692_1204.t0 a_3692_1204.t3 121.5215
Rpar9 a_3692_1204.t2 a_3692_1204.t3 21.4737
Rpar10 a_5934_4187.t0 a_5934_4187.t3 109.7490
Rpar11 a_5934_4187.t0 a_5934_4187.t5 120.2231
Rpar12 a_5934_4187.t3 a_5934_4187.t5 67.3643
Rpar13 ib ib.t0 10.9161
Rpar14 ib ib.t1 9.7910
Rpar15 ib ib.t4 73.9468
Rpar16 ib.t1 ib.t4 143.6545
Rpar17 inn inn.t0 3.2828
Rpar18 inp inp.t0 3.3313
Rpar19 out out.t0 13.2771
Rpar20 out out.t2 65.6797
Rpar21 vdd vdd.t0 42.2818
Rpar22 vdd vdd.t1 49.1562
Rpar23 vdd vdd.t10 189.1892
Rpar24 vdd.t0 vdd.t1 8.2150
Rpar25 vdd.t0 vdd.t10 106.2195
Rpar26 vdd.t1 vdd.t10 117.0625
Rpar27 vss vss.t0 108.3972
Rpar28 vss vss.t4 54.4465
Rpar29 vss vss.t5 213.8882
Rpar30 vss.t0 vss.t4 2.1453
Rpar31 vss.t0 vss.t5 15.2828
Rpar32 vss.t4 vss.t5 6.4671
Cpar0 a_1188_7120.t0 vss 5.19346e-14
Cpar1 a_1188_7120.t1 vss 2.82706e-15
Cpar2 a_1188_7120.t4 vss 4.50821e-15
Cpar3 a_3314_2776.t0 vss 6.59316e-15
Cpar4 a_3314_2776.t4 vss 7.84695e-15
Cpar5 a_3564_8739.t0 vss 8.53115e-15
Cpar6 a_3564_8739.t2 vss 3.83240e-15
Cpar7 a_3564_8739.t4 vss 3.93254e-15
Cpar8 a_3692_1204.t0 vss 8.44730e-16
Cpar9 a_3692_1204.t2 vss 3.46132e-15
Cpar10 a_3692_1204.t3 vss 1.10878e-15
Cpar11 a_5934_4187.t0 vss 9.63355e-15
Cpar12 a_5934_4187.t3 vss 4.32762e-15
Cpar13 a_5934_4187.t5 vss 4.44070e-15
Cpar14 ib inn 2.14800e-17
Cpar15 ib inp 1.28600e-17
Cpar16 ib out 3.37250e-16
Cpar17 ib vdd 6.84423e-15
Cpar18 ib vss 3.12400e-14
Cpar19 ib.t0 vss 7.78482e-15
Cpar20 ib.t1 vss 7.13330e-16
Cpar21 ib.t4 vss 3.23016e-15
Cpar22 inn inp 5.19700e-17
Cpar23 inn out 1.43000e-17
Cpar24 inn vss 5.59287e-15
Cpar25 inn.t0 vss 4.32108e-16
Cpar26 inp vss 5.72032e-15
Cpar27 inp.t0 vss 4.23288e-16
Cpar28 out vdd 1.51412e-15
Cpar29 out vss 7.30396e-15
Cpar30 out.t0 vss 1.37688e-16
Cpar31 out.t2 vss 3.21313e-15
Cpar32 vdd vss 1.22472e-13
Cpar33 vdd.t0 vss 2.87357e-14
Cpar34 vdd.t1 vss 2.67357e-14
Cpar35 vdd.t10 vss 1.10168e-14
.ends opamp_dut

Vdd vdd 0 3.300000
Vss vss 0 0
Ibias vdd ib 1.280000e-08
Vinp inp 0 DC 1.810000 AC 1 PWL(0 1.810000 4.802868e-07 1.810000 5.283154e-07 1.820000)
Rfb out inn 1m
Cload out 0 2.000000e-13
Xdut vdd vss inp inn out ib opamp_dut
.end
