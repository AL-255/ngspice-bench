* opa1000[0127]: 2p/current_reuse_1v8_i50n_subth (current_reuse, VDD=1.8V, CL=2.0pF, Iref=0.0093uA)
.include "pdk_opa.inc"
.temp 27
.option gmin=1e-12 rshunt=1e12 reltol=1e-3 abstol=1e-12 vntol=1e-5 method=gear
* Post-PEX R+C extracted netlist for current_reuse_1v8_i50n_subth
.subckt opamp_dut vdd vss inp inn out ib
XMpar0 out.t0 a_784_12555.t8 vdd.t1 vdd.t0 pfet_03v3 w=0.98u l=6u ad=2.7440e-13 pd=1.5400e-06 as=3.3712e-13 ps=1.8640e-06 nf=1 m=10 par=10
XMpar1 out.t12 ib.t0 vss.t15 vss.t14 nfet_03v3 w=0.4u l=3u ad=1.3760e-13 pd=1.1680e-06 as=1.1200e-13 ps=9.6000e-07 nf=1 m=10 par=10
XMpar2 a_3888_10739.t0 inn.t0 a_6104_19074.t4 vss.t3 nfet_03v3 w=0.95u l=4.4u ad=5.7000e-13 pd=3.1000e-06 as=2.6600e-13 ps=1.5100e-06 nf=1 m=2 par=2
XMpar3 a_6104_19074.t0 inn.t2 a_7304_19282.t0 vdd.t2 pfet_03v3 w=1.79u l=4.4u ad=5.0120e-13 pd=2.3500e-06 as=1.0740e-12 ps=4.7800e-06 nf=1 m=4 par=4
XMpar4 a_3888_10739.t0 inp.t0 a_784_12555.t4 vss.t3 nfet_03v3 w=0.95u l=4.4u ad=5.7000e-13 pd=3.1000e-06 as=2.6600e-13 ps=1.5100e-06 nf=1 m=2 par=2
XMpar5 ib.t1 ib.t0 vss.t15 vss.t14 nfet_03v3 w=0.4u l=3u ad=1.1200e-13 pd=9.6000e-07 as=1.1200e-13 ps=9.6000e-07 nf=1 m=2 par=2
XMpar6 a_3888_10739.t4 ib.t0 vss.t15 vss.t14 nfet_03v3 w=0.4u l=3u ad=1.1200e-13 pd=9.6000e-07 as=1.1200e-13 ps=9.6000e-07 nf=1 m=4 par=4
XMpar7 a_7304_19282.t0 inp.t2 a_784_12555.t0 vdd.t2 pfet_03v3 w=1.79u l=4.4u ad=1.0740e-12 pd=4.7800e-06 as=5.0120e-13 ps=2.3500e-06 nf=1 m=4 par=4
XMpar8 a_784_12555.t7 a_6104_19074.t6 vdd.t1 vdd.t0 pfet_03v3 w=0.98u l=6u ad=5.8800e-13 pd=3.1600e-06 as=2.7440e-13 ps=1.5400e-06 nf=1 m=1
XMpar9 a_7304_19282.t8 a_6104_19074.t6 vdd.t1 vdd.t0 pfet_03v3 w=0.98u l=6u ad=2.7440e-13 pd=1.5400e-06 as=5.8800e-13 ps=3.1600e-06 nf=1 m=2 par=2
XMpar10 a_6104_19074.t7 a_6104_19074.t6 vdd.t1 vdd.t0 pfet_03v3 w=0.98u l=6u ad=5.8800e-13 pd=3.1600e-06 as=2.7440e-13 ps=1.5400e-06 nf=1 m=1
X1 a_784_14115.t0 a_4762_13595.t0 vss.t0 ppolyf_u_1k r_width=1u r_length=19.23u
X2 a_784_16195.t0 a_4762_16715.t0 vss.t0 ppolyf_u_1k r_width=1u r_length=19.23u
X4 a_4762_18795.t1 out.t1 cap_mim_2f0fF c_width=18.91u c_length=18.91u
X7 a_4762_18795.t1 out.t1 cap_mim_2f0fF c_width=18.91u c_length=18.91u
X15 a_784_13075.t0 a_4762_13595.t0 vss.t0 ppolyf_u_1k r_width=1u r_length=19.23u
X21 a_784_16195.t0 a_4762_15675.t0 vss.t0 ppolyf_u_1k r_width=1u r_length=19.23u
X24 a_784_13075.t0 a_4762_12555.t0 vss.t0 ppolyf_u_1k r_width=1u r_length=19.23u
X26 a_4762_18795.t1 out.t1 cap_mim_2f0fF c_width=18.91u c_length=18.91u
X27 a_784_18275.t0 a_4762_18795.t0 vss.t0 ppolyf_u_1k r_width=1u r_length=19.23u
X28 a_784_15155.t0 a_4762_15675.t0 vss.t0 ppolyf_u_1k r_width=1u r_length=19.23u
X30 a_4762_18795.t1 out.t1 cap_mim_2f0fF c_width=18.91u c_length=18.91u
X31 a_784_12555.t6 a_4762_12555.t0 vss.t0 ppolyf_u_1k r_width=1u r_length=19.23u
X34 a_784_18275.t0 a_4762_17755.t0 vss.t0 ppolyf_u_1k r_width=1u r_length=19.23u
X36 a_784_15155.t0 a_4762_14635.t0 vss.t0 ppolyf_u_1k r_width=1u r_length=19.23u
X41 a_784_17235.t0 a_4762_17755.t0 vss.t0 ppolyf_u_1k r_width=1u r_length=19.23u
X44 a_784_14115.t0 a_4762_14635.t0 vss.t0 ppolyf_u_1k r_width=1u r_length=19.23u
X54 a_784_17235.t0 a_4762_16715.t0 vss.t0 ppolyf_u_1k r_width=1u r_length=19.23u
Rpar0 a_3888_10739.t0 a_3888_10739.t4 53.4067
Rpar1 a_4762_18795.t0 a_4762_18795.t1 69.2505
Rpar2 a_6104_19074.t0 a_6104_19074.t6 83.8730
Rpar3 a_6104_19074.t0 a_6104_19074.t4 107.7644
Rpar4 a_6104_19074.t0 a_6104_19074.t7 119.1522
Rpar5 a_6104_19074.t6 a_6104_19074.t4 165.2909
Rpar6 a_6104_19074.t6 a_6104_19074.t7 30.3521
Rpar7 a_6104_19074.t4 a_6104_19074.t7 234.8166
Rpar8 a_7304_19282.t0 a_7304_19282.t8 66.7024
Rpar9 a_784_12555.t0 a_784_12555.t8 165.1680
Rpar10 a_784_12555.t0 a_784_12555.t4 128.0248
Rpar11 a_784_12555.t0 a_784_12555.t6 138.2397
Rpar12 a_784_12555.t0 a_784_12555.t7 145.4435
Rpar13 a_784_12555.t8 a_784_12555.t4 420.9573
Rpar14 a_784_12555.t8 a_784_12555.t6 454.5448
Rpar15 a_784_12555.t8 a_784_12555.t7 107.3826
Rpar16 a_784_12555.t4 a_784_12555.t6 93.1665
Rpar17 a_784_12555.t4 a_784_12555.t7 370.6862
Rpar18 a_784_12555.t6 a_784_12555.t7 400.2627
Rpar19 ib ib.t0 10.8680
Rpar20 ib ib.t1 18.8993
Rpar21 inn inn.t0 3.3722
Rpar22 inn inn.t2 53.9747
Rpar23 inp inp.t0 3.4208
Rpar24 inp inp.t2 34.7741
Rpar25 out out.t0 355.8559
Rpar26 out out.t1 22.5211
Rpar27 out out.t12 100.2913
Rpar28 out.t0 out.t1 1865.0757
Rpar29 out.t0 out.t12 109.4214
Rpar30 out.t1 out.t12 525.6364
Rpar31 vdd vdd.t0 100.9885
Rpar32 vdd vdd.t1 197.4870
Rpar33 vdd vdd.t2 564.6267
Rpar34 vdd.t0 vdd.t1 4.0858
Rpar35 vdd.t0 vdd.t2 69.9847
Rpar36 vdd.t1 vdd.t2 114.5200
Rpar37 vss vss.t0 530.8958
Rpar38 vss vss.t14 67.5500
Rpar39 vss vss.t15 1021.7141
Rpar40 vss vss.t3 320.7161
Rpar41 vss.t0 vss.t14 2.7151
Rpar42 vss.t0 vss.t15 62.2602
Rpar43 vss.t0 vss.t3 30.4751
Rpar44 vss.t14 vss.t15 6.9258
Rpar45 vss.t14 vss.t3 2.7518
Rpar46 vss.t15 vss.t3 38.5096
Cpar0 a_3888_10739.t0 vss 6.30283e-15
Cpar1 a_3888_10739.t4 vss 8.80188e-15
Cpar2 a_4762_12555.t0 vss 3.26400e-17
Cpar3 a_4762_13595.t0 vss 3.15200e-17
Cpar4 a_4762_14635.t0 vss 3.07800e-17
Cpar5 a_4762_15675.t0 vss 3.34600e-17
Cpar6 a_4762_16715.t0 vss 3.32400e-17
Cpar7 a_4762_17755.t0 vss 3.96600e-17
Cpar8 a_4762_18795.t0 vss 1.05651e-16
Cpar9 a_4762_18795.t1 vss 9.38612e-15
Cpar10 a_6104_19074.t0 vss 6.48010e-15
Cpar11 a_6104_19074.t4 vss 3.40711e-15
Cpar12 a_6104_19074.t6 vss 1.83358e-14
Cpar13 a_6104_19074.t7 vss 3.22269e-15
Cpar14 a_7304_19282.t0 vss 1.34033e-14
Cpar15 a_7304_19282.t8 vss 3.92915e-15
Cpar16 a_784_12555.t0 vss 6.35772e-15
Cpar17 a_784_12555.t4 vss 3.28444e-15
Cpar18 a_784_12555.t6 vss 3.91749e-15
Cpar19 a_784_12555.t7 vss 3.56930e-15
Cpar20 a_784_12555.t8 vss 3.52917e-14
Cpar21 a_784_13075.t0 vss 3.91000e-17
Cpar22 a_784_14115.t0 vss 3.64200e-17
Cpar23 a_784_15155.t0 vss 3.64200e-17
Cpar24 a_784_16195.t0 vss 3.64200e-17
Cpar25 a_784_17235.t0 vss 3.71600e-17
Cpar26 a_784_18275.t0 vss 3.35000e-17
Cpar27 ib inn 1.44500e-17
Cpar28 ib inp 1.95900e-17
Cpar29 ib out 9.97400e-16
Cpar30 ib vss 3.55814e-14
Cpar31 ib.t0 vss 4.89340e-15
Cpar32 ib.t1 vss 3.23788e-16
Cpar33 inn inp 1.55930e-16
Cpar34 inn out 4.88400e-17
Cpar35 inn vdd 8.20058e-15
Cpar36 inn vss 8.86554e-15
Cpar37 inn.t0 vss 1.70720e-15
Cpar38 inn.t2 vss 9.65069e-15
Cpar39 inp vdd 8.28383e-15
Cpar40 inp vss 8.23363e-15
Cpar41 inp.t0 vss 1.69949e-15
Cpar42 inp.t2 vss 9.20717e-15
Cpar43 out vdd 1.87621e-14
Cpar44 out vss 3.46785e-14
Cpar45 out.t0 vss 6.07136e-15
Cpar46 out.t1 vss 2.07106e-14
Cpar47 out.t12 vss 5.73840e-15
Cpar48 vdd vss 1.64670e-13
Cpar49 vdd.t0 vss 4.00540e-14
Cpar50 vdd.t1 vss 2.08659e-14
Cpar51 vdd.t2 vss 2.74753e-14
.ends opamp_dut

Vdd vdd 0 1.800000
Vss vss 0 0
Ibias vdd ib 9.300000e-09
Vinp inp 0 DC 0.895000 AC 1 PWL(0 0.895000 5.438592e-06 0.895000 5.982451e-06 0.905000)
Rfb out inn 1m
Cload out 0 2.000000e-12
Xdut vdd vss inp inn out ib opamp_dut
.end
