* opa1000[0863]: 200f/telescopic_nmos_3v3_i2u_subth (telescopic_nmos, VDD=3.3V, CL=0.2pF, Iref=0.5uA)
.include "pdk_opa.inc"
.temp 27
.option gmin=1e-12 rshunt=1e12 reltol=1e-3 abstol=1e-12 vntol=1e-5 method=gear
* Post-PEX R+C extracted netlist for telescopic_nmos_3v3_i2u_subth
.subckt opamp_dut vdd vss inp inn out ib
XMpar0 a_9762_22018.t0 a_6092_21810.t0 out.t2 vdd.t0 pfet_03v3 w=1.99u l=1.95u ad=6.4817e-13 pd=2.9257e-06 as=5.5720e-13 ps=2.5500e-06 nf=1 m=56 par=56
XMpar1 a_10766_9622.t2 inn.t0 a_8274_1205.t8 vss.t0 nfet_03v3 w=1.97u l=2.38u ad=5.7495e-13 pd=2.6267e-06 as=6.9169e-13 ps=3.1100e-06 nf=1 m=54 par=54
XMpar2 a_5972_22018.t0 a_6092_21810.t0 a_6092_21810.t1 vdd.t0 pfet_03v3 w=1.99u l=1.95u ad=6.4817e-13 pd=2.9257e-06 as=6.4817e-13 ps=2.9257e-06 nf=1 m=56 par=56
XMpar3 a_9762_22018.t21 a_6092_21810.t142 vdd.t22 vdd.t0 pfet_03v3 w=1.88u l=5.1u ad=6.4672e-13 pd=2.9440e-06 as=5.2640e-13 ps=2.4400e-06 nf=1 m=20 par=20
XMpar4 a_5972_22018.t16 a_6092_21810.t142 vdd.t22 vdd.t0 pfet_03v3 w=1.88u l=5.1u ad=6.4672e-13 pd=2.9440e-06 as=6.4672e-13 ps=2.9440e-06 nf=1 m=20 par=20
XMpar5 a_6092_21810.t113 a_6092_21810.t112 a_7980_9622.t0 vss.t0 nfet_03v3 w=1.91u l=1.95u ad=6.5704e-13 pd=2.9800e-06 as=6.5704e-13 ps=2.9800e-06 nf=1 m=10 par=10
XMpar6 a_7980_9622.t1 inp.t0 a_8274_1205.t8 vss.t0 nfet_03v3 w=1.97u l=2.38u ad=5.7495e-13 pd=2.6267e-06 as=6.9169e-13 ps=3.1100e-06 nf=1 m=54 par=54
XMpar7 a_10766_9622.t0 a_6092_21810.t112 out.t0 vss.t0 nfet_03v3 w=1.91u l=1.95u ad=6.5704e-13 pd=2.9800e-06 as=5.3480e-13 ps=2.4700e-06 nf=1 m=10 par=10
XMpar8 a_8274_1205.t0 ib.t0 vss.t2 vss.t1 nfet_03v3 w=1.43u l=2.08u ad=4.0040e-13 pd=1.9900e-06 as=7.4360e-13 ps=3.5425e-06 nf=1 m=8 par=8
XMpar9 ib.t1 ib.t0 vss.t2 vss.t1 nfet_03v3 w=1.43u l=2.08u ad=8.5800e-13 pd=4.0600e-06 as=4.0040e-13 ps=1.9900e-06 nf=1 m=2 par=2
X278 out.t66 vss.t42 cap_mim_2f0fF c_width=12.99u c_length=12.99u
Rpar0 a_10766_9622.t0 a_10766_9622.t2 59.1757
Rpar1 a_5972_22018.t0 a_5972_22018.t16 54.8040
Rpar2 a_6092_21810.t0 a_6092_21810.t1 3.6585
Rpar3 a_6092_21810.t0 a_6092_21810.t112 1626.9344
Rpar4 a_6092_21810.t0 a_6092_21810.t113 526.0528
Rpar5 a_6092_21810.t0 a_6092_21810.t142 322.1162
Rpar6 a_6092_21810.t1 a_6092_21810.t112 485.6973
Rpar7 a_6092_21810.t1 a_6092_21810.t113 157.0453
Rpar8 a_6092_21810.t1 a_6092_21810.t142 96.1630
Rpar9 a_6092_21810.t112 a_6092_21810.t113 15.9418
Rpar10 a_6092_21810.t112 a_6092_21810.t142 277.8061
Rpar11 a_6092_21810.t113 a_6092_21810.t142 89.8258
Rpar12 a_7980_9622.t0 a_7980_9622.t1 47.7744
Rpar13 a_8274_1205.t0 a_8274_1205.t8 62.2606
Rpar14 a_9762_22018.t0 a_9762_22018.t21 68.9859
Rpar15 ib ib.t0 12.1611
Rpar16 ib ib.t1 10.9684
Rpar17 ib.t0 ib.t1 31.4248
Rpar18 inn inn.t0 1.4505
Rpar19 inp inp.t0 1.4505
Rpar20 out out.t0 131.7405
Rpar21 out out.t2 68.4215
Rpar22 out out.t66 15.3355
Rpar23 out.t0 out.t2 460.8082
Rpar24 out.t0 out.t66 1385.3504
Rpar25 out.t2 out.t66 719.5032
Rpar26 vdd vdd.t0 60.1967
Rpar27 vdd vdd.t22 4374.5508
Rpar28 vdd.t0 vdd.t22 9.3731
Rpar29 vss vss.t0 89.9678
Rpar30 vss vss.t2 2960.2453
Rpar31 vss vss.t42 153.9878
Rpar32 vss.t0 vss.t1 155.2718
Rpar33 vss.t0 vss.t2 47.0137
Rpar34 vss.t0 vss.t42 74.5903
Rpar35 vss.t1 vss.t2 12.9087
Rpar36 vss.t1 vss.t42 9275.5853
Rpar37 vss.t2 vss.t42 2454.2750
Cpar0 a_10766_9622.t0 vss 1.28620e-14
Cpar1 a_10766_9622.t2 vss 4.95592e-14
Cpar2 a_5972_22018.t0 vss 7.80853e-14
Cpar3 a_5972_22018.t16 vss 5.76085e-14
Cpar4 a_6092_21810.t0 vss 1.50654e-13
Cpar5 a_6092_21810.t1 vss 5.26937e-14
Cpar6 a_6092_21810.t112 vss 2.69946e-14
Cpar7 a_6092_21810.t113 vss 1.05035e-14
Cpar8 a_6092_21810.t142 vss 1.36134e-13
Cpar9 a_7980_9622.t0 vss 1.20427e-14
Cpar10 a_7980_9622.t1 vss 4.70578e-14
Cpar11 a_8274_1205.t0 vss 7.65110e-15
Cpar12 a_8274_1205.t8 vss 7.61956e-14
Cpar13 a_9762_22018.t0 vss 8.56439e-14
Cpar14 a_9762_22018.t21 vss 6.32509e-14
Cpar15 ib vss 2.14858e-14
Cpar16 ib.t0 vss 3.39067e-15
Cpar17 ib.t1 vss 3.81536e-16
Cpar18 inn inp 2.88170e-16
Cpar19 inn out 3.30500e-16
Cpar20 inn vss 5.24434e-14
Cpar21 inn.t0 vss 3.23268e-14
Cpar22 inp out 3.61200e-16
Cpar23 inp vss 5.24515e-14
Cpar24 inp.t0 vss 3.23496e-14
Cpar25 out vdd 3.68601e-14
Cpar26 out vss 4.10745e-14
Cpar27 out.t0 vss 1.20885e-14
Cpar28 out.t2 vss 3.84587e-14
Cpar29 out.t66 vss 4.20808e-14
Cpar30 vdd vss 6.60736e-13
Cpar31 vdd.t0 vss 3.46676e-13
Cpar32 vdd.t22 vss 1.33582e-14
.ends opamp_dut

Vdd vdd 0 3.300000
Vss vss 0 0
Ibias vdd ib 5.000000e-07
Vinp inp 0 DC 1.711000 AC 1 PWL(0 1.711000 3.622098e-08 1.711000 3.984307e-08 1.721000)
Rfb out inn 1m
Cload out 0 2.000000e-13
Xdut vdd vss inp inn out ib opamp_dut
.end
