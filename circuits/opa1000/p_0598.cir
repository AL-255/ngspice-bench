* opa1000[0598]: 200f/pmos_miller_1v8_i10u_weak (pmos_miller, VDD=1.8V, CL=0.2pF, Iref=1.4375uA)
.include "pdk_opa.inc"
.temp 27
.option gmin=1e-12 rshunt=1e12 reltol=1e-3 abstol=1e-12 vntol=1e-5 method=gear
* Post-PEX R+C extracted netlist for pmos_miller_1v8_i10u_weak
.subckt opamp_dut vdd vss inp inn out ib
XMpar0 a_2316_7991.t4 inp.t0 a_977_1290.t3 vdd.t0 pfet_03v3 w=1.89u l=1.63u ad=5.9640e-13 pd=2.7311e-06 as=5.9640e-13 ps=2.7311e-06 nf=1 m=18 par=18
XMpar1 out.t0 a_977_1290.t21 vss.t1 vss.t0 nfet_03v3 w=0.97u l=1.13u ad=2.7160e-13 pd=1.5300e-06 as=3.3368e-13 ps=1.8520e-06 nf=1 m=10 par=10
XMpar2 a_2316_7991.t4 inn.t0 a_6000_3104.t0 vdd.t0 pfet_03v3 w=1.89u l=1.63u ad=5.9640e-13 pd=2.7311e-06 as=5.9640e-13 ps=2.7311e-06 nf=1 m=18 par=18
XMpar3 a_977_1290.t0 a_6000_3104.t18 vss.t1 vss.t0 nfet_03v3 w=0.97u l=1.13u ad=5.8200e-13 pd=3.1400e-06 as=2.7160e-13 ps=1.5300e-06 nf=1 m=2 par=2
XMpar4 out.t4 a_5608_4969.t0 vdd.t10 vdd.t9 pfet_03v3 w=3.17u l=1.2u ad=1.0905e-12 pd=4.4920e-06 as=8.8760e-13 ps=3.7300e-06 nf=1 m=10 par=10
XMpar5 a_2316_7991.t0 a_5608_4969.t0 vdd.t10 vdd.t9 pfet_03v3 w=3.17u l=1.2u ad=8.8760e-13 pd=3.7300e-06 as=8.8760e-13 ps=3.7300e-06 nf=1 m=4 par=4
XMpar6 ib.t1 ib.t0 vss.t26 vss.t25 nfet_03v3 w=0.72u l=1.2u ad=4.3200e-13 pd=2.6400e-06 as=2.0160e-13 ps=1.2800e-06 nf=1 m=2 par=2
XMpar7 a_6000_3104.t19 a_6000_3104.t18 vss.t1 vss.t0 nfet_03v3 w=0.97u l=1.13u ad=2.7160e-13 pd=1.5300e-06 as=2.7160e-13 ps=1.5300e-06 nf=1 m=2 par=2
XMpar8 a_5608_4969.t4 ib.t0 vss.t26 vss.t25 nfet_03v3 w=0.72u l=1.2u ad=2.0160e-13 pd=1.2800e-06 as=2.0160e-13 ps=1.2800e-06 nf=1 m=2 par=2
XMpar9 a_5608_4969.t1 a_5608_4969.t0 vdd.t10 vdd.t9 pfet_03v3 w=3.17u l=1.2u ad=8.8760e-13 pd=3.7300e-06 as=8.8760e-13 ps=3.7300e-06 nf=1 m=2 par=2
X29 a_3097_1290.t1 out.t18 cap_mim_2f0fF c_width=15.37u c_length=15.37u
X69 a_977_1290.t2 a_3097_1290.t0 vss.t20 ppolyf_u_1k r_width=1u r_length=9.94u
Rpar0 a_2316_7991.t0 a_2316_7991.t4 47.8310
Rpar1 a_3097_1290.t0 a_3097_1290.t1 52.5034
Rpar2 a_5608_4969.t0 a_5608_4969.t1 23.0172
Rpar3 a_5608_4969.t0 a_5608_4969.t4 172.1432
Rpar4 a_5608_4969.t1 a_5608_4969.t4 139.7676
Rpar5 a_6000_3104.t0 a_6000_3104.t18 142.5797
Rpar6 a_6000_3104.t0 a_6000_3104.t19 122.0751
Rpar7 a_6000_3104.t18 a_6000_3104.t19 29.5671
Rpar8 a_977_1290.t0 a_977_1290.t3 246.4494
Rpar9 a_977_1290.t0 a_977_1290.t2 260.7510
Rpar10 a_977_1290.t0 a_977_1290.t21 85.2118
Rpar11 a_977_1290.t3 a_977_1290.t2 490.1529
Rpar12 a_977_1290.t3 a_977_1290.t21 160.1789
Rpar13 a_977_1290.t2 a_977_1290.t21 55.3501
Rpar14 ib ib.t0 15.8357
Rpar15 ib ib.t1 7.3989
Rpar16 ib.t0 ib.t1 170.2141
Rpar17 inn inn.t0 1.7365
Rpar18 inp inp.t0 1.7365
Rpar19 out out.t0 35.2759
Rpar20 out out.t4 62.0073
Rpar21 out out.t18 20.9467
Rpar22 out.t0 out.t4 64.5488
Rpar23 out.t0 out.t18 429.5447
Rpar24 out.t4 out.t18 755.0470
Rpar25 vdd vdd.t0 21.2507
Rpar26 vdd vdd.t10 739.4598
Rpar27 vdd vdd.t9 170.7493
Rpar28 vdd.t0 vdd.t10 796.3376
Rpar29 vdd.t0 vdd.t9 183.8830
Rpar30 vdd.t10 vdd.t9 4.4499
Rpar31 vss vss.t0 130.4295
Rpar32 vss vss.t1 347.2838
Rpar33 vss vss.t20 27.7915
Rpar34 vss vss.t25 190.1351
Rpar35 vss vss.t26 396.8655
Rpar36 vss.t0 vss.t1 3.5285
Rpar37 vss.t0 vss.t20 323.6638
Rpar38 vss.t0 vss.t25 136.4825
Rpar39 vss.t0 vss.t26 284.9087
Rpar40 vss.t1 vss.t20 887.7537
Rpar41 vss.t1 vss.t25 364.6292
Rpar42 vss.t1 vss.t26 761.1603
Rpar43 vss.t20 vss.t25 689.0542
Rpar44 vss.t20 vss.t26 1438.2737
Rpar45 vss.t25 vss.t26 12.2360
Cpar0 a_2316_7991.t0 vss 7.59685e-15
Cpar1 a_2316_7991.t4 vss 2.89770e-14
Cpar2 a_3097_1290.t0 vss 1.69480e-16
Cpar3 a_3097_1290.t1 vss 4.55734e-15
Cpar4 a_5608_4969.t0 vss 1.93749e-14
Cpar5 a_5608_4969.t1 vss 5.10948e-15
Cpar6 a_5608_4969.t4 vss 3.76419e-15
Cpar7 a_6000_3104.t0 vss 1.45233e-14
Cpar8 a_6000_3104.t18 vss 4.71958e-15
Cpar9 a_6000_3104.t19 vss 2.56170e-15
Cpar10 a_977_1290.t0 vss 2.34649e-15
Cpar11 a_977_1290.t2 vss 1.73255e-15
Cpar12 a_977_1290.t21 vss 6.90891e-15
Cpar13 a_977_1290.t3 vss 1.04343e-14
Cpar14 ib vss 6.13857e-15
Cpar15 ib.t0 vss 5.47723e-16
Cpar16 ib.t1 vss 6.82120e-17
Cpar17 inn inp 1.03240e-16
Cpar18 inn vdd 1.47874e-14
Cpar19 inn vss 4.38780e-15
Cpar20 inn.t0 vss 1.83020e-14
Cpar21 inp out 3.24500e-17
Cpar22 inp vdd 1.46227e-14
Cpar23 inp vss 4.37535e-15
Cpar24 inp.t0 vss 1.81871e-14
Cpar25 out vdd 7.53825e-15
Cpar26 out vss 1.17130e-14
Cpar27 out.t0 vss 2.09416e-15
Cpar28 out.t18 vss 6.82013e-15
Cpar29 out.t4 vss 5.60147e-15
Cpar30 vdd vss 1.39819e-13
Cpar31 vdd.t0 vss 4.12136e-14
Cpar32 vdd.t10 vss 6.63083e-15
Cpar33 vdd.t9 vss 1.95703e-14
.ends opamp_dut

Vdd vdd 0 1.800000
Vss vss 0 0
Ibias vdd ib 1.437500e-06
Vinp inp 0 DC 0.805000 AC 1 PWL(0 0.805000 1.255319e-08 0.805000 1.380851e-08 0.815000)
Rfb out inn 1m
Cload out 0 2.000000e-13
Xdut vdd vss inp inn out ib opamp_dut
.end
