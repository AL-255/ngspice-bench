* opa1000[0284]: 200f/folded_cascode_pmos_3v3_i20u_weak (folded_cascode_pmos, VDD=3.3V, CL=0.2pF, Iref=3.1111uA)
.include "pdk_opa.inc"
.temp 27
.option gmin=1e-12 rshunt=1e12 reltol=1e-3 abstol=1e-12 vntol=1e-5 method=gear
* Post-PEX R+C extracted netlist for folded_cascode_pmos_3v3_i20u_weak
.subckt opamp_dut vdd vss inp inn out ib
XMpar0 a_3362_7256.t0 inp.t0 a_3752_7256.t0 vdd.t16 pfet_03v3 w=2.06u l=1.35u ad=7.4160e-13 pd=3.2950e-06 as=5.7680e-13 ps=2.6200e-06 nf=1 m=16 par=16
XMpar1 out.t1 a_6134_3326.t0 vdd.t1 vdd.t0 pfet_03v3 w=2.4u l=0.81u ad=6.7200e-13 pd=2.9600e-06 as=6.7200e-13 ps=2.9600e-06 nf=1 m=2 par=2
XMpar2 a_3362_7256.t0 inn.t0 a_6734_3326.t0 vdd.t16 pfet_03v3 w=2.06u l=1.35u ad=7.4160e-13 pd=3.2950e-06 as=5.7680e-13 ps=2.6200e-06 nf=1 m=16 par=16
XMpar3 a_3362_7256.t32 a_2184_1249.t2 vdd.t1 vdd.t0 pfet_03v3 w=2.4u l=0.81u ad=6.7200e-13 pd=2.9600e-06 as=1.0560e-12 ps=4.4800e-06 nf=1 m=4 par=4
XMpar4 a_6734_3326.t20 a_2184_1249.t6 out.t0 vss.t0 nfet_03v3 w=2.25u l=0.9u ad=1.3500e-12 pd=5.7000e-06 as=6.3000e-13 ps=2.8100e-06 nf=1 m=2 par=2
XMpar5 a_3752_7256.t16 ib.t0 vss.t3 vss.t2 nfet_03v3 w=2.48u l=1.8u ad=6.9440e-13 pd=3.0400e-06 as=1.0912e-12 ps=4.6000e-06 nf=1 m=4 par=4
XMpar6 a_6734_3326.t16 ib.t0 vss.t3 vss.t2 nfet_03v3 w=2.48u l=1.8u ad=6.9440e-13 pd=3.0400e-06 as=1.0912e-12 ps=4.6000e-06 nf=1 m=4 par=4
XMpar7 a_2184_1249.t3 a_2184_1249.t2 vdd.t1 vdd.t0 pfet_03v3 w=2.4u l=0.81u ad=6.7200e-13 pd=2.9600e-06 as=6.7200e-13 ps=2.9600e-06 nf=1 m=2 par=2
XMpar8 a_3752_7256.t20 a_2184_1249.t6 a_6134_3326.t4 vss.t0 nfet_03v3 w=2.25u l=0.9u ad=1.3500e-12 pd=5.7000e-06 as=6.3000e-13 ps=2.8100e-06 nf=1 m=2 par=2
XMpar9 a_2184_1249.t0 ib.t0 vss.t3 vss.t2 nfet_03v3 w=2.48u l=1.8u ad=6.9440e-13 pd=3.0400e-06 as=6.9440e-13 ps=3.0400e-06 nf=1 m=2 par=2
XMpar10 a_6134_3326.t1 a_6134_3326.t0 vdd.t1 vdd.t0 pfet_03v3 w=2.4u l=0.81u ad=1.4400e-12 pd=6.0000e-06 as=6.7200e-13 ps=2.9600e-06 nf=1 m=2 par=2
XMpar11 ib.t1 ib.t0 vss.t3 vss.t2 nfet_03v3 w=2.48u l=1.8u ad=1.4880e-12 pd=6.1600e-06 as=6.9440e-13 ps=3.0400e-06 nf=1 m=2 par=2
Rpar0 a_2184_1249.t0 a_2184_1249.t2 265.4085
Rpar1 a_2184_1249.t0 a_2184_1249.t3 157.3215
Rpar2 a_2184_1249.t0 a_2184_1249.t6 61.1425
Rpar3 a_2184_1249.t2 a_2184_1249.t3 25.3545
Rpar4 a_2184_1249.t2 a_2184_1249.t6 241.0771
Rpar5 a_2184_1249.t3 a_2184_1249.t6 142.8991
Rpar6 a_3362_7256.t0 a_3362_7256.t32 71.6929
Rpar7 a_3752_7256.t0 a_3752_7256.t16 162.2565
Rpar8 a_3752_7256.t0 a_3752_7256.t20 86.7632
Rpar9 a_3752_7256.t16 a_3752_7256.t20 46.4667
Rpar10 a_6134_3326.t0 a_6134_3326.t1 22.8915
Rpar11 a_6134_3326.t0 a_6134_3326.t4 161.8380
Rpar12 a_6134_3326.t1 a_6134_3326.t4 39.3972
Rpar13 a_6734_3326.t0 a_6734_3326.t16 162.2565
Rpar14 a_6734_3326.t0 a_6734_3326.t20 86.7632
Rpar15 a_6734_3326.t16 a_6734_3326.t20 46.4667
Rpar16 ib ib.t0 10.6290
Rpar17 ib ib.t1 4.3765
Rpar18 ib.t0 ib.t1 234.3584
Rpar19 inn inn.t0 1.9959
Rpar20 inp inp.t0 1.9959
Rpar21 out out.t0 7.9929
Rpar22 out out.t1 28.4814
Rpar23 vdd vdd.t0 271.4716
Rpar24 vdd vdd.t1 465.0671
Rpar25 vdd vdd.t16 21.3411
Rpar26 vdd.t0 vdd.t1 3.8976
Rpar27 vdd.t0 vdd.t16 109.6118
Rpar28 vdd.t1 vdd.t16 187.7797
Rpar29 vss vss.t0 321.2865
Rpar30 vss vss.t2 38.8955
Rpar31 vss vss.t3 54.7149
Rpar32 vss.t0 vss.t2 7.6369
Rpar33 vss.t0 vss.t3 44.9595
Rpar34 vss.t2 vss.t3 3.9850
Cpar0 a_2184_1249.t0 vss 2.76869e-15
Cpar1 a_2184_1249.t2 vss 4.51957e-15
Cpar2 a_2184_1249.t3 vss 2.76511e-15
Cpar3 a_2184_1249.t6 vss 3.91192e-15
Cpar4 a_3362_7256.t0 vss 2.57727e-14
Cpar5 a_3362_7256.t32 vss 5.90071e-15
Cpar6 a_3752_7256.t0 vss 1.27345e-14
Cpar7 a_3752_7256.t16 vss 4.50399e-15
Cpar8 a_3752_7256.t20 vss 4.43906e-15
Cpar9 a_6134_3326.t0 vss 3.37901e-15
Cpar10 a_6134_3326.t1 vss 3.65973e-15
Cpar11 a_6134_3326.t4 vss 1.91933e-15
Cpar12 a_6734_3326.t0 vss 1.26668e-14
Cpar13 a_6734_3326.t16 vss 4.48006e-15
Cpar14 a_6734_3326.t20 vss 4.41545e-15
Cpar15 ib vss 2.05859e-14
Cpar16 ib.t0 vss 2.38566e-15
Cpar17 ib.t1 vss 1.87108e-16
Cpar18 inn inp 1.04860e-16
Cpar19 inn vdd 1.17953e-14
Cpar20 inn vss 4.16180e-15
Cpar21 inn.t0 vss 1.43781e-14
Cpar22 inp vdd 1.18620e-14
Cpar23 inp vss 4.17695e-15
Cpar24 inp.t0 vss 1.44007e-14
Cpar25 out vdd 1.86069e-15
Cpar26 out vss 3.36196e-15
Cpar27 out.t0 vss 7.22674e-16
Cpar28 out.t1 vss 2.25485e-15
Cpar29 vdd vss 1.13445e-13
Cpar30 vdd.t0 vss 1.03457e-14
Cpar31 vdd.t1 vss 6.49961e-15
Cpar32 vdd.t16 vss 3.37738e-14
.ends opamp_dut

Vdd vdd 0 3.300000
Vss vss 0 0
Ibias vdd ib 3.111100e-06
Vinp inp 0 DC 1.381000 AC 1 PWL(0 1.381000 3.000000e-09 1.381000 3.300000e-09 1.391000)
Rfb out inn 1m
Cload out 0 2.000000e-13
Xdut vdd vss inp inn out ib opamp_dut
.end
