* opa1000[0363]: 200f/nmos_5t_3v3_i2u_subth (nmos_5t, VDD=3.3V, CL=0.2pF, Iref=0.65uA)
.include "pdk_opa.inc"
.temp 27
.option gmin=1e-12 rshunt=1e12 reltol=1e-3 abstol=1e-12 vntol=1e-5 method=gear
* Post-PEX R+C extracted netlist for nmos_5t_3v3_i2u_subth
.subckt opamp_dut vdd vss inp inn out ib
XMpar0 a_1755_1204.t52 ib.t0 vss.t27 vss.t0 nfet_03v3 w=3.09u l=3.25u ad=8.6520e-13 pd=3.6500e-06 as=1.1124e-12 ps=4.5825e-06 nf=1 m=8 par=8
XMpar1 a_1580_8179.t27 a_1580_8179.t26 vdd.t1 vdd.t0 pfet_03v3 w=2.02u l=3.4u ad=6.5794e-13 pd=2.9600e-06 as=6.5794e-13 ps=2.9600e-06 nf=1 m=28 par=28
XMpar2 out.t0 a_1580_8179.t26 vdd.t1 vdd.t0 pfet_03v3 w=2.02u l=3.4u ad=6.5794e-13 pd=2.9600e-06 as=6.5794e-13 ps=2.9600e-06 nf=1 m=28 par=28
XMpar3 a_1580_8179.t0 inp.t0 a_1755_1204.t0 vss.t0 nfet_03v3 w=2.03u l=2.85u ad=6.1837e-13 pd=2.7954e-06 as=7.1831e-13 ps=3.2062e-06 nf=1 m=26 par=26
XMpar4 a_1755_1204.t0 inn.t0 out.t17 vss.t0 nfet_03v3 w=2.03u l=2.85u ad=7.1831e-13 pd=3.2062e-06 as=6.1837e-13 ps=2.7954e-06 nf=1 m=26 par=26
XMpar5 ib.t1 ib.t0 vss.t27 vss.t0 nfet_03v3 w=3.09u l=3.25u ad=8.6520e-13 pd=3.6500e-06 as=8.6520e-13 ps=3.6500e-06 nf=1 m=2 par=2
Rpar0 a_1580_8179.t0 a_1580_8179.t26 122.4149
Rpar1 a_1580_8179.t0 a_1580_8179.t27 52.3532
Rpar2 a_1580_8179.t26 a_1580_8179.t27 4.0145
Rpar3 a_1755_1204.t0 a_1755_1204.t52 47.2309
Rpar4 ib ib.t0 11.7334
Rpar5 ib ib.t1 10.3356
Rpar6 inn inn.t0 1.8331
Rpar7 inp inp.t0 1.8331
Rpar8 out out.t0 4.8842
Rpar9 out out.t17 56.1704
Rpar10 vdd vdd.t0 19.9054
Rpar11 vdd vdd.t1 547.4207
Rpar12 vdd.t0 vdd.t1 9.1932
Rpar13 vss vss.t0 26.4739
Rpar14 vss vss.t27 384.6835
Rpar15 vss.t0 vss.t27 4.1500
Cpar0 a_1580_8179.t0 vss 2.20784e-14
Cpar1 a_1580_8179.t26 vss 1.39109e-13
Cpar2 a_1580_8179.t27 vss 3.54040e-14
Cpar3 a_1755_1204.t0 vss 3.94461e-14
Cpar4 a_1755_1204.t52 vss 8.04891e-15
Cpar5 ib inn 1.43700e-17
Cpar6 ib inp 4.48500e-17
Cpar7 ib vss 2.56808e-14
Cpar8 ib.t0 vss 4.57094e-15
Cpar9 ib.t1 vss 2.87597e-16
Cpar10 inn inp 1.28130e-16
Cpar11 inn out 1.01391e-14
Cpar12 inn vdd 1.87300e-17
Cpar13 inn vss 3.15436e-14
Cpar14 inn.t0 vss 1.60552e-14
Cpar15 inp vdd 1.87300e-17
Cpar16 inp vss 3.17115e-14
Cpar17 inp.t0 vss 1.60991e-14
Cpar18 out vdd 3.05885e-14
Cpar19 out vss 1.88636e-14
Cpar20 out.t0 vss 4.70969e-14
Cpar21 out.t17 vss 3.08192e-14
Cpar22 vdd vss 2.62091e-13
Cpar23 vdd.t0 vss 1.46717e-13
Cpar24 vdd.t1 vss 1.59154e-14
.ends opamp_dut

Vdd vdd 0 3.300000
Vss vss 0 0
Ibias vdd ib 6.500000e-07
Vinp inp 0 DC 1.645000 AC 1 PWL(0 1.645000 1.484365e-08 1.645000 1.632802e-08 1.655000)
Rfb out inn 1m
Cload out 0 2.000000e-13
Xdut vdd vss inp inn out ib opamp_dut
.end
