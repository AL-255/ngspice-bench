* opa1000[0492]: 2p/nmos_miller_3v3_i10u_subth (nmos_miller, VDD=3.3V, CL=2.0pF, Iref=1.6429uA)
.include "pdk_opa.inc"
.temp 27
.option gmin=1e-12 rshunt=1e12 reltol=1e-3 abstol=1e-12 vntol=1e-5 method=gear
* Post-PEX R+C extracted netlist for nmos_miller_3v3_i10u_subth
.subckt opamp_dut vdd vss inp inn out ib
XMpar0 out.t1 ib.t0 vss.t1 vss.t0 nfet_03v3 w=5.1u l=2.25u ad=1.7544e-12 pd=6.8080e-06 as=1.4280e-12 ps=5.6600e-06 nf=1 m=10 par=10
XMpar1 out.t0 a_1039_10138.t9 vdd.t1 vdd.t0 pfet_03v3 w=10u l=0.6u ad=2.8000e-12 pd=1.0560e-05 as=3.4400e-12 ps=1.2688e-05 nf=1 m=10 par=10
XMpar2 a_1039_10138.t7 a_5412_10137.t0 vdd.t1 vdd.t0 pfet_03v3 w=10u l=0.6u ad=6.0000e-12 pd=2.1200e-05 as=2.8000e-12 ps=1.0560e-05 nf=1 m=2 par=2
XMpar3 a_3516_3064.t0 ib.t0 vss.t1 vss.t0 nfet_03v3 w=5.1u l=2.25u ad=1.4280e-12 pd=5.6600e-06 as=1.4280e-12 ps=5.6600e-06 nf=1 m=4 par=4
XMpar4 a_3516_3064.t4 inn.t0 a_5412_10137.t4 vss.t0 nfet_03v3 w=1.97u l=0.72u ad=7.6173e-13 pd=3.4000e-06 as=5.5160e-13 ps=2.5300e-06 nf=1 m=6 par=6
XMpar5 a_1039_10138.t0 inp.t0 a_3516_3064.t4 vss.t0 nfet_03v3 w=1.97u l=0.72u ad=5.5160e-13 pd=2.5300e-06 as=7.6173e-13 ps=3.4000e-06 nf=1 m=6 par=6
XMpar6 ib.t1 ib.t0 vss.t1 vss.t0 nfet_03v3 w=5.1u l=2.25u ad=1.4280e-12 pd=5.6600e-06 as=1.4280e-12 ps=5.6600e-06 nf=1 m=2 par=2
XMpar7 a_5412_10137.t1 a_5412_10137.t0 vdd.t1 vdd.t0 pfet_03v3 w=10u l=0.6u ad=2.8000e-12 pd=1.0560e-05 as=2.8000e-12 ps=1.0560e-05 nf=1 m=2 par=2
X6 a_1039_10138.t6 a_10085_5864.t0 vss.t38 ppolyf_u_1k r_width=1u r_length=9.37u
X34 a_10085_5864.t1 out.t15 cap_mim_2f0fF c_width=14.37u c_length=14.36u
X43 a_10085_5864.t1 out.t15 cap_mim_2f0fF c_width=14.37u c_length=14.36u
Rpar0 a_10085_5864.t0 a_10085_5864.t1 61.1894
Rpar1 a_1039_10138.t0 a_1039_10138.t9 137.1428
Rpar2 a_1039_10138.t0 a_1039_10138.t6 709.2395
Rpar3 a_1039_10138.t0 a_1039_10138.t7 210.8243
Rpar4 a_1039_10138.t9 a_1039_10138.t6 326.4671
Rpar5 a_1039_10138.t9 a_1039_10138.t7 97.0437
Rpar6 a_1039_10138.t6 a_1039_10138.t7 204.7154
Rpar7 a_3516_3064.t0 a_3516_3064.t4 83.2282
Rpar8 a_5412_10137.t0 a_5412_10137.t1 42.8535
Rpar9 a_5412_10137.t0 a_5412_10137.t4 479.9653
Rpar10 a_5412_10137.t1 a_5412_10137.t4 85.4245
Rpar11 ib ib.t0 31.1039
Rpar12 ib ib.t1 11.9558
Rpar13 ib.t0 ib.t1 47.4619
Rpar14 inn inn.t0 5.0413
Rpar15 inp inp.t0 5.0899
Rpar16 out out.t0 47.4518
Rpar17 out out.t1 39.0114
Rpar18 out out.t15 20.7981
Rpar19 out.t0 out.t1 114.1745
Rpar20 vdd vdd.t0 49.3079
Rpar21 vdd vdd.t1 115.3150
Rpar22 vdd.t0 vdd.t1 3.6549
Rpar23 vss vss.t0 35.4881
Rpar24 vss vss.t1 1052.9809
Rpar25 vss vss.t38 3418.5408
Rpar26 vss.t0 vss.t1 4.6155
Rpar27 vss.t0 vss.t38 13.3465
Rpar28 vss.t1 vss.t38 191.9657
Cpar0 a_10085_5864.t0 vss 1.28938e-16
Cpar1 a_10085_5864.t1 vss 5.93753e-15
Cpar2 a_1039_10138.t0 vss 4.67702e-15
Cpar3 a_1039_10138.t6 vss 3.81067e-15
Cpar4 a_1039_10138.t7 vss 8.36575e-15
Cpar5 a_1039_10138.t9 vss 1.22798e-14
Cpar6 a_3516_3064.t0 vss 8.84392e-15
Cpar7 a_3516_3064.t4 vss 8.43922e-15
Cpar8 a_5412_10137.t0 vss 3.43205e-15
Cpar9 a_5412_10137.t1 vss 5.40751e-15
Cpar10 a_5412_10137.t4 vss 5.01238e-15
Cpar11 ib out 3.39919e-15
Cpar12 ib vss 3.23026e-14
Cpar13 ib.t0 vss 7.80067e-15
Cpar14 ib.t1 vss 5.02820e-16
Cpar15 inn inp 5.16800e-17
Cpar16 inn vss 4.12038e-15
Cpar17 inn.t0 vss 6.71764e-16
Cpar18 inp vss 4.10975e-15
Cpar19 inp.t0 vss 6.90413e-16
Cpar20 out vdd 1.63505e-14
Cpar21 out vss 2.07949e-14
Cpar22 out.t0 vss 9.71135e-15
Cpar23 out.t1 vss 8.21546e-15
Cpar24 out.t15 vss 1.31852e-14
Cpar25 vdd vss 6.14236e-14
Cpar26 vdd.t0 vss 2.13897e-14
Cpar27 vdd.t1 vss 1.25843e-14
.ends opamp_dut

Vdd vdd 0 3.300000
Vss vss 0 0
Ibias vdd ib 1.642900e-06
Vinp inp 0 DC 1.645000 AC 1 PWL(0 1.645000 1.700759e-08 1.645000 1.870835e-08 1.655000)
Rfb out inn 1m
Cload out 0 2.000000e-12
Xdut vdd vss inp inn out ib opamp_dut
.end
