* opa1000[0631]: 2p/pmos_miller_1v8_0p1u_1u_subth (pmos_miller, VDD=1.8V, CL=2.0pF, Iref=0.0625uA)
.include "pdk_opa.inc"
.temp 27
.option gmin=1e-12 rshunt=1e12 reltol=1e-3 abstol=1e-12 vntol=1e-5 method=gear
* Post-PEX R+C extracted netlist for pmos_miller_1v8_0p1u_1u_subth
.subckt opamp_dut vdd vss inp inn out ib
XMpar0 a_4466_11468.t0 inn.t0 a_7920_9524.t4 vdd.t5 pfet_03v3 w=1.85u l=3.2u ad=6.6600e-13 pd=3.0325e-06 as=5.9200e-13 ps=2.7213e-06 nf=1 m=16 par=16
XMpar1 out.t2 a_3416_1204.t2 vdd.t1 vdd.t0 pfet_03v3 w=1.62u l=4u ad=7.6464e-13 pd=3.5360e-06 as=6.6096e-13 ps=3.0840e-06 nf=1 m=10 par=10
XMpar2 ib.t1 ib.t0 vss.t12 vss.t11 nfet_03v3 w=0.4u l=4u ad=2.4000e-13 pd=2.0000e-06 as=1.1200e-13 ps=9.6000e-07 nf=1 m=2 par=2
XMpar3 a_4466_11468.t32 a_3416_1204.t2 vdd.t1 vdd.t0 pfet_03v3 w=1.62u l=4u ad=9.7200e-13 pd=4.4400e-06 as=4.5360e-13 ps=2.1800e-06 nf=1 m=4 par=4
XMpar4 a_3416_1204.t3 a_3416_1204.t2 vdd.t1 vdd.t0 pfet_03v3 w=1.62u l=4u ad=9.7200e-13 pd=4.4400e-06 as=4.5360e-13 ps=2.1800e-06 nf=1 m=2 par=2
XMpar5 a_878_4220.t0 a_7920_9524.t0 vss.t1 vss.t0 nfet_03v3 w=0.55u l=3.13u ad=3.3000e-13 pd=2.3000e-06 as=1.5400e-13 ps=1.1100e-06 nf=1 m=2 par=2
XMpar6 a_4466_11468.t0 inp.t0 a_878_4220.t2 vdd.t5 pfet_03v3 w=1.85u l=3.2u ad=6.6600e-13 pd=3.0325e-06 as=5.9200e-13 ps=2.7213e-06 nf=1 m=16 par=16
XMpar7 out.t0 a_878_4220.t19 vss.t1 vss.t0 nfet_03v3 w=0.55u l=3.13u ad=1.8920e-13 pd=1.3480e-06 as=2.2440e-13 ps=1.5860e-06 nf=1 m=10 par=10
XMpar8 a_3416_1204.t0 ib.t0 vss.t12 vss.t11 nfet_03v3 w=0.4u l=4u ad=2.4000e-13 pd=2.0000e-06 as=1.1200e-13 ps=9.6000e-07 nf=1 m=2 par=2
XMpar9 a_7920_9524.t1 a_7920_9524.t0 vss.t1 vss.t0 nfet_03v3 w=0.55u l=3.13u ad=1.5400e-13 pd=1.1100e-06 as=1.5400e-13 ps=1.1100e-06 nf=1 m=2 par=2
X4 a_878_7860.t0 a_4838_7340.t0 vss.t2 ppolyf_u_1k r_width=1u r_length=19.14u
X7 a_878_4740.t0 a_4838_4220.t0 vss.t2 ppolyf_u_1k r_width=1u r_length=19.14u
X18 a_878_6820.t0 a_4838_7340.t0 vss.t2 ppolyf_u_1k r_width=1u r_length=19.14u
X20 a_878_4220.t18 a_4838_4220.t0 vss.t2 ppolyf_u_1k r_width=1u r_length=19.14u
X27 a_878_6820.t0 a_4838_6300.t0 vss.t2 ppolyf_u_1k r_width=1u r_length=19.14u
X36 a_878_8900.t0 a_4838_9420.t0 vss.t2 ppolyf_u_1k r_width=1u r_length=19.14u
X37 a_878_5780.t0 a_4838_6300.t0 vss.t2 ppolyf_u_1k r_width=1u r_length=19.14u
X42 a_878_8900.t0 a_4838_8380.t0 vss.t2 ppolyf_u_1k r_width=1u r_length=19.14u
X61 a_4838_9420.t1 out.t1 cap_mim_2f0fF c_width=14.37u c_length=14.36u
X66 a_878_5780.t0 a_4838_5260.t0 vss.t2 ppolyf_u_1k r_width=1u r_length=19.14u
X68 a_4838_9420.t1 out.t1 cap_mim_2f0fF c_width=14.37u c_length=14.36u
X75 a_878_7860.t0 a_4838_8380.t0 vss.t2 ppolyf_u_1k r_width=1u r_length=19.14u
X77 a_878_4740.t0 a_4838_5260.t0 vss.t2 ppolyf_u_1k r_width=1u r_length=19.14u
Rpar0 a_3416_1204.t0 a_3416_1204.t2 285.6000
Rpar1 a_3416_1204.t0 a_3416_1204.t3 157.9629
Rpar2 a_3416_1204.t2 a_3416_1204.t3 13.1362
Rpar3 a_4466_11468.t0 a_4466_11468.t32 52.1262
Rpar4 a_4838_9420.t0 a_4838_9420.t1 74.8011
Rpar5 a_7920_9524.t0 a_7920_9524.t1 29.7908
Rpar6 a_7920_9524.t0 a_7920_9524.t4 110.6606
Rpar7 a_7920_9524.t1 a_7920_9524.t4 107.5733
Rpar8 a_878_4220.t0 a_878_4220.t2 92.8114
Rpar9 a_878_4220.t0 a_878_4220.t18 191.9711
Rpar10 a_878_4220.t0 a_878_4220.t19 134.5198
Rpar11 a_878_4220.t2 a_878_4220.t18 348.9077
Rpar12 a_878_4220.t2 a_878_4220.t19 244.4899
Rpar13 a_878_4220.t18 a_878_4220.t19 68.6906
Rpar14 ib ib.t0 9.6250
Rpar15 ib ib.t1 11.8090
Rpar16 ib.t0 ib.t1 43.8256
Rpar17 inn inn.t0 2.0282
Rpar18 inp inp.t0 2.0282
Rpar19 out out.t0 103.3692
Rpar20 out out.t1 116.6552
Rpar21 out out.t2 3.4101
Rpar22 out.t0 out.t1 76.0822
Rpar23 vdd vdd.t0 161.5933
Rpar24 vdd vdd.t1 2449.6571
Rpar25 vdd vdd.t5 21.2633
Rpar26 vdd.t0 vdd.t1 11.7971
Rpar27 vdd.t0 vdd.t5 61.5926
Rpar28 vdd.t1 vdd.t5 933.7072
Rpar29 vss vss.t0 529.0148
Rpar30 vss vss.t1 221.8007
Rpar31 vss vss.t11 128.0952
Rpar32 vss vss.t12 189.4675
Rpar33 vss vss.t2 404.8171
Rpar34 vss.t0 vss.t1 6.8144
Rpar35 vss.t0 vss.t11 161.3739
Rpar36 vss.t0 vss.t12 410.3100
Rpar37 vss.t0 vss.t2 514.7927
Rpar38 vss.t1 vss.t11 82.3195
Rpar39 vss.t1 vss.t12 187.9805
Rpar40 vss.t1 vss.t2 262.2198
Rpar41 vss.t11 vss.t12 27.2929
Rpar42 vss.t11 vss.t2 17.8594
Rpar43 vss.t12 vss.t2 82.1151
Cpar0 a_3416_1204.t0 vss 9.08740e-15
Cpar1 a_3416_1204.t2 vss 4.56862e-14
Cpar2 a_3416_1204.t3 vss 1.09750e-14
Cpar3 a_4466_11468.t0 vss 4.16981e-14
Cpar4 a_4466_11468.t32 vss 1.69197e-14
Cpar5 a_4838_4220.t0 vss 3.84800e-17
Cpar6 a_4838_5260.t0 vss 3.79600e-17
Cpar7 a_4838_6300.t0 vss 3.78800e-17
Cpar8 a_4838_7340.t0 vss 3.74400e-17
Cpar9 a_4838_8380.t0 vss 4.18800e-17
Cpar10 a_4838_9420.t0 vss 2.91455e-16
Cpar11 a_4838_9420.t1 vss 7.64457e-15
Cpar12 a_7920_9524.t0 vss 7.47055e-15
Cpar13 a_7920_9524.t1 vss 2.09116e-15
Cpar14 a_7920_9524.t4 vss 1.62285e-14
Cpar15 a_878_4220.t0 vss 3.27455e-15
Cpar16 a_878_4220.t18 vss 2.76732e-15
Cpar17 a_878_4220.t19 vss 1.31271e-14
Cpar18 a_878_4220.t2 vss 1.08519e-14
Cpar19 a_878_4740.t0 vss 3.20200e-17
Cpar20 a_878_5780.t0 vss 2.93600e-17
Cpar21 a_878_6820.t0 vss 2.93600e-17
Cpar22 a_878_7860.t0 vss 3.00800e-17
Cpar23 a_878_8900.t0 vss 2.64400e-17
Cpar24 ib vss 1.53975e-14
Cpar25 ib.t0 vss 2.21667e-15
Cpar26 ib.t1 vss 2.96004e-16
Cpar27 inn inp 7.59400e-17
Cpar28 inn vdd 2.15829e-14
Cpar29 inn vss 4.31819e-15
Cpar30 inn.t0 vss 2.85839e-14
Cpar31 inp vdd 2.13775e-14
Cpar32 inp vss 4.32279e-15
Cpar33 inp.t0 vss 2.85103e-14
Cpar34 out vdd 1.24158e-14
Cpar35 out vss 3.02049e-14
Cpar36 out.t0 vss 6.03194e-15
Cpar37 out.t1 vss 1.55619e-14
Cpar38 out.t2 vss 4.43904e-15
Cpar39 vdd vss 2.49007e-13
Cpar40 vdd.t0 vss 5.12211e-14
Cpar41 vdd.t1 vss 6.19830e-15
Cpar42 vdd.t5 vss 6.07152e-14
.ends opamp_dut

Vdd vdd 0 1.800000
Vss vss 0 0
Ibias vdd ib 6.250000e-08
Vinp inp 0 DC 0.805000 AC 1 PWL(0 0.805000 4.184962e-07 0.805000 4.603458e-07 0.815000)
Rfb out inn 1m
Cload out 0 2.000000e-12
Xdut vdd vss inp inn out ib opamp_dut
.end
