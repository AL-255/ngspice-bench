* opa1000[0913]: 2p/telescopic_nmos_3v3_i150u_subth (telescopic_nmos, VDD=3.3V, CL=2.0pF, Iref=31.875uA)
.include "pdk_opa.inc"
.temp 27
.option gmin=1e-12 rshunt=1e12 reltol=1e-3 abstol=1e-12 vntol=1e-5 method=gear
* Post-PEX R+C extracted netlist for telescopic_nmos_3v3_i150u_subth
.subckt opamp_dut vdd vss inp inn out ib
XMpar0 a_4176_20852.t4 a_4296_20644.t768 vdd.t5 vdd.t4 pfet_03v3 w=2.01u l=0.42u ad=6.2127e-13 pd=2.8109e-06 as=5.6280e-13 ps=2.5700e-06 nf=1 m=66 par=66
XMpar1 a_4801_20852.t8 a_4296_20644.t0 out.t0 vdd.t0 pfet_03v3 w=4.45u l=0.31u ad=1.5308e-12 pd=6.0280e-06 as=1.3884e-12 ps=5.5190e-06 nf=1 m=160 par=160
XMpar2 a_1911_1204.t24 inn.t0 a_7969_13277.t42 vss.t40 nfet_03v3 w=3.33u l=0.53u ad=9.8568e-13 pd=4.0885e-06 as=9.7236e-13 ps=4.0389e-06 nf=1 m=160 par=160
XMpar3 a_7969_13277.t0 a_4296_20644.t320 out.t21 vss.t40 nfet_03v3 w=2.01u l=0.31u ad=8.3080e-13 pd=3.6742e-06 as=6.4320e-13 ps=2.9012e-06 nf=1 m=96 par=96
XMpar4 a_1911_1204.t24 inp.t0 a_7710_1205.t0 vss.t40 nfet_03v3 w=3.33u l=0.53u ad=9.8568e-13 pd=4.0885e-06 as=9.7236e-13 ps=4.0389e-06 nf=1 m=160 par=160
XMpar5 a_4801_20852.t0 a_4296_20644.t768 vdd.t5 vdd.t4 pfet_03v3 w=2.01u l=0.42u ad=5.6280e-13 pd=2.5700e-06 as=5.6280e-13 ps=2.5700e-06 nf=1 m=66 par=66
XMpar6 a_4296_20644.t321 a_4296_20644.t320 a_7710_1205.t160 vss.t40 nfet_03v3 w=2.01u l=0.31u ad=6.5660e-13 pd=2.9565e-06 as=8.3080e-13 ps=3.6742e-06 nf=1 m=96 par=96
XMpar7 a_4176_20852.t0 a_4296_20644.t0 a_4296_20644.t1 vdd.t0 pfet_03v3 w=4.45u l=0.31u ad=1.6020e-12 pd=6.2825e-06 as=1.3884e-12 ps=5.5190e-06 nf=1 m=160 par=160
XMpar8 a_1911_1204.t0 ib.t0 vss.t1 vss.t0 nfet_03v3 w=10u l=0.98u ad=2.8000e-12 pd=1.0560e-05 as=3.6000e-12 ps=1.3220e-05 nf=1 m=24 par=24
XMpar9 ib.t1 ib.t0 vss.t1 vss.t0 nfet_03v3 w=10u l=0.98u ad=2.8000e-12 pd=1.0560e-05 as=2.8000e-12 ps=1.0560e-05 nf=1 m=6 par=6
X761 out.t256 vss.t101 cap_mim_2f0fF c_width=6.71u c_length=6.71u
Rpar0 a_1911_1204.t0 a_1911_1204.t24 52.3024
Rpar1 a_4176_20852.t0 a_4176_20852.t4 58.8491
Rpar2 a_4296_20644.t0 a_4296_20644.t1 4.1118
Rpar3 a_4296_20644.t0 a_4296_20644.t321 657.5887
Rpar4 a_4296_20644.t0 a_4296_20644.t768 529.3635
Rpar5 a_4296_20644.t1 a_4296_20644.t320 551.8385
Rpar6 a_4296_20644.t1 a_4296_20644.t321 107.2867
Rpar7 a_4296_20644.t1 a_4296_20644.t768 86.3665
Rpar8 a_4296_20644.t320 a_4296_20644.t321 3.1479
Rpar9 a_4296_20644.t320 a_4296_20644.t768 1254.7904
Rpar10 a_4296_20644.t321 a_4296_20644.t768 243.9524
Rpar11 a_4801_20852.t0 a_4801_20852.t8 37.7877
Rpar12 a_7710_1205.t0 a_7710_1205.t160 41.3245
Rpar13 a_7969_13277.t0 a_7969_13277.t42 37.5381
Rpar14 ib ib.t0 17.3717
Rpar15 ib ib.t1 5.8014
Rpar16 ib.t0 ib.t1 12.4198
Rpar17 inn inn.t0 1.9408
Rpar18 inp inp.t0 1.9408
Rpar19 out out.t0 1824.3270
Rpar20 out out.t21 2.2445
Rpar21 out out.t256 1126.2894
Rpar22 out.t0 out.t21 172.1505
Rpar23 out.t0 out.t256 81.5446
Rpar24 out.t21 out.t256 106.2810
Rpar25 vdd vdd.t0 153.5949
Rpar26 vdd vdd.t4 21.0843
Rpar27 vdd vdd.t5 1897.9548
Rpar28 vdd.t0 vdd.t4 57.4390
Rpar29 vdd.t0 vdd.t5 5170.5033
Rpar30 vdd.t4 vdd.t5 9.1723
Rpar31 vss vss.t0 3266.3364
Rpar32 vss vss.t1 50.4801
Rpar33 vss vss.t40 35.1193
Rpar34 vss vss.t101 356.0119
Rpar35 vss.t0 vss.t1 11.8682
Rpar36 vss.t0 vss.t40 262.4560
Rpar37 vss.t0 vss.t101 11316.8409
Rpar38 vss.t1 vss.t40 54.7106
Rpar39 vss.t1 vss.t101 169.6863
Rpar40 vss.t40 vss.t101 134.7162
Cpar0 a_1911_1204.t0 vss 5.02647e-14
Cpar1 a_1911_1204.t24 vss 2.22557e-13
Cpar2 a_4176_20852.t0 vss 2.71876e-13
Cpar3 a_4176_20852.t4 vss 6.63841e-14
Cpar4 a_4296_20644.t0 vss 1.82555e-13
Cpar5 a_4296_20644.t1 vss 2.07648e-13
Cpar6 a_4296_20644.t320 vss 8.08193e-14
Cpar7 a_4296_20644.t321 vss 9.40432e-14
Cpar8 a_4296_20644.t768 vss 7.28271e-14
Cpar9 a_4801_20852.t0 vss 7.20877e-14
Cpar10 a_4801_20852.t8 vss 2.99416e-13
Cpar11 a_7710_1205.t0 vss 1.58685e-13
Cpar12 a_7710_1205.t160 vss 1.11137e-13
Cpar13 a_7969_13277.t0 vss 1.00696e-13
Cpar14 a_7969_13277.t42 vss 1.51286e-13
Cpar15 ib vss 5.18669e-14
Cpar16 ib.t0 vss 1.04934e-14
Cpar17 ib.t1 vss 2.68645e-15
Cpar18 inn inp 3.37830e-16
Cpar19 inn vss 5.98778e-14
Cpar20 inn.t0 vss 4.81785e-14
Cpar21 inp vss 5.99683e-14
Cpar22 inp.t0 vss 4.81891e-14
Cpar23 out vdd 5.24521e-14
Cpar24 out vss 3.70324e-14
Cpar25 out.t0 vss 2.72549e-13
Cpar26 out.t21 vss 1.07169e-13
Cpar27 out.t256 vss 3.29761e-14
Cpar28 vdd vss 6.82028e-13
Cpar29 vdd.t0 vss 2.78198e-13
Cpar30 vdd.t4 vss 8.30545e-14
Cpar31 vdd.t5 vss 1.57718e-14
.ends opamp_dut

Vdd vdd 0 3.300000
Vss vss 0 0
Ibias vdd ib 3.187500e-05
Vinp inp 0 DC 1.711000 AC 1 PWL(0 1.711000 3.000000e-09 1.711000 3.300000e-09 1.721000)
Rfb out inn 1m
Cload out 0 2.000000e-12
Xdut vdd vss inp inn out ib opamp_dut
.end
