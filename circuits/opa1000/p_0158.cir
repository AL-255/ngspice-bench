* opa1000[0158]: 2p/current_reuse_3v3_i10u_weak (current_reuse, VDD=3.3V, CL=2.0pF, Iref=1.6429uA)
.include "pdk_opa.inc"
.temp 27
.option gmin=1e-12 rshunt=1e12 reltol=1e-3 abstol=1e-12 vntol=1e-5 method=gear
* Post-PEX R+C extracted netlist for current_reuse_3v3_i10u_weak
.subckt opamp_dut vdd vss inp inn out ib
XMpar0 out.t1 a_991_6062.t8 vdd.t1 vdd.t0 pfet_03v3 w=2.48u l=0.75u ad=6.9440e-13 pd=3.0400e-06 as=8.5312e-13 ps=3.6640e-06 nf=1 m=10 par=10
XMpar1 a_5946_9600.t0 inn.t2 a_7854_11148.t0 vdd.t2 pfet_03v3 w=2.13u l=1.63u ad=9.3720e-13 pd=4.0750e-06 as=5.9640e-13 ps=2.6900e-06 nf=1 m=4 par=4
XMpar2 a_6822_5977.t0 inp.t0 a_991_6062.t4 vss.t0 nfet_03v3 w=1.88u l=1.63u ad=1.1280e-12 pd=4.9600e-06 as=5.2640e-13 ps=2.4400e-06 nf=1 m=2 par=2
XMpar3 out.t12 ib.t0 vss.t5 vss.t4 nfet_03v3 w=0.82u l=1.2u ad=2.8208e-13 pd=1.6720e-06 as=2.2960e-13 ps=1.3800e-06 nf=1 m=10 par=10
XMpar4 a_6822_5977.t4 ib.t0 vss.t5 vss.t4 nfet_03v3 w=0.82u l=1.2u ad=2.2960e-13 pd=1.3800e-06 as=2.2960e-13 ps=1.3800e-06 nf=1 m=4 par=4
XMpar5 a_5946_9600.t0 inp.t2 a_991_6062.t0 vdd.t2 pfet_03v3 w=2.13u l=1.63u ad=9.3720e-13 pd=4.0750e-06 as=5.9640e-13 ps=2.6900e-06 nf=1 m=4 par=4
XMpar6 ib.t1 ib.t0 vss.t5 vss.t4 nfet_03v3 w=0.82u l=1.2u ad=2.2960e-13 pd=1.3800e-06 as=2.2960e-13 ps=1.3800e-06 nf=1 m=2 par=2
XMpar7 a_991_6062.t6 a_7854_11148.t6 vdd.t1 vdd.t0 pfet_03v3 w=2.48u l=0.75u ad=1.4880e-12 pd=6.1600e-06 as=6.9440e-13 ps=3.0400e-06 nf=1 m=1
XMpar8 a_7854_11148.t7 a_7854_11148.t6 vdd.t1 vdd.t0 pfet_03v3 w=2.48u l=0.75u ad=1.4880e-12 pd=6.1600e-06 as=6.9440e-13 ps=3.0400e-06 nf=1 m=1
XMpar9 a_6822_5977.t0 inn.t0 a_7854_11148.t4 vss.t0 nfet_03v3 w=1.88u l=1.63u ad=1.1280e-12 pd=4.9600e-06 as=5.2640e-13 ps=2.4400e-06 nf=1 m=2 par=2
XMpar10 a_5946_9600.t8 a_7854_11148.t6 vdd.t1 vdd.t0 pfet_03v3 w=2.48u l=0.75u ad=6.9440e-13 pd=3.0400e-06 as=1.4880e-12 ps=6.1600e-06 nf=1 m=2 par=2
X1 a_4775_6062.t1 out.t0 cap_mim_2f0fF c_width=15.62u c_length=15.61u
X33 a_4775_6062.t1 out.t0 cap_mim_2f0fF c_width=15.62u c_length=15.61u
X41 a_991_6062.t7 a_4775_6062.t0 vss.t36 ppolyf_u_1k r_width=1u r_length=18.26u
Rpar0 a_4775_6062.t0 a_4775_6062.t1 60.8040
Rpar1 a_5946_9600.t0 a_5946_9600.t8 59.4144
Rpar2 a_6822_5977.t0 a_6822_5977.t4 54.2305
Rpar3 a_7854_11148.t0 a_7854_11148.t6 92.6324
Rpar4 a_7854_11148.t0 a_7854_11148.t4 147.9573
Rpar5 a_7854_11148.t0 a_7854_11148.t7 79.9657
Rpar6 a_7854_11148.t6 a_7854_11148.t4 108.1943
Rpar7 a_7854_11148.t6 a_7854_11148.t7 37.1130
Rpar8 a_7854_11148.t4 a_7854_11148.t7 496.2658
Rpar9 a_991_6062.t0 a_991_6062.t8 90.8426
Rpar10 a_991_6062.t0 a_991_6062.t4 298.8624
Rpar11 a_991_6062.t0 a_991_6062.t6 56.8404
Rpar12 a_991_6062.t0 a_991_6062.t7 272.4966
Rpar13 a_991_6062.t8 a_991_6062.t4 84.2769
Rpar14 a_991_6062.t8 a_991_6062.t6 195.1060
Rpar15 a_991_6062.t8 a_991_6062.t7 76.8419
Rpar16 a_991_6062.t4 a_991_6062.t6 641.8780
Rpar17 a_991_6062.t4 a_991_6062.t7 197.8515
Rpar18 a_991_6062.t6 a_991_6062.t7 585.2512
Rpar19 ib ib.t0 11.1911
Rpar20 ib ib.t1 15.1786
Rpar21 inn inn.t0 6.3393
Rpar22 inn inn.t2 35.0027
Rpar23 inp inp.t0 6.3879
Rpar24 inp inp.t2 34.9541
Rpar25 out out.t0 164.1444
Rpar26 out out.t1 150.0704
Rpar27 out out.t12 3.3573
Rpar28 out.t0 out.t1 196.0268
Rpar29 out.t0 out.t12 114.3202
Rpar30 out.t1 out.t12 104.5182
Rpar31 vdd vdd.t0 58.5994
Rpar32 vdd vdd.t1 52.6581
Rpar33 vdd vdd.t2 102.1554
Rpar34 vdd.t0 vdd.t1 3.7362
Rpar35 vdd.t0 vdd.t2 58.5202
Rpar36 vdd.t1 vdd.t2 49.9899
Rpar37 vss vss.t0 134.9033
Rpar38 vss vss.t4 62.0300
Rpar39 vss vss.t5 238.6109
Rpar40 vss vss.t36 243.4158
Rpar41 vss.t0 vss.t4 11.5924
Rpar42 vss.t0 vss.t5 50.1245
Rpar43 vss.t0 vss.t36 87.7845
Rpar44 vss.t4 vss.t5 5.3932
Rpar45 vss.t4 vss.t36 132.4749
Rpar46 vss.t5 vss.t36 568.3768
Cpar0 a_4775_6062.t0 vss 8.54687e-17
Cpar1 a_4775_6062.t1 vss 4.46807e-15
Cpar2 a_5946_9600.t0 vss 7.79033e-15
Cpar3 a_5946_9600.t8 vss 2.52466e-15
Cpar4 a_6822_5977.t0 vss 6.06244e-15
Cpar5 a_6822_5977.t4 vss 5.10487e-15
Cpar6 a_7854_11148.t0 vss 5.65578e-15
Cpar7 a_7854_11148.t4 vss 3.52753e-15
Cpar8 a_7854_11148.t6 vss 5.53305e-15
Cpar9 a_7854_11148.t7 vss 3.49638e-15
Cpar10 a_991_6062.t0 vss 3.65946e-15
Cpar11 a_991_6062.t4 vss 2.07286e-15
Cpar12 a_991_6062.t6 vss 2.29755e-15
Cpar13 a_991_6062.t7 vss 2.46522e-15
Cpar14 a_991_6062.t8 vss 7.84480e-15
Cpar15 ib out 9.58360e-16
Cpar16 ib vss 1.88216e-14
Cpar17 ib.t0 vss 3.01311e-15
Cpar18 ib.t1 vss 1.43410e-16
Cpar19 inn inp 1.03060e-16
Cpar20 inn out 2.72920e-16
Cpar21 inn vdd 4.75515e-15
Cpar22 inn vss 5.09976e-15
Cpar23 inn.t0 vss 1.31578e-15
Cpar24 inn.t2 vss 5.92873e-15
Cpar25 inp out 4.34600e-17
Cpar26 inp vdd 3.86166e-15
Cpar27 inp vss 5.48568e-15
Cpar28 inp.t0 vss 1.18850e-15
Cpar29 inp.t2 vss 5.32331e-15
Cpar30 out vdd 7.24329e-15
Cpar31 out vss 1.65344e-14
Cpar32 out.t0 vss 1.22905e-14
Cpar33 out.t1 vss 3.22892e-15
Cpar34 out.t12 vss 1.71271e-15
Cpar35 vdd vss 7.40292e-14
Cpar36 vdd.t0 vss 1.03737e-14
Cpar37 vdd.t1 vss 9.41927e-15
Cpar38 vdd.t2 vss 1.15501e-14
.ends opamp_dut

Vdd vdd 0 3.300000
Vss vss 0 0
Ibias vdd ib 1.642900e-06
Vinp inp 0 DC 1.645000 AC 1 PWL(0 1.645000 1.920274e-08 1.645000 2.112301e-08 1.655000)
Rfb out inn 1m
Cload out 0 2.000000e-12
Xdut vdd vss inp inn out ib opamp_dut
.end
