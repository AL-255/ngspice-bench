* opa1000[0521]: 200f/pmos_5t_1v8_i500u_weak (pmos_5t, VDD=1.8V, CL=0.2pF, Iref=100.0uA)
.include "pdk_opa.inc"
.temp 27
.option gmin=1e-12 rshunt=1e12 reltol=1e-3 abstol=1e-12 vntol=1e-5 method=gear
* Post-PEX R+C extracted netlist for pmos_5t_1v8_i500u_weak
.subckt opamp_dut vdd vss inp inn out ib
XMpar0 a_1473_13113.t25 inn.t0 out.t0 vdd.t62 pfet_03v3 w=3.26u l=0.36u ad=9.6496e-13 pd=4.0150e-06 as=9.1280e-13 ps=3.8200e-06 nf=1 m=160 par=160
XMpar1 out.t36 a_1970_6966.t160 vss.t66 vss.t1 nfet_03v3 w=2.03u l=0.5u ad=5.6840e-13 pd=2.5900e-06 as=5.6840e-13 ps=2.5900e-06 nf=1 m=28 par=28
XMpar2 a_1473_13113.t25 inp.t0 a_1970_6966.t0 vdd.t62 pfet_03v3 w=3.26u l=0.36u ad=9.6496e-13 pd=4.0150e-06 as=9.1280e-13 ps=3.8200e-06 nf=1 m=160 par=160
XMpar3 a_1473_13113.t0 a_1383_12905.t16 vdd.t1 vdd.t0 pfet_03v3 w=8.2u l=0.45u ad=2.2960e-12 pd=8.7600e-06 as=2.3780e-12 ps=9.0362e-06 nf=1 m=64 par=64
XMpar4 a_1970_6966.t161 a_1970_6966.t160 vss.t66 vss.t1 nfet_03v3 w=2.03u l=0.5u ad=6.6120e-13 pd=2.9714e-06 as=5.6840e-13 ps=2.5900e-06 nf=1 m=28 par=28
XMpar5 a_1383_12905.t0 ib.t0 vss.t2 vss.t1 nfet_03v3 w=2.33u l=0.45u ad=6.5240e-13 pd=2.8900e-06 as=6.5240e-13 ps=2.8900e-06 nf=1 m=16 par=16
XMpar6 ib.t1 ib.t0 vss.t2 vss.t1 nfet_03v3 w=2.33u l=0.45u ad=6.5240e-13 pd=2.8900e-06 as=7.4560e-13 ps=3.2612e-06 nf=1 m=16 par=16
XMpar7 a_1383_12905.t17 a_1383_12905.t16 vdd.t1 vdd.t0 pfet_03v3 w=8.2u l=0.45u ad=2.2960e-12 pd=8.7600e-06 as=2.2960e-12 ps=8.7600e-06 nf=1 m=16 par=16
X345 out.t188 vss.t0 cap_mim_2f0fF c_width=17.75u c_length=17.75u
Rpar0 a_1383_12905.t0 a_1383_12905.t16 11751.4677
Rpar1 a_1383_12905.t0 a_1383_12905.t17 70.3738
Rpar2 a_1383_12905.t16 a_1383_12905.t17 16.4596
Rpar3 a_1473_13113.t0 a_1473_13113.t25 44.1943
Rpar4 a_1970_6966.t0 a_1970_6966.t160 315.0635
Rpar5 a_1970_6966.t0 a_1970_6966.t161 57.8693
Rpar6 a_1970_6966.t160 a_1970_6966.t161 6.9263
Rpar7 ib ib.t0 78.2750
Rpar8 ib ib.t1 2.2356
Rpar9 ib.t0 ib.t1 17.3236
Rpar10 inn inn.t0 1.7227
Rpar11 inp inp.t0 1.7227
Rpar12 out out.t0 347.0957
Rpar13 out out.t36 2.8072
Rpar14 out out.t188 217.7131
Rpar15 out.t0 out.t36 113.7175
Rpar16 out.t0 out.t188 245.4126
Rpar17 out.t36 out.t188 71.3284
Rpar18 vdd vdd.t0 65.5421
Rpar19 vdd vdd.t1 839.6990
Rpar20 vdd vdd.t62 175.1214
Rpar21 vdd.t0 vdd.t1 3.6481
Rpar22 vdd.t0 vdd.t62 22.2555
Rpar23 vdd.t1 vdd.t62 285.1290
Rpar24 vss vss.t0 79.8096
Rpar25 vss vss.t1 104.1167
Rpar26 vss vss.t2 740.9717
Rpar27 vss vss.t66 134.9986
Rpar28 vss.t0 vss.t1 146.0888
Rpar29 vss.t0 vss.t2 1039.6763
Rpar30 vss.t0 vss.t66 189.4199
Rpar31 vss.t1 vss.t2 3.0485
Rpar32 vss.t1 vss.t66 8.6697
Rpar33 vss.t2 vss.t66 292.3215
Cpar0 a_1383_12905.t0 vss 1.24034e-14
Cpar1 a_1383_12905.t16 vss 6.50980e-14
Cpar2 a_1383_12905.t17 vss 3.04131e-14
Cpar3 a_1473_13113.t0 vss 1.33747e-13
Cpar4 a_1473_13113.t25 vss 2.94449e-13
Cpar5 a_1970_6966.t0 vss 1.21215e-13
Cpar6 a_1970_6966.t160 vss 3.27343e-14
Cpar7 a_1970_6966.t161 vss 2.60298e-14
Cpar8 ib vss 2.94690e-14
Cpar9 ib.t0 vss 2.82043e-15
Cpar10 ib.t1 vss 1.48152e-15
Cpar11 inn inp 2.10350e-16
Cpar12 inn out 2.31622e-14
Cpar13 inn vdd 4.66207e-14
Cpar14 inn vss 1.15288e-14
Cpar15 inn.t0 vss 7.52255e-14
Cpar16 inp out 1.52350e-16
Cpar17 inp vdd 4.67259e-14
Cpar18 inp vss 1.15640e-14
Cpar19 inp.t0 vss 7.53097e-14
Cpar20 out vdd 1.47326e-14
Cpar21 out vss 3.64888e-14
Cpar22 out.t0 vss 7.58792e-14
Cpar23 out.t188 vss 9.07204e-14
Cpar24 out.t36 vss 1.43260e-14
Cpar25 vdd vss 4.71196e-13
Cpar26 vdd.t0 vss 9.22242e-14
Cpar27 vdd.t1 vss 3.74475e-14
Cpar28 vdd.t62 vss 1.73303e-13
.ends opamp_dut

Vdd vdd 0 1.800000
Vss vss 0 0
Ibias vdd ib 1.000000e-04
Vinp inp 0 DC 0.805000 AC 1 PWL(0 0.805000 3.000000e-09 0.805000 3.300000e-09 0.815000)
Rfb out inn 1m
Cload out 0 2.000000e-13
Xdut vdd vss inp inn out ib opamp_dut
.end
