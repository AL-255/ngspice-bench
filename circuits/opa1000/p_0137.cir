* opa1000[0137]: 2p/current_reuse_1v8_i10u_subth (current_reuse, VDD=1.8V, CL=2.0pF, Iref=1.6429uA)
.include "pdk_opa.inc"
.temp 27
.option gmin=1e-12 rshunt=1e12 reltol=1e-3 abstol=1e-12 vntol=1e-5 method=gear
* Post-PEX R+C extracted netlist for current_reuse_1v8_i10u_subth
.subckt opamp_dut vdd vss inp inn out ib
XMpar0 a_6156_11052.t0 inp.t16 a_6824_12963.t0 vdd.t6 pfet_03v3 w=2.19u l=1.13u ad=6.5700e-13 pd=2.9269e-06 as=6.7890e-13 ps=3.0153e-06 nf=1 m=64 par=64
XMpar1 a_5810_11052.t0 inp a_6156_11052.t62 vss.t0 nfet_03v3 w=2u l=1.13u ad=6.4000e-13 pd=2.8900e-06 as=5.6000e-13 ps=2.5600e-06 nf=1 m=16 par=16
XMpar2 a_11374_3570.t58 inn a_5810_11052.t0 vss.t0 nfet_03v3 w=2u l=1.13u ad=5.6000e-13 pd=2.5600e-06 as=6.4000e-13 ps=2.8900e-06 nf=1 m=16 par=16
XMpar3 a_11374_3570.t0 inn.t16 a_6824_12963.t0 vdd.t6 pfet_03v3 w=2.19u l=1.13u ad=6.5700e-13 pd=2.9269e-06 as=6.7890e-13 ps=3.0153e-06 nf=1 m=64 par=64
XMpar4 out.t11 ib.t0 vss.t34 vss.t33 nfet_03v3 w=4.17u l=1.88u ad=1.4345e-12 pd=5.6920e-06 as=1.1676e-12 ps=4.7300e-06 nf=1 m=10 par=10
XMpar5 out.t0 a_6156_11052.t82 vdd.t1 vdd.t0 pfet_03v3 w=10u l=0.75u ad=2.8000e-12 pd=1.0560e-05 as=3.4400e-12 ps=1.2688e-05 nf=1 m=10 par=10
XMpar6 a_5810_11052.t32 ib.t0 vss.t34 vss.t33 nfet_03v3 w=4.17u l=1.88u ad=1.1676e-12 pd=4.7300e-06 as=1.1676e-12 ps=4.7300e-06 nf=1 m=4 par=4
XMpar7 ib.t1 ib.t0 vss.t34 vss.t33 nfet_03v3 w=4.17u l=1.88u ad=1.1676e-12 pd=4.7300e-06 as=1.1676e-12 ps=4.7300e-06 nf=1 m=2 par=2
XMpar8 a_11374_3570.t81 a_11374_3570.t80 vdd.t1 vdd.t0 pfet_03v3 w=10u l=0.75u ad=6.0000e-12 pd=2.1200e-05 as=2.8000e-12 ps=1.0560e-05 nf=1 m=1
XMpar9 a_6156_11052.t81 a_11374_3570.t80 vdd.t1 vdd.t0 pfet_03v3 w=10u l=0.75u ad=6.0000e-12 pd=2.1200e-05 as=2.8000e-12 ps=1.0560e-05 nf=1 m=1
XMpar10 a_6824_12963.t128 a_11374_3570.t80 vdd.t1 vdd.t0 pfet_03v3 w=10u l=0.75u ad=2.8000e-12 pd=1.0560e-05 as=6.0000e-12 ps=2.1200e-05 nf=1 m=2 par=2
X63 a_12444_1290.t1 out.t4 cap_mim_2f0fF c_width=19.48u c_length=19.47u
X92 a_6156_11052.t80 a_12444_1290.t0 vss.t32 ppolyf_u_1k r_width=1u r_length=8.65u
X163 a_12444_1290.t1 out.t4 cap_mim_2f0fF c_width=19.48u c_length=19.47u
X191 a_12444_1290.t1 out.t4 cap_mim_2f0fF c_width=19.48u c_length=19.47u
Rpar0 a_11374_3570.t0 a_11374_3570.t58 54.3398
Rpar1 a_11374_3570.t0 a_11374_3570.t80 605.9930
Rpar2 a_11374_3570.t0 a_11374_3570.t81 405.7723
Rpar3 a_11374_3570.t58 a_11374_3570.t80 209.0492
Rpar4 a_11374_3570.t58 a_11374_3570.t81 139.9791
Rpar5 a_11374_3570.t80 a_11374_3570.t81 40.4647
Rpar6 a_12444_1290.t0 a_12444_1290.t1 75.3298
Rpar7 a_5810_11052.t0 a_5810_11052.t32 57.3236
Rpar8 a_6156_11052.t0 a_6156_11052.t62 42.5581
Rpar9 a_6156_11052.t0 a_6156_11052.t80 689.7442
Rpar10 a_6156_11052.t0 a_6156_11052.t81 368.0709
Rpar11 a_6156_11052.t0 a_6156_11052.t82 769.9692
Rpar12 a_6156_11052.t62 a_6156_11052.t80 321.3484
Rpar13 a_6156_11052.t62 a_6156_11052.t81 171.4824
Rpar14 a_6156_11052.t62 a_6156_11052.t82 358.7249
Rpar15 a_6156_11052.t80 a_6156_11052.t81 121.0037
Rpar16 a_6156_11052.t80 a_6156_11052.t82 195.5348
Rpar17 a_6156_11052.t81 a_6156_11052.t82 135.0778
Rpar18 a_6824_12963.t0 a_6824_12963.t128 72.7765
Rpar19 ib ib.t0 12.0920
Rpar20 ib ib.t1 10.1972
Rpar21 inn inn.t16 42.6077
Rpar22 inp inp.t16 42.5591
Rpar23 out out.t0 343.2694
Rpar24 out out.t11 2.2859
Rpar25 out out.t4 585.7461
Rpar26 out.t0 out.t11 66.0176
Rpar27 out.t0 out.t4 161.1208
Rpar28 out.t11 out.t4 112.6507
Rpar29 vdd vdd.t0 284.3389
Rpar30 vdd vdd.t1 369.5832
Rpar31 vdd vdd.t6 20.5162
Rpar32 vdd.t0 vdd.t1 3.2717
Rpar33 vdd.t0 vdd.t6 298.3335
Rpar34 vdd.t1 vdd.t6 387.7735
Rpar35 vss vss.t0 66.3734
Rpar36 vss vss.t32 71.4987
Rpar37 vss vss.t33 173.5544
Rpar38 vss vss.t34 628.8143
Rpar39 vss.t0 vss.t32 11.9372
Rpar40 vss.t0 vss.t33 126.7557
Rpar41 vss.t0 vss.t34 464.5058
Rpar42 vss.t32 vss.t33 166.5573
Rpar43 vss.t32 vss.t34 603.6040
Rpar44 vss.t33 vss.t34 4.9991
Cpar0 a_11374_3570.t0 vss 4.75918e-14
Cpar1 a_11374_3570.t58 vss 1.39251e-14
Cpar2 a_11374_3570.t80 vss 9.50756e-15
Cpar3 a_11374_3570.t81 vss 9.79548e-15
Cpar4 a_12444_1290.t0 vss 1.18420e-16
Cpar5 a_12444_1290.t1 vss 1.10380e-14
Cpar6 a_5810_11052.t0 vss 1.82914e-14
Cpar7 a_5810_11052.t32 vss 8.85289e-15
Cpar8 a_6156_11052.t0 vss 3.95925e-14
Cpar9 a_6156_11052.t62 vss 1.19107e-14
Cpar10 a_6156_11052.t80 vss 3.97595e-15
Cpar11 a_6156_11052.t81 vss 7.45408e-15
Cpar12 a_6156_11052.t82 vss 1.94026e-14
Cpar13 a_6824_12963.t0 vss 8.75713e-14
Cpar14 a_6824_12963.t128 vss 7.04784e-15
Cpar15 ib out 2.68873e-15
Cpar16 ib vdd 1.05200e-17
Cpar17 ib vss 2.77753e-14
Cpar18 ib.t0 vss 6.13803e-15
Cpar19 ib.t1 vss 4.03524e-16
Cpar20 inn inp 2.79250e-16
Cpar21 inn vdd 3.69859e-14
Cpar22 inn vss 2.63868e-14
Cpar23 inn.t16 vss 5.58117e-14
Cpar24 inp out 3.45400e-17
Cpar25 inp vdd 3.52758e-14
Cpar26 inp vss 2.63839e-14
Cpar27 inp.t16 vss 5.49297e-14
Cpar28 out vdd 1.45943e-14
Cpar29 out vss 2.28844e-14
Cpar30 out.t0 vss 7.96432e-15
Cpar31 out.t11 vss 5.01053e-15
Cpar32 out.t4 vss 1.99240e-14
Cpar33 vdd vss 3.00517e-13
Cpar34 vdd.t0 vss 2.34513e-14
Cpar35 vdd.t1 vss 1.68895e-14
Cpar36 vdd.t6 vss 9.34976e-14
.ends opamp_dut

Vdd vdd 0 1.800000
Vss vss 0 0
Ibias vdd ib 1.642900e-06
Vinp inp 0 DC 0.895000 AC 1 PWL(0 0.895000 2.742459e-08 0.895000 3.016704e-08 0.905000)
Rfb out inn 1m
Cload out 0 2.000000e-12
Xdut vdd vss inp inn out ib opamp_dut
.end
