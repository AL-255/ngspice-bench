* opa1000[0795]: 2p/symmetrical_ota_1v8_i200n_weak (symmetrical_ota, VDD=1.8V, CL=2.0pF, Iref=0.0383uA)
.include "pdk_opa.inc"
.temp 27
.option gmin=1e-12 rshunt=1e12 reltol=1e-3 abstol=1e-12 vntol=1e-5 method=gear
* Post-PEX R+C extracted netlist for symmetrical_ota_1v8_i200n_weak
.subckt opamp_dut vdd vss inp inn out ib
XMpar0 out.t2 a_1916_6822.t2 vdd.t1 vdd.t0 pfet_03v3 w=0.46u l=8.13u ad=2.7600e-13 pd=2.1200e-06 as=2.0240e-13 ps=1.5700e-06 nf=1 m=4 par=4
XMpar1 a_9505_6822.t3 a_9505_6822.t2 vdd.t1 vdd.t0 pfet_03v3 w=0.46u l=8.13u ad=2.7600e-13 pd=2.1200e-06 as=1.2880e-13 ps=1.0200e-06 nf=1 m=2 par=2
XMpar2 a_6964_1041.t5 a_6964_1041.t4 vss.t1 vss.t0 nfet_03v3 w=0.4u l=8.13u ad=2.4000e-13 pd=2.0000e-06 as=1.1200e-13 ps=9.6000e-07 nf=1 m=4 par=4
XMpar3 a_5354_10074.t0 inn.t0 a_9505_6822.t0 vss.t2 nfet_03v3 w=0.46u l=6.5u ad=2.7600e-13 pd=2.1200e-06 as=1.2880e-13 ps=1.0200e-06 nf=1 m=2 par=2
XMpar4 a_5354_10074.t4 ib.t0 vss.t11 vss.t10 nfet_03v3 w=0.4u l=5u ad=2.4000e-13 pd=2.0000e-06 as=1.7600e-13 ps=1.4800e-06 nf=1 m=4 par=4
XMpar5 ib.t1 ib.t0 vss.t11 vss.t10 nfet_03v3 w=0.4u l=5u ad=2.4000e-13 pd=2.0000e-06 as=1.1200e-13 ps=9.6000e-07 nf=1 m=2 par=2
XMpar6 out.t0 a_6964_1041.t4 vss.t1 vss.t0 nfet_03v3 w=0.4u l=8.13u ad=2.4000e-13 pd=2.0000e-06 as=1.1200e-13 ps=9.6000e-07 nf=1 m=4 par=4
XMpar7 a_1916_6822.t0 inp.t0 a_5354_10074.t0 vss.t2 nfet_03v3 w=0.46u l=6.5u ad=1.2880e-13 pd=1.0200e-06 as=2.7600e-13 ps=2.1200e-06 nf=1 m=2 par=2
XMpar8 a_6964_1041.t0 a_9505_6822.t2 vdd.t1 vdd.t0 pfet_03v3 w=0.46u l=8.13u ad=2.7600e-13 pd=2.1200e-06 as=2.0240e-13 ps=1.5700e-06 nf=1 m=4 par=4
XMpar9 a_1916_6822.t3 a_1916_6822.t2 vdd.t1 vdd.t0 pfet_03v3 w=0.46u l=8.13u ad=2.7600e-13 pd=2.1200e-06 as=1.2880e-13 ps=1.0200e-06 nf=1 m=2 par=2
Rpar0 a_1916_6822.t0 a_1916_6822.t2 89.5220
Rpar1 a_1916_6822.t0 a_1916_6822.t3 132.5134
Rpar2 a_1916_6822.t2 a_1916_6822.t3 16.0855
Rpar3 a_5354_10074.t0 a_5354_10074.t4 63.3229
Rpar4 a_6964_1041.t0 a_6964_1041.t4 129.3567
Rpar5 a_6964_1041.t0 a_6964_1041.t5 122.7305
Rpar6 a_6964_1041.t4 a_6964_1041.t5 8.3346
Rpar7 a_9505_6822.t0 a_9505_6822.t2 89.5217
Rpar8 a_9505_6822.t0 a_9505_6822.t3 132.5140
Rpar9 a_9505_6822.t2 a_9505_6822.t3 16.0854
Rpar10 ib ib.t0 11.8691
Rpar11 ib ib.t1 13.1499
Rpar12 ib.t0 ib.t1 37.1268
Rpar13 inn inn.t0 3.2344
Rpar14 inp inp.t0 3.2829
Rpar15 out out.t0 11.0750
Rpar16 out out.t2 222.7698
Rpar17 out.t0 out.t2 91.7273
Rpar18 vdd vdd.t0 191.7612
Rpar19 vdd vdd.t1 81.0984
Rpar20 vdd.t0 vdd.t1 7.4802
Rpar21 vss vss.t0 73.0630
Rpar22 vss vss.t1 241.4497
Rpar23 vss vss.t10 821.4057
Rpar24 vss vss.t11 2483.3160
Rpar25 vss vss.t2 1306.8318
Rpar26 vss.t0 vss.t1 17.1382
Rpar27 vss.t0 vss.t10 199.4733
Rpar28 vss.t0 vss.t11 609.6348
Rpar29 vss.t0 vss.t2 317.9273
Rpar30 vss.t1 vss.t10 658.8177
Rpar31 vss.t1 vss.t11 2014.1439
Rpar32 vss.t1 vss.t2 1050.1170
Rpar33 vss.t10 vss.t11 18.2752
Rpar34 vss.t10 vss.t2 6.0289
Rpar35 vss.t11 vss.t2 42.8102
Cpar0 a_1916_6822.t0 vss 4.12619e-15
Cpar1 a_1916_6822.t2 vss 3.09072e-14
Cpar2 a_1916_6822.t3 vss 6.70225e-15
Cpar3 a_5354_10074.t0 vss 4.00176e-15
Cpar4 a_5354_10074.t4 vss 5.57791e-15
Cpar5 a_6964_1041.t0 vss 4.79927e-15
Cpar6 a_6964_1041.t4 vss 1.64021e-14
Cpar7 a_6964_1041.t5 vss 4.28684e-15
Cpar8 a_9505_6822.t0 vss 4.14283e-15
Cpar9 a_9505_6822.t2 vss 3.10318e-14
Cpar10 a_9505_6822.t3 vss 6.72926e-15
Cpar11 ib inn 1.83700e-17
Cpar12 ib vdd 1.76520e-16
Cpar13 ib vss 2.44905e-14
Cpar14 ib.t0 vss 3.48017e-15
Cpar15 ib.t1 vss 3.48600e-16
Cpar16 inn inp 5.16000e-17
Cpar17 inn vdd 1.29810e-16
Cpar18 inn vss 6.75364e-15
Cpar19 inn.t0 vss 5.37894e-16
Cpar20 inp vdd 3.63700e-17
Cpar21 inp vss 6.75707e-15
Cpar22 inp.t0 vss 4.99473e-16
Cpar23 out vdd 9.05710e-15
Cpar24 out vss 2.40092e-14
Cpar25 out.t0 vss 9.20344e-15
Cpar26 out.t2 vss 1.03656e-14
Cpar27 vdd vss 1.37381e-13
Cpar28 vdd.t0 vss 6.13726e-14
Cpar29 vdd.t1 vss 1.21475e-14
.ends opamp_dut

Vdd vdd 0 1.800000
Vss vss 0 0
Ibias vdd ib 3.830000e-08
Vinp inp 0 DC 0.895000 AC 1 PWL(0 0.895000 9.702312e-07 0.895000 1.067254e-06 0.905000)
Rfb out inn 1m
Cload out 0 2.000000e-12
Xdut vdd vss inp inn out ib opamp_dut
.end
