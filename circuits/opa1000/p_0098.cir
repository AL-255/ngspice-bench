* opa1000[0098]: 200f/current_reuse_1v8_i20u_subth (current_reuse, VDD=1.8V, CL=0.2pF, Iref=2.8571uA)
.include "pdk_opa.inc"
.temp 27
.option gmin=1e-12 rshunt=1e12 reltol=1e-3 abstol=1e-12 vntol=1e-5 method=gear
* Post-PEX R+C extracted netlist for current_reuse_1v8_i20u_subth
.subckt opamp_dut vdd vss inp inn out ib
XMpar0 a_4890_6046.t24 ib.t0 vss.t26 vss.t0 nfet_03v3 w=5.66u l=1.5u ad=1.5848e-12 pd=6.2200e-06 as=1.5848e-12 ps=6.2200e-06 nf=1 m=4 par=4
XMpar1 a_4890_6046.t0 inp.t0 a_742_6086.t40 vss.t0 nfet_03v3 w=1.95u l=0.81u ad=6.5000e-13 pd=2.9417e-06 as=5.4600e-13 ps=2.5100e-06 nf=1 m=12 par=12
XMpar2 a_4890_6046.t0 inn.t0 a_8388_15023.t40 vss.t0 nfet_03v3 w=1.95u l=0.81u ad=6.5000e-13 pd=2.9417e-06 as=5.4600e-13 ps=2.5100e-06 nf=1 m=12 par=12
XMpar3 a_4342_11187.t0 inn.t12 a_8388_15023.t0 vdd.t2 pfet_03v3 w=2.02u l=0.81u ad=6.3024e-13 pd=2.8460e-06 as=5.9792e-13 ps=2.7130e-06 nf=1 m=40 par=40
XMpar4 a_4342_11187.t0 inp.t12 a_742_6086.t0 vdd.t2 pfet_03v3 w=2.02u l=0.81u ad=6.3024e-13 pd=2.8460e-06 as=5.9792e-13 ps=2.7130e-06 nf=1 m=40 par=40
XMpar5 out.t1 a_742_6086.t54 vdd.t1 vdd.t0 pfet_03v3 w=10u l=0.48u ad=2.8000e-12 pd=1.0560e-05 as=3.4400e-12 ps=1.2688e-05 nf=1 m=10 par=10
XMpar6 a_8388_15023.t53 a_8388_15023.t52 vdd.t1 vdd.t0 pfet_03v3 w=10u l=0.48u ad=6.0000e-12 pd=2.1200e-05 as=2.8000e-12 ps=1.0560e-05 nf=1 m=1
XMpar7 out.t12 ib.t0 vss.t26 vss.t0 nfet_03v3 w=5.66u l=1.5u ad=1.9470e-12 pd=7.4800e-06 as=1.5848e-12 ps=6.2200e-06 nf=1 m=10 par=10
XMpar8 a_4342_11187.t80 a_8388_15023.t52 vdd.t1 vdd.t0 pfet_03v3 w=10u l=0.48u ad=2.8000e-12 pd=1.0560e-05 as=6.0000e-12 ps=2.1200e-05 nf=1 m=2 par=2
XMpar9 ib.t1 ib.t0 vss.t26 vss.t0 nfet_03v3 w=5.66u l=1.5u ad=1.5848e-12 pd=6.2200e-06 as=1.5848e-12 ps=6.2200e-06 nf=1 m=2 par=2
XMpar10 a_742_6086.t52 a_8388_15023.t52 vdd.t1 vdd.t0 pfet_03v3 w=10u l=0.48u ad=6.0000e-12 pd=2.1200e-05 as=2.8000e-12 ps=1.0560e-05 nf=1 m=1
X5 a_2258_6086.t1 out.t0 cap_mim_2f0fF c_width=15.74u c_length=15.73u
X14 a_2258_6086.t1 out.t0 cap_mim_2f0fF c_width=15.74u c_length=15.73u
X90 a_742_6086.t53 a_2258_6086.t0 vss.t24 ppolyf_u_1k r_width=1u r_length=6.92u
Rpar0 a_2258_6086.t0 a_2258_6086.t1 49.8833
Rpar1 a_4342_11187.t0 a_4342_11187.t80 49.9612
Rpar2 a_4890_6046.t0 a_4890_6046.t24 50.7372
Rpar3 a_742_6086.t0 a_742_6086.t40 220.2033
Rpar4 a_742_6086.t0 a_742_6086.t52 89.4887
Rpar5 a_742_6086.t0 a_742_6086.t53 223.8843
Rpar6 a_742_6086.t0 a_742_6086.t54 112.4443
Rpar7 a_742_6086.t40 a_742_6086.t52 622.4183
Rpar8 a_742_6086.t40 a_742_6086.t53 98.7879
Rpar9 a_742_6086.t40 a_742_6086.t54 102.3384
Rpar10 a_742_6086.t52 a_742_6086.t53 632.8228
Rpar11 a_742_6086.t52 a_742_6086.t54 317.8309
Rpar12 a_742_6086.t53 a_742_6086.t54 104.0491
Rpar13 a_8388_15023.t0 a_8388_15023.t40 123.8744
Rpar14 a_8388_15023.t0 a_8388_15023.t52 331.5697
Rpar15 a_8388_15023.t0 a_8388_15023.t53 86.8684
Rpar16 a_8388_15023.t40 a_8388_15023.t52 143.7794
Rpar17 a_8388_15023.t40 a_8388_15023.t53 266.0937
Rpar18 a_8388_15023.t52 a_8388_15023.t53 79.4557
Rpar19 ib ib.t0 26.3863
Rpar20 ib ib.t1 10.4847
Rpar21 ib.t0 ib.t1 54.4910
Rpar22 inn inn.t0 1.9073
Rpar23 inn inn.t12 64.0308
Rpar24 inp inp.t0 1.9559
Rpar25 inp inp.t12 63.9822
Rpar26 out out.t0 292.2095
Rpar27 out out.t1 1.5761
Rpar28 out out.t12 197.0898
Rpar29 out.t0 out.t1 415.7393
Rpar30 out.t0 out.t12 65.0008
Rpar31 out.t1 out.t12 280.4083
Rpar32 vdd vdd.t0 55.7137
Rpar33 vdd vdd.t1 81.2302
Rpar34 vdd vdd.t2 76.7981
Rpar35 vdd.t0 vdd.t1 3.4504
Rpar36 vdd.t0 vdd.t2 52.3352
Rpar37 vdd.t1 vdd.t2 75.6154
Rpar38 vss vss.t0 42.8058
Rpar39 vss vss.t24 154.0211
Rpar40 vss vss.t26 520.1230
Rpar41 vss.t0 vss.t24 178.8441
Rpar42 vss.t0 vss.t26 4.3760
Rpar43 vss.t24 vss.t26 2423.4109
Cpar0 a_2258_6086.t0 vss 6.35123e-17
Cpar1 a_2258_6086.t1 vss 4.33005e-15
Cpar2 a_4342_11187.t0 vss 5.35701e-14
Cpar3 a_4342_11187.t80 vss 5.97228e-15
Cpar4 a_4890_6046.t0 vss 1.32634e-14
Cpar5 a_4890_6046.t24 vss 8.15368e-15
Cpar6 a_742_6086.t0 vss 2.46899e-14
Cpar7 a_742_6086.t40 vss 7.65493e-15
Cpar8 a_742_6086.t52 vss 6.08946e-15
Cpar9 a_742_6086.t53 vss 2.81265e-15
Cpar10 a_742_6086.t54 vss 1.21581e-14
Cpar11 a_8388_15023.t0 vss 2.91319e-14
Cpar12 a_8388_15023.t40 vss 1.07758e-14
Cpar13 a_8388_15023.t52 vss 5.83093e-15
Cpar14 a_8388_15023.t53 vss 9.04177e-15
Cpar15 ib out 3.08704e-15
Cpar16 ib vss 2.51150e-14
Cpar17 ib.t0 vss 6.21361e-15
Cpar18 ib.t1 vss 4.99503e-16
Cpar19 inn inp 1.48730e-16
Cpar20 inn out 2.86430e-16
Cpar21 inn vdd 2.08121e-14
Cpar22 inn vss 1.42362e-14
Cpar23 inn.t0 vss 4.50699e-15
Cpar24 inn.t12 vss 3.04465e-14
Cpar25 inp out 1.40130e-16
Cpar26 inp vdd 1.97096e-14
Cpar27 inp vss 1.45099e-14
Cpar28 inp.t0 vss 4.31679e-15
Cpar29 inp.t12 vss 2.86480e-14
Cpar30 out vdd 1.96846e-14
Cpar31 out vss 2.57199e-14
Cpar32 out.t0 vss 1.45625e-14
Cpar33 out.t1 vss 7.96862e-15
Cpar34 out.t12 vss 8.77898e-15
Cpar35 vdd vss 1.94001e-13
Cpar36 vdd.t0 vss 2.13089e-14
Cpar37 vdd.t1 vss 1.63404e-14
Cpar38 vdd.t2 vss 5.71028e-14
.ends opamp_dut

Vdd vdd 0 1.800000
Vss vss 0 0
Ibias vdd ib 2.857100e-06
Vinp inp 0 DC 0.895000 AC 1 PWL(0 0.895000 6.910063e-09 0.895000 7.601069e-09 0.905000)
Rfb out inn 1m
Cload out 0 2.000000e-13
Xdut vdd vss inp inn out ib opamp_dut
.end
