* opa1000[0688]: 200f/rail_to_rail_3v3_i50n_weak (rail_to_rail, VDD=3.3V, CL=0.2pF, Iref=0.0066uA)
.include "pdk_opa.inc"
.temp 27
.option gmin=1e-12 rshunt=1e12 reltol=1e-3 abstol=1e-12 vntol=1e-5 method=gear
* Post-PEX R+C extracted netlist for rail_to_rail_3v3_i50n_weak
.subckt opamp_dut vdd vss inp inn out ib
XMpar0 out.t0 ib.t0 vss.t18 vss.t17 nfet_03v3 w=0.4u l=5u ad=1.1200e-13 pd=9.6000e-07 as=2.0800e-13 ps=1.7400e-06 nf=1 m=8 par=8
XMpar1 a_8224_4150.t1 a_8224_4150.t0 vss.t2 vss.t1 nfet_03v3 w=0.4u l=4.23u ad=2.4000e-13 pd=2.0000e-06 as=1.1200e-13 ps=9.6000e-07 nf=1 m=2 par=2
XMpar2 a_7506_7378.t2 ib.t0 vss.t18 vss.t17 nfet_03v3 w=0.4u l=5u ad=2.4000e-13 pd=2.0000e-06 as=1.1200e-13 ps=9.6000e-07 nf=1 m=2 par=2
XMpar3 out.t3 a_1032_1290.t7 vdd.t1 vdd.t0 pfet_03v3 w=0.4u l=4u ad=1.1200e-13 pd=9.6000e-07 as=1.7600e-13 ps=1.4800e-06 nf=1 m=8 par=8
XMpar4 a_12455_4150.t1 a_12455_4150.t0 vdd.t3 vdd.t2 pfet_03v3 w=0.4u l=5u ad=1.1200e-13 pd=9.6000e-07 as=1.1200e-13 ps=9.6000e-07 nf=1 m=2 par=2
XMpar5 a_7506_9665.t2 inn.t2 a_8224_4150.t4 vdd.t12 pfet_03v3 w=0.4u l=5.2u ad=2.4000e-13 pd=2.0000e-06 as=2.4000e-13 ps=2.0000e-06 nf=1 m=2 par=2
XMpar6 a_7506_7378.t0 inn.t0 a_8270_1086.t6 vss.t7 nfet_03v3 w=0.4u l=5.2u ad=2.4000e-13 pd=2.0000e-06 as=2.4000e-13 ps=2.0000e-06 nf=1 m=2 par=2
XMpar7 a_1032_1290.t0 a_8224_4150.t0 vss.t2 vss.t1 nfet_03v3 w=0.4u l=4.23u ad=2.4000e-13 pd=2.0000e-06 as=1.1200e-13 ps=9.6000e-07 nf=1 m=2 par=2
XMpar8 a_7506_9665.t0 a_12455_4150.t0 vdd.t3 vdd.t2 pfet_03v3 w=0.4u l=5u ad=2.4000e-13 pd=2.0000e-06 as=1.1200e-13 ps=9.6000e-07 nf=1 m=2 par=2
XMpar9 a_7040_15475.t1 a_7040_15475.t0 vss.t2 vss.t1 nfet_03v3 w=0.4u l=4.23u ad=2.4000e-13 pd=2.0000e-06 as=1.1200e-13 ps=9.6000e-07 nf=1 m=2 par=2
XMpar10 a_8270_1086.t3 a_8270_1086.t2 vdd.t1 vdd.t0 pfet_03v3 w=0.4u l=4u ad=2.4000e-13 pd=2.0000e-06 as=1.1200e-13 ps=9.6000e-07 nf=1 m=2 par=2
XMpar11 a_8270_1086.t0 a_7040_15475.t0 vss.t2 vss.t1 nfet_03v3 w=0.4u l=4.23u ad=1.1200e-13 pd=9.6000e-07 as=1.1200e-13 ps=9.6000e-07 nf=1 m=2 par=2
XMpar12 a_1032_1290.t2 inp.t0 a_7506_7378.t0 vss.t7 nfet_03v3 w=0.4u l=5.2u ad=2.4000e-13 pd=2.0000e-06 as=2.4000e-13 ps=2.0000e-06 nf=1 m=2 par=2
XMpar13 a_1032_1290.t4 a_8270_1086.t2 vdd.t1 vdd.t0 pfet_03v3 w=0.4u l=4u ad=2.4000e-13 pd=2.0000e-06 as=1.1200e-13 ps=9.6000e-07 nf=1 m=2 par=2
XMpar14 ib.t1 ib.t0 vss.t18 vss.t17 nfet_03v3 w=0.4u l=5u ad=2.4000e-13 pd=2.0000e-06 as=1.1200e-13 ps=9.6000e-07 nf=1 m=2 par=2
XMpar15 a_12455_4150.t4 ib.t0 vss.t18 vss.t17 nfet_03v3 w=0.4u l=5u ad=2.4000e-13 pd=2.0000e-06 as=1.1200e-13 ps=9.6000e-07 nf=1 m=2 par=2
XMpar16 a_7040_15475.t4 inp.t2 a_7506_9665.t2 vdd.t12 pfet_03v3 w=0.4u l=5.2u ad=2.4000e-13 pd=2.0000e-06 as=2.4000e-13 ps=2.0000e-06 nf=1 m=2 par=2
X1 a_1032_4930.t0 a_5010_4410.t0 vss.t0 ppolyf_u_1k r_width=1u r_length=19.23u
X7 a_1032_1810.t0 a_5010_1290.t0 vss.t0 ppolyf_u_1k r_width=1u r_length=19.23u
X13 a_1032_7010.t0 a_5010_7530.t0 vss.t0 ppolyf_u_1k r_width=1u r_length=19.23u
X15 a_1032_3890.t0 a_5010_4410.t0 vss.t0 ppolyf_u_1k r_width=1u r_length=19.23u
X21 a_1032_7010.t0 a_5010_6490.t0 vss.t0 ppolyf_u_1k r_width=1u r_length=19.23u
X27 a_5010_7530.t1 out.t4 cap_mim_2f0fF c_width=13.83u c_length=13.83u
X29 a_1032_1290.t6 a_5010_1290.t0 vss.t0 ppolyf_u_1k r_width=1u r_length=19.23u
X33 a_1032_3890.t0 a_5010_3370.t0 vss.t0 ppolyf_u_1k r_width=1u r_length=19.23u
X40 a_1032_5970.t0 a_5010_6490.t0 vss.t0 ppolyf_u_1k r_width=1u r_length=19.23u
X43 a_1032_2850.t0 a_5010_3370.t0 vss.t0 ppolyf_u_1k r_width=1u r_length=19.23u
X47 a_1032_5970.t0 a_5010_5450.t0 vss.t0 ppolyf_u_1k r_width=1u r_length=19.23u
X48 a_1032_2850.t0 a_5010_2330.t0 vss.t0 ppolyf_u_1k r_width=1u r_length=19.23u
X54 a_1032_4930.t0 a_5010_5450.t0 vss.t0 ppolyf_u_1k r_width=1u r_length=19.23u
X55 a_1032_1810.t0 a_5010_2330.t0 vss.t0 ppolyf_u_1k r_width=1u r_length=19.23u
Rpar0 a_1032_1290.t0 a_1032_1290.t7 122.1690
Rpar1 a_1032_1290.t0 a_1032_1290.t2 336.7850
Rpar2 a_1032_1290.t0 a_1032_1290.t4 65.2602
Rpar3 a_1032_1290.t0 a_1032_1290.t6 155.1016
Rpar4 a_1032_1290.t7 a_1032_1290.t2 52.2132
Rpar5 a_1032_1290.t7 a_1032_1290.t4 133.7160
Rpar6 a_1032_1290.t7 a_1032_1290.t6 317.7981
Rpar7 a_1032_1290.t2 a_1032_1290.t4 368.6169
Rpar8 a_1032_1290.t2 a_1032_1290.t6 876.0785
Rpar9 a_1032_1290.t4 a_1032_1290.t6 129.2308
Rpar10 a_12455_4150.t0 a_12455_4150.t1 29.6562
Rpar11 a_12455_4150.t0 a_12455_4150.t4 124.4345
Rpar12 a_12455_4150.t1 a_12455_4150.t4 114.6603
Rpar13 a_5010_7530.t0 a_5010_7530.t1 65.0259
Rpar14 a_7040_15475.t0 a_7040_15475.t1 21.7073
Rpar15 a_7040_15475.t0 a_7040_15475.t4 137.1939
Rpar16 a_7040_15475.t1 a_7040_15475.t4 103.3293
Rpar17 a_7506_7378.t0 a_7506_7378.t2 49.7516
Rpar18 a_7506_9665.t0 a_7506_9665.t2 57.1067
Rpar19 a_8224_4150.t0 a_8224_4150.t1 16.3609
Rpar20 a_8224_4150.t0 a_8224_4150.t4 134.6075
Rpar21 a_8224_4150.t1 a_8224_4150.t4 139.4476
Rpar22 a_8270_1086.t0 a_8270_1086.t2 449.6279
Rpar23 a_8270_1086.t0 a_8270_1086.t3 452.0908
Rpar24 a_8270_1086.t0 a_8270_1086.t6 142.8808
Rpar25 a_8270_1086.t2 a_8270_1086.t3 15.9452
Rpar26 a_8270_1086.t2 a_8270_1086.t6 193.5716
Rpar27 a_8270_1086.t3 a_8270_1086.t6 194.6319
Rpar28 ib ib.t0 15.6430
Rpar29 ib ib.t1 16.6361
Rpar30 ib.t0 ib.t1 29.4297
Rpar31 inn inn.t0 4.3026
Rpar32 inn inn.t2 45.0503
Rpar33 inp inp.t0 4.3033
Rpar34 inp inp.t2 53.4252
Rpar35 out out.t0 6.6462
Rpar36 out out.t3 200.7305
Rpar37 out out.t4 585.4601
Rpar38 out.t0 out.t3 76.7697
Rpar39 out.t0 out.t4 223.9100
Rpar40 out.t3 out.t4 93.7681
Rpar41 vdd vdd.t0 345.6966
Rpar42 vdd vdd.t1 191.1419
Rpar43 vdd vdd.t2 523.2783
Rpar44 vdd vdd.t3 1110.9794
Rpar45 vdd vdd.t12 88.2349
Rpar46 vdd.t0 vdd.t1 9.0822
Rpar47 vdd.t0 vdd.t2 138.2867
Rpar48 vdd.t0 vdd.t3 293.5984
Rpar49 vdd.t0 vdd.t12 230.6437
Rpar50 vdd.t1 vdd.t2 273.8064
Rpar51 vdd.t1 vdd.t3 581.3222
Rpar52 vdd.t1 vdd.t12 58.9318
Rpar53 vdd.t2 vdd.t3 13.2920
Rpar54 vdd.t2 vdd.t12 675.0633
Rpar55 vdd.t3 vdd.t12 1433.2362
Rpar56 vss vss.t0 555.4463
Rpar57 vss vss.t1 133.6234
Rpar58 vss vss.t2 154.7095
Rpar59 vss vss.t17 248.4674
Rpar60 vss vss.t18 1501.6462
Rpar61 vss vss.t7 337.4695
Rpar62 vss.t0 vss.t1 73.3837
Rpar63 vss.t0 vss.t2 287.1672
Rpar64 vss.t0 vss.t17 804.2791
Rpar65 vss.t0 vss.t18 4925.8916
Rpar66 vss.t0 vss.t7 167.8899
Rpar67 vss.t1 vss.t2 18.4360
Rpar68 vss.t1 vss.t17 7.7867
Rpar69 vss.t1 vss.t18 58.7438
Rpar70 vss.t1 vss.t7 3.6566
Rpar71 vss.t2 vss.t17 14.0521
Rpar72 vss.t2 vss.t18 118.9653
Rpar73 vss.t2 vss.t7 58.0720
Rpar74 vss.t17 vss.t18 18.1791
Rpar75 vss.t17 vss.t7 493.6750
Cpar0 a_1032_1290.t0 vss 5.41955e-15
Cpar1 a_1032_1290.t2 vss 3.45063e-15
Cpar2 a_1032_1290.t4 vss 5.49840e-15
Cpar3 a_1032_1290.t6 vss 3.96262e-15
Cpar4 a_1032_1290.t7 vss 1.71781e-14
Cpar5 a_1032_1810.t0 vss 4.08000e-17
Cpar6 a_1032_2850.t0 vss 3.72000e-17
Cpar7 a_1032_3890.t0 vss 3.58200e-17
Cpar8 a_1032_4930.t0 vss 3.58200e-17
Cpar9 a_1032_5970.t0 vss 3.65600e-17
Cpar10 a_1032_7010.t0 vss 3.41600e-17
Cpar11 a_12455_4150.t0 vss 1.05090e-14
Cpar12 a_12455_4150.t1 vss 3.36831e-15
Cpar13 a_12455_4150.t4 vss 1.17217e-14
Cpar14 a_5010_1290.t0 vss 3.74600e-17
Cpar15 a_5010_2330.t0 vss 3.89000e-17
Cpar16 a_5010_3370.t0 vss 2.93600e-17
Cpar17 a_5010_4410.t0 vss 2.93600e-17
Cpar18 a_5010_5450.t0 vss 3.36400e-17
Cpar19 a_5010_6490.t0 vss 3.63000e-17
Cpar20 a_5010_7530.t0 vss 2.15570e-16
Cpar21 a_5010_7530.t1 vss 3.70392e-15
Cpar22 a_7040_15475.t0 vss 5.28847e-15
Cpar23 a_7040_15475.t1 vss 1.98684e-15
Cpar24 a_7040_15475.t4 vss 2.68521e-15
Cpar25 a_7506_7378.t0 vss 1.15430e-14
Cpar26 a_7506_7378.t2 vss 1.55030e-14
Cpar27 a_7506_9665.t0 vss 6.85438e-15
Cpar28 a_7506_9665.t2 vss 1.05884e-14
Cpar29 a_8224_4150.t0 vss 5.93565e-15
Cpar30 a_8224_4150.t1 vss 2.12446e-15
Cpar31 a_8224_4150.t4 vss 2.74810e-15
Cpar32 a_8270_1086.t0 vss 6.41314e-15
Cpar33 a_8270_1086.t2 vss 9.29833e-15
Cpar34 a_8270_1086.t3 vss 3.89358e-15
Cpar35 a_8270_1086.t6 vss 6.03813e-15
Cpar36 ib inn 1.11200e-17
Cpar37 ib inp 1.05700e-17
Cpar38 ib out 1.81368e-15
Cpar39 ib vdd 1.21340e-16
Cpar40 ib vss 4.45512e-14
Cpar41 ib.t0 vss 1.45198e-14
Cpar42 ib.t1 vss 1.17620e-15
Cpar43 inn inp 2.09090e-16
Cpar44 inn vdd 5.22631e-15
Cpar45 inn vss 9.82989e-15
Cpar46 inn.t0 vss 2.49935e-15
Cpar47 inn.t2 vss 5.53276e-15
Cpar48 inp vdd 5.54003e-15
Cpar49 inp vss 9.64685e-15
Cpar50 inp.t0 vss 2.51647e-15
Cpar51 inp.t2 vss 5.49915e-15
Cpar52 out vdd 1.26982e-14
Cpar53 out vss 2.07813e-14
Cpar54 out.t0 vss 4.80384e-15
Cpar55 out.t3 vss 6.34092e-15
Cpar56 out.t4 vss 1.09176e-14
Cpar57 vdd vss 1.50188e-13
Cpar58 vdd.t0 vss 3.11134e-14
Cpar59 vdd.t1 vss 1.21488e-14
Cpar60 vdd.t12 vss 1.58810e-14
Cpar61 vdd.t2 vss 1.17956e-14
Cpar62 vdd.t3 vss 5.21928e-15
.ends opamp_dut

Vdd vdd 0 3.300000
Vss vss 0 0
Ibias vdd ib 6.600000e-09
Vinp inp 0 DC 1.645000 AC 1 PWL(0 1.645000 1.537363e-06 1.645000 1.691099e-06 1.655000)
Rfb out inn 1m
Cload out 0 2.000000e-13
Xdut vdd vss inp inn out ib opamp_dut
.end
