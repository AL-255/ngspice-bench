* opa1000[0389]: 2p/nmos_5t_1v8_i10u_subth (nmos_5t, VDD=1.8V, CL=2.0pF, Iref=3.25uA)
.include "pdk_opa.inc"
.temp 27
.option gmin=1e-12 rshunt=1e12 reltol=1e-3 abstol=1e-12 vntol=1e-5 method=gear
* Post-PEX R+C extracted netlist for nmos_5t_1v8_i10u_subth
.subckt opamp_dut vdd vss inp inn out ib
XMpar0 out.t0 a_1647_11577.t0 vdd.t1 vdd.t0 pfet_03v3 w=1.95u l=1.44u ad=6.2088e-13 pd=2.8208e-06 as=5.4600e-13 ps=2.5100e-06 nf=1 m=50 par=50
XMpar1 a_1623_1204.t0 inp.t0 a_1647_11577.t100 vss.t0 nfet_03v3 w=4.55u l=1.35u ad=1.4560e-12 pd=5.7587e-06 as=1.2740e-12 ps=5.1100e-06 nf=1 m=64 par=64
XMpar2 a_1647_11577.t1 a_1647_11577.t0 vdd.t1 vdd.t0 pfet_03v3 w=1.95u l=1.44u ad=5.7096e-13 pd=2.6136e-06 as=6.7080e-13 ps=3.0280e-06 nf=1 m=50 par=50
XMpar3 a_1623_1204.t128 ib.t0 vss.t33 vss.t0 nfet_03v3 w=10u l=2.25u ad=2.8000e-12 pd=1.0560e-05 as=3.6000e-12 ps=1.3220e-05 nf=1 m=8 par=8
XMpar4 a_1623_1204.t0 inn.t0 out.t24 vss.t0 nfet_03v3 w=4.55u l=1.35u ad=1.4560e-12 pd=5.7587e-06 as=1.2740e-12 ps=5.1100e-06 nf=1 m=64 par=64
XMpar5 ib.t1 ib.t0 vss.t33 vss.t0 nfet_03v3 w=10u l=2.25u ad=2.8000e-12 pd=1.0560e-05 as=2.8000e-12 ps=1.0560e-05 nf=1 m=2 par=2
Rpar0 a_1623_1204.t0 a_1623_1204.t128 38.5023
Rpar1 a_1647_11577.t0 a_1647_11577.t1 4.8964
Rpar2 a_1647_11577.t0 a_1647_11577.t100 154.5777
Rpar3 a_1647_11577.t1 a_1647_11577.t100 47.1057
Rpar4 ib ib.t0 14.1995
Rpar5 ib ib.t1 8.7114
Rpar6 inn inn.t0 1.6027
Rpar7 inp inp.t0 1.6027
Rpar8 out out.t0 3.4929
Rpar9 out out.t24 4945.9376
Rpar10 out.t0 out.t24 39.8315
Rpar11 vdd vdd.t0 19.0795
Rpar12 vdd vdd.t1 3293.2784
Rpar13 vdd.t0 vdd.t1 8.9621
Rpar14 vss vss.t0 19.5995
Rpar15 vss vss.t33 452.9280
Rpar16 vss.t0 vss.t33 5.0958
Cpar0 a_1623_1204.t0 vss 1.00669e-13
Cpar1 a_1623_1204.t128 vss 1.28405e-14
Cpar2 a_1647_11577.t0 vss 1.17586e-13
Cpar3 a_1647_11577.t1 vss 4.31988e-14
Cpar4 a_1647_11577.t100 vss 6.46532e-14
Cpar5 ib inp 4.04100e-17
Cpar6 ib vss 2.42500e-14
Cpar7 ib.t0 vss 6.04514e-15
Cpar8 ib.t1 vss 4.44390e-16
Cpar9 inn inp 2.09120e-16
Cpar10 inn out 2.20712e-14
Cpar11 inn vdd 2.15400e-17
Cpar12 inn vss 4.39537e-14
Cpar13 inn.t0 vss 3.64808e-14
Cpar14 inp vdd 2.21000e-17
Cpar15 inp vss 4.39429e-14
Cpar16 inp.t0 vss 3.66090e-14
Cpar17 out vdd 3.78171e-14
Cpar18 out vss 1.79065e-14
Cpar19 out.t0 vss 4.85545e-14
Cpar20 out.t24 vss 7.21613e-14
Cpar21 vdd vss 2.46182e-13
Cpar22 vdd.t0 vss 1.47989e-13
Cpar23 vdd.t1 vss 1.76943e-14
.ends opamp_dut

Vdd vdd 0 1.800000
Vss vss 0 0
Ibias vdd ib 3.250000e-06
Vinp inp 0 DC 0.895000 AC 1 PWL(0 0.895000 1.125567e-08 0.895000 1.238123e-08 0.905000)
Rfb out inn 1m
Cload out 0 2.000000e-12
Xdut vdd vss inp inn out ib opamp_dut
.end
