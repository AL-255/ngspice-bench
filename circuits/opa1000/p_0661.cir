* opa1000[0661]: 2p/pmos_miller_3v3_i20u_weak (pmos_miller, VDD=3.3V, CL=2.0pF, Iref=2.875uA)
.include "pdk_opa.inc"
.temp 27
.option gmin=1e-12 rshunt=1e12 reltol=1e-3 abstol=1e-12 vntol=1e-5 method=gear
* Post-PEX R+C extracted netlist for pmos_miller_3v3_i20u_weak
.subckt opamp_dut vdd vss inp inn out ib
XMpar0 a_1509_8140.t2 inp.t0 a_2412_12540.t0 vdd.t2 pfet_03v3 w=1.98u l=1.35u ad=5.8775e-13 pd=2.6779e-06 as=6.2109e-13 ps=2.8158e-06 nf=1 m=38 par=38
XMpar1 out.t4 a_1509_8140.t41 vss.t1 vss.t0 nfet_03v3 w=2.08u l=0.9u ad=5.8240e-13 pd=2.6400e-06 as=7.1552e-13 ps=3.1840e-06 nf=1 m=10 par=10
XMpar2 a_2412_12540.t0 inn.t0 a_7212_6009.t0 vdd.t2 pfet_03v3 w=1.98u l=1.35u ad=6.2109e-13 pd=2.8158e-06 as=5.8775e-13 ps=2.6779e-06 nf=1 m=38 par=38
XMpar3 out.t0 a_2501_10454.t2 vdd.t1 vdd.t0 pfet_03v3 w=8.1u l=1.5u ad=2.7864e-12 pd=1.0408e-05 as=2.2680e-12 ps=8.6600e-06 nf=1 m=10 par=10
XMpar4 a_2501_10454.t0 ib.t0 vss.t23 vss.t22 nfet_03v3 w=1.85u l=1.5u ad=5.1800e-13 pd=2.4100e-06 as=5.1800e-13 ps=2.4100e-06 nf=1 m=2 par=2
XMpar5 a_1509_8140.t0 a_7212_6009.t38 vss.t1 vss.t0 nfet_03v3 w=2.08u l=0.9u ad=1.2480e-12 pd=5.3600e-06 as=5.8240e-13 ps=2.6400e-06 nf=1 m=2 par=2
XMpar6 a_2412_12540.t38 a_2501_10454.t2 vdd.t1 vdd.t0 pfet_03v3 w=8.1u l=1.5u ad=2.2680e-12 pd=8.6600e-06 as=2.2680e-12 ps=8.6600e-06 nf=1 m=4 par=4
XMpar7 ib.t1 ib.t0 vss.t23 vss.t22 nfet_03v3 w=1.85u l=1.5u ad=1.1100e-12 pd=4.9000e-06 as=5.1800e-13 ps=2.4100e-06 nf=1 m=2 par=2
XMpar8 a_2501_10454.t3 a_2501_10454.t2 vdd.t1 vdd.t0 pfet_03v3 w=8.1u l=1.5u ad=2.2680e-12 pd=8.6600e-06 as=2.2680e-12 ps=8.6600e-06 nf=1 m=2 par=2
XMpar9 a_7212_6009.t39 a_7212_6009.t38 vss.t1 vss.t0 nfet_03v3 w=2.08u l=0.9u ad=5.8240e-13 pd=2.6400e-06 as=5.8240e-13 ps=2.6400e-06 nf=1 m=2 par=2
X26 a_5130_6258.t1 out.t18 cap_mim_2f0fF c_width=16.58u c_length=16.59u
X27 a_5130_6258.t1 out.t18 cap_mim_2f0fF c_width=16.58u c_length=16.59u
X107 a_1509_8140.t40 a_5130_6258.t0 vss.t34 ppolyf_u_1k r_width=1u r_length=6.73u
Rpar0 a_1509_8140.t0 a_1509_8140.t2 206.6928
Rpar1 a_1509_8140.t0 a_1509_8140.t40 102.8195
Rpar2 a_1509_8140.t0 a_1509_8140.t41 88.6606
Rpar3 a_1509_8140.t2 a_1509_8140.t40 250.2940
Rpar4 a_1509_8140.t2 a_1509_8140.t41 49.9753
Rpar5 a_1509_8140.t40 a_1509_8140.t41 107.3633
Rpar6 a_2412_12540.t0 a_2412_12540.t38 38.3677
Rpar7 a_2501_10454.t0 a_2501_10454.t2 132.8145
Rpar8 a_2501_10454.t0 a_2501_10454.t3 94.2671
Rpar9 a_2501_10454.t2 a_2501_10454.t3 25.2189
Rpar10 a_5130_6258.t0 a_5130_6258.t1 70.6235
Rpar11 a_7212_6009.t0 a_7212_6009.t38 208.1450
Rpar12 a_7212_6009.t0 a_7212_6009.t39 97.9760
Rpar13 a_7212_6009.t38 a_7212_6009.t39 26.0521
Rpar14 ib ib.t0 13.3682
Rpar15 ib ib.t1 4.8850
Rpar16 inn inn.t0 1.4359
Rpar17 inp inp.t0 1.4359
Rpar18 out out.t0 61.3947
Rpar19 out out.t4 2.0541
Rpar20 out out.t18 166.6980
Rpar21 out.t0 out.t18 126.3421
Rpar22 vdd vdd.t0 172.4429
Rpar23 vdd vdd.t1 1343.9832
Rpar24 vdd vdd.t2 20.9161
Rpar25 vdd.t0 vdd.t1 5.1140
Rpar26 vdd.t0 vdd.t2 63.0338
Rpar27 vdd.t1 vdd.t2 491.2722
Rpar28 vss vss.t0 168.2832
Rpar29 vss vss.t1 246.1807
Rpar30 vss vss.t22 412.3199
Rpar31 vss vss.t23 1253.7595
Rpar32 vss vss.t34 214.8991
Rpar33 vss.t0 vss.t1 4.6030
Rpar34 vss.t0 vss.t22 1.9627
Rpar35 vss.t0 vss.t23 14.5307
Rpar36 vss.t0 vss.t34 82.6057
Rpar37 vss.t1 vss.t22 13.0741
Rpar38 vss.t1 vss.t23 46.6565
Rpar39 vss.t1 vss.t34 119.2666
Rpar40 vss.t22 vss.t23 22.5223
Rpar41 vss.t22 vss.t34 87.4194
Rpar42 vss.t23 vss.t34 993.7616
Cpar0 a_1509_8140.t0 vss 3.70049e-15
Cpar1 a_1509_8140.t2 vss 2.05586e-14
Cpar2 a_1509_8140.t40 vss 2.18126e-15
Cpar3 a_1509_8140.t41 vss 8.71919e-15
Cpar4 a_2412_12540.t0 vss 5.35199e-14
Cpar5 a_2412_12540.t38 vss 1.08124e-14
Cpar6 a_2501_10454.t0 vss 1.86184e-15
Cpar7 a_2501_10454.t2 vss 2.93353e-14
Cpar8 a_2501_10454.t3 vss 4.35415e-15
Cpar9 a_5130_6258.t0 vss 8.19912e-17
Cpar10 a_5130_6258.t1 vss 5.27133e-15
Cpar11 a_7212_6009.t0 vss 2.69743e-14
Cpar12 a_7212_6009.t38 vss 4.62780e-15
Cpar13 a_7212_6009.t39 vss 4.22034e-15
Cpar14 ib vss 7.39170e-15
Cpar15 ib.t0 vss 7.00471e-16
Cpar16 ib.t1 vss 1.58440e-16
Cpar17 inn inp 1.23870e-16
Cpar18 inn vdd 2.49454e-14
Cpar19 inn vss 5.44943e-15
Cpar20 inn.t0 vss 3.57462e-14
Cpar21 inp vdd 2.47249e-14
Cpar22 inp vss 5.43008e-15
Cpar23 inp.t0 vss 3.55810e-14
Cpar24 out vdd 1.14236e-14
Cpar25 out vss 2.05663e-14
Cpar26 out.t0 vss 8.46460e-15
Cpar27 out.t18 vss 1.29003e-14
Cpar28 out.t4 vss 1.26153e-15
Cpar29 vdd vss 2.26838e-13
Cpar30 vdd.t0 vss 3.11080e-14
Cpar31 vdd.t1 vss 9.32455e-15
Cpar32 vdd.t2 vss 6.50377e-14
.ends opamp_dut

Vdd vdd 0 3.300000
Vss vss 0 0
Ibias vdd ib 2.875000e-06
Vinp inp 0 DC 1.480000 AC 1 PWL(0 1.480000 1.355425e-08 1.480000 1.490967e-08 1.490000)
Rfb out inn 1m
Cload out 0 2.000000e-12
Xdut vdd vss inp inn out ib opamp_dut
.end
