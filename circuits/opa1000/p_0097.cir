* opa1000[0097]: 200f/current_reuse_1v8_i10u_subth (current_reuse, VDD=1.8V, CL=0.2pF, Iref=1.8571uA)
.include "pdk_opa.inc"
.temp 27
.option gmin=1e-12 rshunt=1e12 reltol=1e-3 abstol=1e-12 vntol=1e-5 method=gear
* Post-PEX R+C extracted netlist for current_reuse_1v8_i10u_subth
.subckt opamp_dut vdd vss inp inn out ib
XMpar0 a_4442_6046.t0 inn a_8684_14847.t44 vss.t0 nfet_03v3 w=1.77u l=1.13u ad=5.9000e-13 pd=2.7317e-06 as=4.9560e-13 ps=2.3300e-06 nf=1 m=12 par=12
XMpar1 out.t12 ib.t0 vss.t26 vss.t0 nfet_03v3 w=1.95u l=0.9u ad=6.7080e-13 pd=3.0280e-06 as=5.4600e-13 ps=2.5100e-06 nf=1 m=10 par=10
XMpar2 a_3766_11106.t0 inn.t12 a_8684_14847.t2 vdd.t4 pfet_03v3 w=2.01u l=1.13u ad=6.5469e-13 pd=2.9486e-06 as=5.6280e-13 ps=2.5700e-06 nf=1 m=42 par=42
XMpar3 a_1015_6086.t1 inp.t12 a_3766_11106.t0 vdd.t4 pfet_03v3 w=2.01u l=1.13u ad=5.6280e-13 pd=2.5700e-06 as=6.5469e-13 ps=2.9486e-06 nf=1 m=42 par=42
XMpar4 out.t1 a_1015_6086.t56 vdd.t1 vdd.t0 pfet_03v3 w=10u l=0.6u ad=2.8000e-12 pd=1.0560e-05 as=3.4400e-12 ps=1.2688e-05 nf=1 m=10 par=10
XMpar5 a_8684_14847.t1 a_8684_14847.t0 vdd.t1 vdd.t0 pfet_03v3 w=10u l=0.6u ad=6.0000e-12 pd=2.1200e-05 as=2.8000e-12 ps=1.0560e-05 nf=1 m=1
XMpar6 a_1015_6086.t55 a_8684_14847.t0 vdd.t1 vdd.t0 pfet_03v3 w=10u l=0.6u ad=6.0000e-12 pd=2.1200e-05 as=2.8000e-12 ps=1.0560e-05 nf=1 m=1
XMpar7 a_1015_6086.t43 inp.t0 a_4442_6046.t0 vss.t0 nfet_03v3 w=1.77u l=1.13u ad=4.9560e-13 pd=2.3300e-06 as=5.9000e-13 ps=2.7317e-06 nf=1 m=12 par=12
XMpar8 ib.t1 ib.t0 vss.t26 vss.t0 nfet_03v3 w=1.95u l=0.9u ad=5.4600e-13 pd=2.5100e-06 as=5.4600e-13 ps=2.5100e-06 nf=1 m=2 par=2
XMpar9 a_4442_6046.t24 ib.t0 vss.t26 vss.t0 nfet_03v3 w=1.95u l=0.9u ad=5.4600e-13 pd=2.5100e-06 as=5.4600e-13 ps=2.5100e-06 nf=1 m=4 par=4
XMpar10 a_3766_11106.t84 a_8684_14847.t0 vdd.t1 vdd.t0 pfet_03v3 w=10u l=0.6u ad=2.8000e-12 pd=1.0560e-05 as=6.0000e-12 ps=2.1200e-05 nf=1 m=2 par=2
X8 a_1015_6086.t0 a_2565_6086.t0 vss.t12 ppolyf_u_1k r_width=1u r_length=7.09u
X21 a_2565_6086.t1 out.t0 cap_mim_2f0fF c_width=15.74u c_length=15.73u
X98 a_2565_6086.t1 out.t0 cap_mim_2f0fF c_width=15.74u c_length=15.73u
Rpar0 a_1015_6086.t0 a_1015_6086.t1 324.4684
Rpar1 a_1015_6086.t0 a_1015_6086.t43 68.2864
Rpar2 a_1015_6086.t0 a_1015_6086.t55 667.9975
Rpar3 a_1015_6086.t0 a_1015_6086.t56 103.1105
Rpar4 a_1015_6086.t1 a_1015_6086.t43 301.1721
Rpar5 a_1015_6086.t1 a_1015_6086.t55 92.2242
Rpar6 a_1015_6086.t1 a_1015_6086.t56 128.3953
Rpar7 a_1015_6086.t43 a_1015_6086.t55 620.0365
Rpar8 a_1015_6086.t43 a_1015_6086.t56 95.7073
Rpar9 a_1015_6086.t55 a_1015_6086.t56 264.3330
Rpar10 a_2565_6086.t0 a_2565_6086.t1 59.0736
Rpar11 a_3766_11106.t0 a_3766_11106.t84 50.3717
Rpar12 a_4442_6046.t0 a_4442_6046.t24 49.8207
Rpar13 a_8684_14847.t0 a_8684_14847.t1 70.8250
Rpar14 a_8684_14847.t0 a_8684_14847.t2 160.1846
Rpar15 a_8684_14847.t0 a_8684_14847.t44 148.3253
Rpar16 a_8684_14847.t1 a_8684_14847.t2 59.9541
Rpar17 a_8684_14847.t1 a_8684_14847.t44 280.1371
Rpar18 a_8684_14847.t2 a_8684_14847.t44 92.4961
Rpar19 ib ib.t0 19.5542
Rpar20 ib ib.t1 12.4480
Rpar21 ib.t0 ib.t1 80.4746
Rpar22 inn inn.t12 44.9890
Rpar23 inp inp.t0 1.5357
Rpar24 inp inp.t12 44.9404
Rpar25 out out.t0 166.4781
Rpar26 out out.t1 1.6070
Rpar27 out out.t12 114.7994
Rpar28 out.t0 out.t12 65.1490
Rpar29 vdd vdd.t0 44.2180
Rpar30 vdd vdd.t1 75.2328
Rpar31 vdd vdd.t4 93.6578
Rpar32 vdd.t0 vdd.t1 3.3306
Rpar33 vdd.t0 vdd.t4 61.8417
Rpar34 vdd.t1 vdd.t4 112.3267
Rpar35 vss vss.t0 33.6261
Rpar36 vss vss.t12 107.0469
Rpar37 vss vss.t26 441.9766
Rpar38 vss.t0 vss.t12 247.2722
Rpar39 vss.t0 vss.t26 3.8697
Rpar40 vss.t12 vss.t26 4546.6635
Cpar0 a_1015_6086.t0 vss 2.70753e-15
Cpar1 a_1015_6086.t1 vss 2.70313e-14
Cpar2 a_1015_6086.t43 vss 5.60563e-15
Cpar3 a_1015_6086.t55 vss 6.66385e-15
Cpar4 a_1015_6086.t56 vss 1.56246e-14
Cpar5 a_2565_6086.t0 vss 6.39561e-17
Cpar6 a_2565_6086.t1 vss 4.38744e-15
Cpar7 a_3766_11106.t0 vss 5.44790e-14
Cpar8 a_3766_11106.t84 vss 5.97994e-15
Cpar9 a_4442_6046.t0 vss 1.13315e-14
Cpar10 a_4442_6046.t24 vss 6.97933e-15
Cpar11 a_8684_14847.t0 vss 6.83301e-15
Cpar12 a_8684_14847.t1 vss 8.83260e-15
Cpar13 a_8684_14847.t2 vss 3.05921e-14
Cpar14 a_8684_14847.t44 vss 7.16365e-15
Cpar15 ib out 1.27322e-15
Cpar16 ib vss 1.65550e-14
Cpar17 ib.t0 vss 3.00098e-15
Cpar18 ib.t1 vss 2.50532e-16
Cpar19 inn inp 2.07200e-16
Cpar20 inn out 7.02930e-16
Cpar21 inn vdd 2.42797e-14
Cpar22 inn vss 2.10858e-14
Cpar23 inn.t12 vss 3.68237e-14
Cpar24 inp out 1.20800e-16
Cpar25 inp vdd 2.55242e-14
Cpar26 inp vss 1.63624e-14
Cpar27 inp.t0 vss 5.49999e-15
Cpar28 inp.t12 vss 3.58611e-14
Cpar29 out vdd 1.71973e-14
Cpar30 out vss 2.36242e-14
Cpar31 out.t0 vss 1.41888e-14
Cpar32 out.t1 vss 6.72015e-15
Cpar33 out.t12 vss 5.22485e-15
Cpar34 vdd vss 2.19136e-13
Cpar35 vdd.t0 vss 2.25567e-14
Cpar36 vdd.t1 vss 1.60164e-14
Cpar37 vdd.t4 vss 6.54306e-14
.ends opamp_dut

Vdd vdd 0 1.800000
Vss vss 0 0
Ibias vdd ib 1.857100e-06
Vinp inp 0 DC 0.895000 AC 1 PWL(0 0.895000 1.105737e-08 0.895000 1.216311e-08 0.905000)
Rfb out inn 1m
Cload out 0 2.000000e-13
Xdut vdd vss inp inn out ib opamp_dut
.end
