* opa1000[0336]: 200f/nmos_5t_1v8_i50n_weak (nmos_5t, VDD=1.8V, CL=0.2pF, Iref=0.0144uA)
.include "pdk_opa.inc"
.temp 27
.option gmin=1e-12 rshunt=1e12 reltol=1e-3 abstol=1e-12 vntol=1e-5 method=gear
* Post-PEX R+C extracted netlist for nmos_5t_1v8_i50n_weak
.subckt opamp_dut vdd vss inp inn out ib
XMpar0 out.t0 a_3292_6421.t2 vdd.t1 vdd.t0 pfet_03v3 w=0.4u l=5.2u ad=1.1200e-13 pd=9.6000e-07 as=1.1200e-13 ps=9.6000e-07 nf=1 m=2 par=2
XMpar1 a_3292_6421.t3 a_3292_6421.t2 vdd.t1 vdd.t0 pfet_03v3 w=0.4u l=5.2u ad=2.4000e-13 pd=2.0000e-06 as=1.1200e-13 ps=9.6000e-07 nf=1 m=2 par=2
XMpar2 a_3154_1204.t4 ib.t0 vss.t3 vss.t2 nfet_03v3 w=0.4u l=7.5u ad=1.1200e-13 pd=9.6000e-07 as=2.0800e-13 ps=1.7400e-06 nf=1 m=8 par=8
XMpar3 a_3154_1204.t0 inp.t0 a_3292_6421.t0 vss.t0 nfet_03v3 w=0.4u l=5.2u ad=2.4000e-13 pd=2.0000e-06 as=2.4000e-13 ps=2.0000e-06 nf=1 m=2 par=2
XMpar4 ib.t1 ib.t0 vss.t3 vss.t2 nfet_03v3 w=0.4u l=7.5u ad=2.4000e-13 pd=2.0000e-06 as=1.1200e-13 ps=9.6000e-07 nf=1 m=2 par=2
XMpar5 a_3154_1204.t0 inn.t0 out.t2 vss.t0 nfet_03v3 w=0.4u l=5.2u ad=2.4000e-13 pd=2.0000e-06 as=2.4000e-13 ps=2.0000e-06 nf=1 m=2 par=2
Rpar0 a_3154_1204.t0 a_3154_1204.t4 44.4036
Rpar1 a_3292_6421.t0 a_3292_6421.t2 106.2236
Rpar2 a_3292_6421.t0 a_3292_6421.t3 78.4380
Rpar3 a_3292_6421.t2 a_3292_6421.t3 22.0968
Rpar4 ib ib.t0 15.3065
Rpar5 ib ib.t1 14.9593
Rpar6 ib.t0 ib.t1 33.4724
Rpar7 inn inn.t0 4.3033
Rpar8 inp inp.t0 4.3027
Rpar9 out out.t0 14.7873
Rpar10 out out.t2 40.4358
Rpar11 vdd vdd.t0 36.7777
Rpar12 vdd vdd.t1 57.7187
Rpar13 vdd.t0 vdd.t1 16.9658
Rpar14 vss vss.t0 84.2000
Rpar15 vss vss.t2 27.1851
Rpar16 vss vss.t3 227.4335
Rpar17 vss.t0 vss.t2 4.8506
Rpar18 vss.t0 vss.t3 54.5095
Rpar19 vss.t2 vss.t3 17.0487
Cpar0 a_3154_1204.t0 vss 5.91564e-15
Cpar1 a_3154_1204.t4 vss 9.72475e-15
Cpar2 a_3292_6421.t0 vss 4.15863e-15
Cpar3 a_3292_6421.t2 vss 1.27127e-14
Cpar4 a_3292_6421.t3 vss 3.69870e-15
Cpar5 ib inp 1.12600e-17
Cpar6 ib vss 5.22970e-14
Cpar7 ib.t0 vss 7.24781e-15
Cpar8 ib.t1 vss 5.59644e-16
Cpar9 inn inp 1.04540e-16
Cpar10 inn out 8.89450e-16
Cpar11 inn vss 6.21073e-15
Cpar12 inn.t0 vss 1.01878e-15
Cpar13 inp vss 6.14767e-15
Cpar14 inp.t0 vss 1.03649e-15
Cpar15 out vdd 2.97984e-15
Cpar16 out vss 7.64939e-15
Cpar17 out.t0 vss 4.91105e-16
Cpar18 out.t2 vss 3.45888e-15
Cpar19 vdd vss 3.78447e-14
Cpar20 vdd.t0 vss 6.68126e-15
Cpar21 vdd.t1 vss 4.24531e-15
.ends opamp_dut

Vdd vdd 0 1.800000
Vss vss 0 0
Ibias vdd ib 1.440000e-08
Vinp inp 0 DC 0.895000 AC 1 PWL(0 0.895000 2.538749e-07 0.895000 2.792624e-07 0.905000)
Rfb out inn 1m
Cload out 0 2.000000e-13
Xdut vdd vss inp inn out ib opamp_dut
.end
