* opa1000[0955]: 200f/telescopic_pmos_3v3_10u_100u_weak (telescopic_pmos, VDD=3.3V, CL=0.2pF, Iref=11.5uA)
.include "pdk_opa.inc"
.temp 27
.option gmin=1e-12 rshunt=1e12 reltol=1e-3 abstol=1e-12 vntol=1e-5 method=gear
* Post-PEX R+C extracted netlist for telescopic_pmos_3v3_10u_100u_weak
.subckt opamp_dut vdd vss inp inn out ib
XMpar0 a_2415_12660.t1 a_2415_12660.t0 a_3442_10003.t0 vdd.t0 pfet_03v3 w=2.01u l=0.6u ad=5.6280e-13 pd=2.5700e-06 as=6.2127e-13 ps=2.8109e-06 nf=1 m=44 par=44
XMpar1 a_2295_12869.t5 inn.t0 a_3202_10003.t0 vdd.t17 pfet_03v3 w=1.96u l=0.6u ad=5.4880e-13 pd=2.5200e-06 as=6.1849e-13 ps=2.8089e-06 nf=1 m=36 par=36
XMpar2 a_3202_10003.t0 inp.t0 a_3442_10003.t29 vdd.t17 pfet_03v3 w=1.96u l=0.6u ad=6.1849e-13 pd=2.8089e-06 as=5.4880e-13 ps=2.5200e-06 nf=1 m=36 par=36
XMpar3 a_6284_1249.t1 a_2415_12660.t88 out.t5 vss.t0 nfet_03v3 w=1.85u l=0.6u ad=6.1667e-13 pd=2.8250e-06 as=5.1800e-13 ps=2.4100e-06 nf=1 m=12 par=12
XMpar4 a_2415_12660.t89 a_2415_12660.t88 a_4615_1249.t1 vss.t0 nfet_03v3 w=1.85u l=0.6u ad=5.1800e-13 pd=2.4100e-06 as=7.1533e-13 ps=3.2400e-06 nf=1 m=12 par=12
XMpar5 a_2295_12869.t0 a_2415_12660.t0 out.t0 vdd.t0 pfet_03v3 w=2.01u l=0.6u ad=6.2127e-13 pd=2.8109e-06 as=6.2127e-13 ps=2.8109e-06 nf=1 m=44 par=44
XMpar6 ib.t1 ib.t0 vss.t8 vss.t7 nfet_03v3 w=3.77u l=0.8u ad=2.2620e-12 pd=8.7400e-06 as=1.0556e-12 ps=4.3300e-06 nf=1 m=2 par=2
XMpar7 a_4615_1249.t0 a_2415_12660.t124 vss.t1 vss.t0 nfet_03v3 w=1.77u l=0.6u ad=4.9560e-13 pd=2.3300e-06 as=7.7880e-13 ps=3.5350e-06 nf=1 m=4 par=4
XMpar8 a_3202_10003.t36 a_1748_3359.t2 vdd.t7 vdd.t6 pfet_03v3 w=10u l=0.8u ad=2.8000e-12 pd=1.0560e-05 as=3.6000e-12 ps=1.3220e-05 nf=1 m=8 par=8
XMpar9 a_1748_3359.t3 a_1748_3359.t2 vdd.t7 vdd.t6 pfet_03v3 w=10u l=0.8u ad=2.8000e-12 pd=1.0560e-05 as=2.8000e-12 ps=1.0560e-05 nf=1 m=2 par=2
XMpar10 a_6284_1249.t0 a_2415_12660.t124 vss.t1 vss.t0 nfet_03v3 w=1.77u l=0.6u ad=4.9560e-13 pd=2.3300e-06 as=4.9560e-13 ps=2.3300e-06 nf=1 m=4 par=4
XMpar11 a_1748_3359.t0 ib.t0 vss.t8 vss.t7 nfet_03v3 w=3.77u l=0.8u ad=1.0556e-12 pd=4.3300e-06 as=1.0556e-12 ps=4.3300e-06 nf=1 m=2 par=2
X164 out.t56 vss.t23 cap_mim_2f0fF c_width=15.51u c_length=15.52u
X178 out.t56 vss.t23 cap_mim_2f0fF c_width=15.51u c_length=15.52u
Rpar0 a_1748_3359.t0 a_1748_3359.t2 145.0901
Rpar1 a_1748_3359.t0 a_1748_3359.t3 62.9062
Rpar2 a_1748_3359.t2 a_1748_3359.t3 28.3581
Rpar3 a_2295_12869.t0 a_2295_12869.t5 34.3678
Rpar4 a_2415_12660.t0 a_2415_12660.t1 8.4005
Rpar5 a_2415_12660.t0 a_2415_12660.t88 1658.9570
Rpar6 a_2415_12660.t0 a_2415_12660.t89 395.7019
Rpar7 a_2415_12660.t0 a_2415_12660.t124 653.5390
Rpar8 a_2415_12660.t1 a_2415_12660.t88 661.5203
Rpar9 a_2415_12660.t1 a_2415_12660.t89 157.7888
Rpar10 a_2415_12660.t1 a_2415_12660.t124 260.6031
Rpar11 a_2415_12660.t88 a_2415_12660.t89 16.2585
Rpar12 a_2415_12660.t88 a_2415_12660.t124 225.6327
Rpar13 a_2415_12660.t89 a_2415_12660.t124 53.8189
Rpar14 a_3202_10003.t0 a_3202_10003.t36 46.1583
Rpar15 a_3442_10003.t0 a_3442_10003.t29 48.6702
Rpar16 a_4615_1249.t0 a_4615_1249.t1 73.5532
Rpar17 a_6284_1249.t0 a_6284_1249.t1 49.7229
Rpar18 ib ib.t0 18.6256
Rpar19 ib ib.t1 3.5622
Rpar20 inn inn.t0 2.1088
Rpar21 inp inp.t0 2.1088
Rpar22 out out.t0 2.3945
Rpar23 out out.t5 106.8652
Rpar24 out out.t56 87.0868
Rpar25 out.t5 out.t56 81.9406
Rpar26 vdd vdd.t0 21.5167
Rpar27 vdd vdd.t6 932.7844
Rpar28 vdd vdd.t7 3287.4491
Rpar29 vdd vdd.t17 142.1063
Rpar30 vdd.t0 vdd.t6 342.6156
Rpar31 vdd.t0 vdd.t7 1207.4937
Rpar32 vdd.t0 vdd.t17 52.1962
Rpar33 vdd.t6 vdd.t7 5.6075
Rpar34 vdd.t6 vdd.t17 111.9211
Rpar35 vdd.t7 vdd.t17 394.4479
Rpar36 vss vss.t0 31.0124
Rpar37 vss vss.t1 1062.9487
Rpar38 vss vss.t8 296.2055
Rpar39 vss vss.t7 225.2874
Rpar40 vss vss.t23 424.2276
Rpar41 vss.t0 vss.t1 4.5433
Rpar42 vss.t0 vss.t8 217.4408
Rpar43 vss.t0 vss.t7 163.7861
Rpar44 vss.t0 vss.t23 104.1894
Rpar45 vss.t1 vss.t7 1515.2471
Rpar46 vss.t1 vss.t23 536.7217
Rpar47 vss.t8 vss.t7 9.8315
Rpar48 vss.t8 vss.t23 604.2982
Rpar49 vss.t7 vss.t23 459.6378
Cpar0 a_1748_3359.t0 vss 2.60385e-15
Cpar1 a_1748_3359.t2 vss 1.33097e-14
Cpar2 a_1748_3359.t3 vss 4.89364e-15
Cpar3 a_2295_12869.t0 vss 4.05268e-14
Cpar4 a_2295_12869.t5 vss 2.64075e-14
Cpar5 a_2415_12660.t0 vss 5.31242e-14
Cpar6 a_2415_12660.t1 vss 3.53256e-14
Cpar7 a_2415_12660.t124 vss 6.86838e-15
Cpar8 a_2415_12660.t88 vss 1.43578e-14
Cpar9 a_2415_12660.t89 vss 1.16828e-14
Cpar10 a_3202_10003.t0 vss 4.54019e-14
Cpar11 a_3202_10003.t36 vss 1.84434e-14
Cpar12 a_3442_10003.t0 vss 4.92727e-14
Cpar13 a_3442_10003.t29 vss 3.11463e-14
Cpar14 a_4615_1249.t0 vss 4.00130e-15
Cpar15 a_4615_1249.t1 vss 9.27755e-15
Cpar16 a_6284_1249.t0 vss 3.87822e-15
Cpar17 a_6284_1249.t1 vss 1.19583e-14
Cpar18 ib vss 6.88670e-15
Cpar19 ib.t0 vss 4.26411e-16
Cpar20 ib.t1 vss 2.63220e-16
Cpar21 inn inp 1.04860e-16
Cpar22 inn out 1.38240e-16
Cpar23 inn vdd 1.53184e-14
Cpar24 inn vss 6.41384e-15
Cpar25 inn.t0 vss 1.81931e-14
Cpar26 inp vdd 1.54068e-14
Cpar27 inp vss 6.33807e-15
Cpar28 inp.t0 vss 1.81820e-14
Cpar29 out vdd 7.43491e-15
Cpar30 out vss 2.51981e-14
Cpar31 out.t0 vss 7.38548e-15
Cpar32 out.t5 vss 3.02937e-15
Cpar33 out.t56 vss 4.91505e-14
Cpar34 vdd vss 2.73102e-13
Cpar35 vdd.t0 vss 7.27320e-14
Cpar36 vdd.t17 vss 4.48944e-14
Cpar37 vdd.t6 vss 1.71857e-14
Cpar38 vdd.t7 vss 8.25684e-15
.ends opamp_dut

Vdd vdd 0 3.300000
Vss vss 0 0
Ibias vdd ib 1.150000e-05
Vinp inp 0 DC 1.480000 AC 1 PWL(0 1.480000 3.000000e-09 1.480000 3.300000e-09 1.490000)
Rfb out inn 1m
Cload out 0 2.000000e-13
Xdut vdd vss inp inn out ib opamp_dut
.end
