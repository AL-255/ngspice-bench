* opa1000[0123]: 200f/current_reuse_3v3_i150u_subth (current_reuse, VDD=3.3V, CL=0.2pF, Iref=24.6429uA)
.include "pdk_opa.inc"
.temp 27
.option gmin=1e-12 rshunt=1e12 reltol=1e-3 abstol=1e-12 vntol=1e-5 method=gear
* Post-PEX R+C extracted netlist for current_reuse_3v3_i150u_subth
.subckt opamp_dut vdd vss inp inn out ib
XMpar0 a_1482_12661.t0 inp.t64 a_764_1290.t65 vss.t0 nfet_03v3 w=1.94u l=0.28u ad=8.6376e-13 pd=2.9229e-06 as=8.3420e-13 ps=2.8000e-06 nf=1 m=42 par=42
XMpar1 a_3762_9531.t0 a_10840_14216.t0 vdd.t1 vdd.t0 pfet_03v3 w=10u l=0.5u ad=2.8000e-12 pd=1.0560e-05 as=3.8667e-12 ps=1.4107e-05 nf=1 m=6 par=6
XMpar2 a_3762_9531.t2 inp.t0 a_764_1290.t1 vdd.t18 pfet_03v3 w=2.62u l=0.28u ad=1.1790e-12 pd=3.6837e-06 as=1.1266e-12 ps=3.4800e-06 nf=1 m=64 par=64
XMpar3 a_10840_14216.t6 inn.t0 a_3762_9531.t2 vdd.t18 pfet_03v3 w=2.62u l=0.28u ad=1.1266e-12 pd=3.4800e-06 as=1.1790e-12 ps=3.6837e-06 nf=1 m=64 par=64
XMpar4 a_10840_14216.t70 inn.t64 a_1482_12661.t0 vss.t0 nfet_03v3 w=1.94u l=0.28u ad=8.3420e-13 pd=2.8000e-06 as=8.6376e-13 ps=2.9229e-06 nf=1 m=42 par=42
XMpar5 out.t3 ib.t0 vss.t43 vss.t42 nfet_03v3 w=9.53u l=0.98u ad=2.8717e-12 pd=1.0768e-05 as=2.6684e-12 ps=1.0090e-05 nf=1 m=30 par=30
XMpar6 out a_764_1290.t110 vdd.t1 vdd.t0 pfet_03v3 w=10u l=0.5u ad=2.8000e-12 pd=1.0560e-05 as=3.0133e-12 ps=1.1269e-05 nf=1 m=30 par=30
XMpar7 a_1482_12661.t42 ib.t0 vss.t43 vss.t42 nfet_03v3 w=9.53u l=0.98u ad=2.6684e-12 pd=1.0090e-05 as=2.6684e-12 ps=1.0090e-05 nf=1 m=12 par=12
XMpar8 ib.t1 ib.t0 vss.t43 vss.t42 nfet_03v3 w=9.53u l=0.98u ad=2.6684e-12 pd=1.0090e-05 as=3.6849e-12 ps=1.3480e-05 nf=1 m=6 par=6
XMpar9 a_764_1290.t0 a_10840_14216.t0 vdd.t1 vdd.t0 pfet_03v3 w=10u l=0.5u ad=3.8667e-12 pd=1.4107e-05 as=2.8000e-12 ps=1.0560e-05 nf=1 m=3 par=3
XMpar10 a_10840_14216.t1 a_10840_14216.t0 vdd.t1 vdd.t0 pfet_03v3 w=10u l=0.5u ad=3.8667e-12 pd=1.4107e-05 as=2.8000e-12 ps=1.0560e-05 nf=1 m=3 par=3
X69 a_1096_1290.t1 out.t36 cap_mim_2f0fF c_width=15.74u c_length=15.73u
X239 a_764_1290.t109 a_1096_1290.t0 vss.t180 ppolyf_u_1k r_width=1u r_length=1u
X293 a_1096_1290.t1 out.t36 cap_mim_2f0fF c_width=15.74u c_length=15.73u
Rpar0 a_10840_14216.t0 a_10840_14216.t1 33.2078
Rpar1 a_10840_14216.t0 a_10840_14216.t6 105.4076
Rpar2 a_10840_14216.t0 a_10840_14216.t70 203.2111
Rpar3 a_10840_14216.t1 a_10840_14216.t6 254.1929
Rpar4 a_10840_14216.t1 a_10840_14216.t70 58.8739
Rpar5 a_10840_14216.t6 a_10840_14216.t70 80.5420
Rpar6 a_1096_1290.t0 a_1096_1290.t1 85.0262
Rpar7 a_1482_12661.t0 a_1482_12661.t42 61.3777
Rpar8 a_3762_9531.t0 a_3762_9531.t2 59.8613
Rpar9 a_764_1290.t0 a_764_1290.t1 131.2723
Rpar10 a_764_1290.t0 a_764_1290.t65 106.5092
Rpar11 a_764_1290.t0 a_764_1290.t109 658.3768
Rpar12 a_764_1290.t0 a_764_1290.t110 2134.9759
Rpar13 a_764_1290.t1 a_764_1290.t65 64.4355
Rpar14 a_764_1290.t1 a_764_1290.t109 181.2572
Rpar15 a_764_1290.t1 a_764_1290.t110 587.7786
Rpar16 a_764_1290.t65 a_764_1290.t109 323.1666
Rpar17 a_764_1290.t65 a_764_1290.t110 1047.9605
Rpar18 a_764_1290.t109 a_764_1290.t110 194.2510
Rpar19 ib ib.t0 14.1883
Rpar20 ib ib.t1 2.6423
Rpar21 inn inn.t0 33.0754
Rpar22 inn inn.t64 1.5919
Rpar23 inp inp.t0 33.0268
Rpar24 inp inp.t64 1.6405
Rpar25 out out.t3 62.8360
Rpar26 out out.t36 78.3346
Rpar27 out.t3 out.t36 88.2154
Rpar28 vdd vdd.t0 25.4139
Rpar29 vdd vdd.t1 103.3949
Rpar30 vdd vdd.t18 927.9567
Rpar31 vdd.t0 vdd.t1 1.9710
Rpar32 vdd.t0 vdd.t18 27.4602
Rpar33 vdd.t1 vdd.t18 255.2091
Rpar34 vss vss.t0 1037.1721
Rpar35 vss vss.t42 64.9426
Rpar36 vss vss.t43 660.5056
Rpar37 vss vss.t180 49.6324
Rpar38 vss.t0 vss.t42 48.8873
Rpar39 vss.t0 vss.t43 400.4753
Rpar40 vss.t0 vss.t180 2350.2399
Rpar41 vss.t42 vss.t43 2.5487
Rpar42 vss.t42 vss.t180 169.8199
Rpar43 vss.t43 vss.t180 1213.1866
Cpar0 a_10840_14216.t0 vss 1.83081e-14
Cpar1 a_10840_14216.t1 vss 1.36883e-14
Cpar2 a_10840_14216.t6 vss 4.71013e-14
Cpar3 a_10840_14216.t70 vss 2.76108e-14
Cpar4 a_1096_1290.t0 vss 2.72436e-16
Cpar5 a_1096_1290.t1 vss 1.11227e-14
Cpar6 a_1482_12661.t0 vss 3.67468e-14
Cpar7 a_1482_12661.t42 vss 2.20900e-14
Cpar8 a_3762_9531.t0 vss 1.57174e-14
Cpar9 a_3762_9531.t2 vss 9.33479e-14
Cpar10 a_764_1290.t0 vss 1.02354e-14
Cpar11 a_764_1290.t1 vss 4.12699e-14
Cpar12 a_764_1290.t109 vss 8.94487e-15
Cpar13 a_764_1290.t110 vss 4.35589e-14
Cpar14 a_764_1290.t65 vss 2.37511e-14
Cpar15 ib out 1.02846e-14
Cpar16 ib vss 6.10714e-14
Cpar17 ib.t0 vss 1.61204e-14
Cpar18 ib.t1 vss 1.28726e-15
Cpar19 inn inp 1.50930e-16
Cpar20 inn vdd 2.50611e-14
Cpar21 inn vss 3.11885e-14
Cpar22 inn.t0 vss 2.74917e-14
Cpar23 inn.t64 vss 7.08179e-15
Cpar24 inp out 5.93400e-17
Cpar25 inp vdd 2.48418e-14
Cpar26 inp vss 3.14952e-14
Cpar27 inp.t0 vss 2.75671e-14
Cpar28 inp.t64 vss 7.35740e-15
Cpar29 out vdd 5.42297e-14
Cpar30 out vss 7.61725e-14
Cpar31 out.t3 vss 3.36101e-14
Cpar32 out.t36 vss 1.80133e-14
Cpar33 vdd vss 2.95353e-13
Cpar34 vdd.t0 vss 6.43404e-14
Cpar35 vdd.t1 vss 3.19959e-14
Cpar36 vdd.t18 vss 8.99609e-14
.ends opamp_dut

Vdd vdd 0 3.300000
Vss vss 0 0
Ibias vdd ib 2.464290e-05
Vinp inp 0 DC 1.645000 AC 1 PWL(0 1.645000 3.000000e-09 1.645000 3.300000e-09 1.655000)
Rfb out inn 1m
Cload out 0 2.000000e-13
Xdut vdd vss inp inn out ib opamp_dut
.end
