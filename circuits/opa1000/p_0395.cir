* opa1000[0395]: 2p/nmos_5t_1v8_i500u_weak (nmos_5t, VDD=1.8V, CL=2.0pF, Iref=106.25uA)
.include "pdk_opa.inc"
.temp 27
.option gmin=1e-12 rshunt=1e12 reltol=1e-3 abstol=1e-12 vntol=1e-5 method=gear
* Post-PEX R+C extracted netlist for nmos_5t_1v8_i500u_weak
.subckt opamp_dut vdd vss inp inn out ib
XMpar0 out.t0 a_1665_11391.t148 vdd.t1 vdd.t0 pfet_03v3 w=2.01u l=0.5u ad=7.4954e-13 pd=3.3394e-06 as=5.8355e-13 ps=2.6555e-06 nf=1 m=124 par=124
XMpar1 a_1665_11391.t149 a_1665_11391.t148 vdd.t1 vdd.t0 pfet_03v3 w=2.01u l=0.5u ad=6.6654e-13 pd=2.9974e-06 as=6.2505e-13 ps=2.8265e-06 nf=1 m=124 par=124
XMpar2 a_2218_5453.t0 inn.t0 out.t11 vss.t0 nfet_03v3 w=1.99u l=0.54u ad=5.9162e-13 pd=2.6922e-06 as=5.6581e-13 ps=2.5855e-06 nf=1 m=148 par=148
XMpar3 a_1665_11391.t0 inp.t0 a_2218_5453.t0 vss.t0 nfet_03v3 w=1.99u l=0.54u ad=5.6581e-13 pd=2.5855e-06 as=5.9162e-13 ps=2.6922e-06 nf=1 m=148 par=148
XMpar4 a_2218_5453.t296 ib.t0 vss.t119 vss.t0 nfet_03v3 w=3.64u l=0.68u ad=1.0192e-12 pd=4.2000e-06 as=1.0920e-12 ps=4.4675e-06 nf=1 m=64 par=64
XMpar5 ib.t1 ib.t0 vss.t119 vss.t0 nfet_03v3 w=3.64u l=0.68u ad=1.0192e-12 pd=4.2000e-06 as=1.0192e-12 ps=4.2000e-06 nf=1 m=16 par=16
X340 out.t272 vss.t238 cap_mim_2f0fF c_width=12.99u c_length=12.99u
Rpar0 a_1665_11391.t0 a_1665_11391.t148 233.5450
Rpar1 a_1665_11391.t0 a_1665_11391.t149 57.1434
Rpar2 a_1665_11391.t148 a_1665_11391.t149 3.9193
Rpar3 a_2218_5453.t0 a_2218_5453.t296 36.3588
Rpar4 ib ib.t0 68.7196
Rpar5 ib ib.t1 3.6267
Rpar6 ib.t0 ib.t1 8.9840
Rpar7 inn inn.t0 1.5184
Rpar8 inp inp.t0 1.5184
Rpar9 out out.t0 2.0857
Rpar10 out out.t11 126.4057
Rpar11 out out.t272 87.1554
Rpar12 out.t11 out.t272 235.8731
Rpar13 vdd vdd.t0 19.0263
Rpar14 vdd vdd.t1 2940.8502
Rpar15 vdd.t0 vdd.t1 8.4916
Rpar16 vss vss.t0 60.7801
Rpar17 vss vss.t119 40.6172
Rpar18 vss vss.t238 74.0066
Rpar19 vss.t0 vss.t119 10.3400
Rpar20 vss.t0 vss.t238 345.5846
Rpar21 vss.t119 vss.t238 83.1813
Cpar0 a_1665_11391.t0 vss 9.65250e-14
Cpar1 a_1665_11391.t148 vss 1.59435e-13
Cpar2 a_1665_11391.t149 vss 1.21719e-13
Cpar3 a_2218_5453.t0 vss 1.41393e-13
Cpar4 a_2218_5453.t296 vss 5.21499e-14
Cpar5 ib inn 3.97900e-17
Cpar6 ib inp 1.99000e-17
Cpar7 ib out 4.57560e-16
Cpar8 ib vss 7.72109e-14
Cpar9 ib.t0 vss 1.36095e-14
Cpar10 ib.t1 vss 4.00415e-15
Cpar11 inn inp 2.07300e-16
Cpar12 inn out 2.30173e-14
Cpar13 inn vdd 2.37700e-17
Cpar14 inn vss 5.49836e-14
Cpar15 inn.t0 vss 3.50866e-14
Cpar16 inp out 1.55040e-16
Cpar17 inp vdd 2.53000e-17
Cpar18 inp vss 5.47736e-14
Cpar19 inp.t0 vss 3.51596e-14
Cpar20 out vdd 9.61980e-14
Cpar21 out vss 5.02640e-14
Cpar22 out.t0 vss 8.54475e-14
Cpar23 out.t11 vss 7.85039e-14
Cpar24 out.t272 vss 6.95659e-14
Cpar25 vdd vss 3.47747e-13
Cpar26 vdd.t0 vss 2.68685e-13
Cpar27 vdd.t1 vss 4.52933e-14
.ends opamp_dut

Vdd vdd 0 1.800000
Vss vss 0 0
Ibias vdd ib 1.062500e-04
Vinp inp 0 DC 0.895000 AC 1 PWL(0 0.895000 3.000000e-09 0.895000 3.300000e-09 0.905000)
Rfb out inn 1m
Cload out 0 2.000000e-12
Xdut vdd vss inp inn out ib opamp_dut
.end
