* opa1000[0694]: 200f/rail_to_rail_3v3_i1u_subth (rail_to_rail, VDD=3.3V, CL=0.2pF, Iref=0.1062uA)
.include "pdk_opa.inc"
.temp 27
.option gmin=1e-12 rshunt=1e12 reltol=1e-3 abstol=1e-12 vntol=1e-5 method=gear
* Post-PEX R+C extracted netlist for rail_to_rail_3v3_i1u_subth
.subckt opamp_dut vdd vss inp inn out ib
XMpar0 out.t0 a_847_5986.t13 vdd.t1 vdd.t0 pfet_03v3 w=2.02u l=1.08u ad=5.6560e-13 pd=2.5800e-06 as=7.2720e-13 ps=3.2450e-06 nf=1 m=8 par=8
XMpar1 a_6050_14776.t0 inp.t8 a_6950_14776.t4 vdd.t4 pfet_03v3 w=8u l=3.9u ad=3.5200e-12 pd=1.2880e-05 as=2.2400e-12 ps=8.5600e-06 nf=1 m=8 par=8
XMpar2 a_847_5986.t0 a_8732_12953.t8 vss.t5 vss.t4 nfet_03v3 w=0.4u l=2.7u ad=2.4000e-13 pd=2.0000e-06 as=1.1200e-13 ps=9.6000e-07 nf=1 m=2 par=2
XMpar3 a_6050_1294.t16 ib.t0 vss.t30 vss.t0 nfet_03v3 w=0.54u l=3.5u ad=3.2400e-13 pd=2.2800e-06 as=1.5120e-13 ps=1.1000e-06 nf=1 m=2 par=2
XMpar4 a_6050_14776.t0 inn.t8 a_8732_12953.t0 vdd.t4 pfet_03v3 w=8u l=3.9u ad=3.5200e-12 pd=1.2880e-05 as=2.2400e-12 ps=8.5600e-06 nf=1 m=8 par=8
XMpar5 a_9380_9271.t11 a_9380_9271.t10 vdd.t1 vdd.t0 pfet_03v3 w=2.02u l=1.08u ad=5.6560e-13 pd=2.5800e-06 as=5.6560e-13 ps=2.5800e-06 nf=1 m=2 par=2
XMpar6 a_6050_1294.t0 inn.t0 a_9380_9271.t0 vss.t0 nfet_03v3 w=6.2u l=3.9u ad=2.7280e-12 pd=1.0180e-05 as=1.7360e-12 ps=6.7600e-06 nf=1 m=8 par=8
XMpar7 out.t7 ib.t0 vss.t30 vss.t0 nfet_03v3 w=0.54u l=3.5u ad=1.5120e-13 pd=1.1000e-06 as=1.9440e-13 ps=1.3950e-06 nf=1 m=8 par=8
XMpar8 ib.t1 ib.t0 vss.t30 vss.t0 nfet_03v3 w=0.54u l=3.5u ad=3.2400e-13 pd=2.2800e-06 as=1.5120e-13 ps=1.1000e-06 nf=1 m=2 par=2
XMpar9 a_6050_1294.t0 inp.t0 a_847_5986.t2 vss.t0 nfet_03v3 w=6.2u l=3.9u ad=2.7280e-12 pd=1.0180e-05 as=1.7360e-12 ps=6.7600e-06 nf=1 m=8 par=8
XMpar10 a_6950_14776.t1 a_6950_14776.t0 vss.t5 vss.t4 nfet_03v3 w=0.4u l=2.7u ad=2.4000e-13 pd=2.0000e-06 as=1.1200e-13 ps=9.6000e-07 nf=1 m=2 par=2
XMpar11 a_9380_9271.t8 a_6950_14776.t0 vss.t5 vss.t4 nfet_03v3 w=0.4u l=2.7u ad=1.1200e-13 pd=9.6000e-07 as=1.1200e-13 ps=9.6000e-07 nf=1 m=2 par=2
XMpar12 a_12544_5946.t4 ib.t0 vss.t30 vss.t0 nfet_03v3 w=0.54u l=3.5u ad=1.5120e-13 pd=1.1000e-06 as=1.5120e-13 ps=1.1000e-06 nf=1 m=2 par=2
XMpar13 a_12544_5946.t1 a_12544_5946.t0 vdd.t3 vdd.t2 pfet_03v3 w=2.37u l=3.5u ad=1.4220e-12 pd=5.9400e-06 as=6.6360e-13 ps=2.9300e-06 nf=1 m=2 par=2
XMpar14 a_8732_12953.t9 a_8732_12953.t8 vss.t5 vss.t4 nfet_03v3 w=0.4u l=2.7u ad=1.1200e-13 pd=9.6000e-07 as=1.1200e-13 ps=9.6000e-07 nf=1 m=2 par=2
XMpar15 a_6050_14776.t16 a_12544_5946.t0 vdd.t3 vdd.t2 pfet_03v3 w=2.37u l=3.5u ad=1.4220e-12 pd=5.9400e-06 as=6.6360e-13 ps=2.9300e-06 nf=1 m=2 par=2
XMpar16 a_847_5986.t11 a_9380_9271.t10 vdd.t1 vdd.t0 pfet_03v3 w=2.02u l=1.08u ad=1.2120e-12 pd=5.2400e-06 as=5.6560e-13 ps=2.5800e-06 nf=1 m=2 par=2
X3 a_847_10666.t0 a_4951_10146.t0 vss.t8 ppolyf_u_1k r_width=1u r_length=19.86u
X4 a_847_9626.t0 a_4951_9106.t0 vss.t8 ppolyf_u_1k r_width=1u r_length=19.86u
X7 a_847_6506.t0 a_4951_5986.t0 vss.t8 ppolyf_u_1k r_width=1u r_length=19.86u
X16 a_847_9626.t0 a_4951_10146.t0 vss.t8 ppolyf_u_1k r_width=1u r_length=19.86u
X17 a_847_8586.t0 a_4951_9106.t0 vss.t8 ppolyf_u_1k r_width=1u r_length=19.86u
X37 a_847_5986.t10 a_4951_5986.t0 vss.t8 ppolyf_u_1k r_width=1u r_length=19.86u
X47 a_847_11706.t0 a_4951_11186.t0 vss.t8 ppolyf_u_1k r_width=1u r_length=19.86u
X48 a_847_8586.t0 a_4951_8066.t0 vss.t8 ppolyf_u_1k r_width=1u r_length=19.86u
X58 a_847_7546.t0 a_4951_8066.t0 vss.t8 ppolyf_u_1k r_width=1u r_length=19.86u
X66 a_847_7546.t0 a_4951_7026.t0 vss.t8 ppolyf_u_1k r_width=1u r_length=19.86u
X71 a_847_11706.t1 out.t2 cap_mim_2f0fF c_width=12.99u c_length=12.99u
X78 a_847_10666.t0 a_4951_11186.t0 vss.t8 ppolyf_u_1k r_width=1u r_length=19.86u
X79 a_847_6506.t0 a_4951_7026.t0 vss.t8 ppolyf_u_1k r_width=1u r_length=19.86u
Rpar0 a_12544_5946.t0 a_12544_5946.t1 12.6100
Rpar1 a_12544_5946.t0 a_12544_5946.t4 173.0141
Rpar2 a_12544_5946.t1 a_12544_5946.t4 82.3396
Rpar3 a_6050_1294.t0 a_6050_1294.t16 127.1055
Rpar4 a_6050_14776.t0 a_6050_14776.t16 52.5891
Rpar5 a_6950_14776.t0 a_6950_14776.t1 20.8565
Rpar6 a_6950_14776.t0 a_6950_14776.t4 202.3627
Rpar7 a_6950_14776.t1 a_6950_14776.t4 148.2320
Rpar8 a_847_11706.t0 a_847_11706.t1 61.4620
Rpar9 a_847_5986.t0 a_847_5986.t10 410.1070
Rpar10 a_847_5986.t0 a_847_5986.t11 118.7089
Rpar11 a_847_5986.t0 a_847_5986.t13 214.7618
Rpar12 a_847_5986.t0 a_847_5986.t2 287.0668
Rpar13 a_847_5986.t10 a_847_5986.t11 242.5272
Rpar14 a_847_5986.t10 a_847_5986.t13 504.7854
Rpar15 a_847_5986.t10 a_847_5986.t2 82.2869
Rpar16 a_847_5986.t11 a_847_5986.t13 146.1144
Rpar17 a_847_5986.t11 a_847_5986.t2 169.7643
Rpar18 a_847_5986.t13 a_847_5986.t2 353.3398
Rpar19 a_8732_12953.t0 a_8732_12953.t8 129.9129
Rpar20 a_8732_12953.t0 a_8732_12953.t9 135.1215
Rpar21 a_8732_12953.t8 a_8732_12953.t9 29.4349
Rpar22 a_9380_9271.t0 a_9380_9271.t10 790.9285
Rpar23 a_9380_9271.t0 a_9380_9271.t11 376.5680
Rpar24 a_9380_9271.t0 a_9380_9271.t8 138.8228
Rpar25 a_9380_9271.t10 a_9380_9271.t11 24.8470
Rpar26 a_9380_9271.t10 a_9380_9271.t8 256.6779
Rpar27 a_9380_9271.t11 a_9380_9271.t8 122.2066
Rpar28 ib ib.t0 11.3620
Rpar29 ib ib.t1 11.1003
Rpar30 inn inn.t0 2.8702
Rpar31 inn inn.t8 69.7550
Rpar32 inp inp.t0 2.8702
Rpar33 inp inp.t8 69.7064
Rpar34 out out.t0 2.6456
Rpar35 out out.t7 165.0524
Rpar36 out out.t2 557.0576
Rpar37 out.t0 out.t7 215.5490
Rpar38 out.t0 out.t2 727.4855
Rpar39 out.t7 out.t2 196.8435
Rpar40 vdd vdd.t0 413.9152
Rpar41 vdd vdd.t1 808.8791
Rpar42 vdd vdd.t3 434.9445
Rpar43 vdd vdd.t2 1659.7111
Rpar44 vdd vdd.t4 21.9877
Rpar45 vdd.t0 vdd.t1 3.3114
Rpar46 vdd.t0 vdd.t3 83.6439
Rpar47 vdd.t0 vdd.t2 319.1779
Rpar48 vdd.t0 vdd.t4 172.5167
Rpar49 vdd.t1 vdd.t3 163.6638
Rpar50 vdd.t1 vdd.t2 624.5270
Rpar51 vdd.t1 vdd.t4 337.1347
Rpar52 vdd.t3 vdd.t2 22.0709
Rpar53 vdd.t3 vdd.t4 181.2815
Rpar54 vdd.t2 vdd.t4 691.7549
Rpar55 vss vss.t0 53.5926
Rpar56 vss vss.t8 1174.0552
Rpar57 vss vss.t4 230.8218
Rpar58 vss vss.t5 933.2057
Rpar59 vss vss.t30 472.9205
Rpar60 vss.t0 vss.t8 25.7023
Rpar61 vss.t0 vss.t4 2.2882
Rpar62 vss.t0 vss.t5 13.7642
Rpar63 vss.t0 vss.t30 6.1345
Rpar64 vss.t8 vss.t4 79.5051
Rpar65 vss.t8 vss.t5 313.9342
Rpar66 vss.t8 vss.t30 410.0695
Rpar67 vss.t4 vss.t5 8.6558
Rpar68 vss.t4 vss.t30 37.4887
Rpar69 vss.t5 vss.t30 247.1065
Cpar0 a_12544_5946.t0 vss 1.17112e-14
Cpar1 a_12544_5946.t1 vss 6.36614e-15
Cpar2 a_12544_5946.t4 vss 5.12230e-15
Cpar3 a_4951_10146.t0 vss 3.90800e-17
Cpar4 a_4951_11186.t0 vss 3.99600e-17
Cpar5 a_4951_5986.t0 vss 4.24200e-17
Cpar6 a_4951_7026.t0 vss 3.77600e-17
Cpar7 a_4951_8066.t0 vss 3.78800e-17
Cpar8 a_4951_9106.t0 vss 3.89200e-17
Cpar9 a_6050_1294.t0 vss 2.82818e-14
Cpar10 a_6050_1294.t16 vss 8.58570e-15
Cpar11 a_6050_14776.t0 vss 3.66725e-14
Cpar12 a_6050_14776.t16 vss 6.36563e-15
Cpar13 a_6950_14776.t0 vss 5.15409e-15
Cpar14 a_6950_14776.t1 vss 2.59709e-15
Cpar15 a_6950_14776.t4 vss 1.45147e-14
Cpar16 a_847_10666.t0 vss 4.26200e-17
Cpar17 a_847_11706.t0 vss 4.01100e-16
Cpar18 a_847_11706.t1 vss 5.40192e-15
Cpar19 a_847_5986.t0 vss 3.27158e-15
Cpar20 a_847_5986.t10 vss 2.79868e-15
Cpar21 a_847_5986.t11 vss 4.54103e-15
Cpar22 a_847_5986.t13 vss 8.17565e-15
Cpar23 a_847_5986.t2 vss 1.10618e-14
Cpar24 a_847_6506.t0 vss 4.12200e-17
Cpar25 a_847_7546.t0 vss 3.84800e-17
Cpar26 a_847_8586.t0 vss 3.84800e-17
Cpar27 a_847_9626.t0 vss 3.84800e-17
Cpar28 a_8732_12953.t0 vss 1.60534e-14
Cpar29 a_8732_12953.t8 vss 6.30723e-15
Cpar30 a_8732_12953.t9 vss 2.09193e-15
Cpar31 a_9380_9271.t0 vss 1.53269e-14
Cpar32 a_9380_9271.t10 vss 4.04527e-15
Cpar33 a_9380_9271.t11 vss 3.04200e-15
Cpar34 a_9380_9271.t8 vss 3.99136e-15
Cpar35 ib inn 3.53200e-17
Cpar36 ib inp 2.13000e-17
Cpar37 ib out 9.86710e-16
Cpar38 ib vss 3.21622e-14
Cpar39 ib.t0 vss 9.39784e-15
Cpar40 ib.t1 vss 9.56117e-16
Cpar41 inn inp 2.08480e-16
Cpar42 inn vdd 1.49321e-14
Cpar43 inn vss 2.65833e-14
Cpar44 inn.t0 vss 1.45563e-14
Cpar45 inn.t8 vss 2.33866e-14
Cpar46 inp out 4.59031e-15
Cpar47 inp vdd 1.44891e-14
Cpar48 inp vss 2.48049e-14
Cpar49 inp.t0 vss 1.56502e-14
Cpar50 inp.t8 vss 2.51425e-14
Cpar51 out vdd 5.90932e-15
Cpar52 out vss 2.34326e-14
Cpar53 out.t0 vss 3.47255e-15
Cpar54 out.t2 vss 1.11807e-14
Cpar55 out.t7 vss 8.53020e-15
Cpar56 vdd vss 2.29869e-13
Cpar57 vdd.t0 vss 9.30889e-15
Cpar58 vdd.t1 vss 4.68429e-15
Cpar59 vdd.t2 vss 8.78621e-15
Cpar60 vdd.t3 vss 4.78471e-15
Cpar61 vdd.t4 vss 5.07402e-14
.ends opamp_dut

Vdd vdd 0 3.300000
Vss vss 0 0
Ibias vdd ib 1.062000e-07
Vinp inp 0 DC 1.645000 AC 1 PWL(0 1.645000 8.229734e-08 1.645000 9.052707e-08 1.655000)
Rfb out inn 1m
Cload out 0 2.000000e-13
Xdut vdd vss inp inn out ib opamp_dut
.end
