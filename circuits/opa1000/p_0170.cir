* opa1000[0170]: 200f/folded_cascode_nmos_1v8_i200n_weak (folded_cascode_nmos, VDD=1.8V, CL=0.2pF, Iref=0.0511uA)
.include "pdk_opa.inc"
.temp 27
.option gmin=1e-12 rshunt=1e12 reltol=1e-3 abstol=1e-12 vntol=1e-5 method=gear
* Post-PEX R+C extracted netlist for folded_cascode_nmos_1v8_i200n_weak
.subckt opamp_dut vdd vss inp inn out ib
XMpar0 a_3532_6415.t1 a_3532_6415.t0 vss.t1 vss.t0 nfet_03v3 w=0.4u l=5u ad=2.4000e-13 pd=2.0000e-06 as=1.1200e-13 ps=9.6000e-07 nf=1 m=2 par=2
XMpar1 a_3274_997.t0 ib.t0 vss.t1 vss.t0 nfet_03v3 w=0.4u l=5u ad=2.4000e-13 pd=2.0000e-06 as=1.1200e-13 ps=9.6000e-07 nf=1 m=2 par=2
XMpar2 a_5774_4893.t4 ib.t4 out.t1 vdd.t14 pfet_03v3 w=0.73u l=3.5u ad=4.3800e-13 pd=2.6600e-06 as=2.0440e-13 ps=1.2900e-06 nf=1 m=2 par=2
XMpar3 a_1510_7986.t4 ib.t0 vss.t1 vss.t0 nfet_03v3 w=0.4u l=5u ad=2.4000e-13 pd=2.0000e-06 as=1.1200e-13 ps=9.6000e-07 nf=1 m=4 par=4
XMpar4 out.t0 a_3532_6415.t0 vss.t1 vss.t0 nfet_03v3 w=0.4u l=5u ad=1.1200e-13 pd=9.6000e-07 as=1.1200e-13 ps=9.6000e-07 nf=1 m=2 par=2
XMpar5 a_3728_3403.t2 a_3274_997.t2 vdd.t1 vdd.t0 pfet_03v3 w=0.4u l=5.2u ad=1.1200e-13 pd=9.6000e-07 as=2.4000e-13 ps=2.0000e-06 nf=1 m=4 par=4
XMpar6 a_5774_4893.t0 a_3274_997.t2 vdd.t1 vdd.t0 pfet_03v3 w=0.4u l=5.2u ad=1.1200e-13 pd=9.6000e-07 as=2.4000e-13 ps=2.0000e-06 nf=1 m=4 par=4
XMpar7 ib.t1 ib.t0 vss.t1 vss.t0 nfet_03v3 w=0.4u l=5u ad=2.4000e-13 pd=2.0000e-06 as=1.1200e-13 ps=9.6000e-07 nf=1 m=2 par=2
XMpar8 a_3274_997.t3 a_3274_997.t2 vdd.t1 vdd.t0 pfet_03v3 w=0.4u l=5.2u ad=1.1200e-13 pd=9.6000e-07 as=2.4000e-13 ps=2.0000e-06 nf=1 m=2 par=2
XMpar9 a_1510_7986.t0 inn.t0 a_5774_4893.t2 vss.t2 nfet_03v3 w=0.57u l=8.13u ad=3.4200e-13 pd=2.3400e-06 as=1.5960e-13 ps=1.1300e-06 nf=1 m=2 par=2
XMpar10 a_1510_7986.t0 inp.t0 a_3728_3403.t0 vss.t2 nfet_03v3 w=0.57u l=8.13u ad=3.4200e-13 pd=2.3400e-06 as=1.5960e-13 ps=1.1300e-06 nf=1 m=2 par=2
XMpar11 a_3532_6415.t4 ib.t4 a_3728_3403.t6 vdd.t14 pfet_03v3 w=0.73u l=3.5u ad=2.0440e-13 pd=1.2900e-06 as=4.3800e-13 ps=2.6600e-06 nf=1 m=2 par=2
Rpar0 a_1510_7986.t0 a_1510_7986.t4 54.3087
Rpar1 a_3274_997.t0 a_3274_997.t2 62.9934
Rpar2 a_3274_997.t0 a_3274_997.t3 119.1173
Rpar3 a_3274_997.t2 a_3274_997.t3 28.6050
Rpar4 a_3532_6415.t0 a_3532_6415.t1 22.2772
Rpar5 a_3532_6415.t0 a_3532_6415.t4 107.6296
Rpar6 a_3532_6415.t1 a_3532_6415.t4 82.6798
Rpar7 a_3728_3403.t0 a_3728_3403.t2 114.8781
Rpar8 a_3728_3403.t0 a_3728_3403.t6 65.4061
Rpar9 a_3728_3403.t2 a_3728_3403.t6 133.2397
Rpar10 a_5774_4893.t0 a_5774_4893.t2 86.6930
Rpar11 a_5774_4893.t0 a_5774_4893.t4 137.2400
Rpar12 a_5774_4893.t2 a_5774_4893.t4 84.4796
Rpar13 ib ib.t0 10.8724
Rpar14 ib ib.t1 16.9270
Rpar15 ib ib.t4 265.6418
Rpar16 ib.t0 ib.t1 34.1243
Rpar17 ib.t0 ib.t4 246.1543
Rpar18 ib.t1 ib.t4 239.9884
Rpar19 inn inn.t0 3.3846
Rpar20 inp inp.t0 3.4332
Rpar21 out out.t0 16.2131
Rpar22 out out.t1 52.8876
Rpar23 out.t0 out.t1 344.8558
Rpar24 vdd vdd.t0 180.2843
Rpar25 vdd vdd.t1 245.0107
Rpar26 vdd vdd.t14 198.8420
Rpar27 vdd.t0 vdd.t1 7.7213
Rpar28 vdd.t0 vdd.t14 98.9961
Rpar29 vdd.t1 vdd.t14 81.4102
Rpar30 vss vss.t0 73.0207
Rpar31 vss vss.t1 333.5689
Rpar32 vss vss.t2 112.6294
Rpar33 vss.t0 vss.t1 7.1598
Rpar34 vss.t0 vss.t2 13.4870
Rpar35 vss.t1 vss.t2 61.9733
Cpar0 a_1510_7986.t0 vss 4.91080e-15
Cpar1 a_1510_7986.t4 vss 6.94917e-15
Cpar2 a_3274_997.t0 vss 9.32044e-15
Cpar3 a_3274_997.t2 vss 3.28912e-14
Cpar4 a_3274_997.t3 vss 3.25495e-15
Cpar5 a_3532_6415.t0 vss 3.50517e-15
Cpar6 a_3532_6415.t1 vss 9.70323e-16
Cpar7 a_3532_6415.t4 vss 6.50377e-16
Cpar8 a_3728_3403.t0 vss 3.37023e-15
Cpar9 a_3728_3403.t2 vss 5.60684e-15
Cpar10 a_3728_3403.t6 vss 3.52643e-15
Cpar11 a_5774_4893.t0 vss 6.59504e-15
Cpar12 a_5774_4893.t2 vss 4.23225e-15
Cpar13 a_5774_4893.t4 vss 4.16385e-15
Cpar14 ib inn 2.90000e-17
Cpar15 ib inp 1.53100e-17
Cpar16 ib out 2.35760e-16
Cpar17 ib vdd 9.26662e-15
Cpar18 ib vss 3.12890e-14
Cpar19 ib.t0 vss 1.32611e-14
Cpar20 ib.t1 vss 2.35430e-15
Cpar21 ib.t4 vss 7.46025e-15
Cpar22 inn inp 5.15300e-17
Cpar23 inn vdd 2.10150e-16
Cpar24 inn vss 8.24345e-15
Cpar25 inn.t0 vss 7.20023e-16
Cpar26 inp vdd 8.13700e-17
Cpar27 inp vss 8.26210e-15
Cpar28 inp.t0 vss 6.33944e-16
Cpar29 out vdd 2.37906e-15
Cpar30 out vss 7.24589e-15
Cpar31 out.t0 vss 6.41652e-16
Cpar32 out.t1 vss 2.00383e-15
Cpar33 vdd vss 9.69724e-14
Cpar34 vdd.t0 vss 2.21121e-14
Cpar35 vdd.t1 vss 1.77536e-14
Cpar36 vdd.t14 vss 1.09313e-14
.ends opamp_dut

Vdd vdd 0 1.800000
Vss vss 0 0
Ibias vdd ib 5.110000e-08
Vinp inp 0 DC 0.985000 AC 1 PWL(0 0.985000 1.632861e-07 0.985000 1.796147e-07 0.995000)
Rfb out inn 1m
Cload out 0 2.000000e-13
Xdut vdd vss inp inn out ib opamp_dut
.end
