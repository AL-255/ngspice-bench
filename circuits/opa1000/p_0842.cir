* opa1000[0842]: 200f/telescopic_nmos_1v8_i2u_weak (telescopic_nmos, VDD=1.8V, CL=0.2pF, Iref=0.35uA)
.include "pdk_opa.inc"
.temp 27
.option gmin=1e-12 rshunt=1e12 reltol=1e-3 abstol=1e-12 vntol=1e-5 method=gear
* Post-PEX R+C extracted netlist for telescopic_nmos_1v8_i2u_weak
.subckt opamp_dut vdd vss inp inn out ib
XMpar0 a_1420_9198.t0 a_1540_8989.t0 a_1540_8989.t1 vdd.t0 pfet_03v3 w=1.53u l=1.63u ad=5.9160e-13 pd=2.8133e-06 as=5.9160e-13 ps=2.8133e-06 nf=1 m=6 par=6
XMpar1 a_4974_1204.t0 vdd.t30 out.t1 vss.t3 nfet_03v3 w=1.01u l=1.63u ad=6.0600e-13 pd=3.2200e-06 as=2.8280e-13 ps=1.5700e-06 nf=1 m=2 par=2
XMpar2 a_1420_9198.t1 a_1540_8989.t20 vdd.t3 vdd.t2 pfet_03v3 w=1.99u l=5.1u ad=7.6947e-13 pd=3.4267e-06 as=5.5720e-13 ps=2.5500e-06 nf=1 m=6 par=6
XMpar3 a_1622_1204.t6 ib.t0 vss.t8 vss.t7 nfet_03v3 w=0.57u l=3.25u ad=1.5960e-13 pd=1.1300e-06 as=2.0520e-13 ps=1.4325e-06 nf=1 m=8 par=8
XMpar4 a_1540_8989.t12 vdd.t30 a_2642_1204.t6 vss.t3 nfet_03v3 w=1.01u l=1.63u ad=2.8280e-13 pd=1.5700e-06 as=6.0600e-13 ps=3.2200e-06 nf=1 m=2 par=2
XMpar5 a_3642_5503.t0 a_1540_8989.t0 out.t0 vdd.t0 pfet_03v3 w=1.53u l=1.63u ad=5.9160e-13 pd=2.8133e-06 as=4.2840e-13 ps=2.0900e-06 nf=1 m=6 par=6
XMpar6 a_3642_5503.t1 a_1540_8989.t20 vdd.t3 vdd.t2 pfet_03v3 w=1.99u l=5.1u ad=7.6947e-13 pd=3.4267e-06 as=5.5720e-13 ps=2.5500e-06 nf=1 m=6 par=6
XMpar7 ib.t1 ib.t0 vss.t8 vss.t7 nfet_03v3 w=0.57u l=3.25u ad=1.5960e-13 pd=1.1300e-06 as=1.5960e-13 ps=1.1300e-06 nf=1 m=2 par=2
XMpar8 a_1622_1204.t0 inp.t0 a_2642_1204.t0 vss.t0 nfet_03v3 w=1.82u l=4.5u ad=7.0373e-13 pd=3.2000e-06 as=7.0373e-13 ps=3.2000e-06 nf=1 m=6 par=6
XMpar9 a_1622_1204.t0 inn.t0 a_4974_1204.t2 vss.t0 nfet_03v3 w=1.82u l=4.5u ad=7.0373e-13 pd=3.2000e-06 as=7.0373e-13 ps=3.2000e-06 nf=1 m=6 par=6
Rpar0 a_1420_9198.t0 a_1420_9198.t1 59.4135
Rpar1 a_1540_8989.t0 a_1540_8989.t1 16.4047
Rpar2 a_1540_8989.t0 a_1540_8989.t12 383.7251
Rpar3 a_1540_8989.t0 a_1540_8989.t20 295.7344
Rpar4 a_1540_8989.t1 a_1540_8989.t12 127.5267
Rpar5 a_1540_8989.t1 a_1540_8989.t20 98.2840
Rpar6 a_1540_8989.t12 a_1540_8989.t20 145.5291
Rpar7 a_1622_1204.t0 a_1622_1204.t6 41.3726
Rpar8 a_2642_1204.t0 a_2642_1204.t6 42.8047
Rpar9 a_3642_5503.t0 a_3642_5503.t1 59.6843
Rpar10 a_4974_1204.t0 a_4974_1204.t2 42.8047
Rpar11 ib ib.t0 21.9697
Rpar12 ib ib.t1 19.4460
Rpar13 ib.t0 ib.t1 80.9734
Rpar14 inn inn.t0 2.4925
Rpar15 inp inp.t0 2.4925
Rpar16 out out.t0 5.2348
Rpar17 out out.t1 137.0951
Rpar18 out.t0 out.t1 131.9071
Rpar19 vdd vdd.t0 106.1275
Rpar20 vdd vdd.t3 172.7077
Rpar21 vdd vdd.t2 31.5955
Rpar22 vdd vdd.t30 444.7379
Rpar23 vdd.t0 vdd.t3 374.6941
Rpar24 vdd.t0 vdd.t2 68.5473
Rpar25 vdd.t0 vdd.t30 66.2414
Rpar26 vdd.t3 vdd.t2 14.9774
Rpar27 vdd.t3 vdd.t30 1570.1936
Rpar28 vdd.t2 vdd.t30 287.2542
Rpar29 vss vss.t0 41.7070
Rpar30 vss vss.t8 1078.3759
Rpar31 vss vss.t7 501.9263
Rpar32 vss vss.t3 42.2397
Rpar33 vss.t0 vss.t8 512.0744
Rpar34 vss.t0 vss.t7 238.8536
Rpar35 vss.t0 vss.t3 6.5710
Rpar36 vss.t8 vss.t7 7.1577
Rpar37 vss.t8 vss.t3 442.9780
Rpar38 vss.t7 vss.t3 206.5031
Cpar0 a_1420_9198.t0 vss 8.94194e-15
Cpar1 a_1420_9198.t1 vss 1.97439e-14
Cpar2 a_1540_8989.t0 vss 1.36913e-14
Cpar3 a_1540_8989.t1 vss 5.78292e-15
Cpar4 a_1540_8989.t12 vss 2.43222e-15
Cpar5 a_1540_8989.t20 vss 4.50714e-14
Cpar6 a_1622_1204.t0 vss 1.19292e-14
Cpar7 a_1622_1204.t6 vss 6.74543e-15
Cpar8 a_2642_1204.t0 vss 7.10665e-15
Cpar9 a_2642_1204.t6 vss 2.48855e-15
Cpar10 a_3642_5503.t0 vss 8.22557e-15
Cpar11 a_3642_5503.t1 vss 1.89925e-14
Cpar12 a_4974_1204.t0 vss 2.50310e-15
Cpar13 a_4974_1204.t2 vss 7.14825e-15
Cpar14 ib out 1.89400e-17
Cpar15 ib vdd 3.78160e-16
Cpar16 ib vss 2.39311e-14
Cpar17 ib.t0 vss 3.70080e-15
Cpar18 ib.t1 vss 1.65413e-16
Cpar19 inn inp 1.02310e-16
Cpar20 inn vss 1.30930e-14
Cpar21 inn.t0 vss 3.55012e-15
Cpar22 inp vdd 4.58900e-17
Cpar23 inp vss 1.29356e-14
Cpar24 inp.t0 vss 3.57376e-15
Cpar25 out vdd 4.09794e-15
Cpar26 out vss 7.13630e-15
Cpar27 out.t0 vss 3.90027e-15
Cpar28 out.t1 vss 2.95924e-15
Cpar29 vdd vss 1.36109e-13
Cpar30 vdd.t0 vss 2.28288e-14
Cpar31 vdd.t2 vss 3.66791e-14
Cpar32 vdd.t3 vss 9.58310e-15
Cpar33 vdd.t30 vss 2.33074e-15
.ends opamp_dut

Vdd vdd 0 1.800000
Vss vss 0 0
Ibias vdd ib 3.500000e-07
Vinp inp 0 DC 0.931000 AC 1 PWL(0 0.931000 1.996671e-08 0.931000 2.196338e-08 0.941000)
Rfb out inn 1m
Cload out 0 2.000000e-13
Xdut vdd vss inp inn out ib opamp_dut
.end
