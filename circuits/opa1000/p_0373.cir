* opa1000[0373]: 200f/nmos_5t_3v3_i500u_subth (nmos_5t, VDD=3.3V, CL=0.2pF, Iref=125.0uA)
.include "pdk_opa.inc"
.temp 27
.option gmin=1e-12 rshunt=1e12 reltol=1e-3 abstol=1e-12 vntol=1e-5 method=gear
* Post-PEX R+C extracted netlist for nmos_5t_3v3_i500u_subth
.subckt opamp_dut vdd vss inp inn out ib
XMpar0 a_1640_6703.t161 a_1640_6703.t160 vdd.t1 vdd.t0 pfet_03v3 w=2.96u l=0.4u ad=9.2352e-13 pd=3.8800e-06 as=8.2880e-13 ps=3.5200e-06 nf=1 m=160 par=160
XMpar1 a_1430_6703.t0 inp.t0 a_1640_6703.t0 vss.t0 nfet_03v3 w=12.08u l=0.45u ad=3.4790e-12 pd=1.2958e-05 as=3.4307e-12 ps=1.2799e-05 nf=1 m=160 par=160
XMpar2 out.t0 a_1640_6703.t160 vdd.t1 vdd.t0 pfet_03v3 w=2.96u l=0.4u ad=9.2352e-13 pd=3.8800e-06 as=8.7616e-13 ps=3.7000e-06 nf=1 m=160 par=160
XMpar3 a_1430_6703.t160 ib.t0 vss.t108 vss.t0 nfet_03v3 w=6.82u l=0.36u ad=1.9096e-12 pd=7.3800e-06 as=2.0460e-12 ps=7.8462e-06 nf=1 m=64 par=64
XMpar4 a_1430_6703.t0 inn.t0 out.t13 vss.t0 nfet_03v3 w=12.08u l=0.45u ad=3.4790e-12 pd=1.2958e-05 as=3.4307e-12 ps=1.2799e-05 nf=1 m=160 par=160
XMpar5 ib.t1 ib.t0 vss.t108 vss.t0 nfet_03v3 w=6.82u l=0.36u ad=1.9096e-12 pd=7.3800e-06 as=1.9096e-12 ps=7.3800e-06 nf=1 m=16 par=16
X38 out.t320 vss.t227 cap_mim_2f0fF c_width=17.91u c_length=17.91u
X238 out.t320 vss.t227 cap_mim_2f0fF c_width=17.91u c_length=17.91u
Rpar0 a_1430_6703.t0 a_1430_6703.t160 43.2784
Rpar1 a_1640_6703.t0 a_1640_6703.t160 238.3034
Rpar2 a_1640_6703.t0 a_1640_6703.t161 46.6953
Rpar3 a_1640_6703.t160 a_1640_6703.t161 3.5184
Rpar4 ib ib.t0 16.5102
Rpar5 ib ib.t1 4.4175
Rpar6 ib.t0 ib.t1 14.6291
Rpar7 inn inn.t0 2.4143
Rpar8 inp inp.t0 2.4143
Rpar9 out out.t0 2.2832
Rpar10 out.t0 out.t13 49.4352
Rpar11 out.t0 out.t320 156.6125
Rpar12 out.t13 out.t320 161.7412
Rpar13 vdd vdd.t0 18.9526
Rpar14 vdd.t0 vdd.t1 8.3192
Rpar15 vss vss.t0 25.6243
Rpar16 vss vss.t108 948.5303
Rpar17 vss vss.t227 77.0263
Rpar18 vss.t0 vss.t108 10.4265
Rpar19 vss.t0 vss.t227 228.3369
Rpar20 vss.t108 vss.t227 8452.2990
Cpar0 a_1430_6703.t0 vss 6.70422e-13
Cpar1 a_1430_6703.t160 vss 8.61146e-14
Cpar2 a_1640_6703.t0 vss 3.92029e-13
Cpar3 a_1640_6703.t160 vss 1.93540e-13
Cpar4 a_1640_6703.t161 vss 1.64205e-13
Cpar5 ib inn 2.62100e-17
Cpar6 ib inp 1.16900e-17
Cpar7 ib out 2.36900e-17
Cpar8 ib vss 7.84252e-14
Cpar9 ib.t0 vss 1.05648e-14
Cpar10 ib.t1 vss 5.21884e-15
Cpar11 inn inp 1.05030e-16
Cpar12 inn out 4.80668e-14
Cpar13 inn vdd 2.05000e-17
Cpar14 inn vss 6.82005e-14
Cpar15 inn.t0 vss 7.87583e-14
Cpar16 inp out 4.59870e-16
Cpar17 inp vdd 2.00800e-17
Cpar18 inp vss 6.79726e-14
Cpar19 inp.t0 vss 7.86864e-14
Cpar20 out vdd 1.45660e-13
Cpar21 out vss 4.99432e-14
Cpar22 out.t0 vss 1.04617e-13
Cpar23 out.t13 vss 2.66035e-13
Cpar24 out.t320 vss 2.13553e-13
Cpar25 vdd vss 4.18243e-13
Cpar26 vdd.t0 vss 3.55018e-13
Cpar27 vdd.t1 vss 8.10580e-14
.ends opamp_dut

Vdd vdd 0 3.300000
Vss vss 0 0
Ibias vdd ib 1.250000e-04
Vinp inp 0 DC 1.645000 AC 1 PWL(0 1.645000 3.000000e-09 1.645000 3.300000e-09 1.655000)
Rfb out inn 1m
Cload out 0 2.000000e-13
Xdut vdd vss inp inn out ib opamp_dut
.end
