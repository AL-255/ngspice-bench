* opa1000[0594]: 200f/pmos_miller_1v8_i2u_weak (pmos_miller, VDD=1.8V, CL=0.2pF, Iref=0.2875uA)
.include "pdk_opa.inc"
.temp 27
.option gmin=1e-12 rshunt=1e12 reltol=1e-3 abstol=1e-12 vntol=1e-5 method=gear
* Post-PEX R+C extracted netlist for pmos_miller_1v8_i2u_weak
.subckt opamp_dut vdd vss inp inn out ib
XMpar0 a_1065_1041.t0 inp.t0 a_2050_8811.t0 vdd.t0 pfet_03v3 w=1.75u l=4.5u ad=4.9000e-13 pd=2.3100e-06 as=7.7000e-13 ps=3.5050e-06 nf=1 m=8 par=8
XMpar1 a_2050_8811.t0 inn.t0 a_5480_6573.t0 vdd.t0 pfet_03v3 w=1.75u l=4.5u ad=7.7000e-13 pd=3.5050e-06 as=4.9000e-13 ps=2.3100e-06 nf=1 m=8 par=8
XMpar2 a_1406_4661.t1 a_1406_4661.t0 vdd.t5 vdd.t4 pfet_03v3 w=0.86u l=1.56u ad=2.4080e-13 pd=1.4200e-06 as=2.4080e-13 ps=1.4200e-06 nf=1 m=2 par=2
XMpar3 a_2050_8811.t8 a_1406_4661.t0 vdd.t5 vdd.t4 pfet_03v3 w=0.86u l=1.56u ad=2.4080e-13 pd=1.4200e-06 as=2.4080e-13 ps=1.4200e-06 nf=1 m=4 par=4
XMpar4 ib.t1 ib.t0 vss.t28 vss.t27 nfet_03v3 w=0.4u l=1.56u ad=2.4000e-13 pd=2.0000e-06 as=1.1200e-13 ps=9.6000e-07 nf=1 m=2 par=2
XMpar5 a_5480_6573.t9 a_5480_6573.t8 vss.t1 vss.t0 nfet_03v3 w=0.4u l=2.03u ad=1.1200e-13 pd=9.6000e-07 as=1.1200e-13 ps=9.6000e-07 nf=1 m=2 par=2
XMpar6 a_1065_1041.t8 a_5480_6573.t8 vss.t1 vss.t0 nfet_03v3 w=0.4u l=2.03u ad=2.4000e-13 pd=2.0000e-06 as=1.1200e-13 ps=9.6000e-07 nf=1 m=2 par=2
XMpar7 out.t0 a_1065_1041.t11 vss.t1 vss.t0 nfet_03v3 w=0.4u l=2.03u ad=1.1200e-13 pd=9.6000e-07 as=1.3760e-13 ps=1.1680e-06 nf=1 m=10 par=10
XMpar8 out.t4 a_1406_4661.t0 vdd.t5 vdd.t4 pfet_03v3 w=0.86u l=1.56u ad=2.9584e-13 pd=1.7200e-06 as=2.4080e-13 ps=1.4200e-06 nf=1 m=10 par=10
XMpar9 a_1406_4661.t4 ib.t0 vss.t28 vss.t27 nfet_03v3 w=0.4u l=1.56u ad=1.1200e-13 pd=9.6000e-07 as=1.1200e-13 ps=9.6000e-07 nf=1 m=2 par=2
X12 a_1065_1041.t10 a_11338_1290.t0 vss.t18 ppolyf_u_1k r_width=1u r_length=18.64u
X24 a_7478_2850.t0 a_11338_3370.t0 vss.t18 ppolyf_u_1k r_width=1u r_length=18.64u
X26 a_7478_2850.t0 a_11338_2330.t0 vss.t18 ppolyf_u_1k r_width=1u r_length=18.64u
X32 a_7478_1810.t0 a_11338_2330.t0 vss.t18 ppolyf_u_1k r_width=1u r_length=18.64u
X36 a_7478_1810.t0 a_11338_1290.t0 vss.t18 ppolyf_u_1k r_width=1u r_length=18.64u
X45 a_11338_3370.t1 out.t7 cap_mim_2f0fF c_width=11.46u c_length=11.46u
Rpar0 a_1065_1041.t0 a_1065_1041.t10 562.1082
Rpar1 a_1065_1041.t0 a_1065_1041.t11 122.6066
Rpar2 a_1065_1041.t0 a_1065_1041.t8 132.1383
Rpar3 a_1065_1041.t10 a_1065_1041.t11 69.5372
Rpar4 a_1065_1041.t10 a_1065_1041.t8 487.7197
Rpar5 a_1065_1041.t11 a_1065_1041.t8 106.3810
Rpar6 a_11338_3370.t0 a_11338_3370.t1 58.5553
Rpar7 a_1406_4661.t0 a_1406_4661.t1 27.4812
Rpar8 a_1406_4661.t0 a_1406_4661.t4 228.9578
Rpar9 a_1406_4661.t1 a_1406_4661.t4 185.7134
Rpar10 a_2050_8811.t0 a_2050_8811.t8 52.5301
Rpar11 a_5480_6573.t0 a_5480_6573.t8 146.2669
Rpar12 a_5480_6573.t0 a_5480_6573.t9 149.7561
Rpar13 a_5480_6573.t8 a_5480_6573.t9 29.3453
Rpar14 ib ib.t0 12.1884
Rpar15 ib ib.t1 8.1412
Rpar16 inn inn.t0 2.1027
Rpar17 inp inp.t0 2.1026
Rpar18 out out.t0 80.0533
Rpar19 out out.t4 46.9317
Rpar20 out out.t7 19.9833
Rpar21 out.t0 out.t4 84.5809
Rpar22 out.t0 out.t7 1273.1621
Rpar23 out.t4 out.t7 746.3989
Rpar24 vdd vdd.t0 22.1811
Rpar25 vdd vdd.t4 197.3014
Rpar26 vdd vdd.t5 890.9353
Rpar27 vdd.t0 vdd.t4 89.1855
Rpar28 vdd.t0 vdd.t5 402.7265
Rpar29 vdd.t4 vdd.t5 5.0636
Rpar30 vss vss.t0 148.2669
Rpar31 vss vss.t1 312.1784
Rpar32 vss vss.t18 64.7686
Rpar33 vss vss.t27 399.3711
Rpar34 vss vss.t28 743.6447
Rpar35 vss.t0 vss.t1 5.6491
Rpar36 vss.t0 vss.t18 462.8483
Rpar37 vss.t0 vss.t27 9.2280
Rpar38 vss.t0 vss.t28 19.2445
Rpar39 vss.t1 vss.t18 958.1232
Rpar40 vss.t1 vss.t27 22.9789
Rpar41 vss.t1 vss.t28 45.8474
Rpar42 vss.t18 vss.t27 1262.1243
Rpar43 vss.t18 vss.t28 2364.3524
Rpar44 vss.t27 vss.t28 38.2430
Cpar0 a_1065_1041.t0 vss 4.97338e-15
Cpar1 a_1065_1041.t10 vss 2.39863e-15
Cpar2 a_1065_1041.t11 vss 8.34559e-15
Cpar3 a_1065_1041.t8 vss 2.56661e-15
Cpar4 a_11338_1290.t0 vss 2.64400e-17
Cpar5 a_11338_2330.t0 vss 3.27400e-17
Cpar6 a_11338_3370.t0 vss 1.76840e-16
Cpar7 a_11338_3370.t1 vss 2.49101e-15
Cpar8 a_1406_4661.t0 vss 1.86146e-14
Cpar9 a_1406_4661.t1 vss 4.89391e-15
Cpar10 a_1406_4661.t4 vss 6.09096e-15
Cpar11 a_2050_8811.t0 vss 2.23142e-14
Cpar12 a_2050_8811.t8 vss 8.17846e-15
Cpar13 a_5480_6573.t0 vss 7.88621e-15
Cpar14 a_5480_6573.t8 vss 5.36120e-15
Cpar15 a_5480_6573.t9 vss 1.97983e-15
Cpar16 a_7478_1810.t0 vss 3.41000e-17
Cpar17 a_7478_2850.t0 vss 3.84000e-17
Cpar18 ib vss 6.88248e-15
Cpar19 ib.t0 vss 7.32482e-16
Cpar20 ib.t1 vss 5.63400e-17
Cpar21 inn inp 1.04240e-16
Cpar22 inn out 3.02800e-17
Cpar23 inn vdd 1.50594e-14
Cpar24 inn vss 4.38663e-15
Cpar25 inn.t0 vss 1.70649e-14
Cpar26 inp vdd 1.52259e-14
Cpar27 inp vss 4.40042e-15
Cpar28 inp.t0 vss 1.70456e-14
Cpar29 out vdd 6.19277e-15
Cpar30 out vss 1.39302e-14
Cpar31 out.t0 vss 2.66616e-15
Cpar32 out.t4 vss 3.40883e-15
Cpar33 out.t7 vss 5.36451e-15
Cpar34 vdd vss 1.41261e-13
Cpar35 vdd.t0 vss 4.14583e-14
Cpar36 vdd.t4 vss 1.95952e-14
Cpar37 vdd.t5 vss 4.75455e-15
.ends opamp_dut

Vdd vdd 0 1.800000
Vss vss 0 0
Ibias vdd ib 2.875000e-07
Vinp inp 0 DC 0.805000 AC 1 PWL(0 0.805000 3.684170e-08 0.805000 4.052587e-08 0.815000)
Rfb out inn 1m
Cload out 0 2.000000e-13
Xdut vdd vss inp inn out ib opamp_dut
.end
