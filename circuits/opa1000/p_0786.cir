* opa1000[0786]: 200f/symmetrical_ota_3v3_i20u_weak (symmetrical_ota, VDD=3.3V, CL=0.2pF, Iref=3.5uA)
.include "pdk_opa.inc"
.temp 27
.option gmin=1e-12 rshunt=1e12 reltol=1e-3 abstol=1e-12 vntol=1e-5 method=gear
* Post-PEX R+C extracted netlist for symmetrical_ota_3v3_i20u_weak
.subckt opamp_dut vdd vss inp inn out ib
XMpar0 a_4244_7107.t5 a_4244_7107.t4 vss.t3 vss.t2 nfet_03v3 w=0.89u l=0.88u ad=2.4920e-13 pd=1.4500e-06 as=2.4920e-13 ps=1.4500e-06 nf=1 m=4 par=4
XMpar1 a_5558_3088.t3 a_5558_3088.t2 vdd.t1 vdd.t0 pfet_03v3 w=3.63u l=0.88u ad=1.0164e-12 pd=4.1900e-06 as=1.0164e-12 ps=4.1900e-06 nf=1 m=2 par=2
XMpar2 out.t0 a_2875_4801.t2 vdd.t1 vdd.t0 pfet_03v3 w=3.63u l=0.88u ad=1.0164e-12 pd=4.1900e-06 as=1.5972e-12 ps=6.3250e-06 nf=1 m=4 par=4
XMpar3 a_2875_4801.t3 a_2875_4801.t2 vdd.t1 vdd.t0 pfet_03v3 w=3.63u l=0.88u ad=1.0164e-12 pd=4.1900e-06 as=1.0164e-12 ps=4.1900e-06 nf=1 m=2 par=2
XMpar4 a_4244_7107.t0 a_5558_3088.t2 vdd.t1 vdd.t0 pfet_03v3 w=3.63u l=0.88u ad=1.0164e-12 pd=4.1900e-06 as=1.5972e-12 ps=6.3250e-06 nf=1 m=4 par=4
XMpar5 out.t2 a_4244_7107.t4 vss.t3 vss.t2 nfet_03v3 w=0.89u l=0.88u ad=2.4920e-13 pd=1.4500e-06 as=3.9160e-13 ps=2.2150e-06 nf=1 m=4 par=4
XMpar6 a_2875_4801.t0 inp.t0 a_4466_3088.t0 vss.t0 nfet_03v3 w=2.5u l=0.72u ad=7.0000e-13 pd=3.0600e-06 as=1.5000e-12 ps=6.2000e-06 nf=1 m=2 par=2
XMpar7 a_4466_3088.t0 inn.t0 a_5558_3088.t0 vss.t0 nfet_03v3 w=2.5u l=0.72u ad=1.5000e-12 pd=6.2000e-06 as=7.0000e-13 ps=3.0600e-06 nf=1 m=2 par=2
XMpar8 a_4466_3088.t4 ib.t0 vss.t20 vss.t19 nfet_03v3 w=1.74u l=1.2u ad=4.8720e-13 pd=2.3000e-06 as=7.6560e-13 ps=3.4900e-06 nf=1 m=4 par=4
XMpar9 ib.t1 ib.t0 vss.t20 vss.t19 nfet_03v3 w=1.74u l=1.2u ad=4.8720e-13 pd=2.3000e-06 as=4.8720e-13 ps=2.3000e-06 nf=1 m=2 par=2
X30 out.t8 vss.t14 cap_mim_2f0fF c_width=9.22u c_length=9.22u
Rpar0 a_2875_4801.t0 a_2875_4801.t2 161.8057
Rpar1 a_2875_4801.t0 a_2875_4801.t3 80.5299
Rpar2 a_2875_4801.t2 a_2875_4801.t3 24.9375
Rpar3 a_4244_7107.t0 a_4244_7107.t4 191.3991
Rpar4 a_4244_7107.t0 a_4244_7107.t5 87.4314
Rpar5 a_4244_7107.t4 a_4244_7107.t5 20.7037
Rpar6 a_4466_3088.t0 a_4466_3088.t4 46.3264
Rpar7 a_5558_3088.t0 a_5558_3088.t2 161.8057
Rpar8 a_5558_3088.t0 a_5558_3088.t3 80.5299
Rpar9 a_5558_3088.t2 a_5558_3088.t3 24.9375
Rpar10 ib ib.t0 16.5484
Rpar11 ib ib.t1 10.4418
Rpar12 ib.t0 ib.t1 143.5873
Rpar13 inn inn.t0 16.9647
Rpar14 inp inp.t0 17.0133
Rpar15 out out.t0 3.7457
Rpar16 out out.t2 58.3311
Rpar17 out out.t8 54.7081
Rpar18 out.t2 out.t8 211.8856
Rpar19 vdd vdd.t0 92.9223
Rpar20 vdd vdd.t1 125.6305
Rpar21 vdd.t0 vdd.t1 3.2271
Rpar22 vss vss.t0 199.6505
Rpar23 vss vss.t2 1453.6792
Rpar24 vss vss.t3 1358.5704
Rpar25 vss vss.t14 73.0447
Rpar26 vss vss.t19 84.5402
Rpar27 vss vss.t20 179.0016
Rpar28 vss.t0 vss.t2 433.8912
Rpar29 vss.t0 vss.t3 407.1878
Rpar30 vss.t0 vss.t14 465.0537
Rpar31 vss.t0 vss.t19 4.7755
Rpar32 vss.t0 vss.t20 19.6581
Rpar33 vss.t2 vss.t3 8.2593
Rpar34 vss.t2 vss.t14 3386.1118
Rpar35 vss.t2 vss.t19 149.4212
Rpar36 vss.t2 vss.t20 545.8194
Rpar37 vss.t3 vss.t14 3164.5712
Rpar38 vss.t3 vss.t19 140.1520
Rpar39 vss.t3 vss.t20 513.2039
Rpar40 vss.t14 vss.t19 196.9227
Rpar41 vss.t14 vss.t20 416.9555
Rpar42 vss.t19 vss.t20 9.2821
Cpar0 a_2875_4801.t0 vss 2.86742e-15
Cpar1 a_2875_4801.t2 vss 6.75967e-15
Cpar2 a_2875_4801.t3 vss 3.68235e-15
Cpar3 a_4244_7107.t0 vss 3.20008e-15
Cpar4 a_4244_7107.t4 vss 3.37126e-15
Cpar5 a_4244_7107.t5 vss 1.69375e-15
Cpar6 a_4466_3088.t0 vss 3.09625e-15
Cpar7 a_4466_3088.t4 vss 1.63356e-15
Cpar8 a_5558_3088.t0 vss 2.45535e-15
Cpar9 a_5558_3088.t2 vss 5.78831e-15
Cpar10 a_5558_3088.t3 vss 3.15318e-15
Cpar11 ib vss 8.47934e-15
Cpar12 ib.t0 vss 1.26675e-15
Cpar13 ib.t1 vss 9.41321e-17
Cpar14 inn inp 5.22700e-17
Cpar15 inn vss 1.60636e-15
Cpar16 inn.t0 vss 2.58525e-16
Cpar17 inp vss 1.56302e-15
Cpar18 inp.t0 vss 2.67776e-16
Cpar19 out vdd 3.51684e-15
Cpar20 out vss 8.93918e-15
Cpar21 out.t0 vss 4.80871e-16
Cpar22 out.t2 vss 6.77429e-16
Cpar23 out.t8 vss 7.65359e-15
Cpar24 vdd vss 4.84998e-14
Cpar25 vdd.t0 vss 1.04406e-14
Cpar26 vdd.t1 vss 7.27894e-15
.ends opamp_dut

Vdd vdd 0 3.300000
Vss vss 0 0
Ibias vdd ib 3.500000e-06
Vinp inp 0 DC 1.645000 AC 1 PWL(0 1.645000 3.000000e-09 1.645000 3.300000e-09 1.655000)
Rfb out inn 1m
Cload out 0 2.000000e-13
Xdut vdd vss inp inn out ib opamp_dut
.end
