* opa1000[0152]: 2p/current_reuse_3v3_i1u_subth (current_reuse, VDD=3.3V, CL=2.0pF, Iref=0.1643uA)
.include "pdk_opa.inc"
.temp 27
.option gmin=1e-12 rshunt=1e12 reltol=1e-3 abstol=1e-12 vntol=1e-5 method=gear
* Post-PEX R+C extracted netlist for current_reuse_3v3_i1u_subth
.subckt opamp_dut vdd vss inp inn out ib
XMpar0 a_974_10104.t13 a_9154_15587.t12 vdd.t1 vdd.t0 pfet_03v3 w=4.25u l=2.25u ad=2.5500e-12 pd=9.7000e-06 as=1.1900e-12 ps=4.8100e-06 nf=1 m=1
XMpar1 out.t0 a_974_10104.t14 vdd.t1 vdd.t0 pfet_03v3 w=4.25u l=2.25u ad=1.1900e-12 pd=4.8100e-06 as=1.4620e-12 ps=5.7880e-06 nf=1 m=10 par=10
XMpar2 a_5906_13921.t0 inp.t4 a_974_10104.t0 vdd.t4 pfet_03v3 w=2.49u l=1.56u ad=8.9640e-13 pd=3.8325e-06 as=6.9720e-13 ps=3.0500e-06 nf=1 m=8 par=8
XMpar3 ib.t1 ib.t0 vss.t10 vss.t9 nfet_03v3 w=0.84u l=3.5u ad=5.0400e-13 pd=2.8800e-06 as=2.3520e-13 ps=1.4000e-06 nf=1 m=2 par=2
XMpar4 out.t9 ib.t0 vss.t10 vss.t9 nfet_03v3 w=0.84u l=3.5u ad=3.9648e-13 pd=2.2880e-06 as=3.4272e-13 ps=1.9920e-06 nf=1 m=10 par=10
XMpar5 a_5906_13921.t0 inn.t4 a_9154_15587.t0 vdd.t4 pfet_03v3 w=2.49u l=1.56u ad=8.9640e-13 pd=3.8325e-06 as=6.9720e-13 ps=3.0500e-06 nf=1 m=8 par=8
XMpar6 a_7602_10064.t8 ib.t0 vss.t10 vss.t9 nfet_03v3 w=0.84u l=3.5u ad=5.0400e-13 pd=2.8800e-06 as=2.3520e-13 ps=1.4000e-06 nf=1 m=4 par=4
XMpar7 a_7602_10064.t0 inp.t0 a_974_10104.t8 vss.t0 nfet_03v3 w=1.28u l=1.56u ad=5.6320e-13 pd=2.8000e-06 as=3.5840e-13 ps=1.8400e-06 nf=1 m=4 par=4
XMpar8 a_7602_10064.t0 inn.t0 a_9154_15587.t8 vss.t0 nfet_03v3 w=1.28u l=1.56u ad=5.6320e-13 pd=2.8000e-06 as=3.5840e-13 ps=1.8400e-06 nf=1 m=4 par=4
XMpar9 a_5906_13921.t8 a_9154_15587.t12 vdd.t1 vdd.t0 pfet_03v3 w=4.25u l=2.25u ad=1.1900e-12 pd=4.8100e-06 as=2.5500e-12 ps=9.7000e-06 nf=1 m=2 par=2
XMpar10 a_9154_15587.t13 a_9154_15587.t12 vdd.t1 vdd.t0 pfet_03v3 w=4.25u l=2.25u ad=2.5500e-12 pd=9.7000e-06 as=1.1900e-12 ps=4.8100e-06 nf=1 m=1
X3 a_974_11664.t1 out.t6 cap_mim_2f0fF c_width=17.1u c_length=17.11u
X24 a_974_11664.t1 out.t6 cap_mim_2f0fF c_width=17.1u c_length=17.11u
X36 a_974_11664.t0 a_4566_11144.t0 vss.t8 ppolyf_u_1k r_width=1u r_length=17.3u
X45 a_974_10624.t0 a_4566_11144.t0 vss.t8 ppolyf_u_1k r_width=1u r_length=17.3u
X49 a_974_11664.t1 out.t6 cap_mim_2f0fF c_width=17.1u c_length=17.11u
X52 a_974_10624.t0 a_4566_10104.t0 vss.t8 ppolyf_u_1k r_width=1u r_length=17.3u
X58 a_974_10104.t12 a_4566_10104.t0 vss.t8 ppolyf_u_1k r_width=1u r_length=17.3u
Rpar0 a_5906_13921.t0 a_5906_13921.t8 39.9758
Rpar1 a_7602_10064.t0 a_7602_10064.t8 65.3235
Rpar2 a_9154_15587.t0 a_9154_15587.t8 219.0816
Rpar3 a_9154_15587.t0 a_9154_15587.t12 82.4416
Rpar4 a_9154_15587.t0 a_9154_15587.t13 115.0760
Rpar5 a_9154_15587.t8 a_9154_15587.t12 84.3817
Rpar6 a_9154_15587.t8 a_9154_15587.t13 509.5492
Rpar7 a_9154_15587.t12 a_9154_15587.t13 25.1258
Rpar8 a_974_10104.t0 a_974_10104.t8 226.9833
Rpar9 a_974_10104.t0 a_974_10104.t12 159.1164
Rpar10 a_974_10104.t0 a_974_10104.t13 61.2949
Rpar11 a_974_10104.t0 a_974_10104.t14 64.4675
Rpar12 a_974_10104.t8 a_974_10104.t12 177.4873
Rpar13 a_974_10104.t8 a_974_10104.t13 552.9015
Rpar14 a_974_10104.t8 a_974_10104.t14 84.4404
Rpar15 a_974_10104.t12 a_974_10104.t13 387.5867
Rpar16 a_974_10104.t12 a_974_10104.t14 59.1931
Rpar17 a_974_10104.t13 a_974_10104.t14 157.0343
Rpar18 a_974_11664.t0 a_974_11664.t1 50.1168
Rpar19 ib ib.t0 15.0758
Rpar20 ib ib.t1 13.0087
Rpar21 ib.t0 ib.t1 30.7635
Rpar22 inn inn.t0 2.8786
Rpar23 inn inn.t4 53.0234
Rpar24 inp inp.t0 2.9272
Rpar25 inp inp.t4 62.2628
Rpar26 out out.t0 164.8245
Rpar27 out out.t9 4.2050
Rpar28 out out.t6 353.6649
Rpar29 out.t0 out.t9 111.8934
Rpar30 out.t0 out.t6 209.7556
Rpar31 out.t9 out.t6 240.0903
Rpar32 vdd vdd.t0 51.2986
Rpar33 vdd vdd.t1 61.3975
Rpar34 vdd vdd.t4 74.2315
Rpar35 vdd.t0 vdd.t1 3.4833
Rpar36 vdd.t0 vdd.t4 44.6631
Rpar37 vdd.t1 vdd.t4 49.2819
Rpar38 vss vss.t0 96.7902
Rpar39 vss vss.t10 34.1725
Rpar40 vss vss.t9 90.2282
Rpar41 vss vss.t8 481.0714
Rpar42 vss.t0 vss.t10 45.5324
Rpar43 vss.t0 vss.t9 2.0834
Rpar44 vss.t0 vss.t8 78.5396
Rpar45 vss.t10 vss.t9 16.6569
Rpar46 vss.t10 vss.t8 1431.3088
Rpar47 vss.t9 vss.t8 124.5243
Cpar0 a_4566_10104.t0 vss 4.31800e-17
Cpar1 a_4566_11144.t0 vss 4.03800e-17
Cpar2 a_5906_13921.t0 vss 1.34934e-14
Cpar3 a_5906_13921.t8 vss 3.56037e-15
Cpar4 a_7602_10064.t0 vss 8.60350e-15
Cpar5 a_7602_10064.t8 vss 1.58239e-14
Cpar6 a_9154_15587.t0 vss 6.67674e-15
Cpar7 a_9154_15587.t12 vss 1.14321e-14
Cpar8 a_9154_15587.t13 vss 3.85008e-15
Cpar9 a_9154_15587.t8 vss 2.80808e-15
Cpar10 a_974_10104.t0 vss 5.12017e-15
Cpar11 a_974_10104.t12 vss 1.99354e-15
Cpar12 a_974_10104.t13 vss 2.76873e-15
Cpar13 a_974_10104.t14 vss 2.06070e-14
Cpar14 a_974_10104.t8 vss 1.95192e-15
Cpar15 a_974_10624.t0 vss 4.15400e-17
Cpar16 a_974_11664.t0 vss 8.71400e-17
Cpar17 a_974_11664.t1 vss 7.24726e-15
Cpar18 ib out 2.97051e-15
Cpar19 ib vss 4.41441e-14
Cpar20 ib.t0 vss 8.20603e-15
Cpar21 ib.t1 vss 6.74419e-16
Cpar22 inn inp 1.03950e-16
Cpar23 inn out 4.28450e-16
Cpar24 inn vdd 8.01563e-15
Cpar25 inn vss 7.97415e-15
Cpar26 inn.t0 vss 1.70319e-15
Cpar27 inn.t4 vss 9.33534e-15
Cpar28 inp out 2.75900e-17
Cpar29 inp vdd 7.27684e-15
Cpar30 inp vss 9.31873e-15
Cpar31 inp.t0 vss 1.67363e-15
Cpar32 inp.t4 vss 9.19853e-15
Cpar33 out vdd 8.97970e-15
Cpar34 out vss 3.93697e-14
Cpar35 out.t0 vss 6.63145e-15
Cpar36 out.t6 vss 2.03114e-14
Cpar37 out.t9 vss 4.57000e-15
Cpar38 vdd vss 1.25111e-13
Cpar39 vdd.t0 vss 1.88448e-14
Cpar40 vdd.t1 vss 1.50143e-14
Cpar41 vdd.t4 vss 1.94387e-14
.ends opamp_dut

Vdd vdd 0 3.300000
Vss vss 0 0
Ibias vdd ib 1.643000e-07
Vinp inp 0 DC 1.645000 AC 1 PWL(0 1.645000 2.127750e-07 1.645000 2.340525e-07 1.655000)
Rfb out inn 1m
Cload out 0 2.000000e-12
Xdut vdd vss inp inn out ib opamp_dut
.end
