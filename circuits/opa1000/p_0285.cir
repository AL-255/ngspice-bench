* opa1000[0285]: 200f/folded_cascode_pmos_3v3_i20u_subth (folded_cascode_pmos, VDD=3.3V, CL=0.2pF, Iref=5.7778uA)
.include "pdk_opa.inc"
.temp 27
.option gmin=1e-12 rshunt=1e12 reltol=1e-3 abstol=1e-12 vntol=1e-5 method=gear
* Post-PEX R+C extracted netlist for folded_cascode_pmos_3v3_i20u_subth
.subckt opamp_dut vdd vss inp inn out ib
XMpar0 a_1714_1249.t0 inn.t0 a_9774_6531.t18 vdd.t0 pfet_03v3 w=8u l=0.65u ad=2.4000e-12 pd=9.1000e-06 as=2.2400e-12 ps=8.5600e-06 nf=1 m=64 par=64
XMpar1 a_1964_1249.t0 a_4435_8062.t6 a_5986_6531.t0 vss.t0 nfet_03v3 w=1.82u l=0.6u ad=5.8240e-13 pd=2.6875e-06 as=5.0960e-13 ps=2.3800e-06 nf=1 m=16 par=16
XMpar2 a_1714_1249.t64 a_4435_8062.t0 vdd.t33 vdd.t32 pfet_03v3 w=10u l=1.69u ad=2.8000e-12 pd=1.0560e-05 as=4.4000e-12 ps=1.5880e-05 nf=1 m=4 par=4
XMpar3 a_9774_6531.t0 a_4435_8062.t6 out.t0 vss.t0 nfet_03v3 w=1.82u l=0.6u ad=5.8240e-13 pd=2.6875e-06 as=5.0960e-13 ps=2.3800e-06 nf=1 m=16 par=16
XMpar4 a_1714_1249.t0 inp.t0 a_1964_1249.t2 vdd.t0 pfet_03v3 w=8u l=0.65u ad=2.4000e-12 pd=9.1000e-06 as=2.2400e-12 ps=8.5600e-06 nf=1 m=64 par=64
XMpar5 a_1964_1249.t70 ib.t0 vss.t15 vss.t14 nfet_03v3 w=8.56u l=1.2u ad=2.3968e-12 pd=9.1200e-06 as=3.7664e-12 ps=1.3720e-05 nf=1 m=4 par=4
XMpar6 a_5986_6531.t14 a_5986_6531.t13 vdd.t33 vdd.t32 pfet_03v3 w=10u l=1.69u ad=6.0000e-12 pd=2.1200e-05 as=2.8000e-12 ps=1.0560e-05 nf=1 m=2 par=2
XMpar7 a_4435_8062.t1 a_4435_8062.t0 vdd.t33 vdd.t32 pfet_03v3 w=10u l=1.69u ad=2.8000e-12 pd=1.0560e-05 as=2.8000e-12 ps=1.0560e-05 nf=1 m=2 par=2
XMpar8 out.t3 a_5986_6531.t13 vdd.t33 vdd.t32 pfet_03v3 w=10u l=1.69u ad=2.8000e-12 pd=1.0560e-05 as=2.8000e-12 ps=1.0560e-05 nf=1 m=2 par=2
XMpar9 a_4435_8062.t4 ib.t0 vss.t15 vss.t14 nfet_03v3 w=8.56u l=1.2u ad=2.3968e-12 pd=9.1200e-06 as=2.3968e-12 ps=9.1200e-06 nf=1 m=2 par=2
XMpar10 ib.t1 ib.t0 vss.t15 vss.t14 nfet_03v3 w=8.56u l=1.2u ad=5.1360e-12 pd=1.8320e-05 as=2.3968e-12 ps=9.1200e-06 nf=1 m=2 par=2
XMpar11 a_9774_6531.t8 ib.t0 vss.t15 vss.t14 nfet_03v3 w=8.56u l=1.2u ad=2.3968e-12 pd=9.1200e-06 as=3.7664e-12 ps=1.3720e-05 nf=1 m=4 par=4
X84 out.t18 vss.t41 cap_mim_2f0fF c_width=19.63u c_length=19.62u
X110 out.t18 vss.t41 cap_mim_2f0fF c_width=19.63u c_length=19.62u
X156 out.t18 vss.t41 cap_mim_2f0fF c_width=19.63u c_length=19.62u
X183 out.t18 vss.t41 cap_mim_2f0fF c_width=19.63u c_length=19.62u
Rpar0 a_1714_1249.t0 a_1714_1249.t64 60.2934
Rpar1 a_1964_1249.t0 a_1964_1249.t2 65.2954
Rpar2 a_1964_1249.t0 a_1964_1249.t70 220.9769
Rpar3 a_1964_1249.t2 a_1964_1249.t70 214.7379
Rpar4 a_4435_8062.t0 a_4435_8062.t1 27.4729
Rpar5 a_4435_8062.t0 a_4435_8062.t6 397.3777
Rpar6 a_4435_8062.t0 a_4435_8062.t4 208.1889
Rpar7 a_4435_8062.t1 a_4435_8062.t6 180.5287
Rpar8 a_4435_8062.t1 a_4435_8062.t4 94.5802
Rpar9 a_4435_8062.t6 a_4435_8062.t4 144.4283
Rpar10 a_5986_6531.t0 a_5986_6531.t13 308.5612
Rpar11 a_5986_6531.t0 a_5986_6531.t14 55.7179
Rpar12 a_5986_6531.t13 a_5986_6531.t14 23.5679
Rpar13 a_9774_6531.t0 a_9774_6531.t8 82.9735
Rpar14 a_9774_6531.t0 a_9774_6531.t18 57.8222
Rpar15 a_9774_6531.t8 a_9774_6531.t18 158.0272
Rpar16 ib ib.t0 15.1299
Rpar17 ib ib.t1 3.3787
Rpar18 ib.t0 ib.t1 268.6968
Rpar19 inn inn.t0 2.3265
Rpar20 inp inp.t0 2.3265
Rpar21 out out.t0 61.7532
Rpar22 out out.t3 7.0446
Rpar23 out out.t18 132.2836
Rpar24 out.t0 out.t3 422.3736
Rpar25 out.t0 out.t18 204.1704
Rpar26 out.t3 out.t18 904.7804
Rpar27 vdd vdd.t0 698.3296
Rpar28 vdd vdd.t32 94.3118
Rpar29 vdd vdd.t33 289.4877
Rpar30 vdd.t0 vdd.t32 122.8616
Rpar31 vdd.t0 vdd.t33 377.1206
Rpar32 vdd.t32 vdd.t33 3.8608
Rpar33 vss vss.t0 91.4280
Rpar34 vss vss.t14 2183.5281
Rpar35 vss vss.t15 1398.2799
Rpar36 vss vss.t41 115.8156
Rpar37 vss.t0 vss.t14 154.3184
Rpar38 vss.t0 vss.t15 99.9545
Rpar39 vss.t0 vss.t41 1423.6184
Rpar40 vss.t14 vss.t15 3.3629
Cpar0 a_1714_1249.t0 vss 1.83153e-13
Cpar1 a_1714_1249.t64 vss 1.08900e-14
Cpar2 a_1964_1249.t0 vss 1.07497e-14
Cpar3 a_1964_1249.t2 vss 9.19315e-14
Cpar4 a_1964_1249.t70 vss 1.73947e-14
Cpar5 a_4435_8062.t0 vss 1.08305e-14
Cpar6 a_4435_8062.t1 vss 3.52430e-15
Cpar7 a_4435_8062.t4 vss 2.74942e-15
Cpar8 a_4435_8062.t6 vss 8.92554e-15
Cpar9 a_5986_6531.t0 vss 4.09587e-15
Cpar10 a_5986_6531.t13 vss 1.04153e-14
Cpar11 a_5986_6531.t14 vss 7.53110e-15
Cpar12 a_9774_6531.t0 vss 6.80142e-15
Cpar13 a_9774_6531.t18 vss 9.56834e-14
Cpar14 a_9774_6531.t8 vss 9.76230e-15
Cpar15 ib out 1.07700e-17
Cpar16 ib vdd 3.03610e-16
Cpar17 ib vss 2.22128e-14
Cpar18 ib.t0 vss 3.62279e-15
Cpar19 ib.t1 vss 6.63309e-16
Cpar20 inn inp 1.03940e-16
Cpar21 inn vdd 2.82864e-14
Cpar22 inn vss 1.19583e-14
Cpar23 inn.t0 vss 5.07969e-14
Cpar24 inp vdd 2.78916e-14
Cpar25 inp vss 1.21611e-14
Cpar26 inp.t0 vss 5.05000e-14
Cpar27 out vdd 7.22543e-15
Cpar28 out vss 3.55548e-14
Cpar29 out.t0 vss 1.79463e-16
Cpar30 out.t18 vss 2.37333e-14
Cpar31 out.t3 vss 1.46958e-16
Cpar32 vdd vss 3.76634e-13
Cpar33 vdd.t0 vss 9.00645e-14
Cpar34 vdd.t32 vss 1.94254e-14
Cpar35 vdd.t33 vss 9.36826e-15
.ends opamp_dut

Vdd vdd 0 3.300000
Vss vss 0 0
Ibias vdd ib 5.777800e-06
Vinp inp 0 DC 1.381000 AC 1 PWL(0 1.381000 1.466662e-08 1.381000 1.613328e-08 1.391000)
Rfb out inn 1m
Cload out 0 2.000000e-13
Xdut vdd vss inp inn out ib opamp_dut
.end
