* opa1000[0032]: 200f/cherry_hooper_3v3_i10u_weak (cherry_hooper, VDD=3.3V, CL=0.2pF, Iref=0.6786uA)
.include "pdk_opa.inc"
.temp 27
.option gmin=1e-12 rshunt=1e12 reltol=1e-3 abstol=1e-12 vntol=1e-5 method=gear
* Post-PEX R+C extracted netlist for cherry_hooper_3v3_i10u_weak
.subckt opamp_dut vdd vss inp inn out ib
XMpar0 a_4614_2707.t3 a_4614_2707.t2 vdd.t6 vdd.t5 pfet_03v3 w=2.76u l=0.75u ad=7.7280e-13 pd=3.3200e-06 as=1.6560e-12 ps=6.7200e-06 nf=1 m=2 par=2
XMpar1 a_4159_1204.t4 a_8814_4888.t4 a_8814_8455.t5 vss.t29 nfet_03v3 w=3.71u l=1.3u ad=2.2260e-12 pd=8.6200e-06 as=2.2260e-12 ps=8.6200e-06 nf=1 m=1
XMpar2 a_8814_4888.t0 a_1099_3797.t1 vdd.t2 vdd.t1 pfet_03v3 w=2.7u l=1.5u ad=1.6200e-12 pd=6.6000e-06 as=1.6200e-12 ps=6.6000e-06 nf=1 m=1
XMpar3 a_1609_1204.t0 ib.t0 vss.t1 vss.t0 nfet_03v3 w=0.88u l=1.5u ad=3.4027e-13 pd=1.9467e-06 as=3.4027e-13 ps=1.9467e-06 nf=1 m=6 par=6
XMpar4 a_8814_4888.t1 a_2796_6640.t5 a_8814_8455.t4 vdd.t25 pfet_03v3 w=1.22u l=1u ad=7.3200e-13 pd=3.6400e-06 as=7.3200e-13 ps=3.6400e-06 nf=1 m=1
XMpar5 a_8134_6849.t2 a_1099_3797.t1 vdd.t2 vdd.t1 pfet_03v3 w=2.7u l=1.5u ad=1.6200e-12 pd=6.6000e-06 as=1.6200e-12 ps=6.6000e-06 nf=1 m=1
XMpar6 a_1099_5668.t0 a_2796_6640.t1 a_2796_6640.t2 vdd.t0 pfet_03v3 w=9.03u l=0.75u ad=5.4180e-12 pd=1.9260e-05 as=2.5284e-12 ps=9.5900e-06 nf=1 m=2 par=2
XMpar7 a_2796_6640.t0 ib.t0 vss.t1 vss.t0 nfet_03v3 w=0.88u l=1.5u ad=5.2800e-13 pd=2.9600e-06 as=5.2800e-13 ps=2.9600e-06 nf=1 m=1
XMpar8 a_4983_1204.t2 inn.t0 a_8814_4888.t2 vss.t30 nfet_03v3 w=0.93u l=1.3u ad=5.5800e-13 pd=3.0600e-06 as=2.6040e-13 ps=1.4900e-06 nf=1 m=1
XMpar9 out.t1 a_8010_12327.t0 vdd.t6 vdd.t5 pfet_03v3 w=2.76u l=0.75u ad=1.0672e-12 pd=4.4533e-06 as=7.7280e-13 ps=3.3200e-06 nf=1 m=3 par=3
XMpar10 a_1099_5668.t2 a_1099_5668.t1 vdd.t6 vdd.t5 pfet_03v3 w=2.76u l=0.75u ad=1.6560e-12 pd=6.7200e-06 as=1.6560e-12 ps=6.7200e-06 nf=1 m=1
XMpar11 a_4983_1204.t2 inp.t0 a_8134_6849.t0 vss.t29 nfet_03v3 w=0.93u l=1.3u ad=5.5800e-13 pd=3.0600e-06 as=2.6040e-13 ps=1.4900e-06 nf=1 m=1
XMpar12 a_8010_12327.t1 a_8010_12327.t0 vdd.t6 vdd.t5 pfet_03v3 w=2.76u l=0.75u ad=1.0672e-12 pd=4.4533e-06 as=7.7280e-13 ps=3.3200e-06 nf=1 m=3 par=3
XMpar13 a_1609_1204.t6 a_4614_2707.t6 a_8010_12327.t6 vss.t27 nfet_03v3 w=5.57u l=1.3u ad=3.3420e-12 pd=1.2340e-05 as=3.3420e-12 ps=1.2340e-05 nf=1 m=1
XMpar14 a_4159_1204.t0 ib.t0 vss.t1 vss.t0 nfet_03v3 w=0.88u l=1.5u ad=2.4640e-13 pd=1.4400e-06 as=3.8720e-13 ps=2.2000e-06 nf=1 m=4 par=4
XMpar15 a_4983_1204.t0 ib.t0 vss.t1 vss.t0 nfet_03v3 w=0.88u l=1.5u ad=2.4640e-13 pd=1.4400e-06 as=2.4640e-13 ps=1.4400e-06 nf=1 m=2 par=2
XMpar16 a_4983_1204.t2 inn.t0 a_8814_4888.t2 vss.t29 nfet_03v3 w=0.93u l=1.3u ad=5.5800e-13 pd=3.0600e-06 as=2.6040e-13 ps=1.4900e-06 nf=1 m=1
XMpar17 a_8814_8455.t1 a_8814_8455.t0 vdd.t6 vdd.t5 pfet_03v3 w=2.76u l=0.75u ad=7.7280e-13 pd=3.3200e-06 as=1.6560e-12 ps=6.7200e-06 nf=1 m=2 par=2
XMpar18 a_1609_1204.t6 a_8814_8455.t6 out.t0 vss.t27 nfet_03v3 w=5.57u l=1.3u ad=3.3420e-12 pd=1.2340e-05 as=3.3420e-12 ps=1.2340e-05 nf=1 m=1
XMpar19 ib.t1 ib.t0 vss.t1 vss.t0 nfet_03v3 w=0.88u l=1.5u ad=5.2800e-13 pd=2.9600e-06 as=2.4640e-13 ps=1.4400e-06 nf=1 m=1
XMpar20 a_4983_1204.t2 inp.t0 a_8134_6849.t0 vss.t30 nfet_03v3 w=0.93u l=1.3u ad=5.5800e-13 pd=3.0600e-06 as=2.6040e-13 ps=1.4900e-06 nf=1 m=1
XMpar21 a_1099_3797.t2 a_1099_3797.t1 vdd.t2 vdd.t1 pfet_03v3 w=2.7u l=1.5u ad=1.6200e-12 pd=6.6000e-06 as=1.6200e-12 ps=6.6000e-06 nf=1 m=1
XMpar22 a_4614_2707.t1 a_2796_6640.t5 a_8134_6849.t3 vdd.t25 pfet_03v3 w=1.22u l=1u ad=7.3200e-13 pd=3.6400e-06 as=7.3200e-13 ps=3.6400e-06 nf=1 m=1
XMpar23 a_1099_3797.t0 ib.t0 vss.t1 vss.t0 nfet_03v3 w=0.88u l=1.5u ad=5.2800e-13 pd=2.9600e-06 as=2.4640e-13 ps=1.4400e-06 nf=1 m=1
XMpar24 a_4159_1204.t4 a_8134_6849.t4 a_4614_2707.t0 vss.t29 nfet_03v3 w=3.71u l=1.3u ad=2.2260e-12 pd=8.6200e-06 as=2.2260e-12 ps=8.6200e-06 nf=1 m=1
X17 out.t4 vss.t31 cap_mim_2f0fF c_width=20u c_length=20u
X26 out.t4 vss.t31 cap_mim_2f0fF c_width=20u c_length=20u
X32 out.t4 vss.t31 cap_mim_2f0fF c_width=20u c_length=20u
Rpar0 a_1099_3797.t0 a_1099_3797.t1 96.6219
Rpar1 a_1099_3797.t0 a_1099_3797.t2 181.5762
Rpar2 a_1099_3797.t1 a_1099_3797.t2 29.2864
Rpar3 a_1099_5668.t0 a_1099_5668.t1 286.8198
Rpar4 a_1099_5668.t0 a_1099_5668.t2 45.5696
Rpar5 a_1099_5668.t1 a_1099_5668.t2 61.0641
Rpar6 a_1609_1204.t0 a_1609_1204.t6 80.8789
Rpar7 a_2796_6640.t0 a_2796_6640.t1 1443.0676
Rpar8 a_2796_6640.t0 a_2796_6640.t2 191.0680
Rpar9 a_2796_6640.t0 a_2796_6640.t5 143.3267
Rpar10 a_2796_6640.t1 a_2796_6640.t2 54.9442
Rpar11 a_2796_6640.t1 a_2796_6640.t5 748.7113
Rpar12 a_2796_6640.t2 a_2796_6640.t5 99.1324
Rpar13 a_4159_1204.t0 a_4159_1204.t4 54.9118
Rpar14 a_4614_2707.t0 a_4614_2707.t1 86.1668
Rpar15 a_4614_2707.t0 a_4614_2707.t2 594.8755
Rpar16 a_4614_2707.t0 a_4614_2707.t3 143.6845
Rpar17 a_4614_2707.t0 a_4614_2707.t6 256.5952
Rpar18 a_4614_2707.t1 a_4614_2707.t2 725.2882
Rpar19 a_4614_2707.t1 a_4614_2707.t3 175.1840
Rpar20 a_4614_2707.t1 a_4614_2707.t6 312.8478
Rpar21 a_4614_2707.t2 a_4614_2707.t3 38.6519
Rpar22 a_4614_2707.t2 a_4614_2707.t6 1290.1612
Rpar23 a_4614_2707.t3 a_4614_2707.t6 311.6218
Rpar24 a_4983_1204.t0 a_4983_1204.t2 69.1518
Rpar25 a_8010_12327.t0 a_8010_12327.t1 20.1413
Rpar26 a_8010_12327.t0 a_8010_12327.t6 406.1571
Rpar27 a_8010_12327.t1 a_8010_12327.t6 95.2196
Rpar28 a_8134_6849.t0 a_8134_6849.t2 110.7848
Rpar29 a_8134_6849.t0 a_8134_6849.t3 113.4690
Rpar30 a_8134_6849.t0 a_8134_6849.t4 123.5976
Rpar31 a_8134_6849.t2 a_8134_6849.t3 240.6722
Rpar32 a_8134_6849.t2 a_8134_6849.t4 262.1554
Rpar33 a_8134_6849.t3 a_8134_6849.t4 160.2887
Rpar34 a_8814_4888.t0 a_8814_4888.t1 241.2087
Rpar35 a_8814_4888.t0 a_8814_4888.t2 69.4880
Rpar36 a_8814_4888.t0 a_8814_4888.t4 172.1775
Rpar37 a_8814_4888.t1 a_8814_4888.t2 188.5888
Rpar38 a_8814_4888.t1 a_8814_4888.t4 174.5758
Rpar39 a_8814_4888.t2 a_8814_4888.t4 134.6169
Rpar40 a_8814_8455.t0 a_8814_8455.t1 39.7504
Rpar41 a_8814_8455.t0 a_8814_8455.t4 948.6116
Rpar42 a_8814_8455.t0 a_8814_8455.t5 559.6517
Rpar43 a_8814_8455.t0 a_8814_8455.t6 531.4668
Rpar44 a_8814_8455.t1 a_8814_8455.t4 229.1249
Rpar45 a_8814_8455.t1 a_8814_8455.t5 135.1767
Rpar46 a_8814_8455.t1 a_8814_8455.t6 128.3690
Rpar47 a_8814_8455.t4 a_8814_8455.t5 77.2535
Rpar48 a_8814_8455.t4 a_8814_8455.t6 767.9926
Rpar49 a_8814_8455.t5 a_8814_8455.t6 453.0920
Rpar50 ib ib.t0 3.6298
Rpar51 ib ib.t1 459.1413
Rpar52 ib.t0 ib.t1 26.7543
Rpar53 inn inn.t0 8.3569
Rpar54 inp inp.t0 8.4055
Rpar55 out out.t0 99.8272
Rpar56 out out.t1 4.3519
Rpar57 out out.t4 122.9120
Rpar58 out.t0 out.t1 338.9961
Rpar59 out.t0 out.t4 293.0560
Rpar60 out.t1 out.t4 417.3881
Rpar61 vdd vdd.t0 584.3426
Rpar62 vdd vdd.t6 404.6460
Rpar63 vdd vdd.t5 445.2490
Rpar64 vdd vdd.t2 7197.3032
Rpar65 vdd vdd.t25 96.2010
Rpar66 vdd.t0 vdd.t1 1783.2281
Rpar67 vdd.t0 vdd.t6 86.2227
Rpar68 vdd.t0 vdd.t5 135.1661
Rpar69 vdd.t0 vdd.t2 886.8440
Rpar70 vdd.t0 vdd.t25 113.5816
Rpar71 vdd.t1 vdd.t6 117.5332
Rpar72 vdd.t1 vdd.t5 227.5857
Rpar73 vdd.t1 vdd.t2 11.4397
Rpar74 vdd.t1 vdd.t25 2813.0009
Rpar75 vdd.t6 vdd.t5 3.9185
Rpar76 vdd.t6 vdd.t2 43.0134
Rpar77 vdd.t6 vdd.t25 78.6531
Rpar78 vdd.t5 vdd.t2 82.5336
Rpar79 vdd.t5 vdd.t25 86.5453
Rpar80 vdd.t2 vdd.t25 1398.9759
Rpar81 vss vss.t0 60.0156
Rpar82 vss vss.t1 51.4525
Rpar83 vss vss.t27 185.6871
Rpar84 vss vss.t29 827.2262
Rpar85 vss vss.t30 337.1313
Rpar86 vss vss.t31 7981.0124
Rpar87 vss.t0 vss.t1 4.1914
Rpar88 vss.t0 vss.t27 208.0324
Rpar89 vss.t0 vss.t29 177.8783
Rpar90 vss.t0 vss.t30 103.3300
Rpar91 vss.t0 vss.t31 301.9778
Rpar92 vss.t1 vss.t27 161.2734
Rpar93 vss.t1 vss.t29 277.0537
Rpar94 vss.t1 vss.t30 146.6544
Rpar95 vss.t1 vss.t31 579.2679
Rpar96 vss.t27 vss.t29 201.6137
Rpar97 vss.t27 vss.t30 80.0198
Rpar98 vss.t27 vss.t31 2056.0516
Rpar99 vss.t29 vss.t30 14.1212
Rpar100 vss.t29 vss.t31 448.2818
Rpar101 vss.t30 vss.t31 285.1039
Cpar0 a_1099_3797.t0 vss 3.68195e-15
Cpar1 a_1099_3797.t1 vss 6.70541e-15
Cpar2 a_1099_3797.t2 vss 3.98783e-15
Cpar3 a_1099_5668.t0 vss 6.03547e-15
Cpar4 a_1099_5668.t1 vss 7.51231e-16
Cpar5 a_1099_5668.t2 vss 2.15839e-15
Cpar6 a_1609_1204.t0 vss 3.21082e-15
Cpar7 a_1609_1204.t6 vss 3.47101e-15
Cpar8 a_2796_6640.t0 vss 3.04064e-15
Cpar9 a_2796_6640.t1 vss 2.26396e-15
Cpar10 a_2796_6640.t2 vss 5.19468e-15
Cpar11 a_2796_6640.t5 vss 3.26347e-15
Cpar12 a_4159_1204.t0 vss 4.38607e-15
Cpar13 a_4159_1204.t4 vss 5.32982e-15
Cpar14 a_4614_2707.t0 vss 4.48062e-15
Cpar15 a_4614_2707.t1 vss 2.95464e-15
Cpar16 a_4614_2707.t2 vss 2.02027e-15
Cpar17 a_4614_2707.t3 vss 4.22909e-15
Cpar18 a_4614_2707.t6 vss 3.85858e-15
Cpar19 a_4983_1204.t0 vss 3.67821e-15
Cpar20 a_4983_1204.t2 vss 4.51281e-15
Cpar21 a_8010_12327.t0 vss 5.03795e-15
Cpar22 a_8010_12327.t1 vss 6.53749e-15
Cpar23 a_8010_12327.t6 vss 5.17159e-15
Cpar24 a_8134_6849.t0 vss 2.48953e-15
Cpar25 a_8134_6849.t2 vss 3.23529e-15
Cpar26 a_8134_6849.t3 vss 2.21967e-15
Cpar27 a_8134_6849.t4 vss 2.40984e-15
Cpar28 a_8814_4888.t0 vss 2.45936e-15
Cpar29 a_8814_4888.t1 vss 1.84659e-15
Cpar30 a_8814_4888.t2 vss 1.91904e-15
Cpar31 a_8814_4888.t4 vss 2.05091e-15
Cpar32 a_8814_8455.t0 vss 1.72241e-15
Cpar33 a_8814_8455.t1 vss 3.70489e-15
Cpar34 a_8814_8455.t4 vss 1.85797e-15
Cpar35 a_8814_8455.t5 vss 3.29547e-15
Cpar36 a_8814_8455.t6 vss 2.22895e-15
Cpar37 ib out 1.39149e-15
Cpar38 ib vdd 2.73240e-16
Cpar39 ib vss 2.78684e-14
Cpar40 ib.t0 vss 7.31134e-15
Cpar41 ib.t1 vss 1.21164e-15
Cpar42 inn inp 5.16300e-17
Cpar43 inn vdd 1.07100e-17
Cpar44 inn vss 2.07006e-15
Cpar45 inn.t0 vss 2.51627e-16
Cpar46 inp vdd 1.17300e-17
Cpar47 inp vss 2.03337e-15
Cpar48 inp.t0 vss 2.56528e-16
Cpar49 out vdd 6.85082e-15
Cpar50 out vss 3.15182e-14
Cpar51 out.t0 vss 1.64426e-16
Cpar52 out.t1 vss 9.28936e-17
Cpar53 out.t4 vss 1.45440e-14
Cpar54 vdd vss 1.08135e-13
Cpar55 vdd.t0 vss 6.23810e-15
Cpar56 vdd.t1 vss 3.90850e-15
Cpar57 vdd.t2 vss 6.36679e-15
Cpar58 vdd.t25 vss 4.98807e-15
Cpar59 vdd.t5 vss 1.00659e-14
Cpar60 vdd.t6 vss 1.33067e-14
.ends opamp_dut

Vdd vdd 0 3.300000
Vss vss 0 0
Ibias vdd ib 6.786000e-07
Vinp inp 0 DC 2.119000 AC 1 PWL(0 2.119000 1.198257e-08 2.119000 1.318083e-08 2.129000)
Rfb out inn 1m
Cload out 0 2.000000e-13
Xdut vdd vss inp inn out ib opamp_dut
.end
