* opa1000[0022]: 200f/cherry_hooper_3v3_i200n_subth (cherry_hooper, VDD=3.3V, CL=0.2pF, Iref=0.0094uA)
.include "pdk_opa.inc"
.temp 27
.option gmin=1e-12 rshunt=1e12 reltol=1e-3 abstol=1e-12 vntol=1e-5 method=gear
* Post-PEX R+C extracted netlist for cherry_hooper_3v3_i200n_subth
.subckt opamp_dut vdd vss inp inn out ib
XMpar0 a_7540_15797.t1 a_7540_15797.t0 vdd.t3 vdd.t2 pfet_03v3 w=0.87u l=2.56u ad=2.4360e-13 pd=1.4300e-06 as=3.8280e-13 ps=2.1850e-06 nf=1 m=4 par=4
XMpar1 out.t0 a_7540_15797.t0 vdd.t3 vdd.t2 pfet_03v3 w=0.87u l=2.56u ad=2.4360e-13 pd=1.4300e-06 as=2.4360e-13 ps=1.4300e-06 nf=1 m=4 par=4
XMpar2 a_1398_1249.t0 ib.t0 vss.t3 vss.t2 nfet_03v3 w=0.4u l=5u ad=1.5467e-13 pd=1.3067e-06 as=1.9733e-13 ps=1.6533e-06 nf=1 m=6 par=6
XMpar3 a_13786_9363.t2 a_5003_9408.t1 a_5003_9408.t2 vdd.t36 pfet_03v3 w=0.42u l=1u ad=2.5200e-13 pd=2.0400e-06 as=2.5200e-13 ps=2.0400e-06 nf=1 m=1
XMpar4 a_3630_1249.t0 inn.t0 a_9934_1250.t0 vss.t0 nfet_03v3 w=0.4u l=3.84u ad=2.4000e-13 pd=2.0000e-06 as=1.1200e-13 ps=9.6000e-07 nf=1 m=1
XMpar5 a_9934_1250.t3 a_5003_9408.t3 a_9934_5818.t7 vdd.t18 pfet_03v3 w=0.4u l=6.26u ad=2.4000e-13 pd=2.0000e-06 as=2.4000e-13 ps=2.0000e-06 nf=1 m=1
XMpar6 a_7522_4015.t1 a_5003_9408.t3 a_8746_9319.t3 vdd.t18 pfet_03v3 w=0.4u l=6.26u ad=2.4000e-13 pd=2.0000e-06 as=2.4000e-13 ps=2.0000e-06 nf=1 m=1
XMpar7 a_13786_9363.t1 a_13786_9363.t0 vdd.t3 vdd.t2 pfet_03v3 w=0.87u l=2.56u ad=5.2200e-13 pd=2.9400e-06 as=5.2200e-13 ps=2.9400e-06 nf=1 m=1
XMpar8 a_5003_9408.t0 ib.t0 vss.t3 vss.t2 nfet_03v3 w=0.4u l=5u ad=2.4000e-13 pd=2.0000e-06 as=2.4000e-13 ps=2.0000e-06 nf=1 m=1
XMpar9 a_7522_4015.t3 a_7522_4015.t2 vdd.t3 vdd.t2 pfet_03v3 w=0.87u l=2.56u ad=3.3640e-13 pd=1.9333e-06 as=3.3640e-13 ps=1.9333e-06 nf=1 m=3 par=3
XMpar10 a_8738_12639.t0 ib.t0 vss.t3 vss.t2 nfet_03v3 w=0.4u l=5u ad=1.1200e-13 pd=9.6000e-07 as=1.7600e-13 ps=1.4800e-06 nf=1 m=8 par=8
XMpar11 a_3614_9408.t2 a_3614_9408.t1 vdd.t1 vdd.t0 pfet_03v3 w=0.4u l=5u ad=2.4000e-13 pd=2.0000e-06 as=2.4000e-13 ps=2.0000e-06 nf=1 m=1
XMpar12 a_1398_1249.t6 a_9934_1250.t4 a_9934_5818.t0 vss.t37 nfet_03v3 w=2u l=3.84u ad=1.2000e-12 pd=5.2000e-06 as=1.2000e-12 ps=5.2000e-06 nf=1 m=1
XMpar13 a_3614_9408.t0 ib.t0 vss.t3 vss.t2 nfet_03v3 w=0.4u l=5u ad=2.4000e-13 pd=2.0000e-06 as=1.1200e-13 ps=9.6000e-07 nf=1 m=1
XMpar14 a_9934_1250.t2 a_3614_9408.t1 vdd.t1 vdd.t0 pfet_03v3 w=0.4u l=5u ad=2.4000e-13 pd=2.0000e-06 as=2.4000e-13 ps=2.0000e-06 nf=1 m=1
XMpar15 a_3630_1249.t2 ib.t0 vss.t3 vss.t2 nfet_03v3 w=0.4u l=5u ad=2.4000e-13 pd=2.0000e-06 as=1.1200e-13 ps=9.6000e-07 nf=1 m=2 par=2
XMpar16 a_3630_1249.t0 inp.t0 a_8746_9319.t1 vss.t1 nfet_03v3 w=0.4u l=3.84u ad=2.4000e-13 pd=2.0000e-06 as=1.1200e-13 ps=9.6000e-07 nf=1 m=2 par=2
XMpar17 a_3630_1249.t0 inn.t0 a_9934_1250.t0 vss.t1 nfet_03v3 w=0.4u l=3.84u ad=2.4000e-13 pd=2.0000e-06 as=1.1200e-13 ps=9.6000e-07 nf=1 m=1
XMpar18 ib.t1 ib.t0 vss.t3 vss.t2 nfet_03v3 w=0.4u l=5u ad=2.4000e-13 pd=2.0000e-06 as=1.1200e-13 ps=9.6000e-07 nf=1 m=1
XMpar19 a_9934_5818.t2 a_9934_5818.t1 vdd.t3 vdd.t2 pfet_03v3 w=0.87u l=2.56u ad=3.3640e-13 pd=1.9333e-06 as=3.3640e-13 ps=1.9333e-06 nf=1 m=3 par=3
XMpar20 a_8746_9319.t0 a_3614_9408.t1 vdd.t1 vdd.t0 pfet_03v3 w=0.4u l=5u ad=2.4000e-13 pd=2.0000e-06 as=2.4000e-13 ps=2.0000e-06 nf=1 m=1
XMpar21 a_7540_15797.t8 a_7522_4015.t8 a_8738_12639.t8 vss.t36 nfet_03v3 w=2.66u l=3.84u ad=1.5960e-12 pd=6.5200e-06 as=1.5960e-12 ps=6.5200e-06 nf=1 m=1
XMpar22 a_1398_1249.t6 a_8746_9319.t4 a_7522_4015.t0 vss.t37 nfet_03v3 w=2u l=3.84u ad=1.2000e-12 pd=5.2000e-06 as=1.2000e-12 ps=5.2000e-06 nf=1 m=1
XMpar23 a_8738_12639.t8 a_9934_5818.t8 out.t3 vss.t0 nfet_03v3 w=2.66u l=3.84u ad=1.5960e-12 pd=6.5200e-06 as=1.5960e-12 ps=6.5200e-06 nf=1 m=1
X4 out.t5 vss.t34 cap_mim_2f0fF c_width=15.41u c_length=15.41u
X37 out.t5 vss.t34 cap_mim_2f0fF c_width=15.41u c_length=15.41u
Rpar0 a_13786_9363.t0 a_13786_9363.t1 37.5619
Rpar1 a_13786_9363.t0 a_13786_9363.t2 134.2615
Rpar2 a_13786_9363.t1 a_13786_9363.t2 93.2218
Rpar3 a_1398_1249.t0 a_1398_1249.t6 99.5369
Rpar4 a_3614_9408.t0 a_3614_9408.t1 145.4264
Rpar5 a_3614_9408.t0 a_3614_9408.t2 334.5106
Rpar6 a_3614_9408.t1 a_3614_9408.t2 31.8910
Rpar7 a_3630_1249.t0 a_3630_1249.t2 213.6805
Rpar8 a_5003_9408.t0 a_5003_9408.t1 738.6108
Rpar9 a_5003_9408.t0 a_5003_9408.t2 379.8300
Rpar10 a_5003_9408.t0 a_5003_9408.t3 114.1840
Rpar11 a_5003_9408.t1 a_5003_9408.t2 51.6180
Rpar12 a_5003_9408.t1 a_5003_9408.t3 342.3692
Rpar13 a_5003_9408.t2 a_5003_9408.t3 176.0631
Rpar14 a_7522_4015.t0 a_7522_4015.t1 98.6620
Rpar15 a_7522_4015.t0 a_7522_4015.t2 184.3647
Rpar16 a_7522_4015.t0 a_7522_4015.t3 103.3223
Rpar17 a_7522_4015.t0 a_7522_4015.t8 270.4281
Rpar18 a_7522_4015.t1 a_7522_4015.t2 249.5734
Rpar19 a_7522_4015.t1 a_7522_4015.t3 139.8668
Rpar20 a_7522_4015.t1 a_7522_4015.t8 196.6814
Rpar21 a_7522_4015.t2 a_7522_4015.t3 22.5150
Rpar22 a_7522_4015.t2 a_7522_4015.t8 684.0697
Rpar23 a_7522_4015.t3 a_7522_4015.t8 383.3688
Rpar24 a_7540_15797.t0 a_7540_15797.t1 19.1903
Rpar25 a_7540_15797.t0 a_7540_15797.t8 186.3262
Rpar26 a_7540_15797.t1 a_7540_15797.t8 123.6629
Rpar27 a_8738_12639.t0 a_8738_12639.t8 97.4265
Rpar28 a_8746_9319.t0 a_8746_9319.t1 392.6210
Rpar29 a_8746_9319.t0 a_8746_9319.t3 317.2440
Rpar30 a_8746_9319.t0 a_8746_9319.t4 93.4955
Rpar31 a_8746_9319.t1 a_8746_9319.t3 141.6592
Rpar32 a_8746_9319.t1 a_8746_9319.t4 132.0519
Rpar33 a_8746_9319.t3 a_8746_9319.t4 106.7000
Rpar34 a_9934_1250.t0 a_9934_1250.t2 392.6335
Rpar35 a_9934_1250.t0 a_9934_1250.t3 141.6607
Rpar36 a_9934_1250.t0 a_9934_1250.t4 132.0482
Rpar37 a_9934_1250.t2 a_9934_1250.t3 317.2541
Rpar38 a_9934_1250.t2 a_9934_1250.t4 93.4929
Rpar39 a_9934_1250.t3 a_9934_1250.t4 106.6971
Rpar40 a_9934_5818.t0 a_9934_5818.t1 184.3645
Rpar41 a_9934_5818.t0 a_9934_5818.t2 103.3222
Rpar42 a_9934_5818.t0 a_9934_5818.t7 98.6618
Rpar43 a_9934_5818.t0 a_9934_5818.t8 270.4315
Rpar44 a_9934_5818.t1 a_9934_5818.t2 22.5150
Rpar45 a_9934_5818.t1 a_9934_5818.t7 249.5730
Rpar46 a_9934_5818.t1 a_9934_5818.t8 684.0785
Rpar47 a_9934_5818.t2 a_9934_5818.t7 139.8666
Rpar48 a_9934_5818.t2 a_9934_5818.t8 383.3738
Rpar49 a_9934_5818.t7 a_9934_5818.t8 196.6839
Rpar50 ib ib.t0 2.3221
Rpar51 ib ib.t1 1003.9605
Rpar52 ib.t0 ib.t1 26.7167
Rpar53 inn inn.t0 3.2331
Rpar54 inp inp.t0 3.2817
Rpar55 out out.t0 218.9986
Rpar56 out out.t3 102.2560
Rpar57 out out.t5 17.3329
Rpar58 out.t0 out.t3 103.4777
Rpar59 out.t0 out.t5 1041.3989
Rpar60 out.t3 out.t5 486.2554
Rpar61 vdd vdd.t0 291.7747
Rpar62 vdd vdd.t1 243.9252
Rpar63 vdd vdd.t2 111.8163
Rpar64 vdd vdd.t3 150.2464
Rpar65 vdd vdd.t18 514.7265
Rpar66 vdd vdd.t36 764.8201
Rpar67 vdd.t0 vdd.t1 20.7170
Rpar68 vdd.t0 vdd.t2 163.5511
Rpar69 vdd.t0 vdd.t3 132.6959
Rpar70 vdd.t0 vdd.t18 619.8925
Rpar71 vdd.t0 vdd.t36 1042.8971
Rpar72 vdd.t1 vdd.t2 107.6910
Rpar73 vdd.t1 vdd.t3 82.3743
Rpar74 vdd.t1 vdd.t18 455.3638
Rpar75 vdd.t1 vdd.t36 799.7305
Rpar76 vdd.t2 vdd.t3 3.9331
Rpar77 vdd.t2 vdd.t18 178.3124
Rpar78 vdd.t2 vdd.t36 379.8871
Rpar79 vdd.t3 vdd.t18 137.1716
Rpar80 vdd.t3 vdd.t36 312.1300
Rpar81 vdd.t18 vdd.t36 262.6731
Rpar82 vss vss.t0 779.2935
Rpar83 vss vss.t1 616.4062
Rpar84 vss vss.t2 161.6296
Rpar85 vss vss.t3 32.2007
Rpar86 vss vss.t34 927.3248
Rpar87 vss vss.t36 2132.8223
Rpar88 vss vss.t37 521.8554
Rpar89 vss.t0 vss.t1 26.7263
Rpar90 vss.t0 vss.t2 244.1258
Rpar91 vss.t0 vss.t3 629.9020
Rpar92 vss.t0 vss.t34 183.8369
Rpar93 vss.t0 vss.t36 80.9333
Rpar94 vss.t0 vss.t37 311.8341
Rpar95 vss.t1 vss.t2 193.8030
Rpar96 vss.t1 vss.t3 497.0533
Rpar97 vss.t1 vss.t34 164.9351
Rpar98 vss.t1 vss.t36 87.5138
Rpar99 vss.t1 vss.t37 230.7684
Rpar100 vss.t2 vss.t3 5.2730
Rpar101 vss.t2 vss.t34 291.8902
Rpar102 vss.t2 vss.t36 668.8332
Rpar103 vss.t2 vss.t37 369.2393
Rpar104 vss.t3 vss.t34 767.3795
Rpar105 vss.t3 vss.t36 1732.6859
Rpar106 vss.t3 vss.t37 681.9374
Rpar107 vss.t34 vss.t36 456.6925
Rpar108 vss.t34 vss.t37 404.3010
Rpar109 vss.t36 vss.t37 868.8966
Cpar0 a_13786_9363.t0 vss 2.13762e-15
Cpar1 a_13786_9363.t1 vss 1.64041e-15
Cpar2 a_13786_9363.t2 vss 1.85422e-15
Cpar3 a_1398_1249.t0 vss 9.72532e-15
Cpar4 a_1398_1249.t6 vss 6.50087e-15
Cpar5 a_3614_9408.t0 vss 7.38480e-15
Cpar6 a_3614_9408.t1 vss 1.63331e-14
Cpar7 a_3614_9408.t2 vss 3.78275e-15
Cpar8 a_3630_1249.t0 vss 5.98664e-15
Cpar9 a_3630_1249.t2 vss 1.01078e-14
Cpar10 a_5003_9408.t0 vss 4.82501e-15
Cpar11 a_5003_9408.t1 vss 2.26094e-15
Cpar12 a_5003_9408.t2 vss 3.71164e-15
Cpar13 a_5003_9408.t3 vss 1.03945e-14
Cpar14 a_7522_4015.t0 vss 3.46912e-15
Cpar15 a_7522_4015.t1 vss 3.51424e-15
Cpar16 a_7522_4015.t2 vss 4.53677e-15
Cpar17 a_7522_4015.t3 vss 3.10291e-15
Cpar18 a_7522_4015.t8 vss 6.92525e-15
Cpar19 a_7540_15797.t0 vss 1.74379e-14
Cpar20 a_7540_15797.t1 vss 6.72554e-15
Cpar21 a_7540_15797.t8 vss 8.19962e-15
Cpar22 a_8738_12639.t0 vss 4.88100e-15
Cpar23 a_8738_12639.t8 vss 3.20261e-15
Cpar24 a_8746_9319.t0 vss 2.13763e-15
Cpar25 a_8746_9319.t1 vss 1.95342e-15
Cpar26 a_8746_9319.t3 vss 1.82612e-15
Cpar27 a_8746_9319.t4 vss 4.16430e-15
Cpar28 a_9934_1250.t0 vss 2.65645e-15
Cpar29 a_9934_1250.t2 vss 2.88422e-15
Cpar30 a_9934_1250.t3 vss 2.46391e-15
Cpar31 a_9934_1250.t4 vss 5.61889e-15
Cpar32 a_9934_5818.t0 vss 3.23270e-15
Cpar33 a_9934_5818.t1 vss 4.22756e-15
Cpar34 a_9934_5818.t2 vss 2.89145e-15
Cpar35 a_9934_5818.t7 vss 3.27475e-15
Cpar36 a_9934_5818.t8 vss 6.45319e-15
Cpar37 ib vdd 3.69500e-16
Cpar38 ib vss 6.49579e-14
Cpar39 ib.t0 vss 1.33779e-14
Cpar40 ib.t1 vss 8.41856e-16
Cpar41 inn inp 5.25900e-17
Cpar42 inn vdd 1.17730e-16
Cpar43 inn vss 4.41118e-15
Cpar44 inn.t0 vss 4.09220e-16
Cpar45 inp vdd 2.70600e-17
Cpar46 inp vss 4.42433e-15
Cpar47 inp.t0 vss 3.82706e-16
Cpar48 out vdd 5.80971e-15
Cpar49 out vss 1.68978e-14
Cpar50 out.t0 vss 7.02908e-16
Cpar51 out.t3 vss 5.20112e-16
Cpar52 out.t5 vss 1.86419e-14
Cpar53 vdd vss 1.32546e-13
Cpar54 vdd.t0 vss 6.38636e-15
Cpar55 vdd.t1 vss 9.07748e-15
Cpar56 vdd.t18 vss 8.30567e-15
Cpar57 vdd.t2 vss 2.38406e-14
Cpar58 vdd.t3 vss 2.19125e-14
Cpar59 vdd.t36 vss 3.05825e-15
.ends opamp_dut

Vdd vdd 0 3.300000
Vss vss 0 0
Ibias vdd ib 9.400000e-09
Vinp inp 0 DC 2.053200 AC 1 PWL(0 2.053200 3.161525e-07 2.053200 3.477677e-07 2.063200)
Rfb out inn 1m
Cload out 0 2.000000e-13
Xdut vdd vss inp inn out ib opamp_dut
.end
