* opa1000[0345]: 200f/nmos_5t_1v8_1u_10u_weak (nmos_5t, VDD=1.8V, CL=0.2pF, Iref=1.625uA)
.include "pdk_opa.inc"
.temp 27
.option gmin=1e-12 rshunt=1e12 reltol=1e-3 abstol=1e-12 vntol=1e-5 method=gear
* Post-PEX R+C extracted netlist for nmos_5t_1v8_1u_10u_weak
.subckt opamp_dut vdd vss inp inn out ib
XMpar0 out.t6 a_1934_4517.t6 vdd.t1 vdd.t0 pfet_03v3 w=1.9u l=2.5u ad=5.3200e-13 pd=2.4600e-06 as=5.3200e-13 ps=2.4600e-06 nf=1 m=12 par=12
XMpar1 a_1626_3086.t0 inn.t0 out.t0 vss.t0 nfet_03v3 w=1.54u l=1.3u ad=5.9547e-13 pd=2.8267e-06 as=4.3120e-13 ps=2.1000e-06 nf=1 m=6 par=6
XMpar2 a_1626_3086.t6 ib.t0 vss.t7 vss.t6 nfet_03v3 w=1.95u l=2.5u ad=5.4600e-13 pd=2.5100e-06 as=7.0200e-13 ps=3.1575e-06 nf=1 m=8 par=8
XMpar3 a_1626_3086.t0 inp.t0 a_1934_4517.t0 vss.t0 nfet_03v3 w=1.54u l=1.3u ad=5.9547e-13 pd=2.8267e-06 as=4.3120e-13 ps=2.1000e-06 nf=1 m=6 par=6
XMpar4 a_1934_4517.t7 a_1934_4517.t6 vdd.t1 vdd.t0 pfet_03v3 w=1.9u l=2.5u ad=5.3200e-13 pd=2.4600e-06 as=8.3600e-13 ps=3.7300e-06 nf=1 m=12 par=12
XMpar5 ib.t1 ib.t0 vss.t7 vss.t6 nfet_03v3 w=1.95u l=2.5u ad=5.4600e-13 pd=2.5100e-06 as=5.4600e-13 ps=2.5100e-06 nf=1 m=2 par=2
Rpar0 a_1626_3086.t0 a_1626_3086.t6 36.1011
Rpar1 a_1934_4517.t0 a_1934_4517.t6 110.3362
Rpar2 a_1934_4517.t0 a_1934_4517.t7 54.7214
Rpar3 a_1934_4517.t6 a_1934_4517.t7 5.8233
Rpar4 ib ib.t0 21.6671
Rpar5 ib ib.t1 13.2929
Rpar6 ib.t0 ib.t1 67.3300
Rpar7 inn inn.t0 2.5061
Rpar8 inp inp.t0 2.5547
Rpar9 out out.t0 35.0181
Rpar10 out out.t6 5.7007
Rpar11 vdd vdd.t0 21.2901
Rpar12 vdd vdd.t1 279.9937
Rpar13 vdd.t0 vdd.t1 10.3117
Rpar14 vss vss.t0 50.9499
Rpar15 vss vss.t6 46.8753
Rpar16 vss vss.t7 77.9250
Rpar17 vss.t0 vss.t6 3.3417
Rpar18 vss.t0 vss.t7 10.5528
Rpar19 vss.t6 vss.t7 9.7058
Cpar0 a_1626_3086.t0 vss 4.50375e-15
Cpar1 a_1626_3086.t6 vss 5.96429e-15
Cpar2 a_1934_4517.t0 vss 2.97720e-15
Cpar3 a_1934_4517.t6 vss 4.73518e-14
Cpar4 a_1934_4517.t7 vss 1.37227e-14
Cpar5 ib inn 1.96900e-17
Cpar6 ib inp 1.90500e-17
Cpar7 ib vss 2.04423e-14
Cpar8 ib.t0 vss 3.49395e-15
Cpar9 ib.t1 vss 1.99598e-16
Cpar10 inn inp 5.11900e-17
Cpar11 inn out 5.91720e-16
Cpar12 inn vss 5.62810e-15
Cpar13 inn.t0 vss 9.19583e-16
Cpar14 inp vss 5.53563e-15
Cpar15 inp.t0 vss 9.49051e-16
Cpar16 out vdd 1.14361e-14
Cpar17 out vss 1.10448e-14
Cpar18 out.t0 vss 3.68065e-15
Cpar19 out.t6 vss 1.58326e-14
Cpar20 vdd vss 9.81551e-14
Cpar21 vdd.t0 vss 4.67480e-14
Cpar22 vdd.t1 vss 8.42892e-15
.ends opamp_dut

Vdd vdd 0 1.800000
Vss vss 0 0
Ibias vdd ib 1.625000e-06
Vinp inp 0 DC 0.895000 AC 1 PWL(0 0.895000 4.654475e-09 0.895000 5.119922e-09 0.905000)
Rfb out inn 1m
Cload out 0 2.000000e-13
Xdut vdd vss inp inn out ib opamp_dut
.end
