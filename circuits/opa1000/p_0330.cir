* opa1000[0330]: 2p/folded_cascode_pmos_3v3_i150u_subth (folded_cascode_pmos, VDD=3.3V, CL=2.0pF, Iref=38.3333uA)
.include "pdk_opa.inc"
.temp 27
.option gmin=1e-12 rshunt=1e12 reltol=1e-3 abstol=1e-12 vntol=1e-5 method=gear
* Post-PEX R+C extracted netlist for folded_cascode_pmos_3v3_i150u_subth
.subckt opamp_dut vdd vss inp inn out ib
XMpar0 a_4274_8395.t53 a_4274_8395.t52 vdd.t1 vdd.t0 pfet_03v3 w=10u l=1.05u ad=3.8667e-12 pd=1.4107e-05 as=2.8000e-12 ps=1.0560e-05 nf=1 m=6 par=6
XMpar1 a_2388_14563.t76 a_1646_996.t30 a_4274_8395.t0 vss.t0 nfet_03v3 w=2u l=0.31u ad=5.8207e-13 pd=2.6510e-06 as=5.8207e-13 ps=2.6510e-06 nf=1 m=58 par=58
XMpar2 a_1856_1204.t0 inp.t0 a_2388_14563.t12 vdd.t21 pfet_03v3 w=8u l=0.53u ad=2.4000e-12 pd=9.1000e-06 as=2.2400e-12 ps=8.5600e-06 nf=1 m=64 par=64
XMpar3 a_1856_1204.t0 inn.t0 a_9636_8395.t12 vdd.t21 pfet_03v3 w=8u l=0.53u ad=2.4000e-12 pd=9.1000e-06 as=2.2400e-12 ps=8.5600e-06 nf=1 m=64 par=64
XMpar4 a_1646_996.t7 a_1646_996.t6 vdd.t1 vdd.t0 pfet_03v3 w=10u l=1.05u ad=3.8667e-12 pd=1.4107e-05 as=2.8000e-12 ps=1.0560e-05 nf=1 m=6 par=6
XMpar5 a_9636_8395.t76 a_1646_996.t30 out.t0 vss.t0 nfet_03v3 w=2u l=0.31u ad=5.8207e-13 pd=2.6510e-06 as=5.8207e-13 ps=2.6510e-06 nf=1 m=58 par=58
XMpar6 a_2388_14563.t0 ib.t0 vss.t5 vss.t0 nfet_03v3 w=10u l=0.81u ad=2.8000e-12 pd=1.0560e-05 as=3.3333e-12 ps=1.2333e-05 nf=1 m=12 par=12
XMpar7 ib.t1 ib.t0 vss.t5 vss.t0 nfet_03v3 w=10u l=0.81u ad=3.8667e-12 pd=1.4107e-05 as=2.8000e-12 ps=1.0560e-05 nf=1 m=6 par=6
XMpar8 a_1646_996.t0 ib.t0 vss.t5 vss.t0 nfet_03v3 w=10u l=0.81u ad=2.8000e-12 pd=1.0560e-05 as=2.8000e-12 ps=1.0560e-05 nf=1 m=6 par=6
XMpar9 a_1856_1204.t128 a_1646_996.t6 vdd.t1 vdd.t0 pfet_03v3 w=10u l=1.05u ad=3.8667e-12 pd=1.4107e-05 as=3.3333e-12 ps=1.2333e-05 nf=1 m=12 par=12
XMpar10 a_9636_8395.t0 ib.t0 vss.t5 vss.t0 nfet_03v3 w=10u l=0.81u ad=2.8000e-12 pd=1.0560e-05 as=3.3333e-12 ps=1.2333e-05 nf=1 m=12 par=12
XMpar11 out.t12 a_4274_8395.t52 vdd.t1 vdd.t0 pfet_03v3 w=10u l=1.05u ad=2.8000e-12 pd=1.0560e-05 as=2.8000e-12 ps=1.0560e-05 nf=1 m=6 par=6
X28 out.t64 vss.t114 cap_mim_2f0fF c_width=10.25u c_length=10.25u
Rpar0 a_1646_996.t0 a_1646_996.t6 621.1752
Rpar1 a_1646_996.t0 a_1646_996.t30 151.1156
Rpar2 a_1646_996.t0 a_1646_996.t7 91.4267
Rpar3 a_1646_996.t6 a_1646_996.t30 342.3910
Rpar4 a_1646_996.t6 a_1646_996.t7 11.1534
Rpar5 a_1646_996.t30 a_1646_996.t7 50.3943
Rpar6 a_1856_1204.t0 a_1856_1204.t128 43.4650
Rpar7 a_2388_14563.t0 a_2388_14563.t76 55.6704
Rpar8 a_2388_14563.t0 a_2388_14563.t12 62.6180
Rpar9 a_2388_14563.t76 a_2388_14563.t12 189.1630
Rpar10 a_4274_8395.t0 a_4274_8395.t52 731.5991
Rpar11 a_4274_8395.t0 a_4274_8395.t53 109.5340
Rpar12 a_4274_8395.t52 a_4274_8395.t53 17.9265
Rpar13 a_9636_8395.t0 a_9636_8395.t76 55.6704
Rpar14 a_9636_8395.t0 a_9636_8395.t12 62.6180
Rpar15 a_9636_8395.t76 a_9636_8395.t12 189.1630
Rpar16 ib ib.t0 2.8875
Rpar17 ib ib.t1 89.6135
Rpar18 ib.t0 ib.t1 18.9842
Rpar19 inn inn.t0 2.6351
Rpar20 inp inp.t0 2.6351
Rpar21 out out.t0 63.8687
Rpar22 out out.t12 3.1938
Rpar23 out out.t64 64.9074
Rpar24 out.t0 out.t64 313.2513
Rpar25 vdd vdd.t0 473.6425
Rpar26 vdd vdd.t1 105.7687
Rpar27 vdd vdd.t21 23.2876
Rpar28 vdd.t0 vdd.t1 3.7705
Rpar29 vdd.t0 vdd.t21 1360.3144
Rpar30 vdd.t1 vdd.t21 303.7706
Rpar31 vss vss.t0 48.3013
Rpar32 vss vss.t5 203.7923
Rpar33 vss vss.t114 87.2165
Rpar34 vss.t0 vss.t5 2.6336
Rpar35 vss.t0 vss.t114 83.1844
Rpar36 vss.t5 vss.t114 287.0783
Cpar0 a_1646_996.t0 vss 7.56487e-15
Cpar1 a_1646_996.t30 vss 2.52707e-14
Cpar2 a_1646_996.t6 vss 2.44651e-14
Cpar3 a_1646_996.t7 vss 1.36094e-14
Cpar4 a_1856_1204.t0 vss 1.99707e-13
Cpar5 a_1856_1204.t128 vss 3.66395e-14
Cpar6 a_2388_14563.t0 vss 2.75790e-14
Cpar7 a_2388_14563.t12 vss 1.01798e-13
Cpar8 a_2388_14563.t76 vss 3.07085e-14
Cpar9 a_4274_8395.t0 vss 2.96103e-14
Cpar10 a_4274_8395.t52 vss 2.83470e-14
Cpar11 a_4274_8395.t53 vss 1.97819e-14
Cpar12 a_9636_8395.t0 vss 2.68566e-14
Cpar13 a_9636_8395.t12 vss 9.91321e-14
Cpar14 a_9636_8395.t76 vss 2.99041e-14
Cpar15 ib inn 2.02600e-17
Cpar16 ib inp 1.01300e-17
Cpar17 ib out 4.75800e-17
Cpar18 ib vdd 3.56324e-15
Cpar19 ib vss 5.49630e-14
Cpar20 ib.t0 vss 1.02177e-14
Cpar21 ib.t1 vss 4.19777e-15
Cpar22 inn inp 1.03350e-16
Cpar23 inn vdd 2.56025e-14
Cpar24 inn vss 1.17081e-14
Cpar25 inn.t0 vss 4.41563e-14
Cpar26 inp vdd 2.56784e-14
Cpar27 inp vss 1.17512e-14
Cpar28 inp.t0 vss 4.42267e-14
Cpar29 out vdd 8.79643e-15
Cpar30 out vss 1.97370e-14
Cpar31 out.t0 vss 1.91957e-14
Cpar32 out.t12 vss 6.40065e-15
Cpar33 out.t64 vss 2.85367e-14
Cpar34 vdd vss 4.11674e-13
Cpar35 vdd.t0 vss 5.34593e-14
Cpar36 vdd.t1 vss 1.84684e-14
Cpar37 vdd.t21 vss 9.59477e-14
.ends opamp_dut

Vdd vdd 0 3.300000
Vss vss 0 0
Ibias vdd ib 3.833330e-05
Vinp inp 0 DC 1.381000 AC 1 PWL(0 1.381000 3.000000e-09 1.381000 3.300000e-09 1.391000)
Rfb out inn 1m
Cload out 0 2.000000e-12
Xdut vdd vss inp inn out ib opamp_dut
.end
