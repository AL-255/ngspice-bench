* opa1000[0689]: 200f/rail_to_rail_3v3_i50n_subth (rail_to_rail, VDD=3.3V, CL=0.2pF, Iref=0.0081uA)
.include "pdk_opa.inc"
.temp 27
.option gmin=1e-12 rshunt=1e12 reltol=1e-3 abstol=1e-12 vntol=1e-5 method=gear
* Post-PEX R+C extracted netlist for rail_to_rail_3v3_i50n_subth
.subckt opamp_dut vdd vss inp inn out ib
XMpar0 a_10030_7327.t2 a_7080_18928.t0 vss.t1 vss.t0 nfet_03v3 w=0.4u l=8.13u ad=1.1200e-13 pd=9.6000e-07 as=1.1200e-13 ps=9.6000e-07 nf=1 m=2 par=2
XMpar1 a_10030_7327.t0 inn.t0 a_8770_5249.t0 vss.t4 nfet_03v3 w=0.4u l=6.88u ad=2.4000e-13 pd=2.0000e-06 as=2.4000e-13 ps=2.0000e-06 nf=1 m=2 par=2
XMpar2 out.t1 a_1013_7576.t7 vdd.t1 vdd.t0 pfet_03v3 w=0.57u l=3.2u ad=2.0520e-13 pd=1.4325e-06 as=2.5080e-13 ps=1.7350e-06 nf=1 m=8 par=8
XMpar3 a_15759_14072.t4 ib.t0 vss.t9 vss.t8 nfet_03v3 w=0.4u l=7.5u ad=2.4000e-13 pd=2.0000e-06 as=1.1200e-13 ps=9.6000e-07 nf=1 m=2 par=2
XMpar4 out.t0 ib.t0 vss.t9 vss.t8 nfet_03v3 w=0.4u l=7.5u ad=1.1200e-13 pd=9.6000e-07 as=2.0800e-13 ps=1.7400e-06 nf=1 m=8 par=8
XMpar5 a_7282_17300.t2 inn.t2 a_9044_14072.t0 vdd.t8 pfet_03v3 w=1.04u l=6.88u ad=6.2400e-13 pd=3.2800e-06 as=2.9120e-13 ps=1.6000e-06 nf=1 m=2 par=2
XMpar6 a_7282_17300.t0 a_15759_14072.t0 vdd.t13 vdd.t12 pfet_03v3 w=0.4u l=7.5u ad=2.4000e-13 pd=2.0000e-06 as=1.1200e-13 ps=9.6000e-07 nf=1 m=2 par=2
XMpar7 a_7080_18928.t1 a_7080_18928.t0 vss.t1 vss.t0 nfet_03v3 w=0.4u l=8.13u ad=2.4000e-13 pd=2.0000e-06 as=1.1200e-13 ps=9.6000e-07 nf=1 m=2 par=2
XMpar8 a_1013_7576.t1 a_10030_7327.t3 vdd.t1 vdd.t0 pfet_03v3 w=0.57u l=3.2u ad=3.4200e-13 pd=2.3400e-06 as=1.5960e-13 ps=1.1300e-06 nf=1 m=2 par=2
XMpar9 a_15759_14072.t1 a_15759_14072.t0 vdd.t13 vdd.t12 pfet_03v3 w=0.4u l=7.5u ad=2.4000e-13 pd=2.0000e-06 as=1.1200e-13 ps=9.6000e-07 nf=1 m=2 par=2
XMpar10 a_1013_7576.t3 inp.t0 a_8770_5249.t0 vss.t4 nfet_03v3 w=0.4u l=6.88u ad=2.4000e-13 pd=2.0000e-06 as=2.4000e-13 ps=2.0000e-06 nf=1 m=2 par=2
XMpar11 a_8770_5249.t2 ib.t0 vss.t9 vss.t8 nfet_03v3 w=0.4u l=7.5u ad=2.4000e-13 pd=2.0000e-06 as=1.1200e-13 ps=9.6000e-07 nf=1 m=2 par=2
XMpar12 a_1013_7576.t0 a_9044_14072.t2 vss.t1 vss.t0 nfet_03v3 w=0.4u l=8.13u ad=2.4000e-13 pd=2.0000e-06 as=1.1200e-13 ps=9.6000e-07 nf=1 m=2 par=2
XMpar13 a_10030_7327.t4 a_10030_7327.t3 vdd.t1 vdd.t0 pfet_03v3 w=0.57u l=3.2u ad=3.4200e-13 pd=2.3400e-06 as=1.5960e-13 ps=1.1300e-06 nf=1 m=2 par=2
XMpar14 ib.t1 ib.t0 vss.t9 vss.t8 nfet_03v3 w=0.4u l=7.5u ad=2.4000e-13 pd=2.0000e-06 as=1.1200e-13 ps=9.6000e-07 nf=1 m=2 par=2
XMpar15 a_9044_14072.t3 a_9044_14072.t2 vss.t1 vss.t0 nfet_03v3 w=0.4u l=8.13u ad=2.4000e-13 pd=2.0000e-06 as=1.1200e-13 ps=9.6000e-07 nf=1 m=2 par=2
XMpar16 a_7080_18928.t4 inp.t2 a_7282_17300.t2 vdd.t8 pfet_03v3 w=1.04u l=6.88u ad=2.9120e-13 pd=1.6000e-06 as=6.2400e-13 ps=3.2800e-06 nf=1 m=2 par=2
X4 a_1013_12256.t0 a_4991_11736.t0 vss.t7 ppolyf_u_1k r_width=1u r_length=19.23u
X6 a_1013_11216.t0 a_4991_11736.t0 vss.t7 ppolyf_u_1k r_width=1u r_length=19.23u
X10 a_1013_8096.t0 a_4991_7576.t0 vss.t7 ppolyf_u_1k r_width=1u r_length=19.23u
X16 a_1013_7576.t6 a_4991_7576.t0 vss.t7 ppolyf_u_1k r_width=1u r_length=19.23u
X17 a_1013_11216.t0 a_4991_10696.t0 vss.t7 ppolyf_u_1k r_width=1u r_length=19.23u
X21 a_1013_13296.t0 a_4991_13816.t0 vss.t7 ppolyf_u_1k r_width=1u r_length=19.23u
X24 a_4991_13816.t1 out.t5 cap_mim_2f0fF c_width=15u c_length=15u
X29 a_1013_9136.t0 a_4991_9656.t0 vss.t7 ppolyf_u_1k r_width=1u r_length=19.23u
X37 a_1013_10176.t0 a_4991_10696.t0 vss.t7 ppolyf_u_1k r_width=1u r_length=19.23u
X38 a_1013_9136.t0 a_4991_8616.t0 vss.t7 ppolyf_u_1k r_width=1u r_length=19.23u
X45 a_1013_8096.t0 a_4991_8616.t0 vss.t7 ppolyf_u_1k r_width=1u r_length=19.23u
X49 a_1013_13296.t0 a_4991_12776.t0 vss.t7 ppolyf_u_1k r_width=1u r_length=19.23u
X50 a_1013_10176.t0 a_4991_9656.t0 vss.t7 ppolyf_u_1k r_width=1u r_length=19.23u
X54 a_1013_12256.t0 a_4991_12776.t0 vss.t7 ppolyf_u_1k r_width=1u r_length=19.23u
Rpar0 a_10030_7327.t0 a_10030_7327.t2 228.5676
Rpar1 a_10030_7327.t0 a_10030_7327.t3 137.5422
Rpar2 a_10030_7327.t0 a_10030_7327.t4 126.1198
Rpar3 a_10030_7327.t2 a_10030_7327.t3 362.8109
Rpar4 a_10030_7327.t2 a_10030_7327.t4 332.6807
Rpar5 a_10030_7327.t3 a_10030_7327.t4 15.4278
Rpar6 a_1013_7576.t0 a_1013_7576.t1 233.2658
Rpar7 a_1013_7576.t0 a_1013_7576.t7 302.2448
Rpar8 a_1013_7576.t0 a_1013_7576.t3 249.0308
Rpar9 a_1013_7576.t0 a_1013_7576.t6 332.4543
Rpar10 a_1013_7576.t1 a_1013_7576.t7 212.3451
Rpar11 a_1013_7576.t1 a_1013_7576.t3 174.9591
Rpar12 a_1013_7576.t1 a_1013_7576.t6 233.5691
Rpar13 a_1013_7576.t7 a_1013_7576.t3 67.9479
Rpar14 a_1013_7576.t7 a_1013_7576.t6 178.4732
Rpar15 a_1013_7576.t3 a_1013_7576.t6 147.0508
Rpar16 a_15759_14072.t0 a_15759_14072.t1 16.7566
Rpar17 a_15759_14072.t0 a_15759_14072.t4 125.3892
Rpar18 a_15759_14072.t1 a_15759_14072.t4 116.5888
Rpar19 a_4991_13816.t0 a_4991_13816.t1 66.4079
Rpar20 a_7080_18928.t0 a_7080_18928.t1 23.0933
Rpar21 a_7080_18928.t0 a_7080_18928.t4 107.0727
Rpar22 a_7080_18928.t1 a_7080_18928.t4 84.3372
Rpar23 a_7282_17300.t0 a_7282_17300.t2 53.0167
Rpar24 a_8770_5249.t0 a_8770_5249.t2 70.1922
Rpar25 a_9044_14072.t0 a_9044_14072.t2 137.9169
Rpar26 a_9044_14072.t0 a_9044_14072.t3 130.8519
Rpar27 a_9044_14072.t2 a_9044_14072.t3 17.1661
Rpar28 ib ib.t0 18.7331
Rpar29 ib ib.t1 18.1854
Rpar30 ib.t0 ib.t1 28.5726
Rpar31 inn inn.t0 4.2619
Rpar32 inn inn.t2 62.9273
Rpar33 inp inp.t0 4.2626
Rpar34 inp inp.t2 62.8786
Rpar35 out out.t0 7.0825
Rpar36 out out.t1 188.6090
Rpar37 out out.t5 405.7465
Rpar38 out.t0 out.t1 190.0653
Rpar39 out.t0 out.t5 408.8793
Rpar40 out.t1 out.t5 52.7533
Rpar41 vdd vdd.t0 1483.3084
Rpar42 vdd vdd.t1 513.5402
Rpar43 vdd vdd.t12 899.8466
Rpar44 vdd vdd.t13 499.0871
Rpar45 vdd vdd.t8 68.1872
Rpar46 vdd.t0 vdd.t1 7.3212
Rpar47 vdd.t0 vdd.t12 1965.2997
Rpar48 vdd.t0 vdd.t13 1090.0254
Rpar49 vdd.t0 vdd.t8 855.7226
Rpar50 vdd.t1 vdd.t12 680.4117
Rpar51 vdd.t1 vdd.t13 377.3806
Rpar52 vdd.t1 vdd.t8 296.2620
Rpar53 vdd.t12 vdd.t13 21.3722
Rpar54 vdd.t12 vdd.t8 519.1227
Rpar55 vdd.t13 vdd.t8 287.9240
Rpar56 vss vss.t0 189.8018
Rpar57 vss vss.t1 1724.5174
Rpar58 vss vss.t8 191.6540
Rpar59 vss vss.t9 1027.2178
Rpar60 vss vss.t7 237.7137
Rpar61 vss vss.t4 461.4487
Rpar62 vss.t0 vss.t1 11.9675
Rpar63 vss.t0 vss.t8 3.2195
Rpar64 vss.t0 vss.t9 36.9616
Rpar65 vss.t0 vss.t7 9.1761
Rpar66 vss.t0 vss.t4 21.4424
Rpar67 vss.t1 vss.t8 51.3703
Rpar68 vss.t1 vss.t9 372.2350
Rpar69 vss.t1 vss.t7 81.3267
Rpar70 vss.t1 vss.t4 179.1483
Rpar71 vss.t8 vss.t9 35.5943
Rpar72 vss.t8 vss.t7 3.5021
Rpar73 vss.t8 vss.t4 12.9508
Rpar74 vss.t9 vss.t7 54.6874
Rpar75 vss.t9 vss.t4 158.9042
Rpar76 vss.t7 vss.t4 35.2727
Cpar0 a_10030_7327.t0 vss 5.41427e-15
Cpar1 a_10030_7327.t2 vss 7.18090e-15
Cpar2 a_10030_7327.t3 vss 8.15607e-15
Cpar3 a_10030_7327.t4 vss 4.21270e-15
Cpar4 a_1013_10176.t0 vss 3.83400e-17
Cpar5 a_1013_11216.t0 vss 3.83400e-17
Cpar6 a_1013_12256.t0 vss 3.90800e-17
Cpar7 a_1013_13296.t0 vss 3.67000e-17
Cpar8 a_1013_7576.t0 vss 7.55622e-15
Cpar9 a_1013_7576.t1 vss 5.75569e-15
Cpar10 a_1013_7576.t3 vss 4.93028e-15
Cpar11 a_1013_7576.t6 vss 3.84060e-15
Cpar12 a_1013_7576.t7 vss 1.54002e-14
Cpar13 a_1013_8096.t0 vss 4.10000e-17
Cpar14 a_1013_9136.t0 vss 3.83400e-17
Cpar15 a_15759_14072.t0 vss 1.77423e-14
Cpar16 a_15759_14072.t1 vss 5.43946e-15
Cpar17 a_15759_14072.t4 vss 1.52257e-14
Cpar18 a_4991_10696.t0 vss 3.83000e-17
Cpar19 a_4991_11736.t0 vss 3.74400e-17
Cpar20 a_4991_12776.t0 vss 4.00600e-17
Cpar21 a_4991_13816.t0 vss 3.78950e-16
Cpar22 a_4991_13816.t1 vss 6.38496e-15
Cpar23 a_4991_7576.t0 vss 3.71200e-17
Cpar24 a_4991_8616.t0 vss 3.75400e-17
Cpar25 a_4991_9656.t0 vss 3.83600e-17
Cpar26 a_7080_18928.t0 vss 5.51733e-15
Cpar27 a_7080_18928.t1 vss 1.37655e-15
Cpar28 a_7080_18928.t4 vss 9.38082e-16
Cpar29 a_7282_17300.t0 vss 9.31723e-15
Cpar30 a_7282_17300.t2 vss 8.78991e-15
Cpar31 a_8770_5249.t0 vss 1.27086e-14
Cpar32 a_8770_5249.t2 vss 1.94991e-14
Cpar33 a_9044_14072.t0 vss 1.26091e-15
Cpar34 a_9044_14072.t2 vss 7.04800e-15
Cpar35 a_9044_14072.t3 vss 1.85199e-15
Cpar36 ib inn 3.79800e-17
Cpar37 ib out 1.97909e-15
Cpar38 ib vdd 5.01700e-17
Cpar39 ib vss 6.22104e-14
Cpar40 ib.t0 vss 1.97584e-14
Cpar41 ib.t1 vss 1.53256e-15
Cpar42 inn inp 1.55910e-16
Cpar43 inn out 3.72300e-17
Cpar44 inn vdd 6.89456e-15
Cpar45 inn vss 1.87866e-14
Cpar46 inn.t0 vss 1.99274e-15
Cpar47 inn.t2 vss 7.24050e-15
Cpar48 inp out 9.83200e-17
Cpar49 inp vdd 8.67959e-15
Cpar50 inp vss 2.14160e-14
Cpar51 inp.t0 vss 2.22088e-15
Cpar52 inp.t2 vss 8.06493e-15
Cpar53 out vdd 1.29335e-14
Cpar54 out vss 2.85662e-14
Cpar55 out.t0 vss 6.09298e-15
Cpar56 out.t1 vss 7.92776e-15
Cpar57 out.t5 vss 1.10076e-14
Cpar58 vdd vss 1.71910e-13
Cpar59 vdd.t0 vss 3.29951e-14
Cpar60 vdd.t1 vss 9.72263e-15
Cpar61 vdd.t12 vss 1.88116e-14
Cpar62 vdd.t13 vss 6.62011e-15
Cpar63 vdd.t8 vss 1.67207e-14
.ends opamp_dut

Vdd vdd 0 3.300000
Vss vss 0 0
Ibias vdd ib 8.100000e-09
Vinp inp 0 DC 1.645000 AC 1 PWL(0 1.645000 1.480853e-06 1.645000 1.628939e-06 1.655000)
Rfb out inn 1m
Cload out 0 2.000000e-13
Xdut vdd vss inp inn out ib opamp_dut
.end
