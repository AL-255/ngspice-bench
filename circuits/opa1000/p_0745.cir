* opa1000[0745]: 2p/rail_to_rail_3v3_10u_100u_weak (rail_to_rail, VDD=3.3V, CL=2.0pF, Iref=5.3125uA)
.include "pdk_opa.inc"
.temp 27
.option gmin=1e-12 rshunt=1e12 reltol=1e-3 abstol=1e-12 vntol=1e-5 method=gear
* Post-PEX R+C extracted netlist for rail_to_rail_3v3_10u_100u_weak
.subckt opamp_dut vdd vss inp inn out ib
XMpar0 a_3730_10656.t0 inp.t4 a_4010_10656.t4 vdd.t8 pfet_03v3 w=1.98u l=0.8u ad=6.4491e-13 pd=2.9143e-06 as=5.5440e-13 ps=2.5400e-06 nf=1 m=14 par=14
XMpar1 a_3730_10656.t0 inn.t4 a_7232_12264.t0 vdd.t8 pfet_03v3 w=1.98u l=0.8u ad=6.4491e-13 pd=2.9143e-06 as=5.5440e-13 ps=2.5400e-06 nf=1 m=14 par=14
XMpar2 a_5710_6739.t4 ib.t0 vss.t15 vss.t2 nfet_03v3 w=1.3u l=0.65u ad=7.8000e-13 pd=3.8000e-06 as=3.6400e-13 ps=1.8600e-06 nf=1 m=2 par=2
XMpar3 a_3730_10656.t28 a_6955_6739.t2 vdd.t1 vdd.t0 pfet_03v3 w=5u l=0.65u ad=3.0000e-12 pd=1.1200e-05 as=1.4000e-12 ps=5.5600e-06 nf=1 m=2 par=2
XMpar4 out.t0 ib.t0 vss.t15 vss.t2 nfet_03v3 w=1.3u l=0.65u ad=3.6400e-13 pd=1.8600e-06 as=4.6800e-13 ps=2.3450e-06 nf=1 m=8 par=8
XMpar5 out.t1 a_1159_1086.t9 vdd.t3 vdd.t2 pfet_03v3 w=10u l=0.75u ad=2.8000e-12 pd=1.0560e-05 as=3.6000e-12 ps=1.3220e-05 nf=1 m=8 par=8
XMpar6 a_1159_1086.t6 a_7432_1086.t6 vdd.t3 vdd.t2 pfet_03v3 w=10u l=0.75u ad=6.0000e-12 pd=2.1200e-05 as=2.8000e-12 ps=1.0560e-05 nf=1 m=2 par=2
XMpar7 a_1159_1086.t0 a_7232_12264.t14 vss.t1 vss.t0 nfet_03v3 w=1.2u l=1.25u ad=7.2000e-13 pd=3.6000e-06 as=3.3600e-13 ps=1.7600e-06 nf=1 m=2 par=2
XMpar8 ib.t1 ib.t0 vss.t15 vss.t2 nfet_03v3 w=1.3u l=0.65u ad=7.8000e-13 pd=3.8000e-06 as=3.6400e-13 ps=1.8600e-06 nf=1 m=2 par=2
XMpar9 a_7432_1086.t4 a_4010_10656.t0 vss.t1 vss.t0 nfet_03v3 w=1.2u l=1.25u ad=3.3600e-13 pd=1.7600e-06 as=3.3600e-13 ps=1.7600e-06 nf=1 m=2 par=2
XMpar10 a_4010_10656.t1 a_4010_10656.t0 vss.t1 vss.t0 nfet_03v3 w=1.2u l=1.25u ad=7.2000e-13 pd=3.6000e-06 as=3.3600e-13 ps=1.7600e-06 nf=1 m=2 par=2
XMpar11 a_7232_12264.t15 a_7232_12264.t14 vss.t1 vss.t0 nfet_03v3 w=1.2u l=1.25u ad=3.3600e-13 pd=1.7600e-06 as=3.3600e-13 ps=1.7600e-06 nf=1 m=2 par=2
XMpar12 a_1159_1086.t2 inp.t0 a_5710_6739.t0 vss.t2 nfet_03v3 w=1.45u l=0.8u ad=4.0600e-13 pd=2.0100e-06 as=6.3800e-13 ps=3.0550e-06 nf=1 m=4 par=4
XMpar13 a_7432_1086.t7 a_7432_1086.t6 vdd.t3 vdd.t2 pfet_03v3 w=10u l=0.75u ad=2.8000e-12 pd=1.0560e-05 as=2.8000e-12 ps=1.0560e-05 nf=1 m=2 par=2
XMpar14 a_5710_6739.t0 inn.t0 a_7432_1086.t0 vss.t2 nfet_03v3 w=1.45u l=0.8u ad=6.3800e-13 pd=3.0550e-06 as=4.0600e-13 ps=2.0100e-06 nf=1 m=4 par=4
XMpar15 a_6955_6739.t0 ib.t0 vss.t15 vss.t2 nfet_03v3 w=1.3u l=0.65u ad=3.6400e-13 pd=1.8600e-06 as=3.6400e-13 ps=1.8600e-06 nf=1 m=2 par=2
XMpar16 a_6955_6739.t3 a_6955_6739.t2 vdd.t1 vdd.t0 pfet_03v3 w=5u l=0.65u ad=1.4000e-12 pd=5.5600e-06 as=1.4000e-12 ps=5.5600e-06 nf=1 m=2 par=2
X9 a_14301_4960.t1 out.t8 cap_mim_2f0fF c_width=15.62u c_length=15.61u
X67 a_1159_1086.t8 a_14301_4960.t0 vss.t52 ppolyf_u_1k r_width=1u r_length=5.45u
X75 a_14301_4960.t1 out.t8 cap_mim_2f0fF c_width=15.62u c_length=15.61u
Rpar0 a_1159_1086.t0 a_1159_1086.t9 864.6821
Rpar1 a_1159_1086.t0 a_1159_1086.t2 96.5377
Rpar2 a_1159_1086.t0 a_1159_1086.t6 248.0823
Rpar3 a_1159_1086.t0 a_1159_1086.t8 1191.9894
Rpar4 a_1159_1086.t9 a_1159_1086.t2 414.3850
Rpar5 a_1159_1086.t9 a_1159_1086.t6 81.3084
Rpar6 a_1159_1086.t9 a_1159_1086.t8 300.9110
Rpar7 a_1159_1086.t2 a_1159_1086.t6 118.8895
Rpar8 a_1159_1086.t2 a_1159_1086.t8 571.2418
Rpar9 a_1159_1086.t6 a_1159_1086.t8 112.0860
Rpar10 a_14301_4960.t0 a_14301_4960.t1 101.3561
Rpar11 a_3730_10656.t0 a_3730_10656.t28 56.9791
Rpar12 a_4010_10656.t0 a_4010_10656.t1 21.4338
Rpar13 a_4010_10656.t0 a_4010_10656.t4 186.9165
Rpar14 a_4010_10656.t1 a_4010_10656.t4 93.8512
Rpar15 a_5710_6739.t0 a_5710_6739.t4 49.7435
Rpar16 a_6955_6739.t0 a_6955_6739.t2 253.1857
Rpar17 a_6955_6739.t0 a_6955_6739.t3 76.9958
Rpar18 a_6955_6739.t2 a_6955_6739.t3 32.6620
Rpar19 a_7232_12264.t0 a_7232_12264.t14 91.1608
Rpar20 a_7232_12264.t0 a_7232_12264.t15 76.9148
Rpar21 a_7232_12264.t14 a_7232_12264.t15 31.4230
Rpar22 a_7432_1086.t0 a_7432_1086.t6 837.4885
Rpar23 a_7432_1086.t0 a_7432_1086.t4 128.0672
Rpar24 a_7432_1086.t0 a_7432_1086.t7 171.6685
Rpar25 a_7432_1086.t6 a_7432_1086.t4 428.4507
Rpar26 a_7432_1086.t6 a_7432_1086.t7 39.4615
Rpar27 a_7432_1086.t4 a_7432_1086.t7 87.8239
Rpar28 ib ib.t0 12.9612
Rpar29 ib ib.t1 7.8725
Rpar30 inn inn.t0 5.4149
Rpar31 inn inn.t4 51.6875
Rpar32 inp inp.t0 5.4635
Rpar33 inp inp.t4 52.7909
Rpar34 out out.t0 117.7348
Rpar35 out out.t1 49.4629
Rpar36 out out.t8 20.9990
Rpar37 out.t0 out.t1 71.7926
Rpar38 vdd vdd.t8 76.5978
Rpar39 vdd vdd.t2 1440.9114
Rpar40 vdd vdd.t3 4537.4648
Rpar41 vdd.t0 vdd.t1 10.0569
Rpar42 vdd.t0 vdd.t8 1322.2392
Rpar43 vdd.t0 vdd.t2 103.5048
Rpar44 vdd.t0 vdd.t3 302.6132
Rpar45 vdd.t1 vdd.t8 1689.9460
Rpar46 vdd.t1 vdd.t2 132.2889
Rpar47 vdd.t1 vdd.t3 386.7681
Rpar48 vdd.t8 vdd.t2 124.0459
Rpar49 vdd.t8 vdd.t3 390.6236
Rpar50 vdd.t2 vdd.t3 3.7535
Rpar51 vss vss.t0 260.9035
Rpar52 vss vss.t1 691.0126
Rpar53 vss vss.t15 487.2109
Rpar54 vss vss.t2 97.8343
Rpar55 vss vss.t52 159.2035
Rpar56 vss.t0 vss.t1 8.3820
Rpar57 vss.t0 vss.t15 19.2076
Rpar58 vss.t0 vss.t2 1.9555
Rpar59 vss.t0 vss.t52 274.9702
Rpar60 vss.t1 vss.t15 125.4143
Rpar61 vss.t1 vss.t2 11.8988
Rpar62 vss.t1 vss.t52 733.4954
Rpar63 vss.t15 vss.t2 5.8328
Rpar64 vss.t15 vss.t52 546.9309
Rpar65 vss.t2 vss.t52 108.4752
Cpar0 a_1159_1086.t0 vss 2.70022e-15
Cpar1 a_1159_1086.t2 vss 3.14345e-15
Cpar2 a_1159_1086.t6 vss 7.45231e-15
Cpar3 a_1159_1086.t8 vss 2.50522e-15
Cpar4 a_1159_1086.t9 vss 9.20445e-15
Cpar5 a_14301_4960.t0 vss 3.23475e-16
Cpar6 a_14301_4960.t1 vss 1.00379e-14
Cpar7 a_3730_10656.t0 vss 1.77242e-14
Cpar8 a_3730_10656.t28 vss 6.01077e-15
Cpar9 a_4010_10656.t0 vss 3.33420e-15
Cpar10 a_4010_10656.t1 vss 2.44914e-15
Cpar11 a_4010_10656.t4 vss 7.28713e-15
Cpar12 a_5710_6739.t0 vss 5.12723e-15
Cpar13 a_5710_6739.t4 vss 4.49554e-15
Cpar14 a_6955_6739.t0 vss 2.73055e-15
Cpar15 a_6955_6739.t2 vss 3.65715e-15
Cpar16 a_6955_6739.t3 vss 3.96118e-15
Cpar17 a_7232_12264.t0 vss 8.70039e-15
Cpar18 a_7232_12264.t14 vss 4.56162e-15
Cpar19 a_7232_12264.t15 vss 1.76690e-15
Cpar20 a_7432_1086.t0 vss 2.56483e-15
Cpar21 a_7432_1086.t4 vss 2.14346e-15
Cpar22 a_7432_1086.t6 vss 5.32234e-15
Cpar23 a_7432_1086.t7 vss 5.47682e-15
Cpar24 ib out 8.85730e-16
Cpar25 ib vss 1.23434e-14
Cpar26 ib.t0 vss 3.50732e-15
Cpar27 ib.t1 vss 4.26586e-16
Cpar28 inn inp 1.02820e-16
Cpar29 inn vdd 8.68197e-15
Cpar30 inn vss 6.83393e-15
Cpar31 inn.t0 vss 1.11280e-15
Cpar32 inn.t4 vss 9.86620e-15
Cpar33 inp out 3.95100e-17
Cpar34 inp vdd 9.22069e-15
Cpar35 inp vss 7.76971e-15
Cpar36 inp.t0 vss 1.21621e-15
Cpar37 inp.t4 vss 1.09535e-14
Cpar38 out vdd 1.21874e-14
Cpar39 out vss 1.85775e-14
Cpar40 out.t0 vss 1.95402e-15
Cpar41 out.t1 vss 6.70449e-15
Cpar42 out.t8 vss 1.06423e-14
Cpar43 vdd vss 1.32716e-13
Cpar44 vdd.t0 vss 5.43362e-15
Cpar45 vdd.t1 vss 3.82050e-15
Cpar46 vdd.t2 vss 2.24627e-14
Cpar47 vdd.t3 vss 1.22478e-14
Cpar48 vdd.t8 vss 2.50290e-14
.ends opamp_dut

Vdd vdd 0 3.300000
Vss vss 0 0
Ibias vdd ib 5.312500e-06
Vinp inp 0 DC 1.645000 AC 1 PWL(0 1.645000 7.462399e-09 1.645000 8.208639e-09 1.655000)
Rfb out inn 1m
Cload out 0 2.000000e-12
Xdut vdd vss inp inn out ib opamp_dut
.end
