* opa1000[0264]: 200f/folded_cascode_pmos_1v8_i10u_subth (folded_cascode_pmos, VDD=1.8V, CL=0.2pF, Iref=1.8889uA)
.include "pdk_opa.inc"
.temp 27
.option gmin=1e-12 rshunt=1e12 reltol=1e-3 abstol=1e-12 vntol=1e-5 method=gear
* Post-PEX R+C extracted netlist for folded_cascode_pmos_1v8_i10u_subth
.subckt opamp_dut vdd vss inp inn out ib
XMpar0 a_1735_18699.t1 inp.t0 a_4090_14327.t6 vdd.t4 pfet_03v3 w=2.64u l=0.72u ad=7.9200e-13 pd=3.4050e-06 as=7.6560e-13 ps=3.3025e-06 nf=1 m=64 par=64
XMpar1 a_9774_8249.t2 ib.t0 vss.t7 vss.t0 nfet_03v3 w=4.81u l=1.88u ad=1.3468e-12 pd=5.3700e-06 as=2.1164e-12 ps=8.0950e-06 nf=1 m=4 par=4
XMpar2 a_1735_18699.t1 inn.t0 a_9774_8249.t8 vdd.t4 pfet_03v3 w=2.64u l=0.72u ad=7.9200e-13 pd=3.4050e-06 as=7.6560e-13 ps=3.3025e-06 nf=1 m=64 par=64
XMpar3 a_9774_8249.t0 a_1195_18491.t6 out.t0 vss.t0 nfet_03v3 w=1.54u l=0.6u ad=5.9547e-13 pd=2.8267e-06 as=4.3120e-13 ps=2.1000e-06 nf=1 m=6 par=6
XMpar4 a_1195_18491.t4 ib.t0 vss.t7 vss.t0 nfet_03v3 w=4.81u l=1.88u ad=1.3468e-12 pd=5.3700e-06 as=1.3468e-12 ps=5.3700e-06 nf=1 m=2 par=2
XMpar5 out.t5 a_8306_8249.t6 vdd.t1 vdd.t0 pfet_03v3 w=10u l=2.7u ad=2.8000e-12 pd=1.0560e-05 as=2.8000e-12 ps=1.0560e-05 nf=1 m=2 par=2
XMpar6 a_1735_18699.t0 a_1195_18491.t0 vdd.t1 vdd.t0 pfet_03v3 w=10u l=2.7u ad=2.8000e-12 pd=1.0560e-05 as=4.4000e-12 ps=1.5880e-05 nf=1 m=4 par=4
XMpar7 a_4090_14327.t0 a_1195_18491.t6 a_8306_8249.t0 vss.t0 nfet_03v3 w=1.54u l=0.6u ad=5.9547e-13 pd=2.8267e-06 as=4.3120e-13 ps=2.1000e-06 nf=1 m=6 par=6
XMpar8 a_8306_8249.t7 a_8306_8249.t6 vdd.t1 vdd.t0 pfet_03v3 w=10u l=2.7u ad=6.0000e-12 pd=2.1200e-05 as=2.8000e-12 ps=1.0560e-05 nf=1 m=2 par=2
XMpar9 ib.t1 ib.t0 vss.t7 vss.t0 nfet_03v3 w=4.81u l=1.88u ad=2.8860e-12 pd=1.0820e-05 as=1.3468e-12 ps=5.3700e-06 nf=1 m=2 par=2
XMpar10 a_4090_14327.t2 ib.t0 vss.t7 vss.t0 nfet_03v3 w=4.81u l=1.88u ad=1.3468e-12 pd=5.3700e-06 as=2.1164e-12 ps=8.0950e-06 nf=1 m=4 par=4
XMpar11 a_1195_18491.t1 a_1195_18491.t0 vdd.t1 vdd.t0 pfet_03v3 w=10u l=2.7u ad=2.8000e-12 pd=1.0560e-05 as=2.8000e-12 ps=1.0560e-05 nf=1 m=2 par=2
X135 out.t8 vss.t2 cap_mim_2f0fF c_width=15.52u c_length=15.51u
X145 out.t8 vss.t2 cap_mim_2f0fF c_width=15.52u c_length=15.51u
Rpar0 a_1195_18491.t0 a_1195_18491.t1 24.6087
Rpar1 a_1195_18491.t0 a_1195_18491.t6 969.1385
Rpar2 a_1195_18491.t0 a_1195_18491.t4 365.4683
Rpar3 a_1195_18491.t1 a_1195_18491.t6 342.7772
Rpar4 a_1195_18491.t1 a_1195_18491.t4 129.2635
Rpar5 a_1195_18491.t6 a_1195_18491.t4 75.4261
Rpar6 a_1735_18699.t0 a_1735_18699.t1 49.6993
Rpar7 a_4090_14327.t0 a_4090_14327.t6 127.0174
Rpar8 a_4090_14327.t0 a_4090_14327.t2 43.3626
Rpar9 a_4090_14327.t6 a_4090_14327.t2 82.9654
Rpar10 a_8306_8249.t0 a_8306_8249.t6 214.3385
Rpar11 a_8306_8249.t0 a_8306_8249.t7 46.1700
Rpar12 a_8306_8249.t6 a_8306_8249.t7 21.5009
Rpar13 a_9774_8249.t0 a_9774_8249.t8 127.0174
Rpar14 a_9774_8249.t0 a_9774_8249.t2 43.3626
Rpar15 a_9774_8249.t8 a_9774_8249.t2 82.9654
Rpar16 ib ib.t0 12.3746
Rpar17 ib ib.t1 3.6219
Rpar18 ib.t0 ib.t1 264.9178
Rpar19 inn inn.t0 1.8668
Rpar20 inp inp.t0 1.8668
Rpar21 out out.t0 3.5029
Rpar22 out out.t5 79.7408
Rpar23 out out.t8 91.3041
Rpar24 out.t5 out.t8 588.1478
Rpar25 vdd vdd.t0 73.4788
Rpar26 vdd vdd.t1 251.7991
Rpar27 vdd vdd.t4 50.1353
Rpar28 vdd.t0 vdd.t1 3.7402
Rpar29 vdd.t0 vdd.t4 44.4421
Rpar30 vdd.t1 vdd.t4 161.7154
Rpar31 vss vss.t0 87.8711
Rpar32 vss vss.t7 100.7137
Rpar33 vss vss.t2 55.0627
Rpar34 vss.t0 vss.t7 3.4006
Rpar35 vss.t0 vss.t2 336.1042
Rpar36 vss.t7 vss.t2 385.2269
Cpar0 a_1195_18491.t0 vss 1.86098e-14
Cpar1 a_1195_18491.t1 vss 4.75042e-15
Cpar2 a_1195_18491.t4 vss 3.65815e-15
Cpar3 a_1195_18491.t6 vss 4.60803e-15
Cpar4 a_1735_18699.t0 vss 1.19846e-14
Cpar5 a_1735_18699.t1 vss 8.86074e-14
Cpar6 a_4090_14327.t0 vss 4.41670e-15
Cpar7 a_4090_14327.t2 vss 8.24376e-15
Cpar8 a_4090_14327.t6 vss 5.08403e-14
Cpar9 a_8306_8249.t0 vss 1.85657e-15
Cpar10 a_8306_8249.t6 vss 1.32891e-14
Cpar11 a_8306_8249.t7 vss 5.94767e-15
Cpar12 a_9774_8249.t0 vss 4.17746e-15
Cpar13 a_9774_8249.t2 vss 7.79726e-15
Cpar14 a_9774_8249.t8 vss 4.80871e-14
Cpar15 ib out 1.65360e-16
Cpar16 ib vss 2.56728e-14
Cpar17 ib.t0 vss 4.66300e-15
Cpar18 ib.t1 vss 4.96132e-16
Cpar19 inn inp 9.95000e-17
Cpar20 inn vdd 2.81451e-14
Cpar21 inn vss 7.28959e-15
Cpar22 inn.t0 vss 4.19758e-14
Cpar23 inp out 2.30900e-17
Cpar24 inp vdd 2.77627e-14
Cpar25 inp vss 7.24884e-15
Cpar26 inp.t0 vss 4.17300e-14
Cpar27 out vdd 2.76331e-15
Cpar28 out vss 2.21697e-14
Cpar30 out.t5 vss 4.14721e-16
Cpar31 out.t8 vss 1.06754e-14
Cpar32 vdd vss 2.82107e-13
Cpar33 vdd.t0 vss 3.05815e-14
Cpar34 vdd.t1 vss 1.18382e-14
Cpar35 vdd.t4 vss 6.97671e-14
.ends opamp_dut

Vdd vdd 0 1.800000
Vss vss 0 0
Ibias vdd ib 1.888900e-06
Vinp inp 0 DC 0.751000 AC 1 PWL(0 0.751000 1.875405e-08 0.751000 2.062945e-08 0.761000)
Rfb out inn 1m
Cload out 0 2.000000e-13
Xdut vdd vss inp inn out ib opamp_dut
.end
