* opa1000[0260]: 200f/folded_cascode_pmos_1v8_i2u_weak (folded_cascode_pmos, VDD=1.8V, CL=0.2pF, Iref=0.4444uA)
.include "pdk_opa.inc"
.temp 27
.option gmin=1e-12 rshunt=1e12 reltol=1e-3 abstol=1e-12 vntol=1e-5 method=gear
* Post-PEX R+C extracted netlist for folded_cascode_pmos_1v8_i2u_weak
.subckt opamp_dut vdd vss inp inn out ib
XMpar0 a_1964_1249.t0 inn.t0 a_5614_3371.t0 vdd.t2 pfet_03v3 w=1.59u l=1.8u ad=6.9960e-13 pd=3.2650e-06 as=4.4520e-13 ps=2.1500e-06 nf=1 m=4 par=4
XMpar1 a_4012_4826.t1 a_4012_4826.t0 vdd.t1 vdd.t0 pfet_03v3 w=2.71u l=3.4u ad=1.6260e-12 pd=6.6200e-06 as=7.5880e-13 ps=3.2700e-06 nf=1 m=2 par=2
XMpar2 a_5614_3371.t4 ib.t0 vss.t2 vss.t1 nfet_03v3 w=0.56u l=2.6u ad=1.5680e-13 pd=1.1200e-06 as=2.4640e-13 ps=1.7200e-06 nf=1 m=4 par=4
XMpar3 out.t1 a_4012_4826.t0 vdd.t1 vdd.t0 pfet_03v3 w=2.71u l=3.4u ad=7.5880e-13 pd=3.2700e-06 as=7.5880e-13 ps=3.2700e-06 nf=1 m=2 par=2
XMpar4 a_1964_1249.t8 a_1284_1041.t2 vdd.t1 vdd.t0 pfet_03v3 w=2.71u l=3.4u ad=7.5880e-13 pd=3.2700e-06 as=1.1924e-12 ps=4.9450e-06 nf=1 m=4 par=4
XMpar5 ib.t1 ib.t0 vss.t2 vss.t1 nfet_03v3 w=0.56u l=2.6u ad=3.3600e-13 pd=2.3200e-06 as=1.5680e-13 ps=1.1200e-06 nf=1 m=2 par=2
XMpar6 a_3410_8732.t8 a_1284_1041.t10 a_4012_4826.t4 vss.t0 nfet_03v3 w=0.4u l=1.04u ad=2.4000e-13 pd=2.0000e-06 as=1.1200e-13 ps=9.6000e-07 nf=1 m=2 par=2
XMpar7 a_1964_1249.t0 inp.t0 a_3410_8732.t4 vdd.t2 pfet_03v3 w=1.59u l=1.8u ad=6.9960e-13 pd=3.2650e-06 as=4.4520e-13 ps=2.1500e-06 nf=1 m=4 par=4
XMpar8 a_5614_3371.t8 a_1284_1041.t10 out.t0 vss.t0 nfet_03v3 w=0.4u l=1.04u ad=2.4000e-13 pd=2.0000e-06 as=1.1200e-13 ps=9.6000e-07 nf=1 m=2 par=2
XMpar9 a_3410_8732.t0 ib.t0 vss.t2 vss.t1 nfet_03v3 w=0.56u l=2.6u ad=1.5680e-13 pd=1.1200e-06 as=2.4640e-13 ps=1.7200e-06 nf=1 m=4 par=4
XMpar10 a_1284_1041.t3 a_1284_1041.t2 vdd.t1 vdd.t0 pfet_03v3 w=2.71u l=3.4u ad=7.5880e-13 pd=3.2700e-06 as=7.5880e-13 ps=3.2700e-06 nf=1 m=2 par=2
XMpar11 a_1284_1041.t0 ib.t0 vss.t2 vss.t1 nfet_03v3 w=0.56u l=2.6u ad=1.5680e-13 pd=1.1200e-06 as=1.5680e-13 ps=1.1200e-06 nf=1 m=2 par=2
Rpar0 a_1284_1041.t0 a_1284_1041.t10 82.9042
Rpar1 a_1284_1041.t0 a_1284_1041.t2 177.3295
Rpar2 a_1284_1041.t0 a_1284_1041.t3 84.9319
Rpar3 a_1284_1041.t10 a_1284_1041.t2 172.9509
Rpar4 a_1284_1041.t10 a_1284_1041.t3 82.8348
Rpar5 a_1284_1041.t2 a_1284_1041.t3 25.3956
Rpar6 a_1964_1249.t0 a_1964_1249.t8 50.3899
Rpar7 a_3410_8732.t0 a_3410_8732.t4 88.6639
Rpar8 a_3410_8732.t0 a_3410_8732.t8 118.1138
Rpar9 a_3410_8732.t4 a_3410_8732.t8 75.0997
Rpar10 a_4012_4826.t0 a_4012_4826.t1 17.7398
Rpar11 a_4012_4826.t0 a_4012_4826.t4 189.1355
Rpar12 a_4012_4826.t1 a_4012_4826.t4 62.8503
Rpar13 a_5614_3371.t0 a_5614_3371.t4 88.6639
Rpar14 a_5614_3371.t0 a_5614_3371.t8 75.0997
Rpar15 a_5614_3371.t4 a_5614_3371.t8 118.1138
Rpar16 ib ib.t0 13.1180
Rpar17 ib ib.t1 8.3535
Rpar18 ib.t0 ib.t1 82.4909
Rpar19 inn inn.t0 2.7888
Rpar20 inp inp.t0 2.8374
Rpar21 out out.t0 13.8154
Rpar22 out out.t1 38.7575
Rpar23 vdd vdd.t0 193.6488
Rpar24 vdd vdd.t1 398.4421
Rpar25 vdd vdd.t2 47.7517
Rpar26 vdd.t0 vdd.t1 3.5767
Rpar27 vdd.t0 vdd.t2 64.9797
Rpar28 vdd.t1 vdd.t2 133.6989
Rpar29 vss vss.t0 111.8939
Rpar30 vss vss.t1 95.5001
Rpar31 vss vss.t2 94.1353
Rpar32 vss.t0 vss.t1 111.0891
Rpar33 vss.t0 vss.t2 52.3620
Rpar34 vss.t1 vss.t2 7.4739
Cpar0 a_1284_1041.t0 vss 1.57504e-15
Cpar1 a_1284_1041.t10 vss 2.73610e-15
Cpar2 a_1284_1041.t2 vss 1.53460e-14
Cpar3 a_1284_1041.t3 vss 2.85517e-15
Cpar4 a_1964_1249.t0 vss 8.37166e-15
Cpar5 a_1964_1249.t8 vss 8.21360e-15
Cpar6 a_3410_8732.t0 vss 3.04722e-15
Cpar7 a_3410_8732.t4 vss 3.18253e-15
Cpar8 a_3410_8732.t8 vss 2.33825e-15
Cpar9 a_4012_4826.t0 vss 9.81252e-15
Cpar10 a_4012_4826.t1 vss 3.87779e-15
Cpar11 a_4012_4826.t4 vss 1.08067e-15
Cpar12 a_5614_3371.t0 vss 3.17916e-15
Cpar13 a_5614_3371.t4 vss 3.04400e-15
Cpar14 a_5614_3371.t8 vss 2.33577e-15
Cpar15 ib inn 1.35000e-17
Cpar16 ib vdd 3.38270e-16
Cpar17 ib vss 2.59826e-14
Cpar18 ib.t0 vss 3.72595e-15
Cpar19 ib.t1 vss 1.52984e-16
Cpar20 inn inp 5.14200e-17
Cpar21 inn vdd 4.06110e-15
Cpar22 inn vss 2.27662e-15
Cpar23 inn.t0 vss 3.17310e-15
Cpar24 inp vdd 4.18965e-15
Cpar25 inp vss 2.31712e-15
Cpar26 inp.t0 vss 3.26204e-15
Cpar27 out vdd 2.46610e-15
Cpar28 out vss 4.10433e-15
Cpar29 out.t0 vss 1.24724e-16
Cpar30 out.t1 vss 3.59691e-15
Cpar31 vdd vss 9.88540e-14
Cpar32 vdd.t0 vss 2.13489e-14
Cpar33 vdd.t1 vss 1.05346e-14
Cpar34 vdd.t2 vss 1.19451e-14
.ends opamp_dut

Vdd vdd 0 1.800000
Vss vss 0 0
Ibias vdd ib 4.444000e-07
Vinp inp 0 DC 0.751000 AC 1 PWL(0 0.751000 2.259932e-08 0.751000 2.485925e-08 0.761000)
Rfb out inn 1m
Cload out 0 2.000000e-13
Xdut vdd vss inp inn out ib opamp_dut
.end
