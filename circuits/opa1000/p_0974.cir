* opa1000[0974]: 2p/telescopic_pmos_1v8_i20u_subth (telescopic_pmos, VDD=1.8V, CL=2.0pF, Iref=2.8uA)
.include "pdk_opa.inc"
.temp 27
.option gmin=1e-12 rshunt=1e12 reltol=1e-3 abstol=1e-12 vntol=1e-5 method=gear
* Post-PEX R+C extracted netlist for telescopic_pmos_1v8_i20u_subth
.subckt opamp_dut vdd vss inp inn out ib
XMpar0 a_4134_12159.t0 a_4697_17025.t2 vdd.t1 vdd.t0 pfet_03v3 w=10u l=1.5u ad=2.8000e-12 pd=1.0560e-05 as=3.6000e-12 ps=1.3220e-05 nf=1 m=8 par=8
XMpar1 a_3034_6824.t0 inp.t0 a_4134_12159.t1 vdd.t2 pfet_03v3 w=3.39u l=0.65u ad=9.8310e-13 pd=4.0759e-06 as=1.0170e-12 ps=4.2019e-06 nf=1 m=64 par=64
XMpar2 a_3055_4742.t0 a_3175_4534.t0 out.t32 vss.t0 nfet_03v3 w=1.93u l=0.9u ad=5.9655e-13 pd=2.7236e-06 as=5.9655e-13 ps=2.7236e-06 nf=1 m=22 par=22
XMpar3 a_4134_12159.t1 inn.t0 a_9774_6824.t0 vdd.t2 pfet_03v3 w=3.39u l=0.65u ad=1.0170e-12 pd=4.2019e-06 as=9.8310e-13 ps=4.0759e-06 nf=1 m=64 par=64
XMpar4 a_9774_6824.t64 vss.t71 out.t0 vdd.t96 pfet_03v3 w=4.17u l=0.9u ad=1.2510e-12 pd=5.0306e-06 as=1.2093e-12 ps=4.8803e-06 nf=1 m=64 par=64
XMpar5 a_6544_4742.t11 a_3175_4534.t108 vss.t27 vss.t0 nfet_03v3 w=1.92u l=1.35u ad=7.4240e-13 pd=3.3333e-06 as=5.3760e-13 ps=2.4800e-06 nf=1 m=6 par=6
XMpar6 a_3175_4534.t1 a_3175_4534.t0 a_6544_4742.t0 vss.t0 nfet_03v3 w=1.93u l=0.9u ad=5.4040e-13 pd=2.4900e-06 as=5.9655e-13 ps=2.7236e-06 nf=1 m=22 par=22
XMpar7 a_3034_6824.t64 vss.t71 a_3175_4534.t44 vdd.t96 pfet_03v3 w=4.17u l=0.9u ad=1.2510e-12 pd=5.0306e-06 as=1.2093e-12 ps=4.8803e-06 nf=1 m=64 par=64
XMpar8 a_3055_4742.t6 a_3175_4534.t108 vss.t27 vss.t0 nfet_03v3 w=1.92u l=1.35u ad=7.4240e-13 pd=3.3333e-06 as=5.3760e-13 ps=2.4800e-06 nf=1 m=6 par=6
XMpar9 a_4697_17025.t0 ib.t0 vss.t11 vss.t10 nfet_03v3 w=5.55u l=1.5u ad=1.5540e-12 pd=6.1100e-06 as=1.5540e-12 ps=6.1100e-06 nf=1 m=2 par=2
XMpar10 a_4697_17025.t3 a_4697_17025.t2 vdd.t1 vdd.t0 pfet_03v3 w=10u l=1.5u ad=2.8000e-12 pd=1.0560e-05 as=2.8000e-12 ps=1.0560e-05 nf=1 m=2 par=2
XMpar11 ib.t1 ib.t0 vss.t11 vss.t10 nfet_03v3 w=5.55u l=1.5u ad=3.3300e-12 pd=1.2300e-05 as=1.5540e-12 ps=6.1100e-06 nf=1 m=2 par=2
X264 out.t86 vss.t2 cap_mim_2f0fF c_width=7.75u c_length=7.75u
Rpar0 a_3034_6824.t0 a_3034_6824.t64 47.8852
Rpar1 a_3055_4742.t0 a_3055_4742.t6 60.1311
Rpar2 a_3175_4534.t0 a_3175_4534.t1 18.3182
Rpar3 a_3175_4534.t0 a_3175_4534.t44 207.1154
Rpar4 a_3175_4534.t0 a_3175_4534.t108 396.0875
Rpar5 a_3175_4534.t1 a_3175_4534.t44 104.7723
Rpar6 a_3175_4534.t1 a_3175_4534.t108 200.3664
Rpar7 a_3175_4534.t44 a_3175_4534.t108 195.5143
Rpar8 a_4134_12159.t0 a_4134_12159.t1 59.3504
Rpar9 a_4697_17025.t0 a_4697_17025.t2 117.7886
Rpar10 a_4697_17025.t0 a_4697_17025.t3 64.0853
Rpar11 a_4697_17025.t2 a_4697_17025.t3 26.6062
Rpar12 a_6544_4742.t0 a_6544_4742.t11 54.3518
Rpar13 a_9774_6824.t0 a_9774_6824.t64 47.8852
Rpar14 ib ib.t0 16.2474
Rpar15 ib ib.t1 3.4552
Rpar16 inn inn.t0 2.0870
Rpar17 inp inp.t0 2.0870
Rpar18 out out.t0 61.0518
Rpar19 out out.t32 2.0634
Rpar20 out out.t86 117.5155
Rpar21 out.t0 out.t86 324.6158
Rpar22 vdd vdd.t0 29.5550
Rpar23 vdd vdd.t1 159.7665
Rpar24 vdd vdd.t2 90.8008
Rpar25 vdd vdd.t96 499.9902
Rpar26 vdd.t0 vdd.t1 5.8377
Rpar27 vdd.t0 vdd.t2 49.6705
Rpar28 vdd.t0 vdd.t96 273.5079
Rpar29 vdd.t1 vdd.t2 268.5056
Rpar30 vdd.t1 vdd.t96 1478.5128
Rpar31 vdd.t2 vdd.t96 58.8545
Rpar32 vss vss.t0 101.6068
Rpar33 vss vss.t10 1167.8704
Rpar34 vss vss.t71 235.1177
Rpar35 vss vss.t11 1523.3364
Rpar36 vss vss.t2 78.2413
Rpar37 vss vss.t27 146.8993
Rpar38 vss.t0 vss.t10 533.2880
Rpar39 vss.t0 vss.t71 110.4940
Rpar40 vss.t0 vss.t11 699.2563
Rpar41 vss.t0 vss.t2 203.1790
Rpar42 vss.t0 vss.t27 11.8155
Rpar43 vss.t10 vss.t71 144.2897
Rpar44 vss.t10 vss.t11 9.2097
Rpar45 vss.t10 vss.t2 2335.3434
Rpar46 vss.t71 vss.t11 188.1715
Rpar47 vss.t71 vss.t2 470.1553
Rpar48 vss.t71 vss.t27 848.9645
Rpar49 vss.t11 vss.t2 3046.1546
Rpar50 vss.t2 vss.t27 293.7487
Cpar0 a_3034_6824.t0 vss 4.80152e-14
Cpar1 a_3034_6824.t64 vss 5.63183e-14
Cpar2 a_3055_4742.t0 vss 1.81286e-14
Cpar3 a_3055_4742.t6 vss 1.12357e-14
Cpar4 a_3175_4534.t0 vss 2.07677e-14
Cpar5 a_3175_4534.t1 vss 1.03572e-14
Cpar6 a_3175_4534.t108 vss 1.03714e-14
Cpar7 a_3175_4534.t44 vss 3.39547e-14
Cpar8 a_4134_12159.t0 vss 1.94449e-14
Cpar9 a_4134_12159.t1 vss 1.01731e-13
Cpar10 a_4697_17025.t0 vss 2.24414e-15
Cpar11 a_4697_17025.t2 vss 1.97831e-14
Cpar12 a_4697_17025.t3 vss 3.94570e-15
Cpar13 a_6544_4742.t0 vss 1.85349e-14
Cpar14 a_6544_4742.t11 vss 1.04491e-14
Cpar15 a_9774_6824.t0 vss 4.83781e-14
Cpar16 a_9774_6824.t64 vss 5.67441e-14
Cpar17 ib vdd 3.15000e-17
Cpar18 ib vss 9.31400e-15
Cpar19 ib.t0 vss 8.86899e-16
Cpar20 ib.t1 vss 3.50090e-16
Cpar21 inn inp 1.00620e-16
Cpar22 inn out 1.11100e-17
Cpar23 inn vdd 2.69867e-14
Cpar24 inn vss 7.62439e-15
Cpar25 inn.t0 vss 4.15783e-14
Cpar26 inp vdd 2.66197e-14
Cpar27 inp vss 7.58229e-15
Cpar28 inp.t0 vss 4.12803e-14
Cpar29 out vdd 9.59576e-15
Cpar30 out vss 3.77684e-14
Cpar31 out.t0 vss 4.07776e-14
Cpar32 out.t32 vss 8.85153e-15
Cpar33 out.t86 vss 2.13006e-14
Cpar34 vdd vss 5.47805e-13
Cpar35 vdd.t0 vss 1.19913e-14
Cpar36 vdd.t1 vss 5.05686e-15
Cpar37 vdd.t2 vss 4.74879e-14
Cpar38 vdd.t96 vss 6.05714e-14
.ends opamp_dut

Vdd vdd 0 1.800000
Vss vss 0 0
Ibias vdd ib 2.800000e-06
Vinp inp 0 DC 0.805000 AC 1 PWL(0 0.805000 1.333015e-08 0.805000 1.466316e-08 0.815000)
Rfb out inn 1m
Cload out 0 2.000000e-12
Xdut vdd vss inp inn out ib opamp_dut
.end
