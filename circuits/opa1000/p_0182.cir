* opa1000[0182]: 200f/folded_cascode_nmos_1v8_10u_100u_weak (folded_cascode_nmos, VDD=1.8V, CL=0.2pF, Iref=7.7778uA)
.include "pdk_opa.inc"
.temp 27
.option gmin=1e-12 rshunt=1e12 reltol=1e-3 abstol=1e-12 vntol=1e-5 method=gear
* Post-PEX R+C extracted netlist for folded_cascode_nmos_1v8_10u_100u_weak
.subckt opamp_dut vdd vss inp inn out ib
XMpar0 a_3930_5169.t7 ib.t10 a_4136_5169.t0 vdd.t2 pfet_03v3 w=1.91u l=0.28u ad=1.0250e-12 pd=3.6200e-06 as=8.2130e-13 ps=2.7700e-06 nf=1 m=6 par=6
XMpar1 a_5614_5169.t6 ib.t10 out.t0 vdd.t2 pfet_03v3 w=1.91u l=0.28u ad=1.0250e-12 pd=3.6200e-06 as=8.2130e-13 ps=2.7700e-06 nf=1 m=6 par=6
XMpar2 a_3930_5169.t6 a_1200_4961.t2 vdd.t1 vdd.t0 pfet_03v3 w=9.81u l=0.8u ad=2.7468e-12 pd=1.0370e-05 as=4.3164e-12 ps=1.5595e-05 nf=1 m=4 par=4
XMpar3 a_1764_3087.t12 ib.t0 vss.t1 vss.t0 nfet_03v3 w=1.93u l=0.6u ad=5.4040e-13 pd=2.4900e-06 as=5.4040e-13 ps=2.4900e-06 nf=1 m=4 par=4
XMpar4 a_1764_3087.t0 inn.t0 a_5614_5169.t0 vss.t2 nfet_03v3 w=1.64u l=0.35u ad=6.3413e-13 pd=2.9600e-06 as=4.5920e-13 ps=2.2000e-06 nf=1 m=6 par=6
XMpar5 ib.t1 ib.t0 vss.t1 vss.t0 nfet_03v3 w=1.93u l=0.6u ad=1.1580e-12 pd=5.0600e-06 as=5.4040e-13 ps=2.4900e-06 nf=1 m=2 par=2
XMpar6 a_5614_5169.t12 a_1200_4961.t2 vdd.t1 vdd.t0 pfet_03v3 w=9.81u l=0.8u ad=2.7468e-12 pd=1.0370e-05 as=4.3164e-12 ps=1.5595e-05 nf=1 m=4 par=4
XMpar7 a_1764_3087.t0 inp.t0 a_3930_5169.t0 vss.t2 nfet_03v3 w=1.64u l=0.35u ad=6.3413e-13 pd=2.9600e-06 as=4.5920e-13 ps=2.2000e-06 nf=1 m=6 par=6
XMpar8 a_1200_4961.t3 a_1200_4961.t2 vdd.t1 vdd.t0 pfet_03v3 w=9.81u l=0.8u ad=2.7468e-12 pd=1.0370e-05 as=5.8860e-12 ps=2.0820e-05 nf=1 m=2 par=2
XMpar9 a_1200_4961.t0 ib.t0 vss.t1 vss.t0 nfet_03v3 w=1.93u l=0.6u ad=5.4040e-13 pd=2.4900e-06 as=5.4040e-13 ps=2.4900e-06 nf=1 m=2 par=2
XMpar10 out.t1 a_4136_5169.t6 vss.t1 vss.t0 nfet_03v3 w=1.93u l=0.6u ad=5.4040e-13 pd=2.4900e-06 as=5.4040e-13 ps=2.4900e-06 nf=1 m=2 par=2
XMpar11 a_4136_5169.t7 a_4136_5169.t6 vss.t1 vss.t0 nfet_03v3 w=1.93u l=0.6u ad=1.1580e-12 pd=5.0600e-06 as=5.4040e-13 ps=2.4900e-06 nf=1 m=2 par=2
Rpar0 a_1200_4961.t0 a_1200_4961.t2 143.1033
Rpar1 a_1200_4961.t0 a_1200_4961.t3 83.6059
Rpar2 a_1200_4961.t2 a_1200_4961.t3 33.0510
Rpar3 a_1764_3087.t0 a_1764_3087.t12 65.7748
Rpar4 a_3930_5169.t0 a_3930_5169.t7 147.6177
Rpar5 a_3930_5169.t0 a_3930_5169.t6 156.1286
Rpar6 a_3930_5169.t7 a_3930_5169.t6 88.0839
Rpar7 a_4136_5169.t0 a_4136_5169.t6 449.0007
Rpar8 a_4136_5169.t0 a_4136_5169.t7 97.5892
Rpar9 a_4136_5169.t6 a_4136_5169.t7 25.3574
Rpar10 a_5614_5169.t0 a_5614_5169.t6 42.5510
Rpar11 a_5614_5169.t0 a_5614_5169.t12 220.6258
Rpar12 a_5614_5169.t6 a_5614_5169.t12 108.8352
Rpar13 ib ib.t0 14.5094
Rpar14 ib ib.t1 4.9995
Rpar15 ib ib.t10 42.1293
Rpar16 ib.t1 ib.t10 228.2503
Rpar17 inn inn.t0 8.4734
Rpar18 inp inp.t0 8.5220
Rpar19 out out.t0 3.4334
Rpar20 out out.t1 49.9302
Rpar21 vdd vdd.t0 115.3181
Rpar22 vdd vdd.t1 41.2531
Rpar23 vdd vdd.t2 69.4792
Rpar24 vdd.t0 vdd.t1 4.5439
Rpar25 vdd.t0 vdd.t2 132.6193
Rpar26 vdd.t1 vdd.t2 71.5953
Rpar27 vss vss.t0 96.0363
Rpar28 vss vss.t1 126.1442
Rpar29 vss vss.t2 99.7004
Rpar30 vss.t0 vss.t1 5.4579
Rpar31 vss.t0 vss.t2 3.0886
Rpar32 vss.t1 vss.t2 8.3628
Cpar0 a_1200_4961.t0 vss 2.36144e-15
Cpar1 a_1200_4961.t2 vss 1.25005e-14
Cpar2 a_1200_4961.t3 vss 4.57048e-15
Cpar3 a_1764_3087.t0 vss 6.00769e-15
Cpar4 a_1764_3087.t12 vss 5.15630e-15
Cpar5 a_3930_5169.t0 vss 4.67307e-15
Cpar6 a_3930_5169.t6 vss 8.91860e-15
Cpar7 a_3930_5169.t7 vss 6.40731e-15
Cpar8 a_4136_5169.t0 vss 4.43191e-15
Cpar9 a_4136_5169.t6 vss 1.84342e-15
Cpar10 a_4136_5169.t7 vss 3.21976e-15
Cpar11 a_5614_5169.t0 vss 2.86603e-15
Cpar12 a_5614_5169.t12 vss 8.54165e-15
Cpar13 a_5614_5169.t6 vss 5.81794e-15
Cpar14 ib out 3.82170e-16
Cpar15 ib vdd 5.70501e-15
Cpar16 ib vss 1.14037e-14
Cpar17 ib.t0 vss 2.77658e-15
Cpar18 ib.t1 vss 8.57751e-16
Cpar19 ib.t10 vss 3.59093e-15
Cpar20 inn inp 5.13600e-17
Cpar21 inn vss 3.04680e-15
Cpar22 inn.t0 vss 3.42769e-16
Cpar23 inp vss 3.02932e-15
Cpar24 inp.t0 vss 3.48611e-16
Cpar25 out vdd 1.44924e-15
Cpar26 out vss 5.76967e-15
Cpar27 out.t0 vss 2.26543e-15
Cpar28 out.t1 vss 2.76931e-15
Cpar29 vdd vss 7.71655e-14
Cpar30 vdd.t0 vss 1.40497e-14
Cpar31 vdd.t1 vss 1.16568e-14
Cpar32 vdd.t2 vss 8.54077e-15
.ends opamp_dut

Vdd vdd 0 1.800000
Vss vss 0 0
Ibias vdd ib 7.777800e-06
Vinp inp 0 DC 0.985000 AC 1 PWL(0 0.985000 3.000000e-09 0.985000 3.300000e-09 0.995000)
Rfb out inn 1m
Cload out 0 2.000000e-13
Xdut vdd vss inp inn out ib opamp_dut
.end
