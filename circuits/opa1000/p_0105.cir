* opa1000[0105]: 200f/current_reuse_3v3_i50n_subth (current_reuse, VDD=3.3V, CL=0.2pF, Iref=0.0061uA)
.include "pdk_opa.inc"
.temp 27
.option gmin=1e-12 rshunt=1e12 reltol=1e-3 abstol=1e-12 vntol=1e-5 method=gear
* Post-PEX R+C extracted netlist for current_reuse_3v3_i50n_subth
.subckt opamp_dut vdd vss inp inn out ib
XMpar0 out.t10 ib.t0 vss.t14 vss.t13 nfet_03v3 w=0.4u l=5u ad=1.8880e-13 pd=1.5840e-06 as=1.6320e-13 ps=1.3760e-06 nf=1 m=10 par=10
XMpar1 a_7765_9456.t2 inn.t0 a_7926_1294.t0 vss.t4 nfet_03v3 w=0.4u l=5.5u ad=2.4000e-13 pd=2.0000e-06 as=2.4000e-13 ps=2.0000e-06 nf=1 m=2 par=2
XMpar2 a_6714_11407.t2 a_7765_9456.t4 vdd.t3 vdd.t2 pfet_03v3 w=0.4u l=5u ad=1.1200e-13 pd=9.6000e-07 as=2.4000e-13 ps=2.0000e-06 nf=1 m=2 par=2
XMpar3 a_7926_1294.t4 ib.t0 vss.t14 vss.t13 nfet_03v3 w=0.4u l=5u ad=2.4000e-13 pd=2.0000e-06 as=1.1200e-13 ps=9.6000e-07 nf=1 m=4 par=4
XMpar4 out.t0 a_1114_3667.t6 vdd.t3 vdd.t2 pfet_03v3 w=0.4u l=5u ad=1.3760e-13 pd=1.1680e-06 as=1.3760e-13 ps=1.1680e-06 nf=1 m=10 par=10
XMpar5 a_1114_3667.t1 inp.t2 a_6714_11407.t0 vdd.t0 pfet_03v3 w=0.62u l=5.5u ad=1.7360e-13 pd=1.1800e-06 as=3.7200e-13 ps=2.4400e-06 nf=1 m=2 par=2
XMpar6 ib.t1 ib.t0 vss.t14 vss.t13 nfet_03v3 w=0.4u l=5u ad=2.4000e-13 pd=2.0000e-06 as=1.1200e-13 ps=9.6000e-07 nf=1 m=2 par=2
XMpar7 a_1114_3667.t5 a_7765_9456.t4 vdd.t3 vdd.t2 pfet_03v3 w=0.4u l=5u ad=2.4000e-13 pd=2.0000e-06 as=1.1200e-13 ps=9.6000e-07 nf=1 m=1
XMpar8 a_7765_9456.t5 a_7765_9456.t4 vdd.t3 vdd.t2 pfet_03v3 w=0.4u l=5u ad=2.4000e-13 pd=2.0000e-06 as=1.1200e-13 ps=9.6000e-07 nf=1 m=1
XMpar9 a_1114_3667.t3 inp.t0 a_7926_1294.t0 vss.t4 nfet_03v3 w=0.4u l=5.5u ad=2.4000e-13 pd=2.0000e-06 as=2.4000e-13 ps=2.0000e-06 nf=1 m=2 par=2
XMpar10 a_6714_11407.t0 inn.t2 a_7765_9456.t0 vdd.t0 pfet_03v3 w=0.62u l=5.5u ad=3.7200e-13 pd=2.4400e-06 as=1.7360e-13 ps=1.1800e-06 nf=1 m=2 par=2
X5 a_1114_4187.t0 a_5092_3667.t0 vss.t0 ppolyf_u_1k r_width=1u r_length=19.23u
X10 a_1114_6267.t0 a_5092_6787.t0 vss.t0 ppolyf_u_1k r_width=1u r_length=19.23u
X12 a_1114_3667.t0 a_5092_3667.t0 vss.t0 ppolyf_u_1k r_width=1u r_length=19.23u
X18 a_1114_9387.t0 a_5092_8867.t0 vss.t0 ppolyf_u_1k r_width=1u r_length=19.23u
X19 a_1114_6267.t0 a_5092_5747.t0 vss.t0 ppolyf_u_1k r_width=1u r_length=19.23u
X25 a_1114_8347.t0 a_5092_8867.t0 vss.t0 ppolyf_u_1k r_width=1u r_length=19.23u
X27 a_1114_5227.t0 a_5092_5747.t0 vss.t0 ppolyf_u_1k r_width=1u r_length=19.23u
X32 a_1114_8347.t0 a_5092_7827.t0 vss.t0 ppolyf_u_1k r_width=1u r_length=19.23u
X35 a_1114_5227.t0 a_5092_4707.t0 vss.t0 ppolyf_u_1k r_width=1u r_length=19.23u
X37 a_5092_9907.t1 out.t6 cap_mim_2f0fF c_width=15u c_length=15u
X39 a_1114_7307.t0 a_5092_7827.t0 vss.t0 ppolyf_u_1k r_width=1u r_length=19.23u
X42 a_1114_4187.t0 a_5092_4707.t0 vss.t0 ppolyf_u_1k r_width=1u r_length=19.23u
X47 a_1114_7307.t0 a_5092_6787.t0 vss.t0 ppolyf_u_1k r_width=1u r_length=19.23u
X51 a_1114_9387.t0 a_5092_9907.t0 vss.t0 ppolyf_u_1k r_width=1u r_length=19.23u
Rpar0 a_1114_3667.t0 a_1114_3667.t1 548.5234
Rpar1 a_1114_3667.t0 a_1114_3667.t6 105.0182
Rpar2 a_1114_3667.t0 a_1114_3667.t3 113.7941
Rpar3 a_1114_3667.t0 a_1114_3667.t5 811.5762
Rpar4 a_1114_3667.t1 a_1114_3667.t6 97.6452
Rpar5 a_1114_3667.t1 a_1114_3667.t3 497.5483
Rpar6 a_1114_3667.t1 a_1114_3667.t5 108.9156
Rpar7 a_1114_3667.t6 a_1114_3667.t3 95.2587
Rpar8 a_1114_3667.t6 a_1114_3667.t5 144.4724
Rpar9 a_1114_3667.t3 a_1114_3667.t5 736.1551
Rpar10 a_5092_9907.t0 a_5092_9907.t1 81.7901
Rpar11 a_6714_11407.t0 a_6714_11407.t2 57.6529
Rpar12 a_7765_9456.t0 a_7765_9456.t2 173.8662
Rpar13 a_7765_9456.t0 a_7765_9456.t4 70.5497
Rpar14 a_7765_9456.t0 a_7765_9456.t5 175.0771
Rpar15 a_7765_9456.t2 a_7765_9456.t4 174.0916
Rpar16 a_7765_9456.t2 a_7765_9456.t5 581.1661
Rpar17 a_7765_9456.t4 a_7765_9456.t5 32.6960
Rpar18 a_7926_1294.t0 a_7926_1294.t4 62.7231
Rpar19 ib ib.t0 16.4424
Rpar20 ib ib.t1 15.2949
Rpar21 ib.t0 ib.t1 34.2079
Rpar22 inn inn.t0 4.3097
Rpar23 inn inn.t2 68.9578
Rpar24 inp inp.t0 4.3104
Rpar25 inp inp.t2 87.2890
Rpar26 out out.t0 5.4350
Rpar27 out out.t10 67.6639
Rpar28 out out.t6 69.7074
Rpar29 out.t10 out.t6 96.1055
Rpar30 vdd vdd.t0 148.3322
Rpar31 vdd vdd.t2 37.2487
Rpar32 vdd vdd.t3 74.9081
Rpar33 vdd.t0 vdd.t2 60.8115
Rpar34 vdd.t0 vdd.t3 167.0274
Rpar35 vdd.t2 vdd.t3 6.3284
Rpar36 vss vss.t0 90.9289
Rpar37 vss vss.t13 69.0412
Rpar38 vss vss.t14 156.7981
Rpar39 vss vss.t4 411.4962
Rpar40 vss.t0 vss.t13 53.8360
Rpar41 vss.t0 vss.t14 163.3151
Rpar42 vss.t0 vss.t4 319.9723
Rpar43 vss.t13 vss.t14 13.0911
Rpar44 vss.t13 vss.t4 7.7519
Rpar45 vss.t14 vss.t4 77.5069
Cpar0 a_1114_3667.t0 vss 3.65019e-15
Cpar1 a_1114_3667.t1 vss 3.29229e-15
Cpar2 a_1114_3667.t3 vss 4.34844e-15
Cpar3 a_1114_3667.t5 vss 2.91801e-15
Cpar4 a_1114_3667.t6 vss 2.66859e-14
Cpar5 a_1114_4187.t0 vss 3.70200e-17
Cpar6 a_1114_5227.t0 vss 3.43400e-17
Cpar7 a_1114_6267.t0 vss 3.43400e-17
Cpar8 a_1114_7307.t0 vss 3.43400e-17
Cpar9 a_1114_8347.t0 vss 3.50800e-17
Cpar10 a_1114_9387.t0 vss 3.47200e-17
Cpar11 a_5092_3667.t0 vss 3.54200e-17
Cpar12 a_5092_4707.t0 vss 3.83000e-17
Cpar13 a_5092_5747.t0 vss 3.41000e-17
Cpar14 a_5092_6787.t0 vss 3.52400e-17
Cpar15 a_5092_7827.t0 vss 3.86600e-17
Cpar16 a_5092_8867.t0 vss 3.94600e-17
Cpar17 a_5092_9907.t0 vss 4.30820e-16
Cpar18 a_5092_9907.t1 vss 6.64405e-15
Cpar19 a_6714_11407.t0 vss 6.69890e-15
Cpar20 a_6714_11407.t2 vss 3.24586e-15
Cpar21 a_7765_9456.t0 vss 5.88729e-15
Cpar22 a_7765_9456.t2 vss 8.91289e-15
Cpar23 a_7765_9456.t4 vss 1.57114e-14
Cpar24 a_7765_9456.t5 vss 2.76539e-15
Cpar25 a_7926_1294.t0 vss 9.21903e-15
Cpar26 a_7926_1294.t4 vss 1.72288e-14
Cpar27 ib inn 3.57800e-17
Cpar28 ib inp 1.05200e-17
Cpar29 ib out 2.37293e-15
Cpar30 ib vdd 1.55200e-17
Cpar31 ib vss 5.72030e-14
Cpar32 ib.t0 vss 9.57121e-15
Cpar33 ib.t1 vss 7.30221e-16
Cpar34 inn inp 1.55800e-16
Cpar35 inn out 4.74580e-16
Cpar36 inn vdd 5.39123e-15
Cpar37 inn vss 1.61047e-14
Cpar38 inn.t0 vss 2.06938e-15
Cpar39 inn.t2 vss 6.70554e-15
Cpar40 inp vdd 5.28714e-15
Cpar41 inp vss 1.66993e-14
Cpar42 inp.t0 vss 1.22816e-15
Cpar43 inp.t2 vss 4.66673e-15
Cpar44 out vdd 1.45477e-14
Cpar45 out vss 2.48034e-14
Cpar46 out.t0 vss 3.76287e-15
Cpar47 out.t10 vss 1.08398e-14
Cpar48 out.t6 vss 1.05005e-14
Cpar49 vdd vss 1.21262e-13
Cpar50 vdd.t0 vss 1.30823e-14
Cpar51 vdd.t2 vss 4.02777e-14
Cpar52 vdd.t3 vss 1.26779e-14
.ends opamp_dut

Vdd vdd 0 3.300000
Vss vss 0 0
Ibias vdd ib 6.100000e-09
Vinp inp 0 DC 1.645000 AC 1 PWL(0 1.645000 1.409680e-06 1.645000 1.550648e-06 1.655000)
Rfb out inn 1m
Cload out 0 2.000000e-13
Xdut vdd vss inp inn out ib opamp_dut
.end
