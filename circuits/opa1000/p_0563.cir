* opa1000[0563]: 2p/pmos_5t_1v8_i500u_weak (pmos_5t, VDD=1.8V, CL=2.0pF, Iref=130.0uA)
.include "pdk_opa.inc"
.temp 27
.option gmin=1e-12 rshunt=1e12 reltol=1e-3 abstol=1e-12 vntol=1e-5 method=gear
* Post-PEX R+C extracted netlist for pmos_5t_1v8_i500u_weak
.subckt opamp_dut vdd vss inp inn out ib
XMpar0 a_1561_6606.t0 inp.t0 a_3410_11843.t108 vdd.t50 pfet_03v3 w=7.43u l=0.36u ad=2.1993e-12 pd=8.3935e-06 as=2.0804e-12 ps=7.9900e-06 nf=1 m=160 par=160
XMpar1 a_1561_6606.t0 inn.t0 out.t0 vdd.t50 pfet_03v3 w=7.43u l=0.36u ad=2.1993e-12 pd=8.3935e-06 as=2.0804e-12 ps=7.9900e-06 nf=1 m=160 par=160
XMpar2 a_1561_6606.t320 a_1491_6397.t16 vdd.t1 vdd.t0 pfet_03v3 w=7.91u l=0.35u ad=2.2148e-12 pd=8.4700e-06 as=2.2939e-12 ps=8.7372e-06 nf=1 m=64 par=64
XMpar3 a_3410_11843.t1 a_3410_11843.t0 vss.t1 vss.t0 nfet_03v3 w=1.95u l=0.63u ad=5.4600e-13 pd=2.5100e-06 as=5.4600e-13 ps=2.5100e-06 nf=1 m=54 par=54
XMpar4 out.t70 a_3410_11843.t0 vss.t1 vss.t0 nfet_03v3 w=1.95u l=0.63u ad=6.1533e-13 pd=2.7978e-06 as=5.4600e-13 ps=2.5100e-06 nf=1 m=54 par=54
XMpar5 ib.t1 ib.t0 vss.t14 vss.t13 nfet_03v3 w=2.47u l=0.35u ad=6.9160e-13 pd=3.0300e-06 as=7.9040e-13 ps=3.4187e-06 nf=1 m=16 par=16
XMpar6 a_1491_6397.t0 ib.t0 vss.t14 vss.t13 nfet_03v3 w=2.47u l=0.35u ad=6.9160e-13 pd=3.0300e-06 as=6.9160e-13 ps=3.0300e-06 nf=1 m=16 par=16
XMpar7 a_1491_6397.t17 a_1491_6397.t16 vdd.t1 vdd.t0 pfet_03v3 w=7.91u l=0.35u ad=2.2148e-12 pd=8.4700e-06 as=2.2148e-12 ps=8.4700e-06 nf=1 m=16 par=16
X448 out.t214 vss.t4 cap_mim_2f0fF c_width=17.43u c_length=17.43u
Rpar0 a_1491_6397.t0 a_1491_6397.t16 117.3789
Rpar1 a_1491_6397.t0 a_1491_6397.t17 33.3669
Rpar2 a_1491_6397.t16 a_1491_6397.t17 18.4292
Rpar3 a_1561_6606.t0 a_1561_6606.t320 68.1771
Rpar4 a_3410_11843.t0 a_3410_11843.t1 4.8372
Rpar5 a_3410_11843.t0 a_3410_11843.t108 311.3030
Rpar6 a_3410_11843.t1 a_3410_11843.t108 85.8368
Rpar7 ib ib.t0 12.1376
Rpar8 ib ib.t1 2.0209
Rpar9 inn inn.t0 2.3597
Rpar10 inp inp.t0 2.3597
Rpar11 out out.t0 8372.5183
Rpar12 out out.t70 2.4933
Rpar13 out out.t214 7236.6583
Rpar14 out.t0 out.t70 109.7214
Rpar15 out.t0 out.t214 71.3938
Rpar16 out.t70 out.t214 94.8360
Rpar17 vdd vdd.t0 202.3563
Rpar18 vdd vdd.t50 20.2423
Rpar19 vdd.t0 vdd.t1 2.4220
Rpar20 vdd.t0 vdd.t50 72.2114
Rpar21 vdd.t1 vdd.t50 1581.8941
Rpar22 vss vss.t0 609.0681
Rpar23 vss vss.t1 54.7121
Rpar24 vss vss.t13 125.4713
Rpar25 vss vss.t14 209.1922
Rpar26 vss vss.t4 225.0243
Rpar27 vss.t0 vss.t1 9.2929
Rpar28 vss.t0 vss.t4 984.3056
Rpar29 vss.t1 vss.t13 936.6770
Rpar30 vss.t1 vss.t4 88.2744
Rpar31 vss.t13 vss.t14 2.6211
Rpar32 vss.t13 vss.t4 3861.7848
Rpar33 vss.t14 vss.t4 6438.5743
Cpar0 a_1491_6397.t0 vss 1.05482e-14
Cpar1 a_1491_6397.t16 vss 5.87638e-14
Cpar2 a_1491_6397.t17 vss 2.88907e-14
Cpar3 a_1561_6606.t0 vss 5.81270e-13
Cpar4 a_1561_6606.t320 vss 1.25368e-13
Cpar5 a_3410_11843.t0 vss 6.66320e-14
Cpar6 a_3410_11843.t1 vss 4.34782e-14
Cpar7 a_3410_11843.t108 vss 2.12994e-13
Cpar8 ib inp 1.86000e-17
Cpar9 ib vdd 2.08480e-16
Cpar10 ib vss 2.96122e-14
Cpar11 ib.t0 vss 2.58860e-15
Cpar12 ib.t1 vss 1.47670e-15
Cpar13 inn inp 2.10380e-16
Cpar14 inn out 3.29131e-14
Cpar15 inn vdd 4.84477e-14
Cpar16 inn vss 1.57359e-14
Cpar17 inn.t0 vss 9.26608e-14
Cpar18 inp vdd 4.88912e-14
Cpar19 inp vss 1.57521e-14
Cpar20 inp.t0 vss 9.28644e-14
Cpar21 out vdd 1.52629e-14
Cpar22 out vss 5.44103e-14
Cpar23 out.t0 vss 1.79832e-13
Cpar24 out.t214 vss 1.06965e-13
Cpar25 out.t70 vss 3.19861e-14
Cpar26 vdd vss 6.38535e-13
Cpar27 vdd.t0 vss 6.90914e-14
Cpar28 vdd.t1 vss 3.12911e-14
Cpar29 vdd.t50 vss 2.24832e-13
.ends opamp_dut

Vdd vdd 0 1.800000
Vss vss 0 0
Ibias vdd ib 1.300000e-04
Vinp inp 0 DC 0.805000 AC 1 PWL(0 0.805000 3.000000e-09 0.805000 3.300000e-09 0.815000)
Rfb out inn 1m
Cload out 0 2.000000e-12
Xdut vdd vss inp inn out ib opamp_dut
.end
