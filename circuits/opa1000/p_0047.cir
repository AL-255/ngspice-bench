* opa1000[0047]: 2p/cherry_hooper_1v8_0p1u_1u_weak (cherry_hooper, VDD=1.8V, CL=2.0pF, Iref=0.0312uA)
.include "pdk_opa.inc"
.temp 27
.option gmin=1e-12 rshunt=1e12 reltol=1e-3 abstol=1e-12 vntol=1e-5 method=gear
* Post-PEX R+C extracted netlist for cherry_hooper_1v8_0p1u_1u_weak
.subckt opamp_dut vdd vss inp inn out ib
XMpar0 a_1735_14674.t0 a_2020_16651.t1 a_2020_16651.t2 vdd.t0 pfet_03v3 w=10u l=1u ad=3.2000e-12 pd=1.1890e-05 as=2.8000e-12 ps=1.0560e-05 nf=1 m=16 par=16
XMpar1 ib.t1 ib vss.t4 vss.t3 nfet_03v3 w=0.4u l=6.25u ad=2.4000e-13 pd=2.0000e-06 as=1.1200e-13 ps=9.6000e-07 nf=1 m=1
XMpar2 out.t0 a_12640_1428.t0 vdd.t5 vdd.t4 pfet_03v3 w=0.54u l=1.3u ad=2.0880e-13 pd=1.4933e-06 as=1.5120e-13 ps=1.1000e-06 nf=1 m=3 par=3
XMpar3 a_9827_16859.t1 ib vss.t4 vss.t3 nfet_03v3 w=0.4u l=6.25u ad=1.5467e-13 pd=1.3067e-06 as=1.1200e-13 ps=9.6000e-07 nf=1 m=6 par=6
XMpar4 a_12574_18924.t3 a_4917_12613.t1 vdd.t21 vdd.t20 pfet_03v3 w=0.44u l=6.25u ad=2.6400e-13 pd=2.0800e-06 as=2.6400e-13 ps=2.0800e-06 nf=1 m=1
XMpar5 a_4917_12613.t2 a_4917_12613.t1 vdd.t21 vdd.t20 pfet_03v3 w=0.44u l=6.25u ad=2.6400e-13 pd=2.0800e-06 as=2.6400e-13 ps=2.0800e-06 nf=1 m=1
XMpar6 a_12574_18924.t2 a_2020_16651.t33 a_5408_1266.t1 vdd.t12 pfet_03v3 w=6.41u l=1u ad=1.7948e-12 pd=6.9700e-06 as=3.8460e-12 ps=1.4020e-05 nf=1 m=2 par=2
XMpar7 a_12640_1428.t1 a_12640_1428.t0 vdd.t5 vdd.t4 pfet_03v3 w=0.54u l=1.3u ad=2.0880e-13 pd=1.4933e-06 as=1.5120e-13 ps=1.1000e-06 nf=1 m=3 par=3
XMpar8 a_11674_18924.t2 ib vss.t4 vss.t3 nfet_03v3 w=0.4u l=6.25u ad=1.1200e-13 pd=9.6000e-07 as=1.1200e-13 ps=9.6000e-07 nf=1 m=2 par=2
XMpar9 a_13774_14892.t4 a_4917_12613.t1 vdd.t21 vdd.t20 pfet_03v3 w=0.44u l=6.25u ad=2.6400e-13 pd=2.0800e-06 as=2.6400e-13 ps=2.0800e-06 nf=1 m=1
XMpar10 a_11674_18924.t0 inn.t0 a_13774_14892.t0 vss.t0 nfet_03v3 w=0.4u l=3.9u ad=2.4000e-13 pd=2.0000e-06 as=1.1200e-13 ps=9.6000e-07 nf=1 m=2 par=2
XMpar11 a_12566_3521.t6 a_13774_6652.t9 out.t3 vss.t2 nfet_03v3 w=6.31u l=3.9u ad=3.7860e-12 pd=1.3820e-05 as=3.7860e-12 ps=1.3820e-05 nf=1 m=1
XMpar12 a_13774_14892.t2 a_2020_16651.t33 a_13774_6652.t1 vdd.t12 pfet_03v3 w=6.41u l=1u ad=1.7948e-12 pd=6.9700e-06 as=3.8460e-12 ps=1.4020e-05 nf=1 m=2 par=2
XMpar13 a_13774_6652.t3 a_13774_6652.t2 vdd.t5 vdd.t4 pfet_03v3 w=0.54u l=1.3u ad=2.0880e-13 pd=1.4933e-06 as=2.0880e-13 ps=1.4933e-06 nf=1 m=3 par=3
XMpar14 a_12566_3521.t0 ib vss.t4 vss.t3 nfet_03v3 w=0.4u l=6.25u ad=1.1200e-13 pd=9.6000e-07 as=1.5467e-13 ps=1.3067e-06 nf=1 m=6 par=6
XMpar15 a_11674_18924.t0 inp.t0 a_12574_18924.t0 vss.t0 nfet_03v3 w=0.4u l=3.9u ad=2.4000e-13 pd=2.0000e-06 as=1.1200e-13 ps=9.6000e-07 nf=1 m=2 par=2
XMpar16 a_5408_1266.t3 a_5408_1266.t2 vdd.t5 vdd.t4 pfet_03v3 w=0.54u l=1.3u ad=2.0880e-13 pd=1.4933e-06 as=2.0880e-13 ps=1.4933e-06 nf=1 m=3 par=3
XMpar17 a_13774_6652.t0 a_13774_14892.t5 a_9827_16859.t0 vss.t2 nfet_03v3 w=6.31u l=3.9u ad=3.7860e-12 pd=1.3820e-05 as=3.7860e-12 ps=1.3820e-05 nf=1 m=1
XMpar18 a_12566_3521.t6 a_5408_1266.t9 a_12640_1428.t6 vss.t2 nfet_03v3 w=6.31u l=3.9u ad=3.7860e-12 pd=1.3820e-05 as=3.7860e-12 ps=1.3820e-05 nf=1 m=1
XMpar19 a_4917_12613.t0 ib vss.t4 vss.t3 nfet_03v3 w=0.4u l=6.25u ad=2.4000e-13 pd=2.0000e-06 as=1.1200e-13 ps=9.6000e-07 nf=1 m=1
XMpar20 a_2020_16651.t0 ib vss.t4 vss.t3 nfet_03v3 w=0.4u l=6.25u ad=2.4000e-13 pd=2.0000e-06 as=2.4000e-13 ps=2.0000e-06 nf=1 m=1
XMpar21 a_5408_1266.t0 a_12574_18924.t5 a_9827_16859.t0 vss.t2 nfet_03v3 w=6.31u l=3.9u ad=3.7860e-12 pd=1.3820e-05 as=3.7860e-12 ps=1.3820e-05 nf=1 m=1
XMpar22 a_1735_14674.t16 a_1735_14674.t15 vdd.t5 vdd.t4 pfet_03v3 w=0.54u l=1.3u ad=3.2400e-13 pd=2.2800e-06 as=3.2400e-13 ps=2.2800e-06 nf=1 m=1
X0 out.t4 vss.t38 cap_mim_2f0fF c_width=17.8u c_length=17.8u
X9 out.t4 vss.t38 cap_mim_2f0fF c_width=17.8u c_length=17.8u
X63 out.t4 vss.t38 cap_mim_2f0fF c_width=17.8u c_length=17.8u
Rpar0 a_11674_18924.t0 a_11674_18924.t2 54.3660
Rpar1 a_12566_3521.t0 a_12566_3521.t6 56.7254
Rpar2 a_12574_18924.t0 a_12574_18924.t2 444.6675
Rpar3 a_12574_18924.t0 a_12574_18924.t3 145.9853
Rpar4 a_12574_18924.t0 a_12574_18924.t5 354.6399
Rpar5 a_12574_18924.t2 a_12574_18924.t3 240.7653
Rpar6 a_12574_18924.t2 a_12574_18924.t5 56.3497
Rpar7 a_12574_18924.t3 a_12574_18924.t5 192.0198
Rpar8 a_12640_1428.t0 a_12640_1428.t1 20.0358
Rpar9 a_12640_1428.t0 a_12640_1428.t6 141.7020
Rpar10 a_12640_1428.t1 a_12640_1428.t6 81.6803
Rpar11 a_13774_14892.t0 a_13774_14892.t2 444.6774
Rpar12 a_13774_14892.t0 a_13774_14892.t4 145.9856
Rpar13 a_13774_14892.t0 a_13774_14892.t5 354.6307
Rpar14 a_13774_14892.t2 a_13774_14892.t4 240.7707
Rpar15 a_13774_14892.t2 a_13774_14892.t5 56.3483
Rpar16 a_13774_14892.t4 a_13774_14892.t5 192.0149
Rpar17 a_13774_6652.t0 a_13774_6652.t1 65.6863
Rpar18 a_13774_6652.t0 a_13774_6652.t2 1344.9433
Rpar19 a_13774_6652.t0 a_13774_6652.t3 684.1324
Rpar20 a_13774_6652.t0 a_13774_6652.t9 302.3990
Rpar21 a_13774_6652.t1 a_13774_6652.t2 440.5270
Rpar22 a_13774_6652.t1 a_13774_6652.t3 224.0829
Rpar23 a_13774_6652.t1 a_13774_6652.t9 99.0487
Rpar24 a_13774_6652.t2 a_13774_6652.t3 23.7380
Rpar25 a_13774_6652.t2 a_13774_6652.t9 214.1106
Rpar26 a_13774_6652.t3 a_13774_6652.t9 108.9117
Rpar27 a_1735_14674.t0 a_1735_14674.t15 127.8375
Rpar28 a_1735_14674.t0 a_1735_14674.t16 64.3779
Rpar29 a_1735_14674.t15 a_1735_14674.t16 55.0313
Rpar30 a_2020_16651.t0 a_2020_16651.t1 4870.5429
Rpar31 a_2020_16651.t0 a_2020_16651.t2 93.3414
Rpar32 a_2020_16651.t0 a_2020_16651.t33 166.2824
Rpar33 a_2020_16651.t1 a_2020_16651.t2 16.7801
Rpar34 a_2020_16651.t1 a_2020_16651.t33 6595.1489
Rpar35 a_2020_16651.t2 a_2020_16651.t33 126.3926
Rpar36 a_4917_12613.t0 a_4917_12613.t1 86.3167
Rpar37 a_4917_12613.t0 a_4917_12613.t2 180.0435
Rpar38 a_4917_12613.t1 a_4917_12613.t2 31.0840
Rpar39 a_5408_1266.t0 a_5408_1266.t1 65.6861
Rpar40 a_5408_1266.t0 a_5408_1266.t2 1344.9153
Rpar41 a_5408_1266.t0 a_5408_1266.t3 684.1182
Rpar42 a_5408_1266.t0 a_5408_1266.t9 302.4072
Rpar43 a_5408_1266.t1 a_5408_1266.t2 440.5178
Rpar44 a_5408_1266.t1 a_5408_1266.t3 224.0782
Rpar45 a_5408_1266.t1 a_5408_1266.t9 99.0514
Rpar46 a_5408_1266.t2 a_5408_1266.t3 23.7380
Rpar47 a_5408_1266.t2 a_5408_1266.t9 214.1164
Rpar48 a_5408_1266.t3 a_5408_1266.t9 108.9146
Rpar49 a_9827_16859.t0 a_9827_16859.t1 73.5876
Rpar50 ib ib.t1 25.7183
Rpar51 inn inn.t0 3.2588
Rpar52 inp inp.t0 3.3074
Rpar53 out out.t0 117.1483
Rpar54 out out.t3 238.6765
Rpar55 out out.t4 17.5105
Rpar56 out.t0 out.t3 90.1781
Rpar57 out.t0 out.t4 483.8629
Rpar58 out.t3 out.t4 985.8164
Rpar59 vdd vdd.t0 73.9929
Rpar60 vdd vdd.t4 467.5034
Rpar61 vdd vdd.t5 372.6248
Rpar62 vdd vdd.t12 698.3487
Rpar63 vdd vdd.t20 418.9811
Rpar64 vdd vdd.t21 198.6625
Rpar65 vdd.t0 vdd.t4 576.3878
Rpar66 vdd.t0 vdd.t5 459.4114
Rpar67 vdd.t0 vdd.t12 860.9983
Rpar68 vdd.t0 vdd.t20 516.5643
Rpar69 vdd.t0 vdd.t21 244.9322
Rpar70 vdd.t4 vdd.t5 4.0971
Rpar71 vdd.t4 vdd.t12 227.8589
Rpar72 vdd.t4 vdd.t20 567.1675
Rpar73 vdd.t4 vdd.t21 317.1516
Rpar74 vdd.t5 vdd.t12 240.1813
Rpar75 vdd.t5 vdd.t20 512.9686
Rpar76 vdd.t5 vdd.t21 277.5352
Rpar77 vdd.t12 vdd.t20 160.4485
Rpar78 vdd.t12 vdd.t21 112.4053
Rpar79 vdd.t20 vdd.t21 17.5444
Rpar80 vss vss.t0 3127.9215
Rpar81 vss vss.t4 2528.8061
Rpar82 vss vss.t3 721.5580
Rpar83 vss vss.t2 125.9586
Rpar84 vss vss.t38 87.2694
Rpar85 vss.t0 vss.t4 19.9506
Rpar86 vss.t0 vss.t3 4.6123
Rpar87 vss.t0 vss.t2 351.0860
Rpar88 vss.t0 vss.t38 4337.4796
Rpar89 vss.t4 vss.t3 3.5491
Rpar90 vss.t4 vss.t2 276.4541
Rpar91 vss.t4 vss.t38 3506.6880
Rpar92 vss.t3 vss.t2 78.6983
Rpar93 vss.t3 vss.t38 1000.5824
Rpar94 vss.t2 vss.t38 174.6665
Cpar0 a_11674_18924.t0 vss 4.90961e-15
Cpar1 a_11674_18924.t2 vss 4.62409e-15
Cpar2 a_12566_3521.t0 vss 2.15027e-15
Cpar3 a_12566_3521.t6 vss 2.17630e-15
Cpar4 a_12574_18924.t0 vss 5.48632e-15
Cpar5 a_12574_18924.t2 vss 3.95522e-15
Cpar6 a_12574_18924.t3 vss 4.46914e-15
Cpar7 a_12574_18924.t5 vss 6.26795e-15
Cpar8 a_12640_1428.t0 vss 6.16681e-15
Cpar9 a_12640_1428.t1 vss 2.85239e-15
Cpar10 a_12640_1428.t6 vss 4.71791e-15
Cpar11 a_13774_14892.t0 vss 2.85075e-15
Cpar12 a_13774_14892.t2 vss 2.05516e-15
Cpar13 a_13774_14892.t4 vss 2.32222e-15
Cpar14 a_13774_14892.t5 vss 3.25694e-15
Cpar15 a_13774_6652.t0 vss 2.48950e-15
Cpar16 a_13774_6652.t1 vss 4.29275e-15
Cpar17 a_13774_6652.t2 vss 1.90323e-15
Cpar18 a_13774_6652.t3 vss 1.85637e-15
Cpar19 a_13774_6652.t9 vss 4.48779e-15
Cpar20 a_1735_14674.t0 vss 2.76233e-14
Cpar21 a_1735_14674.t15 vss 1.00151e-15
Cpar22 a_1735_14674.t16 vss 1.20076e-15
Cpar23 a_2020_16651.t0 vss 3.20470e-15
Cpar24 a_2020_16651.t1 vss 2.03792e-14
Cpar25 a_2020_16651.t2 vss 2.01173e-14
Cpar26 a_2020_16651.t33 vss 6.00024e-15
Cpar27 a_4917_12613.t0 vss 4.02717e-15
Cpar28 a_4917_12613.t1 vss 1.41073e-14
Cpar29 a_4917_12613.t2 vss 2.36319e-15
Cpar30 a_5408_1266.t0 vss 3.12864e-15
Cpar31 a_5408_1266.t1 vss 5.39484e-15
Cpar32 a_5408_1266.t2 vss 2.39186e-15
Cpar33 a_5408_1266.t3 vss 2.35300e-15
Cpar34 a_5408_1266.t9 vss 5.63990e-15
Cpar35 a_9827_16859.t0 vss 5.81918e-15
Cpar36 a_9827_16859.t1 vss 6.40671e-15
Cpar37 ib out 9.86500e-17
Cpar38 ib vdd 1.90407e-15
Cpar39 ib vss 7.77339e-14
Cpar40 ib.t1 vss 6.30519e-16
Cpar41 inn inp 5.23500e-17
Cpar42 inn vdd 1.26700e-17
Cpar43 inn vss 4.41710e-15
Cpar44 inn.t0 vss 3.40063e-16
Cpar45 inp vdd 1.31300e-17
Cpar46 inp vss 4.46652e-15
Cpar47 inp.t0 vss 3.57874e-16
Cpar48 out vdd 4.48380e-15
Cpar49 out vss 3.07455e-14
Cpar50 out.t0 vss 1.80258e-16
Cpar51 out.t3 vss 1.84275e-16
Cpar52 out.t4 vss 1.16863e-14
Cpar53 vdd vss 1.80226e-13
Cpar54 vdd.t0 vss 2.50015e-14
Cpar55 vdd.t12 vss 9.26039e-15
Cpar56 vdd.t20 vss 5.57014e-15
Cpar57 vdd.t21 vss 7.30338e-15
Cpar58 vdd.t4 vss 1.18827e-14
Cpar59 vdd.t5 vss 9.67357e-15
.ends opamp_dut

Vdd vdd 0 1.800000
Vss vss 0 0
Ibias vdd ib 3.120000e-08
Vinp inp 0 DC 1.173600 AC 1 PWL(0 1.173600 3.875512e-07 1.173600 4.263063e-07 1.183600)
Rfb out inn 1m
Cload out 0 2.000000e-12
Xdut vdd vss inp inn out ib opamp_dut
.end
