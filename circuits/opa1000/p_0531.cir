* opa1000[0531]: 200f/pmos_5t_3v3_1u_10u_subth (pmos_5t, VDD=3.3V, CL=0.2pF, Iref=0.7uA)
.include "pdk_opa.inc"
.temp 27
.option gmin=1e-12 rshunt=1e12 reltol=1e-3 abstol=1e-12 vntol=1e-5 method=gear
* Post-PEX R+C extracted netlist for pmos_5t_3v3_1u_10u_subth
.subckt opamp_dut vdd vss inp inn out ib
XMpar0 a_1906_6679.t0 inn.t0 out.t0 vdd.t4 pfet_03v3 w=2.36u l=0.8u ad=7.5520e-13 pd=3.2950e-06 as=6.6080e-13 ps=2.9200e-06 nf=1 m=64 par=64
XMpar1 a_1084_1204.t12 inp.t0 a_1906_6679.t0 vdd.t4 pfet_03v3 w=2.36u l=0.8u ad=6.6080e-13 pd=2.9200e-06 as=7.5520e-13 ps=3.2950e-06 nf=1 m=64 par=64
XMpar2 a_1084_1204.t1 a_1084_1204.t0 vss.t1 vss.t0 nfet_03v3 w=1.99u l=4u ad=7.6947e-13 pd=3.4267e-06 as=5.5720e-13 ps=2.5500e-06 nf=1 m=6 par=6
XMpar3 out.t6 a_1084_1204.t0 vss.t1 vss.t0 nfet_03v3 w=1.99u l=4u ad=5.5720e-13 pd=2.5500e-06 as=5.5720e-13 ps=2.5500e-06 nf=1 m=6 par=6
XMpar4 a_1796_3092.t3 a_1796_3092.t2 vdd.t1 vdd.t0 pfet_03v3 w=5.74u l=1.2u ad=1.6072e-12 pd=6.3000e-06 as=1.6072e-12 ps=6.3000e-06 nf=1 m=2 par=2
XMpar5 a_1906_6679.t128 a_1796_3092.t2 vdd.t1 vdd.t0 pfet_03v3 w=5.74u l=1.2u ad=1.6072e-12 pd=6.3000e-06 as=2.0664e-12 ps=7.8950e-06 nf=1 m=8 par=8
XMpar6 ib.t1 ib.t0 vss.t24 vss.t23 nfet_03v3 w=1.17u l=1.2u ad=7.0200e-13 pd=3.5400e-06 as=3.2760e-13 ps=1.7300e-06 nf=1 m=2 par=2
XMpar7 a_1796_3092.t0 ib.t0 vss.t24 vss.t23 nfet_03v3 w=1.17u l=1.2u ad=3.2760e-13 pd=1.7300e-06 as=3.2760e-13 ps=1.7300e-06 nf=1 m=2 par=2
X110 out.t70 vss.t14 cap_mim_2f0fF c_width=9.69u c_length=9.68u
Rpar0 a_1084_1204.t0 a_1084_1204.t1 15.9468
Rpar1 a_1084_1204.t0 a_1084_1204.t12 181.0255
Rpar2 a_1084_1204.t1 a_1084_1204.t12 68.2131
Rpar3 a_1796_3092.t0 a_1796_3092.t2 153.4732
Rpar4 a_1796_3092.t0 a_1796_3092.t3 88.9679
Rpar5 a_1796_3092.t2 a_1796_3092.t3 23.5787
Rpar6 a_1906_6679.t0 a_1906_6679.t128 58.1186
Rpar7 ib ib.t0 13.6741
Rpar8 ib ib.t1 6.6657
Rpar9 inn inn.t0 1.6238
Rpar10 inp inp.t0 1.6238
Rpar11 out out.t0 63.6451
Rpar12 out out.t6 53.7680
Rpar13 out out.t70 15.1847
Rpar14 out.t0 out.t6 152.7653
Rpar15 out.t0 out.t70 842.3275
Rpar16 out.t6 out.t70 711.6065
Rpar17 vdd vdd.t0 255.7099
Rpar18 vdd vdd.t1 834.7493
Rpar19 vdd vdd.t4 20.4690
Rpar20 vdd.t0 vdd.t1 5.1718
Rpar21 vdd.t0 vdd.t4 94.0014
Rpar22 vdd.t1 vdd.t4 306.8618
Rpar23 vss vss.t0 85.1828
Rpar24 vss vss.t1 328.3586
Rpar25 vss vss.t14 348.8482
Rpar26 vss vss.t23 133.2282
Rpar27 vss vss.t24 565.2982
Rpar28 vss.t0 vss.t1 10.0513
Rpar29 vss.t0 vss.t14 86.8617
Rpar30 vss.t0 vss.t23 3.8025
Rpar31 vss.t0 vss.t24 19.6262
Rpar32 vss.t1 vss.t14 326.7979
Rpar33 vss.t1 vss.t23 17.2069
Rpar34 vss.t1 vss.t24 100.0929
Rpar35 vss.t14 vss.t23 141.4403
Rpar36 vss.t14 vss.t24 680.1834
Rpar37 vss.t23 vss.t24 21.1917
Cpar0 a_1084_1204.t0 vss 2.59365e-14
Cpar1 a_1084_1204.t1 vss 7.10502e-15
Cpar2 a_1084_1204.t12 vss 2.75833e-14
Cpar3 a_1796_3092.t0 vss 1.45961e-15
Cpar4 a_1796_3092.t2 vss 1.42408e-14
Cpar5 a_1796_3092.t3 vss 3.62285e-15
Cpar6 a_1906_6679.t0 vss 8.72692e-14
Cpar7 a_1906_6679.t128 vss 1.30095e-14
Cpar8 ib vss 6.42991e-15
Cpar9 ib.t0 vss 6.31772e-16
Cpar10 ib.t1 vss 7.68000e-17
Cpar11 inn inp 2.09090e-16
Cpar12 inn out 1.29781e-14
Cpar13 inn vdd 2.88953e-14
Cpar14 inn vss 6.17946e-15
Cpar15 inn.t0 vss 4.54203e-14
Cpar16 inp vdd 2.91677e-14
Cpar17 inp vss 6.15797e-15
Cpar18 inp.t0 vss 4.55563e-14
Cpar19 out vdd 8.47181e-15
Cpar20 out vss 1.73567e-14
Cpar21 out.t0 vss 2.51147e-14
Cpar22 out.t6 vss 5.73135e-15
Cpar23 out.t70 vss 2.41062e-14
Cpar24 vdd vss 2.23635e-13
Cpar25 vdd.t0 vss 1.39558e-14
Cpar26 vdd.t1 vss 6.80668e-15
Cpar27 vdd.t4 vss 7.83919e-14
.ends opamp_dut

Vdd vdd 0 3.300000
Vss vss 0 0
Ibias vdd ib 7.000000e-07
Vinp inp 0 DC 1.480000 AC 1 PWL(0 1.480000 1.188268e-08 1.480000 1.307095e-08 1.490000)
Rfb out inn 1m
Cload out 0 2.000000e-13
Xdut vdd vss inp inn out ib opamp_dut
.end
