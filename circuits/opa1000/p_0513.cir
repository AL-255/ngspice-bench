* opa1000[0513]: 200f/pmos_5t_1v8_i10u_subth (pmos_5t, VDD=1.8V, CL=0.2pF, Iref=2.6uA)
.include "pdk_opa.inc"
.temp 27
.option gmin=1e-12 rshunt=1e12 reltol=1e-3 abstol=1e-12 vntol=1e-5 method=gear
* Post-PEX R+C extracted netlist for pmos_5t_1v8_i10u_subth
.subckt opamp_dut vdd vss inp inn out ib
XMpar0 a_3026_7847.t0 inn.t0 out.t0 vdd.t10 pfet_03v3 w=5.32u l=0.9u ad=1.7024e-12 pd=6.6250e-06 as=1.4896e-12 ps=5.8800e-06 nf=1 m=64 par=64
XMpar1 a_3026_7847.t128 a_2441_1294.t2 vdd.t1 vdd.t0 pfet_03v3 w=10u l=2.25u ad=2.8000e-12 pd=1.0560e-05 as=3.6000e-12 ps=1.3220e-05 nf=1 m=8 par=8
XMpar2 a_3026_7847.t0 inp.t0 a_3326_7847.t16 vdd.t10 pfet_03v3 w=5.32u l=0.9u ad=1.7024e-12 pd=6.6250e-06 as=1.4896e-12 ps=5.8800e-06 nf=1 m=64 par=64
XMpar3 a_3326_7847.t1 a_3326_7847.t0 vss.t1 vss.t0 nfet_03v3 w=1.82u l=1.44u ad=5.0960e-13 pd=2.3800e-06 as=5.8240e-13 ps=2.6875e-06 nf=1 m=8 par=8
XMpar4 ib.t1 ib.t0 vss.t16 vss.t15 nfet_03v3 w=8.07u l=2.25u ad=4.8420e-12 pd=1.7340e-05 as=2.2596e-12 ps=8.6300e-06 nf=1 m=2 par=2
XMpar5 a_2441_1294.t3 a_2441_1294.t2 vdd.t1 vdd.t0 pfet_03v3 w=10u l=2.25u ad=2.8000e-12 pd=1.0560e-05 as=2.8000e-12 ps=1.0560e-05 nf=1 m=2 par=2
XMpar6 out.t9 a_3326_7847.t0 vss.t1 vss.t0 nfet_03v3 w=1.82u l=1.44u ad=5.0960e-13 pd=2.3800e-06 as=5.8240e-13 ps=2.6875e-06 nf=1 m=8 par=8
XMpar7 a_2441_1294.t0 ib.t0 vss.t16 vss.t15 nfet_03v3 w=8.07u l=2.25u ad=2.2596e-12 pd=8.6300e-06 as=2.2596e-12 ps=8.6300e-06 nf=1 m=2 par=2
X33 out.t72 vss.t2 cap_mim_2f0fF c_width=14.79u c_length=14.79u
Rpar0 a_2441_1294.t0 a_2441_1294.t2 129.9577
Rpar1 a_2441_1294.t0 a_2441_1294.t3 82.1562
Rpar2 a_2441_1294.t2 a_2441_1294.t3 25.6161
Rpar3 a_3026_7847.t0 a_3026_7847.t128 69.6542
Rpar4 a_3326_7847.t0 a_3326_7847.t1 16.1855
Rpar5 a_3326_7847.t0 a_3326_7847.t16 148.3233
Rpar6 a_3326_7847.t1 a_3326_7847.t16 55.5700
Rpar7 ib ib.t0 16.2389
Rpar8 ib ib.t1 3.4972
Rpar9 inn inn.t0 2.0299
Rpar10 inp inp.t0 2.0299
Rpar11 out out.t0 158.3682
Rpar12 out out.t9 46.6026
Rpar13 out out.t72 15.6114
Rpar14 out.t0 out.t9 92.5954
Rpar15 out.t0 out.t72 1532.4765
Rpar16 out.t9 out.t72 450.9576
Rpar17 vdd vdd.t0 239.1316
Rpar18 vdd vdd.t1 1159.4178
Rpar19 vdd vdd.t10 43.4217
Rpar20 vdd.t0 vdd.t1 5.8614
Rpar21 vdd.t0 vdd.t10 72.2617
Rpar22 vdd.t1 vdd.t10 350.3571
Rpar23 vss vss.t0 166.4536
Rpar24 vss vss.t1 279.6251
Rpar25 vss vss.t15 95.2650
Rpar26 vss vss.t16 157.4542
Rpar27 vss vss.t2 62.1736
Rpar28 vss.t0 vss.t1 5.1014
Rpar29 vss.t0 vss.t15 162.6686
Rpar30 vss.t0 vss.t16 268.8701
Rpar31 vss.t0 vss.t2 1440.6015
Rpar32 vss.t1 vss.t15 281.3250
Rpar33 vss.t1 vss.t16 464.9918
Rpar34 vss.t1 vss.t2 2420.0634
Rpar35 vss.t15 vss.t16 10.4128
Rpar36 vss.t15 vss.t2 824.4876
Rpar37 vss.t16 vss.t2 1362.7141
Cpar0 a_2441_1294.t0 vss 2.34204e-15
Cpar1 a_2441_1294.t2 vss 2.55018e-14
Cpar2 a_2441_1294.t3 vss 3.62234e-15
Cpar3 a_3026_7847.t0 vss 1.29409e-13
Cpar4 a_3026_7847.t128 vss 1.90272e-14
Cpar5 a_3326_7847.t0 vss 1.62451e-14
Cpar6 a_3326_7847.t1 vss 5.08696e-15
Cpar7 a_3326_7847.t16 vss 6.10974e-14
Cpar8 ib vss 1.25691e-14
Cpar9 ib.t0 vss 1.26991e-15
Cpar10 ib.t1 vss 3.93160e-16
Cpar11 inn inp 2.09140e-16
Cpar12 inn out 1.96554e-14
Cpar13 inn vdd 3.20051e-14
Cpar14 inn vss 8.26313e-15
Cpar15 inn.t0 vss 5.98362e-14
Cpar16 inp vdd 3.23601e-14
Cpar17 inp vss 8.32783e-15
Cpar18 inp.t0 vss 6.01680e-14
Cpar19 out vdd 8.85383e-15
Cpar20 out vss 1.72185e-14
Cpar21 out.t0 vss 3.35076e-14
Cpar22 out.t72 vss 4.08316e-14
Cpar23 out.t9 vss 3.18268e-15
Cpar24 vdd vss 3.54684e-13
Cpar25 vdd.t0 vss 2.08895e-14
Cpar26 vdd.t1 vss 8.10001e-15
Cpar27 vdd.t10 vss 9.13494e-14
.ends opamp_dut

Vdd vdd 0 1.800000
Vss vss 0 0
Ibias vdd ib 2.600000e-06
Vinp inp 0 DC 0.805000 AC 1 PWL(0 0.805000 5.851201e-09 0.805000 6.436321e-09 0.815000)
Rfb out inn 1m
Cload out 0 2.000000e-13
Xdut vdd vss inp inn out ib opamp_dut
.end
