* opa1000[0663]: 2p/pmos_miller_3v3_10u_100u_weak (pmos_miller, VDD=3.3V, CL=2.0pF, Iref=8.125uA)
.include "pdk_opa.inc"
.temp 27
.option gmin=1e-12 rshunt=1e12 reltol=1e-3 abstol=1e-12 vntol=1e-5 method=gear
* Post-PEX R+C extracted netlist for pmos_miller_3v3_10u_100u_weak
.subckt opamp_dut vdd vss inp inn out ib
XMpar0 a_2370_11230.t112 a_7584_3834.t0 vdd.t1 vdd.t0 pfet_03v3 w=10u l=1.25u ad=6.0000e-12 pd=2.1200e-05 as=2.8000e-12 ps=1.0560e-05 nf=1 m=4 par=4
XMpar1 a_2370_11230.t0 inn.t0 a_7432_1041.t0 vdd.t7 pfet_03v3 w=1.99u l=0.8u ad=6.0269e-13 pd=2.7379e-06 as=5.7994e-13 ps=2.6439e-06 nf=1 m=56 par=56
XMpar2 out.t0 a_7584_3834.t0 vdd.t1 vdd.t0 pfet_03v3 w=10u l=1.25u ad=4.7200e-12 pd=1.6944e-05 as=4.0800e-12 ps=1.4816e-05 nf=1 m=10 par=10
XMpar3 a_2370_11230.t0 inp.t0 a_967_1041.t0 vdd.t7 pfet_03v3 w=1.99u l=0.8u ad=6.0269e-13 pd=2.7379e-06 as=5.7994e-13 ps=2.6439e-06 nf=1 m=56 par=56
XMpar4 out.t4 a_967_1041.t59 vss.t1 vss.t0 nfet_03v3 w=5.25u l=0.75u ad=1.4700e-12 pd=5.8100e-06 as=1.8060e-12 ps=6.9880e-06 nf=1 m=10 par=10
XMpar5 a_7584_3834.t1 a_7584_3834.t0 vdd.t1 vdd.t0 pfet_03v3 w=10u l=1.25u ad=6.0000e-12 pd=2.1200e-05 as=2.8000e-12 ps=1.0560e-05 nf=1 m=2 par=2
XMpar6 a_967_1041.t57 a_7432_1041.t56 vss.t1 vss.t0 nfet_03v3 w=5.25u l=0.75u ad=3.1500e-12 pd=1.1700e-05 as=1.4700e-12 ps=5.8100e-06 nf=1 m=2 par=2
XMpar7 a_7432_1041.t57 a_7432_1041.t56 vss.t1 vss.t0 nfet_03v3 w=5.25u l=0.75u ad=1.4700e-12 pd=5.8100e-06 as=1.4700e-12 ps=5.8100e-06 nf=1 m=2 par=2
XMpar8 ib.t1 ib.t0 vss.t29 vss.t28 nfet_03v3 w=4.47u l=1.25u ad=2.6820e-12 pd=1.0140e-05 as=1.2516e-12 ps=5.0300e-06 nf=1 m=2 par=2
XMpar9 a_7584_3834.t4 ib.t0 vss.t29 vss.t28 nfet_03v3 w=4.47u l=1.25u ad=1.2516e-12 pd=5.0300e-06 as=1.2516e-12 ps=5.0300e-06 nf=1 m=2 par=2
X23 a_5350_3920.t1 out.t2 cap_mim_2f0fF c_width=16.59u c_length=16.58u
X100 a_5350_3920.t1 out.t2 cap_mim_2f0fF c_width=16.59u c_length=16.58u
X143 a_967_1041.t56 a_5350_3920.t0 vss.t36 ppolyf_u_1k r_width=1u r_length=1.99u
Rpar0 a_2370_11230.t0 a_2370_11230.t112 41.3828
Rpar1 a_5350_3920.t0 a_5350_3920.t1 85.8618
Rpar2 a_7432_1041.t0 a_7432_1041.t56 330.9466
Rpar3 a_7432_1041.t0 a_7432_1041.t57 89.2371
Rpar4 a_7432_1041.t56 a_7432_1041.t57 30.9753
Rpar5 a_7584_3834.t0 a_7584_3834.t1 13.6709
Rpar6 a_7584_3834.t0 a_7584_3834.t4 250.0076
Rpar7 a_7584_3834.t1 a_7584_3834.t4 80.0918
Rpar8 a_967_1041.t0 a_967_1041.t56 129.2894
Rpar9 a_967_1041.t0 a_967_1041.t57 299.4170
Rpar10 a_967_1041.t0 a_967_1041.t59 339.1589
Rpar11 a_967_1041.t56 a_967_1041.t57 141.0688
Rpar12 a_967_1041.t56 a_967_1041.t59 159.7930
Rpar13 a_967_1041.t57 a_967_1041.t59 109.0969
Rpar14 ib ib.t0 21.2201
Rpar15 ib ib.t1 3.6489
Rpar16 ib.t0 ib.t1 105.8245
Rpar17 inn inn.t0 1.4721
Rpar18 inp inp.t0 1.4721
Rpar19 out out.t0 69.8672
Rpar20 out out.t4 146.0541
Rpar21 out out.t2 22.6285
Rpar22 out.t0 out.t4 193.4389
Rpar23 out.t0 out.t2 410.5594
Rpar24 out.t4 out.t2 858.2552
Rpar25 vdd vdd.t0 2056.9110
Rpar26 vdd vdd.t1 225.1218
Rpar27 vdd vdd.t7 20.6647
Rpar28 vdd.t0 vdd.t1 12.9679
Rpar29 vdd.t0 vdd.t7 759.9412
Rpar30 vdd.t1 vdd.t7 83.1729
Rpar31 vss vss.t0 49.1070
Rpar32 vss vss.t1 125.8817
Rpar33 vss vss.t28 222.6041
Rpar34 vss vss.t29 458.4348
Rpar35 vss vss.t36 62.6284
Rpar36 vss.t0 vss.t1 3.7901
Rpar37 vss.t0 vss.t28 3.2967
Rpar38 vss.t0 vss.t29 18.9798
Rpar39 vss.t0 vss.t36 79.6755
Rpar40 vss.t1 vss.t28 14.7914
Rpar41 vss.t1 vss.t29 61.7661
Rpar42 vss.t1 vss.t36 210.3131
Rpar43 vss.t28 vss.t29 13.4597
Rpar44 vss.t28 vss.t36 272.5498
Rpar45 vss.t29 vss.t36 542.5737
Cpar0 a_2370_11230.t0 vss 7.09820e-14
Cpar1 a_2370_11230.t112 vss 2.56086e-14
Cpar2 a_5350_3920.t0 vss 2.07128e-16
Cpar3 a_5350_3920.t1 vss 9.50420e-15
Cpar4 a_7432_1041.t0 vss 3.64248e-14
Cpar5 a_7432_1041.t56 vss 5.67162e-15
Cpar6 a_7432_1041.t57 vss 7.48355e-15
Cpar7 a_7584_3834.t0 vss 3.30657e-14
Cpar8 a_7584_3834.t1 vss 1.21404e-14
Cpar9 a_7584_3834.t4 vss 4.44126e-15
Cpar10 a_967_1041.t0 vss 2.84905e-14
Cpar11 a_967_1041.t56 vss 3.77686e-15
Cpar12 a_967_1041.t57 vss 6.15390e-15
Cpar13 a_967_1041.t59 vss 1.22245e-14
Cpar14 ib out 2.05500e-17
Cpar15 ib vss 8.20439e-15
Cpar16 ib.t0 vss 7.08471e-16
Cpar17 ib.t1 vss 3.31805e-16
Cpar18 inn inp 1.27130e-16
Cpar19 inn out 1.12100e-17
Cpar20 inn vdd 2.58404e-14
Cpar21 inn vss 6.10251e-15
Cpar22 inn.t0 vss 3.76926e-14
Cpar23 inp out 8.77200e-17
Cpar24 inp vdd 2.57275e-14
Cpar25 inp vss 6.11927e-15
Cpar26 inp.t0 vss 3.75825e-14
Cpar27 out vdd 1.77274e-14
Cpar28 out vss 2.71721e-14
Cpar29 out.t0 vss 1.64460e-14
Cpar30 out.t2 vss 1.36194e-14
Cpar31 out.t4 vss 6.31390e-15
Cpar32 vdd vss 2.59437e-13
Cpar33 vdd.t0 vss 4.78645e-14
Cpar34 vdd.t1 vss 1.25927e-14
Cpar35 vdd.t7 vss 6.98085e-14
.ends opamp_dut

Vdd vdd 0 3.300000
Vss vss 0 0
Ibias vdd ib 8.125000e-06
Vinp inp 0 DC 1.480000 AC 1 PWL(0 1.480000 4.920663e-09 1.480000 5.412729e-09 1.490000)
Rfb out inn 1m
Cload out 0 2.000000e-12
Xdut vdd vss inp inn out ib opamp_dut
.end
