* opa1000[0314]: 2p/folded_cascode_pmos_3v3_i50n_subth (folded_cascode_pmos, VDD=3.3V, CL=2.0pF, Iref=0.0144uA)
.include "pdk_opa.inc"
.temp 27
.option gmin=1e-12 rshunt=1e12 reltol=1e-3 abstol=1e-12 vntol=1e-5 method=gear
* Post-PEX R+C extracted netlist for folded_cascode_pmos_3v3_i50n_subth
.subckt opamp_dut vdd vss inp inn out ib
XMpar0 a_1772_8998.t0 inp.t0 a_2980_2910.t4 vdd.t8 pfet_03v3 w=8u l=8.25u ad=3.5200e-12 pd=1.2880e-05 as=2.8800e-12 ps=1.0720e-05 nf=1 m=8 par=8
XMpar1 a_7374_4366.t12 a_1242_7157.t6 out.t1 vss.t0 nfet_03v3 w=0.4u l=3.5u ad=2.4000e-13 pd=2.0000e-06 as=1.1200e-13 ps=9.6000e-07 nf=1 m=2 par=2
XMpar2 out.t0 a_3880_5777.t1 vdd.t1 vdd.t0 pfet_03v3 w=0.49u l=8.13u ad=1.3720e-13 pd=1.0500e-06 as=1.3720e-13 ps=1.0500e-06 nf=1 m=2 par=2
XMpar3 a_1772_8998.t0 inn.t0 a_7374_4366.t4 vdd.t8 pfet_03v3 w=8u l=8.25u ad=3.5200e-12 pd=1.2880e-05 as=2.8800e-12 ps=1.0720e-05 nf=1 m=8 par=8
XMpar4 a_7374_4366.t0 ib vss.t2 vss.t1 nfet_03v3 w=0.4u l=6.25u ad=1.1200e-13 pd=9.6000e-07 as=1.7600e-13 ps=1.4800e-06 nf=1 m=4 par=4
XMpar5 a_1772_8998.t16 a_1242_7157.t2 vdd.t1 vdd.t0 pfet_03v3 w=0.49u l=8.13u ad=1.3720e-13 pd=1.0500e-06 as=2.1560e-13 ps=1.6150e-06 nf=1 m=4 par=4
XMpar6 a_2980_2910.t12 a_1242_7157.t6 a_3880_5777.t0 vss.t0 nfet_03v3 w=0.4u l=3.5u ad=2.4000e-13 pd=2.0000e-06 as=1.1200e-13 ps=9.6000e-07 nf=1 m=2 par=2
XMpar7 a_2980_2910.t0 ib vss.t2 vss.t1 nfet_03v3 w=0.4u l=6.25u ad=1.1200e-13 pd=9.6000e-07 as=1.7600e-13 ps=1.4800e-06 nf=1 m=4 par=4
XMpar8 a_1242_7157.t3 a_1242_7157.t2 vdd.t1 vdd.t0 pfet_03v3 w=0.49u l=8.13u ad=1.3720e-13 pd=1.0500e-06 as=1.3720e-13 ps=1.0500e-06 nf=1 m=2 par=2
XMpar9 a_3880_5777.t2 a_3880_5777.t1 vdd.t1 vdd.t0 pfet_03v3 w=0.49u l=8.13u ad=2.9400e-13 pd=2.1800e-06 as=1.3720e-13 ps=1.0500e-06 nf=1 m=2 par=2
XMpar10 a_1242_7157.t0 ib vss.t2 vss.t1 nfet_03v3 w=0.4u l=6.25u ad=1.1200e-13 pd=9.6000e-07 as=1.1200e-13 ps=9.6000e-07 nf=1 m=2 par=2
XMpar11 ib.t1 ib vss.t2 vss.t1 nfet_03v3 w=0.4u l=6.25u ad=2.4000e-13 pd=2.0000e-06 as=1.1200e-13 ps=9.6000e-07 nf=1 m=2 par=2
Rpar0 a_1242_7157.t0 a_1242_7157.t2 400.9137
Rpar1 a_1242_7157.t0 a_1242_7157.t3 610.8013
Rpar2 a_1242_7157.t0 a_1242_7157.t6 107.1639
Rpar3 a_1242_7157.t2 a_1242_7157.t3 29.8792
Rpar4 a_1242_7157.t2 a_1242_7157.t6 635.5782
Rpar5 a_1242_7157.t3 a_1242_7157.t6 968.3182
Rpar6 a_1772_8998.t0 a_1772_8998.t16 54.8022
Rpar7 a_2980_2910.t0 a_2980_2910.t4 84.5324
Rpar8 a_2980_2910.t0 a_2980_2910.t12 62.3625
Rpar9 a_2980_2910.t4 a_2980_2910.t12 143.5497
Rpar10 a_3880_5777.t0 a_3880_5777.t1 118.9551
Rpar11 a_3880_5777.t0 a_3880_5777.t2 85.5835
Rpar12 a_3880_5777.t1 a_3880_5777.t2 21.9851
Rpar13 a_7374_4366.t0 a_7374_4366.t4 84.5324
Rpar14 a_7374_4366.t0 a_7374_4366.t12 62.3625
Rpar15 a_7374_4366.t4 a_7374_4366.t12 143.5497
Rpar16 ib ib.t1 17.7339
Rpar17 inn inn.t0 2.8910
Rpar18 inp inp.t0 2.8910
Rpar19 out out.t0 16.2177
Rpar20 out out.t1 64.1102
Rpar21 out.t0 out.t1 244.7670
Rpar22 vdd vdd.t0 186.9607
Rpar23 vdd vdd.t1 389.4682
Rpar24 vdd vdd.t8 22.0752
Rpar25 vdd.t0 vdd.t1 5.6613
Rpar26 vdd.t0 vdd.t8 72.4788
Rpar27 vdd.t1 vdd.t8 150.9845
Rpar28 vss vss.t0 139.2189
Rpar29 vss vss.t1 24.3503
Rpar30 vss vss.t2 87.8406
Rpar31 vss.t0 vss.t1 9.0431
Rpar32 vss.t0 vss.t2 34.2239
Rpar33 vss.t1 vss.t2 5.7936
Cpar0 a_1242_7157.t0 vss 1.11867e-14
Cpar1 a_1242_7157.t2 vss 2.85071e-14
Cpar2 a_1242_7157.t3 vss 8.17278e-15
Cpar3 a_1242_7157.t6 vss 1.34197e-14
Cpar4 a_1772_8998.t0 vss 5.18156e-14
Cpar5 a_1772_8998.t16 vss 6.84252e-15
Cpar6 a_2980_2910.t0 vss 5.86172e-15
Cpar7 a_2980_2910.t12 vss 3.74530e-15
Cpar8 a_2980_2910.t4 vss 2.55798e-14
Cpar9 a_3880_5777.t0 vss 2.62752e-15
Cpar10 a_3880_5777.t1 vss 1.88725e-14
Cpar11 a_3880_5777.t2 vss 4.96988e-15
Cpar12 a_7374_4366.t0 vss 5.58455e-15
Cpar13 a_7374_4366.t12 vss 3.59375e-15
Cpar14 a_7374_4366.t4 vss 2.45446e-14
Cpar15 ib vss 4.93896e-14
Cpar16 ib.t1 vss 4.14207e-16
Cpar17 inn inp 1.05060e-16
Cpar18 inn vdd 2.69343e-14
Cpar19 inn vss 6.10878e-15
Cpar20 inn.t0 vss 3.91147e-14
Cpar21 inp vdd 2.63521e-14
Cpar22 inp vss 6.04228e-15
Cpar23 inp.t0 vss 3.87930e-14
Cpar24 out vdd 4.36492e-15
Cpar25 out vss 7.60316e-15
Cpar26 out.t0 vss 1.31857e-15
Cpar27 out.t1 vss 2.54411e-15
Cpar28 vdd vss 3.85063e-13
Cpar29 vdd.t0 vss 2.55098e-14
Cpar30 vdd.t1 vss 1.26305e-14
Cpar31 vdd.t8 vss 1.01009e-13
.ends opamp_dut

Vdd vdd 0 3.300000
Vss vss 0 0
Ibias vdd ib 1.440000e-08
Vinp inp 0 DC 1.381000 AC 1 PWL(0 1.381000 3.270016e-06 1.381000 3.597017e-06 1.391000)
Rfb out inn 1m
Cload out 0 2.000000e-12
Xdut vdd vss inp inn out ib opamp_dut
.end
