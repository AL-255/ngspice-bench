* opa1000[0134]: 2p/current_reuse_1v8_i2u_weak (current_reuse, VDD=1.8V, CL=2.0pF, Iref=0.2uA)
.include "pdk_opa.inc"
.temp 27
.option gmin=1e-12 rshunt=1e12 reltol=1e-3 abstol=1e-12 vntol=1e-5 method=gear
* Post-PEX R+C extracted netlist for current_reuse_1v8_i2u_weak
.subckt opamp_dut vdd vss inp inn out ib
XMpar0 a_1042_13544.t4 a_880_13336.t0 vdd.t1 vdd.t0 pfet_03v3 w=0.58u l=0.81u ad=1.6240e-13 pd=1.1400e-06 as=3.4800e-13 ps=2.3600e-06 nf=1 m=2 par=2
XMpar1 a_1015_10041.t0 inp.t2 a_1042_13544.t0 vdd.t12 pfet_03v3 w=1.81u l=3.75u ad=5.0680e-13 pd=2.3700e-06 as=7.9640e-13 ps=3.5950e-06 nf=1 m=4 par=4
XMpar2 out.t0 ib.t0 vss.t3 vss.t2 nfet_03v3 w=0.4u l=3.25u ad=1.8880e-13 pd=1.5840e-06 as=1.6320e-13 ps=1.3760e-06 nf=1 m=10 par=10
XMpar3 a_880_13336.t1 a_880_13336.t0 vdd.t1 vdd.t0 pfet_03v3 w=0.58u l=0.81u ad=3.4800e-13 pd=2.3600e-06 as=1.6240e-13 ps=1.1400e-06 nf=1 m=1
XMpar4 a_1015_10041.t3 inp.t0 a_5174_6550.t0 vss.t0 nfet_03v3 w=1.81u l=3.75u ad=5.0680e-13 pd=2.3700e-06 as=1.0860e-12 ps=4.8200e-06 nf=1 m=2 par=2
XMpar5 a_1042_13544.t0 inn.t2 a_880_13336.t4 vdd.t12 pfet_03v3 w=1.81u l=3.75u ad=7.9640e-13 pd=3.5950e-06 as=5.0680e-13 ps=2.3700e-06 nf=1 m=4 par=4
XMpar6 out.t1 a_1015_10041.t8 vdd.t1 vdd.t0 pfet_03v3 w=0.58u l=0.81u ad=1.6240e-13 pd=1.1400e-06 as=1.9952e-13 ps=1.3840e-06 nf=1 m=10 par=10
XMpar7 a_5174_6550.t2 ib.t0 vss.t3 vss.t2 nfet_03v3 w=0.4u l=3.25u ad=2.4000e-13 pd=2.0000e-06 as=1.1200e-13 ps=9.6000e-07 nf=1 m=4 par=4
XMpar8 a_5174_6550.t0 inn.t0 a_880_13336.t2 vss.t0 nfet_03v3 w=1.81u l=3.75u ad=1.0860e-12 pd=4.8200e-06 as=5.0680e-13 ps=2.3700e-06 nf=1 m=2 par=2
XMpar9 ib.t1 ib.t0 vss.t3 vss.t2 nfet_03v3 w=0.4u l=3.25u ad=2.4000e-13 pd=2.0000e-06 as=1.1200e-13 ps=9.6000e-07 nf=1 m=2 par=2
XMpar10 a_1015_10041.t6 a_880_13336.t0 vdd.t1 vdd.t0 pfet_03v3 w=0.58u l=0.81u ad=3.4800e-13 pd=2.3600e-06 as=1.6240e-13 ps=1.1400e-06 nf=1 m=1
X2 a_9519_1810.t0 a_13135_2330.t0 vss.t1 ppolyf_u_1k r_width=1u r_length=17.42u
X11 a_9519_1810.t0 a_13135_1290.t0 vss.t1 ppolyf_u_1k r_width=1u r_length=17.42u
X25 a_1015_10041.t7 a_13135_1290.t0 vss.t1 ppolyf_u_1k r_width=1u r_length=17.42u
X26 a_13135_3370.t1 out.t12 cap_mim_2f0fF c_width=18.03u c_length=18.03u
X39 a_9519_2850.t0 a_13135_3370.t0 vss.t1 ppolyf_u_1k r_width=1u r_length=17.42u
X40 a_13135_3370.t1 out.t12 cap_mim_2f0fF c_width=18.03u c_length=18.03u
X44 a_9519_2850.t0 a_13135_2330.t0 vss.t1 ppolyf_u_1k r_width=1u r_length=17.42u
Rpar0 a_1015_10041.t0 a_1015_10041.t8 69.4756
Rpar1 a_1015_10041.t0 a_1015_10041.t3 199.9742
Rpar2 a_1015_10041.t0 a_1015_10041.t6 162.1596
Rpar3 a_1015_10041.t0 a_1015_10041.t7 330.8603
Rpar4 a_1015_10041.t8 a_1015_10041.t3 165.4492
Rpar5 a_1015_10041.t8 a_1015_10041.t6 249.5821
Rpar6 a_1015_10041.t8 a_1015_10041.t7 273.7382
Rpar7 a_1015_10041.t3 a_1015_10041.t6 718.3810
Rpar8 a_1015_10041.t3 a_1015_10041.t7 175.6061
Rpar9 a_1015_10041.t6 a_1015_10041.t7 1188.5719
Rpar10 a_1042_13544.t0 a_1042_13544.t4 62.0454
Rpar11 a_13135_3370.t0 a_13135_3370.t1 61.5473
Rpar12 a_5174_6550.t0 a_5174_6550.t2 73.7172
Rpar13 a_880_13336.t0 a_880_13336.t1 34.6394
Rpar14 a_880_13336.t0 a_880_13336.t2 345.4829
Rpar15 a_880_13336.t0 a_880_13336.t4 148.5782
Rpar16 a_880_13336.t1 a_880_13336.t2 495.6243
Rpar17 a_880_13336.t1 a_880_13336.t4 213.1480
Rpar18 a_880_13336.t2 a_880_13336.t4 83.7850
Rpar19 ib ib.t0 14.1754
Rpar20 ib ib.t1 14.5818
Rpar21 ib.t0 ib.t1 34.3204
Rpar22 inn inn.t0 4.0540
Rpar23 inn inn.t2 32.9913
Rpar24 inp inp.t0 4.1026
Rpar25 inp inp.t2 32.9427
Rpar26 out out.t0 52.9158
Rpar27 out out.t1 3.2502
Rpar28 out out.t12 92.7416
Rpar29 out.t0 out.t12 376.7612
Rpar30 vdd vdd.t0 57.5416
Rpar31 vdd vdd.t1 58.6823
Rpar32 vdd vdd.t12 130.1539
Rpar33 vdd.t0 vdd.t1 4.5549
Rpar34 vdd.t0 vdd.t12 104.0471
Rpar35 vdd.t1 vdd.t12 105.5477
Rpar36 vss vss.t0 196.3359
Rpar37 vss vss.t1 24.9833
Rpar38 vss vss.t3 1364.6966
Rpar39 vss vss.t2 247.8667
Rpar40 vss.t0 vss.t1 296.4824
Rpar41 vss.t0 vss.t3 768.6133
Rpar42 vss.t0 vss.t2 138.6400
Rpar43 vss.t1 vss.t3 3139.4126
Rpar44 vss.t1 vss.t2 569.6931
Rpar45 vss.t3 vss.t2 13.1381
Cpar0 a_1015_10041.t0 vss 5.52129e-15
Cpar1 a_1015_10041.t3 vss 4.75541e-15
Cpar2 a_1015_10041.t6 vss 2.82905e-15
Cpar3 a_1015_10041.t7 vss 5.88870e-15
Cpar4 a_1015_10041.t8 vss 8.10780e-15
Cpar5 a_1042_13544.t0 vss 8.87598e-15
Cpar6 a_1042_13544.t4 vss 3.44435e-15
Cpar7 a_13135_1290.t0 vss 2.64400e-17
Cpar8 a_13135_2330.t0 vss 3.27400e-17
Cpar9 a_13135_3370.t0 vss 8.13574e-17
Cpar10 a_13135_3370.t1 vss 5.32420e-15
Cpar11 a_5174_6550.t0 vss 7.43578e-15
Cpar12 a_5174_6550.t2 vss 1.56532e-14
Cpar13 a_880_13336.t0 vss 5.82906e-15
Cpar14 a_880_13336.t1 vss 2.83286e-15
Cpar15 a_880_13336.t2 vss 3.01151e-15
Cpar16 a_880_13336.t4 vss 5.19483e-15
Cpar17 a_9519_1810.t0 vss 4.23400e-17
Cpar18 a_9519_2850.t0 vss 3.60400e-17
Cpar19 ib inn 2.22000e-17
Cpar20 ib out 2.16051e-15
Cpar21 ib vdd 1.69340e-16
Cpar22 ib vss 4.13932e-14
Cpar23 ib.t0 vss 7.20771e-15
Cpar24 ib.t1 vss 6.06954e-16
Cpar25 inn inp 1.03180e-16
Cpar26 inn out 2.42600e-17
Cpar27 inn vdd 7.32739e-15
Cpar28 inn vss 8.06510e-15
Cpar29 inn.t0 vss 1.95993e-15
Cpar30 inn.t2 vss 6.88494e-15
Cpar31 inp out 4.84600e-17
Cpar32 inp vdd 7.39292e-15
Cpar33 inp vss 7.13914e-15
Cpar34 inp.t0 vss 2.19384e-15
Cpar35 inp.t2 vss 7.64973e-15
Cpar36 out vdd 6.03077e-15
Cpar37 out vss 2.44203e-14
Cpar38 out.t0 vss 5.49877e-15
Cpar39 out.t1 vss 4.33455e-16
Cpar40 out.t12 vss 1.64080e-14
Cpar41 vdd vss 8.44703e-14
Cpar42 vdd.t0 vss 1.03328e-14
Cpar43 vdd.t1 vss 8.08092e-15
Cpar44 vdd.t12 vss 2.19443e-14
.ends opamp_dut

Vdd vdd 0 1.800000
Vss vss 0 0
Ibias vdd ib 2.000000e-07
Vinp inp 0 DC 0.895000 AC 1 PWL(0 0.895000 1.678561e-07 0.895000 1.846417e-07 0.905000)
Rfb out inn 1m
Cload out 0 2.000000e-12
Xdut vdd vss inp inn out ib opamp_dut
.end
