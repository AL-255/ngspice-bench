* opa1000[0380]: 2p/nmos_5t_1v8_0p1u_1u_weak (nmos_5t, VDD=1.8V, CL=2.0pF, Iref=0.1437uA)
.include "pdk_opa.inc"
.temp 27
.option gmin=1e-12 rshunt=1e12 reltol=1e-3 abstol=1e-12 vntol=1e-5 method=gear
* Post-PEX R+C extracted netlist for nmos_5t_1v8_0p1u_1u_weak
.subckt opamp_dut vdd vss inp inn out ib
XMpar0 out.t0 a_1958_7059.t0 vdd.t1 vdd.t0 pfet_03v3 w=1.62u l=10u ad=4.5360e-13 pd=2.1800e-06 as=4.5360e-13 ps=2.1800e-06 nf=1 m=6 par=6
XMpar1 a_1554_4218.t8 inp.t0 a_1958_7059.t12 vss.t15 nfet_03v3 w=2.01u l=10u ad=1.2060e-12 pd=5.2200e-06 as=5.6280e-13 ps=2.5700e-06 nf=1 m=4 par=4
XMpar2 a_1958_7059.t1 a_1958_7059.t0 vdd.t1 vdd.t0 pfet_03v3 w=1.62u l=10u ad=9.7200e-13 pd=4.4400e-06 as=4.5360e-13 ps=2.1800e-06 nf=1 m=6 par=6
XMpar3 a_1554_4218.t0 ib.t0 vss.t1 vss.t0 nfet_03v3 w=0.61u l=7.5u ad=1.7080e-13 pd=1.1700e-06 as=3.1720e-13 ps=2.1075e-06 nf=1 m=8 par=8
XMpar4 a_1554_4218.t8 inn.t0 out.t4 vss.t15 nfet_03v3 w=2.01u l=10u ad=1.2060e-12 pd=5.2200e-06 as=5.6280e-13 ps=2.5700e-06 nf=1 m=4 par=4
XMpar5 ib.t1 ib.t0 vss.t1 vss.t0 nfet_03v3 w=0.61u l=7.5u ad=3.6600e-13 pd=2.4200e-06 as=1.7080e-13 ps=1.1700e-06 nf=1 m=2 par=2
Rpar0 a_1554_4218.t0 a_1554_4218.t8 31.0130
Rpar1 a_1958_7059.t0 a_1958_7059.t1 6.1400
Rpar2 a_1958_7059.t0 a_1958_7059.t12 123.2550
Rpar3 a_1958_7059.t1 a_1958_7059.t12 58.1783
Rpar4 ib ib.t0 15.6941
Rpar5 ib ib.t1 13.8403
Rpar6 ib.t0 ib.t1 31.1722
Rpar7 inn inn.t0 3.4266
Rpar8 inp inp.t0 3.4266
Rpar9 out out.t0 10.0625
Rpar10 out out.t4 37.8368
Rpar11 vdd vdd.t0 23.4092
Rpar12 vdd vdd.t1 154.8447
Rpar13 vdd.t0 vdd.t1 12.8408
Rpar14 vss vss.t0 62.2164
Rpar15 vss vss.t1 615.2551
Rpar16 vss vss.t15 111.3945
Rpar17 vss.t0 vss.t1 18.6147
Rpar18 vss.t0 vss.t15 3.7988
Rpar19 vss.t1 vss.t15 37.0023
Cpar0 a_1554_4218.t0 vss 9.24591e-15
Cpar1 a_1554_4218.t8 vss 1.49123e-14
Cpar2 a_1958_7059.t0 vss 7.69705e-14
Cpar3 a_1958_7059.t1 vss 1.66104e-14
Cpar4 a_1958_7059.t12 vss 7.26268e-15
Cpar5 ib inn 3.72900e-17
Cpar6 ib inp 4.36600e-17
Cpar7 ib vss 5.21570e-14
Cpar8 ib.t0 vss 7.40125e-15
Cpar9 ib.t1 vss 5.73183e-16
Cpar10 inn inp 1.03940e-16
Cpar11 inn out 2.43486e-15
Cpar12 inn vdd 1.88000e-17
Cpar13 inn vss 1.71756e-14
Cpar14 inn.t0 vss 3.97439e-15
Cpar15 inp vdd 2.05900e-17
Cpar16 inp vss 1.69518e-14
Cpar17 inp.t0 vss 4.01575e-15
Cpar18 out vdd 1.44047e-14
Cpar19 out vss 1.70345e-14
Cpar20 out.t0 vss 1.68182e-14
Cpar21 out.t4 vss 1.01443e-14
Cpar22 vdd vss 1.54749e-13
Cpar23 vdd.t0 vss 6.69495e-14
Cpar24 vdd.t1 vss 1.38436e-14
.ends opamp_dut

Vdd vdd 0 1.800000
Vss vss 0 0
Ibias vdd ib 1.437000e-07
Vinp inp 0 DC 0.895000 AC 1 PWL(0 0.895000 2.830225e-07 0.895000 3.113247e-07 0.905000)
Rfb out inn 1m
Cload out 0 2.000000e-12
Xdut vdd vss inp inn out ib opamp_dut
.end
