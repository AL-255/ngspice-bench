* opa1000[0855]: 200f/telescopic_nmos_3v3_i50n_subth (telescopic_nmos, VDD=3.3V, CL=0.2pF, Iref=0.0144uA)
.include "pdk_opa.inc"
.temp 27
.option gmin=1e-12 rshunt=1e12 reltol=1e-3 abstol=1e-12 vntol=1e-5 method=gear
* Post-PEX R+C extracted netlist for telescopic_nmos_3v3_i50n_subth
.subckt opamp_dut vdd vss inp inn out ib
XMpar0 a_1966_6705.t4 ib.t0 vss.t7 vss.t6 nfet_03v3 w=0.4u l=3u ad=1.1200e-13 pd=9.6000e-07 as=1.4400e-13 ps=1.2200e-06 nf=1 m=8 par=8
XMpar1 a_3620_4621.t0 a_1488_4413.t4 out.t1 vdd.t0 pfet_03v3 w=1.72u l=4.38u ad=7.5680e-13 pd=3.4600e-06 as=4.8160e-13 ps=2.2800e-06 nf=1 m=4 par=4
XMpar2 a_1368_4621.t0 a_1488_4413.t4 a_1488_4413.t5 vdd.t0 pfet_03v3 w=1.72u l=4.38u ad=1.0320e-12 pd=4.6400e-06 as=4.8160e-13 ps=2.2800e-06 nf=1 m=4 par=4
XMpar3 a_1368_4621.t1 a_1488_4413.t18 vdd.t3 vdd.t2 pfet_03v3 w=0.97u l=5.2u ad=5.8200e-13 pd=3.1400e-06 as=2.7160e-13 ps=1.5300e-06 nf=1 m=2 par=2
XMpar4 a_3620_4621.t3 a_1488_4413.t18 vdd.t3 vdd.t2 pfet_03v3 w=0.97u l=5.2u ad=2.7160e-13 pd=1.5300e-06 as=2.7160e-13 ps=1.5300e-06 nf=1 m=2 par=2
XMpar5 a_1966_6705.t0 inp.t0 a_3344_2772.t1 vss.t1 nfet_03v3 w=1.18u l=5.5u ad=7.0800e-13 pd=3.5600e-06 as=3.3040e-13 ps=1.7400e-06 nf=1 m=2 par=2
XMpar6 a_1966_6705.t0 inn.t0 a_4608_2772.t0 vss.t1 nfet_03v3 w=1.18u l=5.5u ad=7.0800e-13 pd=3.5600e-06 as=3.3040e-13 ps=1.7400e-06 nf=1 m=2 par=2
XMpar7 ib.t1 ib.t0 vss.t7 vss.t6 nfet_03v3 w=0.4u l=3u ad=1.1200e-13 pd=9.6000e-07 as=1.1200e-13 ps=9.6000e-07 nf=1 m=2 par=2
XMpar8 a_1488_4413.t1 a_1488_4413.t0 a_3344_2772.t0 vss.t0 nfet_03v3 w=0.77u l=4.38u ad=4.6200e-13 pd=2.7400e-06 as=4.6200e-13 ps=2.7400e-06 nf=1 m=2 par=2
XMpar9 a_4608_2772.t2 a_1488_4413.t0 out.t0 vss.t0 nfet_03v3 w=0.77u l=4.38u ad=4.6200e-13 pd=2.7400e-06 as=2.1560e-13 ps=1.3300e-06 nf=1 m=2 par=2
Rpar0 a_1368_4621.t0 a_1368_4621.t1 72.3265
Rpar1 a_1488_4413.t0 a_1488_4413.t1 23.4780
Rpar2 a_1488_4413.t0 a_1488_4413.t4 436.7863
Rpar3 a_1488_4413.t0 a_1488_4413.t5 242.3912
Rpar4 a_1488_4413.t0 a_1488_4413.t18 389.7921
Rpar5 a_1488_4413.t1 a_1488_4413.t4 312.4257
Rpar6 a_1488_4413.t1 a_1488_4413.t5 173.3783
Rpar7 a_1488_4413.t1 a_1488_4413.t18 278.8116
Rpar8 a_1488_4413.t4 a_1488_4413.t5 20.7235
Rpar9 a_1488_4413.t4 a_1488_4413.t18 171.1339
Rpar10 a_1488_4413.t5 a_1488_4413.t18 94.9694
Rpar11 a_1966_6705.t0 a_1966_6705.t4 64.1483
Rpar12 a_3344_2772.t0 a_3344_2772.t1 49.8644
Rpar13 a_3620_4621.t0 a_3620_4621.t3 61.9301
Rpar14 a_4608_2772.t0 a_4608_2772.t2 50.6823
Rpar15 ib ib.t0 10.8684
Rpar16 ib ib.t1 16.8204
Rpar17 inn inn.t0 3.5145
Rpar18 inp inp.t0 3.5631
Rpar19 out out.t0 46.2845
Rpar20 out out.t1 7.6085
Rpar21 vdd vdd.t0 129.9624
Rpar22 vdd vdd.t3 68.7359
Rpar23 vdd vdd.t2 38.3441
Rpar24 vdd.t0 vdd.t3 214.5826
Rpar25 vdd.t0 vdd.t2 119.7043
Rpar26 vdd.t3 vdd.t2 15.1716
Rpar27 vss vss.t0 60.0740
Rpar28 vss vss.t1 132.4591
Rpar29 vss vss.t6 367.1063
Rpar30 vss vss.t7 766.1313
Rpar31 vss.t0 vss.t1 9.8983
Rpar32 vss.t0 vss.t6 186.0988
Rpar33 vss.t0 vss.t7 388.9489
Rpar34 vss.t1 vss.t6 410.3349
Rpar35 vss.t1 vss.t7 857.6053
Rpar36 vss.t6 vss.t7 6.8925
Cpar0 a_1368_4621.t0 vss 1.06382e-14
Cpar1 a_1368_4621.t1 vss 6.88879e-15
Cpar2 a_1488_4413.t0 vss 8.90368e-15
Cpar3 a_1488_4413.t1 vss 2.98016e-15
Cpar4 a_1488_4413.t18 vss 1.14926e-14
Cpar5 a_1488_4413.t4 vss 2.20147e-14
Cpar6 a_1488_4413.t5 vss 5.21097e-15
Cpar7 a_1966_6705.t0 vss 4.45624e-15
Cpar8 a_1966_6705.t4 vss 5.32236e-15
Cpar9 a_3344_2772.t0 vss 3.41170e-15
Cpar10 a_3344_2772.t1 vss 2.02889e-15
Cpar11 a_3620_4621.t0 vss 1.24580e-14
Cpar12 a_3620_4621.t3 vss 6.18404e-15
Cpar13 a_4608_2772.t0 vss 2.60611e-15
Cpar14 a_4608_2772.t2 vss 4.28022e-15
Cpar15 ib out 1.03500e-17
Cpar16 ib vdd 2.66970e-16
Cpar17 ib vss 2.25887e-14
Cpar18 ib.t0 vss 3.13205e-15
Cpar19 ib.t1 vss 1.61979e-16
Cpar20 inn inp 5.23500e-17
Cpar21 inn vss 5.98929e-15
Cpar22 inn.t0 vss 5.71862e-16
Cpar23 inp vss 5.85294e-15
Cpar24 inp.t0 vss 5.68050e-16
Cpar25 out vdd 5.02955e-15
Cpar26 out vss 1.13445e-14
Cpar27 out.t0 vss 3.68108e-15
Cpar28 out.t1 vss 2.88557e-15
Cpar29 vdd vss 9.60230e-14
Cpar30 vdd.t0 vss 2.54382e-14
Cpar31 vdd.t2 vss 7.78129e-15
Cpar32 vdd.t3 vss 4.37343e-15
.ends opamp_dut

Vdd vdd 0 3.300000
Vss vss 0 0
Ibias vdd ib 1.440000e-08
Vinp inp 0 DC 1.711000 AC 1 PWL(0 1.711000 2.853570e-07 1.711000 3.138927e-07 1.721000)
Rfb out inn 1m
Cload out 0 2.000000e-13
Xdut vdd vss inp inn out ib opamp_dut
.end
