* opa1000[0801]: 2p/symmetrical_ota_1v8_i2u_subth (symmetrical_ota, VDD=1.8V, CL=2.0pF, Iref=0.4333uA)
.include "pdk_opa.inc"
.temp 27
.option gmin=1e-12 rshunt=1e12 reltol=1e-3 abstol=1e-12 vntol=1e-5 method=gear
* Post-PEX R+C extracted netlist for symmetrical_ota_1v8_i2u_subth
.subckt opamp_dut vdd vss inp inn out ib
XMpar0 a_4148_10226.t5 a_4148_10226.t4 vss.t1 vss.t0 nfet_03v3 w=1.32u l=3.4u ad=3.6960e-13 pd=1.8800e-06 as=3.6960e-13 ps=1.8800e-06 nf=1 m=4 par=4
XMpar1 a_4148_10226.t0 a_7214_2875.t0 vdd.t1 vdd.t0 pfet_03v3 w=5.34u l=3.4u ad=1.4952e-12 pd=5.9000e-06 as=2.3496e-12 ps=8.8900e-06 nf=1 m=4 par=4
XMpar2 a_1114_7668.t0 inp.t0 a_1426_1204.t0 vss.t4 nfet_03v3 w=1.94u l=1.9u ad=5.7972e-13 pd=2.6518e-06 as=6.5275e-13 ps=2.9553e-06 nf=1 m=34 par=34
XMpar3 a_1426_1204.t0 inn.t0 a_7214_2875.t4 vss.t4 nfet_03v3 w=1.94u l=1.9u ad=6.5275e-13 pd=2.9553e-06 as=5.7972e-13 ps=2.6518e-06 nf=1 m=34 par=34
XMpar4 a_1114_7668.t35 a_1114_7668.t34 vdd.t1 vdd.t0 pfet_03v3 w=5.34u l=3.4u ad=1.4952e-12 pd=5.9000e-06 as=1.4952e-12 ps=5.9000e-06 nf=1 m=2 par=2
XMpar5 a_7214_2875.t1 a_7214_2875.t0 vdd.t1 vdd.t0 pfet_03v3 w=5.34u l=3.4u ad=1.4952e-12 pd=5.9000e-06 as=1.4952e-12 ps=5.9000e-06 nf=1 m=2 par=2
XMpar6 ib.t1 ib.t0 vss.t45 vss.t44 nfet_03v3 w=0.9u l=1.56u ad=2.5200e-13 pd=1.4600e-06 as=2.5200e-13 ps=1.4600e-06 nf=1 m=2 par=2
XMpar7 out.t1 a_4148_10226.t4 vss.t1 vss.t0 nfet_03v3 w=1.32u l=3.4u ad=3.6960e-13 pd=1.8800e-06 as=5.8080e-13 ps=2.8600e-06 nf=1 m=4 par=4
XMpar8 a_1426_1204.t68 ib.t0 vss.t45 vss.t44 nfet_03v3 w=0.9u l=1.56u ad=2.5200e-13 pd=1.4600e-06 as=3.9600e-13 ps=2.2300e-06 nf=1 m=4 par=4
XMpar9 out.t0 a_1114_7668.t34 vdd.t1 vdd.t0 pfet_03v3 w=5.34u l=3.4u ad=1.4952e-12 pd=5.9000e-06 as=2.3496e-12 ps=8.8900e-06 nf=1 m=4 par=4
Rpar0 a_1114_7668.t0 a_1114_7668.t34 99.7861
Rpar1 a_1114_7668.t0 a_1114_7668.t35 67.0697
Rpar2 a_1114_7668.t34 a_1114_7668.t35 24.6780
Rpar3 a_1426_1204.t0 a_1426_1204.t68 41.9404
Rpar4 a_4148_10226.t0 a_4148_10226.t4 152.7946
Rpar5 a_4148_10226.t0 a_4148_10226.t5 60.9868
Rpar6 a_4148_10226.t4 a_4148_10226.t5 22.0139
Rpar7 a_7214_2875.t0 a_7214_2875.t1 24.6780
Rpar8 a_7214_2875.t0 a_7214_2875.t4 99.7861
Rpar9 a_7214_2875.t1 a_7214_2875.t4 67.0697
Rpar10 ib ib.t0 12.0455
Rpar11 ib ib.t1 13.5861
Rpar12 inn inn.t0 1.7540
Rpar13 inp inp.t0 1.7540
Rpar14 out out.t0 4.5239
Rpar15 out out.t1 77.6511
Rpar16 out.t0 out.t1 96.5186
Rpar17 vdd vdd.t0 83.8995
Rpar18 vdd vdd.t1 221.2347
Rpar19 vdd.t0 vdd.t1 2.9161
Rpar20 vss vss.t0 557.5851
Rpar21 vss vss.t1 1246.4817
Rpar22 vss vss.t4 51.4801
Rpar23 vss vss.t44 142.0842
Rpar24 vss vss.t45 371.2051
Rpar25 vss.t0 vss.t1 7.1176
Rpar26 vss.t0 vss.t4 39.9003
Rpar27 vss.t0 vss.t44 252.4725
Rpar28 vss.t0 vss.t45 1058.2173
Rpar29 vss.t1 vss.t4 89.2904
Rpar30 vss.t1 vss.t44 565.0693
Rpar31 vss.t4 vss.t44 2.1935
Rpar32 vss.t4 vss.t45 11.1305
Rpar33 vss.t44 vss.t45 12.5763
Cpar0 a_1114_7668.t0 vss 1.96060e-14
Cpar1 a_1114_7668.t34 vss 2.27798e-14
Cpar2 a_1114_7668.t35 vss 4.09842e-15
Cpar3 a_1426_1204.t0 vss 4.45161e-14
Cpar4 a_1426_1204.t68 vss 2.81752e-15
Cpar5 a_4148_10226.t0 vss 3.11490e-15
Cpar6 a_4148_10226.t4 vss 7.44739e-15
Cpar7 a_4148_10226.t5 vss 1.68987e-15
Cpar8 a_7214_2875.t0 vss 2.35251e-14
Cpar9 a_7214_2875.t1 vss 4.23250e-15
Cpar10 a_7214_2875.t4 vss 2.02474e-14
Cpar11 ib inp 1.06400e-17
Cpar12 ib vss 9.38754e-15
Cpar13 ib.t0 vss 1.26208e-15
Cpar14 ib.t1 vss 5.37039e-17
Cpar15 inn inp 1.35160e-16
Cpar16 inn vdd 1.25820e-16
Cpar17 inn vss 3.01145e-14
Cpar18 inn.t0 vss 1.65579e-14
Cpar19 inp vdd 1.84700e-17
Cpar20 inp vss 3.03378e-14
Cpar21 inp.t0 vss 1.65272e-14
Cpar22 out vdd 4.23789e-15
Cpar23 out vss 8.66276e-15
Cpar24 out.t0 vss 4.47857e-15
Cpar25 out.t1 vss 4.45172e-15
Cpar26 vdd vss 1.03393e-13
Cpar27 vdd.t0 vss 2.59337e-14
Cpar28 vdd.t1 vss 1.10534e-14
.ends opamp_dut

Vdd vdd 0 1.800000
Vss vss 0 0
Ibias vdd ib 4.333000e-07
Vinp inp 0 DC 0.895000 AC 1 PWL(0 0.895000 6.682585e-08 0.895000 7.350843e-08 0.905000)
Rfb out inn 1m
Cload out 0 2.000000e-12
Xdut vdd vss inp inn out ib opamp_dut
.end
