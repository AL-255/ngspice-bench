* opa1000[0975]: 2p/telescopic_pmos_1v8_10u_100u_weak (telescopic_pmos, VDD=1.8V, CL=2.0pF, Iref=11.5uA)
.include "pdk_opa.inc"
.temp 27
.option gmin=1e-12 rshunt=1e12 reltol=1e-3 abstol=1e-12 vntol=1e-5 method=gear
* Post-PEX R+C extracted netlist for telescopic_pmos_1v8_10u_100u_weak
.subckt opamp_dut vdd vss inp inn out ib
XMpar0 a_1554_12649.t0 inn.t0 a_7854_8712.t0 vdd.t36 pfet_03v3 w=5.03u l=0.8u ad=1.5090e-12 pd=5.9444e-06 as=1.4587e-12 ps=5.7672e-06 nf=1 m=64 par=64
XMpar1 a_1834_12649.t64 vss.t56 a_4066_8712.t24 vdd.t0 pfet_03v3 w=1.99u l=0.6u ad=6.1257e-13 pd=2.7787e-06 as=5.8489e-13 ps=2.6643e-06 nf=1 m=46 par=46
XMpar2 a_1554_12649.t0 inp.t0 a_1834_12649.t0 vdd.t36 pfet_03v3 w=5.03u l=0.8u ad=1.5090e-12 pd=5.9444e-06 as=1.4587e-12 ps=5.7672e-06 nf=1 m=64 par=64
XMpar3 a_4066_8712.t1 a_4066_8712.t0 a_4775_6634.t0 vss.t8 nfet_03v3 w=1.91u l=0.6u ad=5.3480e-13 pd=2.4700e-06 as=7.3853e-13 ps=3.3200e-06 nf=1 m=12 par=12
XMpar4 a_7854_8712.t64 vss.t56 out.t0 vdd.t0 pfet_03v3 w=1.99u l=0.6u ad=6.1257e-13 pd=2.7787e-06 as=5.8489e-13 ps=2.6643e-06 nf=1 m=46 par=46
XMpar5 a_6444_6634.t0 a_4066_8712.t0 out.t6 vss.t8 nfet_03v3 w=1.91u l=0.6u ad=6.3667e-13 pd=2.8950e-06 as=5.3480e-13 ps=2.4700e-06 nf=1 m=12 par=12
XMpar6 a_6444_6634.t1 a_4066_8712.t70 vss.t12 vss.t8 nfet_03v3 w=1.57u l=0.6u ad=4.3960e-13 pd=2.1300e-06 as=4.3960e-13 ps=2.1300e-06 nf=1 m=6 par=6
XMpar7 a_1554_12649.t128 a_1680_1205.t2 vdd.t2 vdd.t1 pfet_03v3 w=10u l=0.8u ad=2.8000e-12 pd=1.0560e-05 as=3.6000e-12 ps=1.3220e-05 nf=1 m=8 par=8
XMpar8 a_4775_6634.t2 a_4066_8712.t70 vss.t12 vss.t8 nfet_03v3 w=1.57u l=0.6u ad=6.0707e-13 pd=2.8667e-06 as=4.3960e-13 ps=2.1300e-06 nf=1 m=6 par=6
XMpar9 ib.t1 ib.t0 vss.t1 vss.t0 nfet_03v3 w=3.81u l=0.8u ad=2.2860e-12 pd=8.8200e-06 as=1.0668e-12 ps=4.3700e-06 nf=1 m=2 par=2
XMpar10 a_1680_1205.t0 ib.t0 vss.t1 vss.t0 nfet_03v3 w=3.81u l=0.8u ad=1.0668e-12 pd=4.3700e-06 as=1.0668e-12 ps=4.3700e-06 nf=1 m=2 par=2
XMpar11 a_1680_1205.t3 a_1680_1205.t2 vdd.t2 vdd.t1 pfet_03v3 w=10u l=0.8u ad=2.8000e-12 pd=1.0560e-05 as=2.8000e-12 ps=1.0560e-05 nf=1 m=2 par=2
Rpar0 a_1554_12649.t0 a_1554_12649.t128 73.6756
Rpar1 a_1680_1205.t0 a_1680_1205.t2 169.0707
Rpar2 a_1680_1205.t0 a_1680_1205.t3 73.3033
Rpar3 a_1680_1205.t2 a_1680_1205.t3 27.8202
Rpar4 a_1834_12649.t0 a_1834_12649.t64 48.8900
Rpar5 a_4066_8712.t0 a_4066_8712.t1 16.2012
Rpar6 a_4066_8712.t0 a_4066_8712.t24 369.4499
Rpar7 a_4066_8712.t0 a_4066_8712.t70 291.4243
Rpar8 a_4066_8712.t1 a_4066_8712.t24 87.8754
Rpar9 a_4066_8712.t1 a_4066_8712.t70 69.3166
Rpar10 a_4066_8712.t24 a_4066_8712.t70 208.4921
Rpar11 a_4775_6634.t0 a_4775_6634.t2 48.7515
Rpar12 a_6444_6634.t0 a_6444_6634.t1 49.1485
Rpar13 a_7854_8712.t0 a_7854_8712.t64 48.8900
Rpar14 ib ib.t0 18.6797
Rpar15 ib ib.t1 3.5617
Rpar16 inn inn.t0 1.9553
Rpar17 inp inp.t0 1.9553
Rpar18 out out.t0 187.1518
Rpar19 out out.t6 3.8824
Rpar20 out.t0 out.t6 80.1143
Rpar21 vdd vdd.t0 196.2921
Rpar22 vdd vdd.t1 1380.7798
Rpar23 vdd vdd.t36 20.9011
Rpar24 vdd.t0 vdd.t1 102.8230
Rpar25 vdd.t0 vdd.t36 71.1387
Rpar26 vdd.t0 vdd.t2 362.3830
Rpar27 vdd.t1 vdd.t36 500.4115
Rpar28 vdd.t1 vdd.t2 5.6042
Rpar29 vdd.t36 vdd.t2 1763.6203
Rpar30 vss vss.t0 84.2523
Rpar31 vss vss.t1 98.6755
Rpar32 vss vss.t8 76.4078
Rpar33 vss vss.t56 393.7702
Rpar34 vss vss.t12 737.8888
Rpar35 vss.t0 vss.t1 10.4571
Rpar36 vss.t0 vss.t8 619.5461
Rpar37 vss.t0 vss.t56 3872.1352
Rpar38 vss.t1 vss.t8 841.1954
Rpar39 vss.t1 vss.t56 4726.9882
Rpar40 vss.t8 vss.t56 53.8733
Rpar41 vss.t8 vss.t12 4.1024
Rpar42 vss.t56 vss.t12 1341.2311
Cpar0 a_1554_12649.t0 vss 1.29452e-13
Cpar1 a_1554_12649.t128 vss 1.91445e-14
Cpar2 a_1680_1205.t0 vss 2.13489e-15
Cpar3 a_1680_1205.t2 vss 1.28032e-14
Cpar4 a_1680_1205.t3 vss 4.60356e-15
Cpar5 a_1834_12649.t0 vss 7.17639e-14
Cpar6 a_1834_12649.t64 vss 2.83468e-14
Cpar7 a_4066_8712.t0 vss 1.12159e-14
Cpar8 a_4066_8712.t1 vss 8.49619e-15
Cpar9 a_4066_8712.t24 vss 2.14384e-14
Cpar10 a_4066_8712.t70 vss 6.27766e-15
Cpar11 a_4775_6634.t0 vss 8.47856e-15
Cpar12 a_4775_6634.t2 vss 3.99880e-15
Cpar13 a_6444_6634.t0 vss 1.15015e-14
Cpar14 a_6444_6634.t1 vss 5.01609e-15
Cpar15 a_7854_8712.t0 vss 7.18765e-14
Cpar16 a_7854_8712.t64 vss 2.83914e-14
Cpar17 ib vss 6.91242e-15
Cpar18 ib.t0 vss 4.17222e-16
Cpar19 ib.t1 vss 2.57960e-16
Cpar20 inn inp 9.76300e-17
Cpar21 inn out 1.16300e-17
Cpar22 inn vdd 3.06504e-14
Cpar23 inn vss 8.33492e-15
Cpar24 inn.t0 vss 5.33545e-14
Cpar25 inp vdd 3.01373e-14
Cpar26 inp vss 8.29428e-15
Cpar27 inp.t0 vss 5.30169e-14
Cpar28 out vdd 7.23166e-15
Cpar29 out vss 1.60408e-14
Cpar30 out.t0 vss 2.84880e-14
Cpar31 out.t6 vss 7.87414e-15
Cpar32 vdd vss 4.49169e-13
Cpar33 vdd.t0 vss 3.61344e-14
Cpar34 vdd.t1 vss 1.10734e-14
Cpar35 vdd.t2 vss 5.39759e-15
Cpar36 vdd.t36 vss 7.38863e-14
.ends opamp_dut

Vdd vdd 0 1.800000
Vss vss 0 0
Ibias vdd ib 1.150000e-05
Vinp inp 0 DC 0.805000 AC 1 PWL(0 0.805000 3.396043e-09 0.805000 3.735647e-09 0.815000)
Rfb out inn 1m
Cload out 0 2.000000e-12
Xdut vdd vss inp inn out ib opamp_dut
.end
