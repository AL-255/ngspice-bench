* opa1000[0181]: 200f/folded_cascode_nmos_1v8_i20u_subth (folded_cascode_nmos, VDD=1.8V, CL=0.2pF, Iref=4.6667uA)
.include "pdk_opa.inc"
.temp 27
.option gmin=1e-12 rshunt=1e12 reltol=1e-3 abstol=1e-12 vntol=1e-5 method=gear
* Post-PEX R+C extracted netlist for folded_cascode_nmos_1v8_i20u_subth
.subckt opamp_dut vdd vss inp inn out ib
XMpar0 a_1969_8242.t0 inp.t0 a_2538_1249.t0 vss.t0 nfet_03v3 w=1.94u l=0.52u ad=5.7587e-13 pd=2.6358e-06 as=5.7587e-13 ps=2.6358e-06 nf=1 m=38 par=38
XMpar1 a_2538_1249.t72 a_2673_8242.t2 vdd.t1 vdd.t0 pfet_03v3 w=10u l=0.88u ad=2.8000e-12 pd=1.0560e-05 as=4.4000e-12 ps=1.5880e-05 nf=1 m=4 par=4
XMpar2 a_2538_1249.t38 ib.t10 a_4336_11356.t0 vdd.t18 pfet_03v3 w=1.99u l=0.39u ad=6.3212e-13 pd=2.8594e-06 as=5.9466e-13 ps=2.7047e-06 nf=1 m=34 par=34
XMpar3 a_1969_8242.t0 inn.t0 a_6734_1249.t0 vss.t0 nfet_03v3 w=1.94u l=0.52u ad=5.7587e-13 pd=2.6358e-06 as=5.7587e-13 ps=2.6358e-06 nf=1 m=38 par=38
XMpar4 ib.t1 ib.t0 vss.t1 vss.t0 nfet_03v3 w=6.87u l=1.2u ad=4.1220e-12 pd=1.4940e-05 as=1.9236e-12 ps=7.4300e-06 nf=1 m=2 par=2
XMpar5 a_1969_8242.t76 ib.t0 vss.t1 vss.t0 nfet_03v3 w=6.87u l=1.2u ad=1.9236e-12 pd=7.4300e-06 as=1.9236e-12 ps=7.4300e-06 nf=1 m=4 par=4
XMpar6 a_4336_11356.t35 a_4336_11356.t34 vss.t1 vss.t0 nfet_03v3 w=6.87u l=1.2u ad=4.1220e-12 pd=1.4940e-05 as=1.9236e-12 ps=7.4300e-06 nf=1 m=2 par=2
XMpar7 a_6734_1249.t38 ib.t10 out.t0 vdd.t18 pfet_03v3 w=1.99u l=0.39u ad=6.3212e-13 pd=2.8594e-06 as=5.9466e-13 ps=2.7047e-06 nf=1 m=34 par=34
XMpar8 a_2673_8242.t0 ib.t0 vss.t1 vss.t0 nfet_03v3 w=6.87u l=1.2u ad=1.9236e-12 pd=7.4300e-06 as=1.9236e-12 ps=7.4300e-06 nf=1 m=2 par=2
XMpar9 a_6734_1249.t72 a_2673_8242.t2 vdd.t1 vdd.t0 pfet_03v3 w=10u l=0.88u ad=2.8000e-12 pd=1.0560e-05 as=4.4000e-12 ps=1.5880e-05 nf=1 m=4 par=4
XMpar10 out.t26 a_4336_11356.t34 vss.t1 vss.t0 nfet_03v3 w=6.87u l=1.2u ad=1.9236e-12 pd=7.4300e-06 as=1.9236e-12 ps=7.4300e-06 nf=1 m=2 par=2
XMpar11 a_2673_8242.t3 a_2673_8242.t2 vdd.t1 vdd.t0 pfet_03v3 w=10u l=0.88u ad=2.8000e-12 pd=1.0560e-05 as=6.0000e-12 ps=2.1200e-05 nf=1 m=2 par=2
X115 out.t36 vss.t62 cap_mim_2f0fF c_width=12.2u c_length=12.2u
Rpar0 a_1969_8242.t0 a_1969_8242.t76 51.3567
Rpar1 a_2538_1249.t0 a_2538_1249.t38 178.1744
Rpar2 a_2538_1249.t0 a_2538_1249.t72 60.9967
Rpar3 a_2538_1249.t38 a_2538_1249.t72 63.0129
Rpar4 a_2673_8242.t0 a_2673_8242.t2 114.0303
Rpar5 a_2673_8242.t0 a_2673_8242.t3 102.3281
Rpar6 a_2673_8242.t2 a_2673_8242.t3 39.5233
Rpar7 a_4336_11356.t0 a_4336_11356.t34 1030.8017
Rpar8 a_4336_11356.t0 a_4336_11356.t35 183.3696
Rpar9 a_4336_11356.t34 a_4336_11356.t35 22.7613
Rpar10 a_6734_1249.t0 a_6734_1249.t38 178.1744
Rpar11 a_6734_1249.t0 a_6734_1249.t72 60.9967
Rpar12 a_6734_1249.t38 a_6734_1249.t72 63.0129
Rpar13 ib ib.t0 690.8996
Rpar14 ib ib.t1 109.3111
Rpar15 ib ib.t10 2.1490
Rpar16 ib.t0 ib.t1 19.6770
Rpar17 ib.t0 ib.t10 682.0065
Rpar18 ib.t1 ib.t10 107.9041
Rpar19 inn inn.t0 2.2395
Rpar20 inp inp.t0 2.2395
Rpar21 out out.t0 146.5472
Rpar22 out out.t26 126.5567
Rpar23 out out.t36 14.8005
Rpar24 out.t0 out.t26 107.7885
Rpar25 vdd vdd.t0 413.1653
Rpar26 vdd vdd.t1 564.1112
Rpar27 vdd vdd.t18 20.4089
Rpar28 vdd.t0 vdd.t1 4.5435
Rpar29 vdd.t0 vdd.t18 159.4012
Rpar30 vdd.t1 vdd.t18 217.6368
Rpar31 vss vss.t0 61.2157
Rpar32 vss vss.t1 747.1630
Rpar33 vss vss.t62 940.4751
Rpar34 vss.t0 vss.t1 3.2972
Rpar35 vss.t0 vss.t62 56.4519
Rpar36 vss.t1 vss.t62 264.6833
Cpar0 a_1969_8242.t0 vss 4.42060e-14
Cpar1 a_1969_8242.t76 vss 9.92136e-15
Cpar2 a_2538_1249.t0 vss 2.60377e-14
Cpar3 a_2538_1249.t38 vss 2.36782e-14
Cpar4 a_2538_1249.t72 vss 1.28109e-14
Cpar5 a_2673_8242.t0 vss 4.71029e-15
Cpar6 a_2673_8242.t2 vss 1.59443e-14
Cpar7 a_2673_8242.t3 vss 5.61160e-15
Cpar8 a_4336_11356.t0 vss 2.16660e-14
Cpar9 a_4336_11356.t34 vss 7.56613e-15
Cpar10 a_4336_11356.t35 vss 1.37656e-14
Cpar11 a_6734_1249.t0 vss 2.61313e-14
Cpar12 a_6734_1249.t38 vss 2.37633e-14
Cpar13 a_6734_1249.t72 vss 1.28568e-14
Cpar14 ib out 5.35883e-15
Cpar15 ib vdd 2.53405e-14
Cpar16 ib vss 2.19891e-14
Cpar17 ib.t0 vss 1.36260e-14
Cpar18 ib.t1 vss 7.09854e-15
Cpar19 ib.t10 vss 2.18903e-14
Cpar20 inn inp 1.03210e-16
Cpar21 inn vss 1.77598e-14
Cpar22 inn.t0 vss 6.48333e-15
Cpar23 inp vss 1.77250e-14
Cpar24 inp.t0 vss 6.48899e-15
Cpar25 out vdd 6.69164e-15
Cpar26 out vss 1.57010e-14
Cpar27 out.t0 vss 9.71969e-15
Cpar28 out.t26 vss 3.13147e-15
Cpar29 out.t36 vss 2.51097e-14
Cpar30 vdd vss 1.45740e-13
Cpar31 vdd.t0 vss 1.61758e-14
Cpar32 vdd.t1 vss 1.33684e-14
Cpar33 vdd.t18 vss 3.48206e-14
.ends opamp_dut

Vdd vdd 0 1.800000
Vss vss 0 0
Ibias vdd ib 4.666700e-06
Vinp inp 0 DC 0.985000 AC 1 PWL(0 0.985000 3.848054e-09 0.985000 4.232859e-09 0.995000)
Rfb out inn 1m
Cload out 0 2.000000e-13
Xdut vdd vss inp inn out ib opamp_dut
.end
