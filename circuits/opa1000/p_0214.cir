* opa1000[0214]: 2p/folded_cascode_nmos_1v8_0p1u_1u_weak (folded_cascode_nmos, VDD=1.8V, CL=2.0pF, Iref=0.1444uA)
.include "pdk_opa.inc"
.temp 27
.option gmin=1e-12 rshunt=1e12 reltol=1e-3 abstol=1e-12 vntol=1e-5 method=gear
* Post-PEX R+C extracted netlist for folded_cascode_nmos_1v8_0p1u_1u_weak
.subckt opamp_dut vdd vss inp inn out ib
XMpar0 a_1560_1204.t2 ib.t0 vss.t3 vss.t2 nfet_03v3 w=0.61u l=7.5u ad=3.6600e-13 pd=2.4200e-06 as=1.7080e-13 ps=1.1700e-06 nf=1 m=4 par=4
XMpar1 a_4914_8734.t4 a_4234_6004.t2 vdd.t1 vdd.t0 pfet_03v3 w=1.21u l=5.2u ad=3.3880e-13 pd=1.7700e-06 as=7.2600e-13 ps=3.6200e-06 nf=1 m=4 par=4
XMpar2 a_1560_1204.t0 inp.t0 a_4914_8734.t0 vss.t0 nfet_03v3 w=1.72u l=6.5u ad=1.0320e-12 pd=4.6400e-06 as=4.8160e-13 ps=2.2800e-06 nf=1 m=2 par=2
XMpar3 a_6734_8734.t4 a_4234_6004.t2 vdd.t1 vdd.t0 pfet_03v3 w=1.21u l=5.2u ad=3.3880e-13 pd=1.7700e-06 as=7.2600e-13 ps=3.6200e-06 nf=1 m=4 par=4
XMpar4 a_3492_10445.t4 ib.t10 a_4914_8734.t2 vdd.t12 pfet_03v3 w=1.9u l=3.2u ad=5.3200e-13 pd=2.4600e-06 as=1.1400e-12 ps=5.0000e-06 nf=1 m=2 par=2
XMpar5 a_6734_8734.t0 ib.t10 out.t0 vdd.t12 pfet_03v3 w=1.9u l=3.2u ad=1.1400e-12 pd=5.0000e-06 as=5.3200e-13 ps=2.4600e-06 nf=1 m=2 par=2
XMpar6 a_4234_6004.t3 a_4234_6004.t2 vdd.t1 vdd.t0 pfet_03v3 w=1.21u l=5.2u ad=3.3880e-13 pd=1.7700e-06 as=7.2600e-13 ps=3.6200e-06 nf=1 m=2 par=2
XMpar7 out.t2 a_3492_10445.t0 vss.t3 vss.t2 nfet_03v3 w=0.61u l=7.5u ad=1.7080e-13 pd=1.1700e-06 as=1.7080e-13 ps=1.1700e-06 nf=1 m=2 par=2
XMpar8 a_1560_1204.t0 inn.t0 a_6734_8734.t2 vss.t0 nfet_03v3 w=1.72u l=6.5u ad=1.0320e-12 pd=4.6400e-06 as=4.8160e-13 ps=2.2800e-06 nf=1 m=2 par=2
XMpar9 a_3492_10445.t1 a_3492_10445.t0 vss.t3 vss.t2 nfet_03v3 w=0.61u l=7.5u ad=3.6600e-13 pd=2.4200e-06 as=1.7080e-13 ps=1.1700e-06 nf=1 m=2 par=2
XMpar10 a_4234_6004.t0 ib.t0 vss.t3 vss.t2 nfet_03v3 w=0.61u l=7.5u ad=3.6600e-13 pd=2.4200e-06 as=1.7080e-13 ps=1.1700e-06 nf=1 m=2 par=2
XMpar11 ib.t1 ib.t0 vss.t3 vss.t2 nfet_03v3 w=0.61u l=7.5u ad=3.6600e-13 pd=2.4200e-06 as=1.7080e-13 ps=1.1700e-06 nf=1 m=2 par=2
Rpar0 a_1560_1204.t0 a_1560_1204.t2 51.1143
Rpar1 a_3492_10445.t0 a_3492_10445.t1 21.5499
Rpar2 a_3492_10445.t0 a_3492_10445.t4 127.5239
Rpar3 a_3492_10445.t1 a_3492_10445.t4 92.1300
Rpar4 a_4234_6004.t0 a_4234_6004.t2 109.5883
Rpar5 a_4234_6004.t0 a_4234_6004.t3 253.0450
Rpar6 a_4234_6004.t2 a_4234_6004.t3 24.1192
Rpar7 a_4914_8734.t0 a_4914_8734.t2 123.7592
Rpar8 a_4914_8734.t0 a_4914_8734.t4 86.0614
Rpar9 a_4914_8734.t2 a_4914_8734.t4 54.6649
Rpar10 a_6734_8734.t0 a_6734_8734.t2 123.7592
Rpar11 a_6734_8734.t0 a_6734_8734.t4 54.6649
Rpar12 a_6734_8734.t2 a_6734_8734.t4 86.0614
Rpar13 ib ib.t0 15.2794
Rpar14 ib ib.t1 14.5122
Rpar15 ib ib.t10 121.2204
Rpar16 ib.t0 ib.t1 30.2924
Rpar17 ib.t0 ib.t10 261.3755
Rpar18 ib.t1 ib.t10 248.2498
Rpar19 inn inn.t0 3.5929
Rpar20 inp inp.t0 3.6414
Rpar21 out out.t0 8.9973
Rpar22 out out.t2 55.5793
Rpar23 vdd vdd.t0 302.0738
Rpar24 vdd vdd.t1 129.1718
Rpar25 vdd vdd.t12 43.4701
Rpar26 vdd.t0 vdd.t1 6.9138
Rpar27 vdd.t0 vdd.t12 187.0392
Rpar28 vdd.t1 vdd.t12 77.3917
Rpar29 vss vss.t0 120.1530
Rpar30 vss vss.t3 314.8858
Rpar31 vss vss.t2 94.1900
Rpar32 vss.t0 vss.t3 27.3265
Rpar33 vss.t0 vss.t2 6.2254
Rpar34 vss.t3 vss.t2 9.2548
Cpar0 a_1560_1204.t0 vss 4.84809e-15
Cpar1 a_1560_1204.t2 vss 8.57122e-15
Cpar2 a_3492_10445.t0 vss 4.79013e-15
Cpar3 a_3492_10445.t1 vss 1.20532e-15
Cpar4 a_3492_10445.t4 vss 8.89418e-16
Cpar5 a_4234_6004.t0 vss 1.18793e-14
Cpar6 a_4234_6004.t2 vss 3.45314e-14
Cpar7 a_4234_6004.t3 vss 3.60558e-15
Cpar8 a_4914_8734.t0 vss 3.56198e-15
Cpar9 a_4914_8734.t2 vss 4.58151e-15
Cpar10 a_4914_8734.t4 vss 5.93816e-15
Cpar11 a_6734_8734.t0 vss 4.64388e-15
Cpar12 a_6734_8734.t2 vss 3.61045e-15
Cpar13 a_6734_8734.t4 vss 6.01901e-15
Cpar14 ib inn 2.79500e-17
Cpar15 ib inp 2.23800e-17
Cpar16 ib out 3.13640e-16
Cpar17 ib vdd 9.21715e-15
Cpar18 ib vss 4.05105e-14
Cpar19 ib.t0 vss 1.70803e-14
Cpar20 ib.t1 vss 1.82491e-15
Cpar21 ib.t10 vss 7.09827e-15
Cpar22 inn inp 5.16000e-17
Cpar23 inn vdd 1.53500e-17
Cpar24 inn vss 6.64979e-15
Cpar25 inn.t0 vss 8.13297e-16
Cpar26 inp vdd 1.49300e-17
Cpar27 inp vss 6.76703e-15
Cpar28 inp.t0 vss 7.92051e-16
Cpar29 out vdd 2.56174e-15
Cpar30 out vss 7.78165e-15
Cpar31 out.t0 vss 5.64795e-16
Cpar32 out.t2 vss 3.63343e-15
Cpar33 vdd vss 1.08997e-13
Cpar34 vdd.t0 vss 2.31893e-14
Cpar35 vdd.t1 vss 1.88888e-14
Cpar36 vdd.t12 vss 1.12664e-14
.ends opamp_dut

Vdd vdd 0 1.800000
Vss vss 0 0
Ibias vdd ib 1.444000e-07
Vinp inp 0 DC 0.985000 AC 1 PWL(0 0.985000 5.161458e-07 0.985000 5.677604e-07 0.995000)
Rfb out inn 1m
Cload out 0 2.000000e-12
Xdut vdd vss inp inn out ib opamp_dut
.end
