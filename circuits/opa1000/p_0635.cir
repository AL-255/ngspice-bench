* opa1000[0635]: 2p/pmos_miller_1v8_i2u_weak (pmos_miller, VDD=1.8V, CL=2.0pF, Iref=0.325uA)
.include "pdk_opa.inc"
.temp 27
.option gmin=1e-12 rshunt=1e12 reltol=1e-3 abstol=1e-12 vntol=1e-5 method=gear
* Post-PEX R+C extracted netlist for pmos_miller_1v8_i2u_weak
.subckt opamp_dut vdd vss inp inn out ib
XMpar0 out.t1 a_5610_1294.t7 vss.t1 vss.t0 nfet_03v3 w=0.4u l=1.35u ad=1.3760e-13 pd=1.1680e-06 as=1.3760e-13 ps=1.1680e-06 nf=1 m=10 par=10
XMpar1 out.t0 a_1882_4617.t0 vdd.t1 vdd.t0 pfet_03v3 w=2.11u l=3.25u ad=9.9592e-13 pd=4.3200e-06 as=8.6088e-13 ps=3.7700e-06 nf=1 m=10 par=10
XMpar2 a_1882_4617.t1 a_1882_4617.t0 vdd.t1 vdd.t0 pfet_03v3 w=2.11u l=3.25u ad=1.2660e-12 pd=5.4200e-06 as=5.9080e-13 ps=2.6700e-06 nf=1 m=2 par=2
XMpar3 a_3294_4826.t4 a_1882_4617.t0 vdd.t1 vdd.t0 pfet_03v3 w=2.11u l=3.25u ad=1.2660e-12 pd=5.4200e-06 as=5.9080e-13 ps=2.6700e-06 nf=1 m=4 par=4
XMpar4 a_5610_1294.t5 a_7032_2912.t4 vss.t1 vss.t0 nfet_03v3 w=0.4u l=1.35u ad=2.4000e-13 pd=2.0000e-06 as=1.1200e-13 ps=9.6000e-07 nf=1 m=2 par=2
XMpar5 ib.t1 ib.t0 vss.t14 vss.t0 nfet_03v3 w=0.53u l=3.25u ad=3.1800e-13 pd=2.2600e-06 as=1.4840e-13 ps=1.0900e-06 nf=1 m=2 par=2
XMpar6 a_7032_2912.t5 a_7032_2912.t4 vss.t1 vss.t0 nfet_03v3 w=0.4u l=1.35u ad=1.1200e-13 pd=9.6000e-07 as=1.1200e-13 ps=9.6000e-07 nf=1 m=2 par=2
XMpar7 a_1882_4617.t4 ib.t0 vss.t14 vss.t0 nfet_03v3 w=0.53u l=3.25u ad=1.4840e-13 pd=1.0900e-06 as=1.4840e-13 ps=1.0900e-06 nf=1 m=2 par=2
XMpar8 a_3294_4826.t0 inn.t0 a_7032_2912.t0 vdd.t6 pfet_03v3 w=1.58u l=2.4u ad=6.9520e-13 pd=3.2500e-06 as=4.4240e-13 ps=2.1400e-06 nf=1 m=4 par=4
XMpar9 a_3294_4826.t0 inp.t0 a_5610_1294.t1 vdd.t6 pfet_03v3 w=1.58u l=2.4u ad=6.9520e-13 pd=3.2500e-06 as=4.4240e-13 ps=2.1400e-06 nf=1 m=4 par=4
X18 a_11850_10969.t1 out.t10 cap_mim_2f0fF c_width=14.37u c_length=14.36u
X19 a_11850_10969.t1 out.t10 cap_mim_2f0fF c_width=14.37u c_length=14.36u
X22 a_8420_9409.t0 a_11850_9929.t0 vss.t4 ppolyf_u_1k r_width=1u r_length=16.49u
X28 a_8420_9409.t0 a_11850_8889.t0 vss.t4 ppolyf_u_1k r_width=1u r_length=16.49u
X38 a_8420_10449.t0 a_11850_10969.t0 vss.t4 ppolyf_u_1k r_width=1u r_length=16.49u
X40 a_5610_1294.t0 a_11850_8889.t0 vss.t4 ppolyf_u_1k r_width=1u r_length=16.49u
X46 a_8420_10449.t0 a_11850_9929.t0 vss.t4 ppolyf_u_1k r_width=1u r_length=16.49u
Rpar0 a_11850_10969.t0 a_11850_10969.t1 60.3132
Rpar1 a_1882_4617.t0 a_1882_4617.t1 12.6571
Rpar2 a_1882_4617.t0 a_1882_4617.t4 152.2581
Rpar3 a_1882_4617.t1 a_1882_4617.t4 75.9429
Rpar4 a_3294_4826.t0 a_3294_4826.t4 51.8631
Rpar5 a_5610_1294.t0 a_5610_1294.t1 363.2006
Rpar6 a_5610_1294.t0 a_5610_1294.t7 149.3892
Rpar7 a_5610_1294.t0 a_5610_1294.t5 375.9453
Rpar8 a_5610_1294.t1 a_5610_1294.t7 89.0056
Rpar9 a_5610_1294.t1 a_5610_1294.t5 84.5697
Rpar10 a_5610_1294.t7 a_5610_1294.t5 92.1288
Rpar11 a_7032_2912.t0 a_7032_2912.t4 105.9113
Rpar12 a_7032_2912.t0 a_7032_2912.t5 105.0303
Rpar13 a_7032_2912.t4 a_7032_2912.t5 31.1322
Rpar14 ib ib.t0 16.7404
Rpar15 ib ib.t1 8.5063
Rpar16 ib.t0 ib.t1 88.3844
Rpar17 inn inn.t0 2.4376
Rpar18 inp inp.t0 2.4862
Rpar19 out out.t0 4.2271
Rpar20 out out.t1 199.8278
Rpar21 out out.t10 898.6482
Rpar22 out.t0 out.t1 50.3246
Rpar23 out.t0 out.t10 226.3156
Rpar24 out.t1 out.t10 202.4176
Rpar25 vdd vdd.t0 2425.2948
Rpar26 vdd vdd.t1 76.8506
Rpar27 vdd vdd.t6 305.7573
Rpar28 vdd.t0 vdd.t1 11.8258
Rpar29 vdd.t0 vdd.t6 2677.5116
Rpar30 vdd.t1 vdd.t6 84.8426
Rpar31 vss vss.t0 77.6924
Rpar32 vss vss.t1 119.0315
Rpar33 vss vss.t14 958.2837
Rpar34 vss vss.t4 321.0742
Rpar35 vss.t0 vss.t1 7.2661
Rpar36 vss.t0 vss.t14 11.3676
Rpar37 vss.t0 vss.t4 6.3230
Rpar38 vss.t1 vss.t14 163.2782
Rpar39 vss.t1 vss.t4 76.6586
Rpar40 vss.t14 vss.t4 77.2606
Cpar0 a_11850_10969.t0 vss 1.18245e-16
Cpar1 a_11850_10969.t1 vss 5.57102e-15
Cpar2 a_11850_8889.t0 vss 3.67600e-17
Cpar3 a_11850_9929.t0 vss 4.17200e-17
Cpar4 a_1882_4617.t0 vss 4.27341e-14
Cpar5 a_1882_4617.t1 vss 8.55637e-15
Cpar6 a_1882_4617.t4 vss 2.79878e-15
Cpar7 a_3294_4826.t0 vss 7.93446e-15
Cpar8 a_3294_4826.t4 vss 1.84401e-14
Cpar9 a_5610_1294.t0 vss 3.54207e-15
Cpar10 a_5610_1294.t1 vss 2.50572e-15
Cpar11 a_5610_1294.t5 vss 2.09018e-15
Cpar12 a_5610_1294.t7 vss 6.88043e-15
Cpar13 a_7032_2912.t0 vss 2.34151e-15
Cpar14 a_7032_2912.t4 vss 2.91303e-15
Cpar15 a_7032_2912.t5 vss 1.06914e-15
Cpar16 a_8420_10449.t0 vss 4.36000e-17
Cpar17 a_8420_9409.t0 vss 4.50800e-17
Cpar18 ib vss 1.08341e-14
Cpar19 ib.t0 vss 1.29265e-15
Cpar20 ib.t1 vss 9.11441e-17
Cpar21 inn inp 5.13900e-17
Cpar22 inn vdd 5.06496e-15
Cpar23 inn vss 2.84848e-15
Cpar24 inn.t0 vss 3.94290e-15
Cpar25 inp vdd 5.02550e-15
Cpar26 inp vss 2.74855e-15
Cpar27 inp.t0 vss 3.98057e-15
Cpar28 out vdd 1.46416e-14
Cpar29 out vss 2.13375e-14
Cpar30 out.t0 vss 8.91843e-15
Cpar31 out.t1 vss 4.71176e-15
Cpar32 out.t10 vss 1.86070e-14
Cpar33 vdd vss 1.39835e-13
Cpar34 vdd.t0 vss 4.74885e-14
Cpar35 vdd.t1 vss 9.48052e-15
Cpar36 vdd.t6 vss 1.50783e-14
.ends opamp_dut

Vdd vdd 0 1.800000
Vss vss 0 0
Ibias vdd ib 3.250000e-07
Vinp inp 0 DC 0.805000 AC 1 PWL(0 0.805000 1.178832e-07 0.805000 1.296715e-07 0.815000)
Rfb out inn 1m
Cload out 0 2.000000e-12
Xdut vdd vss inp inn out ib opamp_dut
.end
