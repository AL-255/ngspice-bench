* opa1000[0470]: 2p/nmos_miller_1v8_1u_10u_weak (nmos_miller, VDD=1.8V, CL=2.0pF, Iref=0.9286uA)
.include "pdk_opa.inc"
.temp 27
.option gmin=1e-12 rshunt=1e12 reltol=1e-3 abstol=1e-12 vntol=1e-5 method=gear
* Post-PEX R+C extracted netlist for nmos_miller_1v8_1u_10u_weak
.subckt opamp_dut vdd vss inp inn out ib
XMpar0 a_2370_10198.t0 inn.t0 a_4412_11704.t0 vss.t0 nfet_03v3 w=1.47u l=2.5u ad=6.4680e-13 pd=3.0850e-06 as=4.1160e-13 ps=2.0300e-06 nf=1 m=4 par=4
XMpar1 out.t0 a_893_7635.t7 vdd.t1 vdd.t0 pfet_03v3 w=5.92u l=1.5u ad=1.6576e-12 pd=6.4800e-06 as=2.0365e-12 ps=7.7920e-06 nf=1 m=10 par=10
XMpar2 a_2370_10198.t0 inp.t0 a_893_7635.t1 vss.t0 nfet_03v3 w=1.47u l=2.5u ad=6.4680e-13 pd=3.0850e-06 as=4.1160e-13 ps=2.0300e-06 nf=1 m=4 par=4
XMpar3 a_2370_10198.t8 ib.t0 vss.t10 vss.t9 nfet_03v3 w=0.86u l=2u ad=2.4080e-13 pd=1.4200e-06 as=2.4080e-13 ps=1.4200e-06 nf=1 m=4 par=4
XMpar4 out.t11 ib.t0 vss.t10 vss.t9 nfet_03v3 w=0.86u l=2u ad=2.9584e-13 pd=1.7200e-06 as=2.4080e-13 ps=1.4200e-06 nf=1 m=10 par=10
XMpar5 a_4412_11704.t5 a_4412_11704.t4 vdd.t1 vdd.t0 pfet_03v3 w=5.92u l=1.5u ad=1.6576e-12 pd=6.4800e-06 as=1.6576e-12 ps=6.4800e-06 nf=1 m=2 par=2
XMpar6 ib.t1 ib.t0 vss.t10 vss.t9 nfet_03v3 w=0.86u l=2u ad=2.4080e-13 pd=1.4200e-06 as=2.4080e-13 ps=1.4200e-06 nf=1 m=2 par=2
XMpar7 a_893_7635.t0 a_4412_11704.t4 vdd.t1 vdd.t0 pfet_03v3 w=5.92u l=1.5u ad=3.5520e-12 pd=1.3040e-05 as=1.6576e-12 ps=6.4800e-06 nf=1 m=2 par=2
X0 a_893_8155.t1 out.t7 cap_mim_2f0fF c_width=14.37u c_length=14.36u
X26 a_893_8155.t0 a_3631_7635.t0 vss.t8 ppolyf_u_1k r_width=1u r_length=13.03u
X30 a_893_7635.t6 a_3631_7635.t0 vss.t8 ppolyf_u_1k r_width=1u r_length=13.03u
X32 a_893_8155.t1 out.t7 cap_mim_2f0fF c_width=14.37u c_length=14.36u
Rpar0 a_2370_10198.t0 a_2370_10198.t8 61.8600
Rpar1 a_4412_11704.t0 a_4412_11704.t4 209.8114
Rpar2 a_4412_11704.t0 a_4412_11704.t5 71.7364
Rpar3 a_4412_11704.t4 a_4412_11704.t5 25.6757
Rpar4 a_893_7635.t0 a_893_7635.t1 51.9464
Rpar5 a_893_7635.t0 a_893_7635.t7 261.2964
Rpar6 a_893_7635.t0 a_893_7635.t6 295.2857
Rpar7 a_893_7635.t1 a_893_7635.t7 167.9697
Rpar8 a_893_7635.t1 a_893_7635.t6 189.8191
Rpar9 a_893_7635.t7 a_893_7635.t6 57.0811
Rpar10 a_893_8155.t0 a_893_8155.t1 59.6514
Rpar11 ib ib.t0 10.9845
Rpar12 ib ib.t1 16.3240
Rpar13 inn inn.t0 1.9272
Rpar14 inp inp.t0 2.3192
Rpar15 out out.t0 49.5095
Rpar16 out out.t11 3.6526
Rpar17 out out.t7 68.9045
Rpar18 out.t0 out.t7 234.9262
Rpar19 vdd vdd.t0 46.4004
Rpar20 vdd vdd.t1 109.5696
Rpar21 vdd.t0 vdd.t1 3.2214
Rpar22 vss vss.t0 206.2889
Rpar23 vss vss.t10 476.9188
Rpar24 vss vss.t9 72.9417
Rpar25 vss vss.t8 256.6753
Rpar26 vss.t0 vss.t10 246.5677
Rpar27 vss.t0 vss.t9 33.5359
Rpar28 vss.t0 vss.t8 9.0640
Rpar29 vss.t10 vss.t9 5.3586
Rpar30 vss.t10 vss.t8 230.6611
Rpar31 vss.t9 vss.t8 18.1395
Cpar0 a_2370_10198.t0 vss 8.34760e-15
Cpar1 a_2370_10198.t8 vss 9.12182e-15
Cpar2 a_3631_7635.t0 vss 3.78000e-17
Cpar3 a_4412_11704.t0 vss 2.71222e-15
Cpar4 a_4412_11704.t4 vss 7.20070e-15
Cpar5 a_4412_11704.t5 vss 3.63170e-15
Cpar6 a_893_7635.t0 vss 4.53832e-15
Cpar7 a_893_7635.t1 vss 2.41523e-15
Cpar8 a_893_7635.t6 vss 2.07254e-15
Cpar9 a_893_7635.t7 vss 1.59925e-14
Cpar10 a_893_8155.t0 vss 9.45401e-17
Cpar11 a_893_8155.t1 vss 4.05028e-15
Cpar12 ib out 1.15764e-15
Cpar13 ib vss 2.63524e-14
Cpar14 ib.t0 vss 4.21622e-15
Cpar15 ib.t1 vss 2.15490e-16
Cpar16 inn inp 5.21200e-17
Cpar17 inn vdd 8.89900e-17
Cpar18 inn vss 6.11603e-15
Cpar19 inn.t0 vss 8.02757e-16
Cpar20 inp vss 6.07277e-15
Cpar21 inp.t0 vss 9.28349e-16
Cpar22 out vdd 8.97743e-15
Cpar23 out vss 1.89518e-14
Cpar24 out.t0 vss 5.81408e-15
Cpar25 out.t11 vss 1.14158e-15
Cpar26 out.t7 vss 1.21544e-14
Cpar27 vdd vss 6.71648e-14
Cpar28 vdd.t0 vss 1.98934e-14
Cpar29 vdd.t1 vss 9.77721e-15
.ends opamp_dut

Vdd vdd 0 1.800000
Vss vss 0 0
Ibias vdd ib 9.286000e-07
Vinp inp 0 DC 0.895000 AC 1 PWL(0 0.895000 3.979040e-08 0.895000 4.376944e-08 0.905000)
Rfb out inn 1m
Cload out 0 2.000000e-12
Xdut vdd vss inp inn out ib opamp_dut
.end
