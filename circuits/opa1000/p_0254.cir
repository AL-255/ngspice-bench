* opa1000[0254]: 200f/folded_cascode_pmos_1v8_i200n_subth (folded_cascode_pmos, VDD=1.8V, CL=0.2pF, Iref=0.0578uA)
.include "pdk_opa.inc"
.temp 27
.option gmin=1e-12 rshunt=1e12 reltol=1e-3 abstol=1e-12 vntol=1e-5 method=gear
* Post-PEX R+C extracted netlist for folded_cascode_pmos_1v8_i200n_subth
.subckt opamp_dut vdd vss inp inn out ib
XMpar0 a_6574_11779.t9 ib.t0 vss.t2 vss.t1 nfet_03v3 w=0.56u l=6.25u ad=1.5680e-13 pd=1.1200e-06 as=3.3600e-13 ps=2.3200e-06 nf=1 m=4 par=4
XMpar1 a_3088_7545.t1 inp.t0 a_4202_4199.t0 vdd.t2 pfet_03v3 w=3.05u l=2.88u ad=1.3420e-12 pd=5.4550e-06 as=8.5400e-13 ps=3.6100e-06 nf=1 m=8 par=8
XMpar2 a_4202_4199.t8 ib.t0 vss.t2 vss.t1 nfet_03v3 w=0.56u l=6.25u ad=1.5680e-13 pd=1.1200e-06 as=3.3600e-13 ps=2.3200e-06 nf=1 m=4 par=4
XMpar3 a_3088_7545.t1 inn.t0 a_6574_11779.t1 vdd.t2 pfet_03v3 w=3.05u l=2.88u ad=1.3420e-12 pd=5.4550e-06 as=8.5400e-13 ps=3.6100e-06 nf=1 m=8 par=8
XMpar4 a_1462_7337.t0 ib.t0 vss.t2 vss.t1 nfet_03v3 w=0.56u l=6.25u ad=3.3600e-13 pd=2.3200e-06 as=1.5680e-13 ps=1.1200e-06 nf=1 m=2 par=2
XMpar5 a_3088_7545.t0 a_1462_7337.t2 vdd.t1 vdd.t0 pfet_03v3 w=1.96u l=8.13u ad=5.4880e-13 pd=2.5200e-06 as=8.6240e-13 ps=3.8200e-06 nf=1 m=4 par=4
XMpar6 a_3080_13337.t1 a_3080_13337.t0 vdd.t1 vdd.t0 pfet_03v3 w=1.96u l=8.13u ad=1.1760e-12 pd=5.1200e-06 as=5.4880e-13 ps=2.5200e-06 nf=1 m=2 par=2
XMpar7 a_1462_7337.t3 a_1462_7337.t2 vdd.t1 vdd.t0 pfet_03v3 w=1.96u l=8.13u ad=5.4880e-13 pd=2.5200e-06 as=5.4880e-13 ps=2.5200e-06 nf=1 m=2 par=2
XMpar8 out.t1 a_3080_13337.t0 vdd.t1 vdd.t0 pfet_03v3 w=1.96u l=8.13u ad=5.4880e-13 pd=2.5200e-06 as=5.4880e-13 ps=2.5200e-06 nf=1 m=2 par=2
XMpar9 a_6574_11779.t0 a_1462_7337.t10 out.t0 vss.t0 nfet_03v3 w=1.14u l=3.5u ad=6.8400e-13 pd=3.4800e-06 as=3.1920e-13 ps=1.7000e-06 nf=1 m=2 par=2
XMpar10 ib.t1 ib.t0 vss.t2 vss.t1 nfet_03v3 w=0.56u l=6.25u ad=3.3600e-13 pd=2.3200e-06 as=1.5680e-13 ps=1.1200e-06 nf=1 m=2 par=2
XMpar11 a_3080_13337.t4 a_1462_7337.t10 a_4202_4199.t12 vss.t0 nfet_03v3 w=1.14u l=3.5u ad=3.1920e-13 pd=1.7000e-06 as=6.8400e-13 ps=3.4800e-06 nf=1 m=2 par=2
Rpar0 a_1462_7337.t0 a_1462_7337.t10 128.1338
Rpar1 a_1462_7337.t0 a_1462_7337.t2 161.9300
Rpar2 a_1462_7337.t0 a_1462_7337.t3 183.2736
Rpar3 a_1462_7337.t10 a_1462_7337.t2 126.9694
Rpar4 a_1462_7337.t10 a_1462_7337.t3 143.7049
Rpar5 a_1462_7337.t2 a_1462_7337.t3 29.8651
Rpar6 a_3080_13337.t0 a_3080_13337.t1 18.6978
Rpar7 a_3080_13337.t0 a_3080_13337.t4 182.5489
Rpar8 a_3080_13337.t1 a_3080_13337.t4 82.6294
Rpar9 a_3088_7545.t0 a_3088_7545.t1 50.0954
Rpar10 a_4202_4199.t0 a_4202_4199.t8 82.9464
Rpar11 a_4202_4199.t0 a_4202_4199.t12 124.6374
Rpar12 a_4202_4199.t8 a_4202_4199.t12 59.8836
Rpar13 a_6574_11779.t0 a_6574_11779.t1 124.6374
Rpar14 a_6574_11779.t0 a_6574_11779.t9 59.8836
Rpar15 a_6574_11779.t1 a_6574_11779.t9 82.9464
Rpar16 ib ib.t0 1.9668
Rpar17 ib ib.t1 128.0153
Rpar18 ib.t0 ib.t1 14.6367
Rpar19 inn inn.t0 2.5510
Rpar20 inp inp.t0 2.5510
Rpar21 out out.t0 12.9406
Rpar22 out out.t1 52.0596
Rpar23 vdd vdd.t0 30.9032
Rpar24 vdd vdd.t1 65.1334
Rpar25 vdd vdd.t2 277.1896
Rpar26 vdd.t0 vdd.t1 4.8319
Rpar27 vdd.t0 vdd.t2 72.0510
Rpar28 vdd.t1 vdd.t2 130.1745
Rpar29 vss vss.t0 217.4921
Rpar30 vss vss.t1 87.2223
Rpar31 vss vss.t2 46.5817
Rpar32 vss.t0 vss.t1 22.1783
Rpar33 vss.t0 vss.t2 23.4166
Rpar34 vss.t1 vss.t2 11.4045
Cpar0 a_1462_7337.t0 vss 5.43016e-15
Cpar1 a_1462_7337.t10 vss 8.96095e-15
Cpar2 a_1462_7337.t2 vss 2.94475e-14
Cpar3 a_1462_7337.t3 vss 4.50326e-15
Cpar4 a_3080_13337.t0 vss 2.00224e-14
Cpar5 a_3080_13337.t1 vss 5.06195e-15
Cpar6 a_3080_13337.t4 vss 1.87386e-15
Cpar7 a_3088_7545.t0 vss 8.65323e-15
Cpar8 a_3088_7545.t1 vss 2.37163e-14
Cpar9 a_4202_4199.t0 vss 1.03808e-14
Cpar10 a_4202_4199.t12 vss 3.26274e-15
Cpar11 a_4202_4199.t8 vss 5.58343e-15
Cpar12 a_6574_11779.t0 vss 3.01250e-15
Cpar13 a_6574_11779.t1 vss 9.58468e-15
Cpar14 a_6574_11779.t9 vss 5.15521e-15
Cpar15 ib vdd 1.20830e-16
Cpar16 ib vss 4.84704e-14
Cpar17 ib.t0 vss 8.36725e-15
Cpar18 ib.t1 vss 1.06520e-15
Cpar19 inn inp 1.04540e-16
Cpar20 inn vdd 1.09695e-14
Cpar21 inn vss 3.65630e-15
Cpar22 inn.t0 vss 1.33585e-14
Cpar23 inp vdd 1.08826e-14
Cpar24 inp vss 3.59195e-15
Cpar25 inp.t0 vss 1.33003e-14
Cpar26 out vdd 4.63967e-15
Cpar27 out vss 6.46275e-15
Cpar28 out.t0 vss 2.59251e-16
Cpar29 out.t1 vss 5.82702e-15
Cpar30 vdd vss 1.94938e-13
Cpar31 vdd.t0 vss 3.44695e-14
Cpar32 vdd.t1 vss 1.89230e-14
Cpar33 vdd.t2 vss 3.59691e-14
.ends opamp_dut

Vdd vdd 0 1.800000
Vss vss 0 0
Ibias vdd ib 5.780000e-08
Vinp inp 0 DC 0.751000 AC 1 PWL(0 0.751000 1.260621e-07 0.751000 1.386683e-07 0.761000)
Rfb out inn 1m
Cload out 0 2.000000e-13
Xdut vdd vss inp inn out ib opamp_dut
.end
