* opa1000[0490]: 2p/nmos_miller_3v3_1u_10u_weak (nmos_miller, VDD=3.3V, CL=2.0pF, Iref=0.9286uA)
.include "pdk_opa.inc"
.temp 27
.option gmin=1e-12 rshunt=1e12 reltol=1e-3 abstol=1e-12 vntol=1e-5 method=gear
* Post-PEX R+C extracted netlist for nmos_miller_3v3_1u_10u_weak
.subckt opamp_dut vdd vss inp inn out ib
XMpar0 a_3174_3304.t0 inn.t0 a_5812_1041.t4 vss.t0 nfet_03v3 w=1.47u l=2.5u ad=6.4680e-13 pd=3.0850e-06 as=4.1160e-13 ps=2.0300e-06 nf=1 m=4 par=4
XMpar1 out.t0 a_1004_1291.t7 vdd.t1 vdd.t0 pfet_03v3 w=2.6u l=0.8u ad=7.2800e-13 pd=3.1600e-06 as=8.9440e-13 ps=3.8080e-06 nf=1 m=10 par=10
XMpar2 out.t12 ib.t0 vss.t10 vss.t9 nfet_03v3 w=0.86u l=2u ad=2.9584e-13 pd=1.7200e-06 as=2.4080e-13 ps=1.4200e-06 nf=1 m=10 par=10
XMpar3 a_5812_1041.t1 a_5812_1041.t0 vdd.t1 vdd.t0 pfet_03v3 w=2.6u l=0.8u ad=7.2800e-13 pd=3.1600e-06 as=7.2800e-13 ps=3.1600e-06 nf=1 m=2 par=2
XMpar4 ib.t1 ib.t0 vss.t10 vss.t9 nfet_03v3 w=0.86u l=2u ad=2.4080e-13 pd=1.4200e-06 as=2.4080e-13 ps=1.4200e-06 nf=1 m=2 par=2
XMpar5 a_1004_1291.t4 a_5812_1041.t0 vdd.t1 vdd.t0 pfet_03v3 w=2.6u l=0.8u ad=1.5600e-12 pd=6.4000e-06 as=7.2800e-13 ps=3.1600e-06 nf=1 m=2 par=2
XMpar6 a_1004_1291.t0 inp.t0 a_3174_3304.t0 vss.t0 nfet_03v3 w=1.47u l=2.5u ad=4.1160e-13 pd=2.0300e-06 as=6.4680e-13 ps=3.0850e-06 nf=1 m=4 par=4
XMpar7 a_3174_3304.t8 ib.t0 vss.t10 vss.t9 nfet_03v3 w=0.86u l=2u ad=2.4080e-13 pd=1.4200e-06 as=2.4080e-13 ps=1.4200e-06 nf=1 m=4 par=4
X8 a_1004_1291.t6 a_3220_1291.t0 vss.t8 ppolyf_u_1k r_width=1u r_length=10.42u
X13 a_1004_1811.t1 out.t1 cap_mim_2f0fF c_width=14.37u c_length=14.36u
X32 a_1004_1811.t0 a_3220_1291.t0 vss.t8 ppolyf_u_1k r_width=1u r_length=10.42u
X41 a_1004_1811.t1 out.t1 cap_mim_2f0fF c_width=14.37u c_length=14.36u
Rpar0 a_1004_1291.t0 a_1004_1291.t7 54.1590
Rpar1 a_1004_1291.t0 a_1004_1291.t4 176.4053
Rpar2 a_1004_1291.t0 a_1004_1291.t6 364.9287
Rpar3 a_1004_1291.t7 a_1004_1291.t4 115.3220
Rpar4 a_1004_1291.t7 a_1004_1291.t6 238.5660
Rpar5 a_1004_1291.t4 a_1004_1291.t6 103.1984
Rpar6 a_1004_1811.t0 a_1004_1811.t1 63.8958
Rpar7 a_3174_3304.t0 a_3174_3304.t8 41.9601
Rpar8 a_5812_1041.t0 a_5812_1041.t1 26.6842
Rpar9 a_5812_1041.t0 a_5812_1041.t4 234.6583
Rpar10 a_5812_1041.t1 a_5812_1041.t4 90.9320
Rpar11 ib ib.t0 10.9836
Rpar12 ib ib.t1 16.3249
Rpar13 inn inn.t0 1.9272
Rpar14 inp inp.t0 2.3192
Rpar15 out out.t0 1.8546
Rpar16 out out.t1 65.8684
Rpar17 out out.t12 54.0614
Rpar18 out.t1 out.t12 255.9383
Rpar19 vdd vdd.t0 67.8257
Rpar20 vdd vdd.t1 104.4285
Rpar21 vdd.t0 vdd.t1 3.3378
Rpar22 vss vss.t0 139.0645
Rpar23 vss vss.t10 512.8030
Rpar24 vss vss.t9 57.8172
Rpar25 vss vss.t8 188.0081
Rpar26 vss.t0 vss.t10 15.8229
Rpar27 vss.t0 vss.t9 1.5174
Rpar28 vss.t0 vss.t8 414.8404
Rpar29 vss.t10 vss.t9 7.0113
Rpar30 vss.t10 vss.t8 1342.1056
Rpar31 vss.t9 vss.t8 153.8411
Cpar0 a_1004_1291.t0 vss 3.79722e-15
Cpar1 a_1004_1291.t4 vss 4.86087e-15
Cpar2 a_1004_1291.t6 vss 3.16217e-15
Cpar3 a_1004_1291.t7 vss 9.74346e-15
Cpar4 a_1004_1811.t0 vss 1.40181e-16
Cpar5 a_1004_1811.t1 vss 5.12770e-15
Cpar6 a_3174_3304.t0 vss 7.21558e-15
Cpar7 a_3174_3304.t8 vss 6.59755e-15
Cpar8 a_3220_1291.t0 vss 2.83400e-17
Cpar9 a_5812_1041.t0 vss 4.10629e-15
Cpar10 a_5812_1041.t1 vss 3.85698e-15
Cpar11 a_5812_1041.t4 vss 4.15671e-15
Cpar12 ib inn 1.74600e-17
Cpar13 ib inp 1.71800e-17
Cpar14 ib out 9.73030e-16
Cpar15 ib vdd 6.72500e-17
Cpar16 ib vss 2.63039e-14
Cpar17 ib.t0 vss 4.04569e-15
Cpar18 ib.t1 vss 2.06822e-16
Cpar19 inn inp 5.21200e-17
Cpar20 inn out 1.15900e-17
Cpar21 inn vss 6.11816e-15
Cpar22 inn.t0 vss 7.79771e-16
Cpar23 inp out 3.09800e-17
Cpar24 inp vss 6.10059e-15
Cpar25 inp.t0 vss 8.80894e-16
Cpar26 out vdd 9.08902e-15
Cpar27 out vss 1.85047e-14
Cpar28 out.t0 vss 1.71506e-15
Cpar29 out.t1 vss 1.25248e-14
Cpar30 out.t12 vss 3.19600e-15
Cpar31 vdd vss 4.84175e-14
Cpar32 vdd.t0 vss 1.40514e-14
Cpar33 vdd.t1 vss 8.50447e-15
.ends opamp_dut

Vdd vdd 0 3.300000
Vss vss 0 0
Ibias vdd ib 9.286000e-07
Vinp inp 0 DC 1.645000 AC 1 PWL(0 1.645000 3.780449e-08 1.645000 4.158493e-08 1.655000)
Rfb out inn 1m
Cload out 0 2.000000e-12
Xdut vdd vss inp inn out ib opamp_dut
.end
