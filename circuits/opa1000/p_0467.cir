* opa1000[0467]: 2p/nmos_miller_1v8_i2u_weak (nmos_miller, VDD=1.8V, CL=2.0pF, Iref=0.2857uA)
.include "pdk_opa.inc"
.temp 27
.option gmin=1e-12 rshunt=1e12 reltol=1e-3 abstol=1e-12 vntol=1e-5 method=gear
* Post-PEX R+C extracted netlist for nmos_miller_1v8_i2u_weak
.subckt opamp_dut vdd vss inp inn out ib
XMpar0 a_6128_4494.t3 a_6128_4494.t2 vdd.t1 vdd.t0 pfet_03v3 w=0.66u l=0.81u ad=1.8480e-13 pd=1.2200e-06 as=1.8480e-13 ps=1.2200e-06 nf=1 m=2 par=2
XMpar1 out.t10 a_1004_8193.t5 vdd.t1 vdd.t0 pfet_03v3 w=0.66u l=0.81u ad=1.8480e-13 pd=1.2200e-06 as=2.2704e-13 ps=1.4800e-06 nf=1 m=10 par=10
XMpar2 a_1004_8193.t3 a_6128_4494.t2 vdd.t1 vdd.t0 pfet_03v3 w=0.66u l=0.81u ad=3.9600e-13 pd=2.5200e-06 as=1.8480e-13 ps=1.2200e-06 nf=1 m=2 par=2
XMpar3 a_3563_1249.t0 ib.t0 vss.t1 vss.t0 nfet_03v3 w=0.57u l=3.9u ad=3.4200e-13 pd=2.3400e-06 as=1.5960e-13 ps=1.1300e-06 nf=1 m=4 par=4
XMpar4 out.t0 ib.t0 vss.t1 vss.t0 nfet_03v3 w=0.57u l=3.9u ad=2.6904e-13 pd=1.8560e-06 as=2.3256e-13 ps=1.6140e-06 nf=1 m=10 par=10
XMpar5 a_3563_1249.t4 inn.t0 a_6128_4494.t0 vss.t25 nfet_03v3 w=1.36u l=4.5u ad=8.1600e-13 pd=3.9200e-06 as=3.8080e-13 ps=1.9200e-06 nf=1 m=2 par=2
XMpar6 a_1004_8193.t0 inp.t0 a_3563_1249.t4 vss.t25 nfet_03v3 w=1.36u l=4.5u ad=3.8080e-13 pd=1.9200e-06 as=8.1600e-13 ps=3.9200e-06 nf=1 m=2 par=2
XMpar7 ib.t1 ib.t0 vss.t1 vss.t0 nfet_03v3 w=0.57u l=3.9u ad=3.4200e-13 pd=2.3400e-06 as=1.5960e-13 ps=1.1300e-06 nf=1 m=2 par=2
X2 a_4354_9233.t1 out.t12 cap_mim_2f0fF c_width=14.37u c_length=14.36u
X9 a_1004_8713.t0 a_4354_9233.t0 vss.t24 ppolyf_u_1k r_width=1u r_length=16.09u
X16 a_1004_8713.t0 a_4354_8193.t0 vss.t24 ppolyf_u_1k r_width=1u r_length=16.09u
X32 a_4354_9233.t1 out.t12 cap_mim_2f0fF c_width=14.37u c_length=14.36u
X35 a_1004_8193.t2 a_4354_8193.t0 vss.t24 ppolyf_u_1k r_width=1u r_length=16.09u
Rpar0 a_1004_8193.t0 a_1004_8193.t5 169.9085
Rpar1 a_1004_8193.t0 a_1004_8193.t2 506.3755
Rpar2 a_1004_8193.t0 a_1004_8193.t3 100.3534
Rpar3 a_1004_8193.t5 a_1004_8193.t2 52.7173
Rpar4 a_1004_8193.t5 a_1004_8193.t3 186.0242
Rpar5 a_1004_8193.t2 a_1004_8193.t3 554.4050
Rpar6 a_3563_1249.t0 a_3563_1249.t4 45.0223
Rpar7 a_4354_9233.t0 a_4354_9233.t1 68.8917
Rpar8 a_6128_4494.t0 a_6128_4494.t2 159.3412
Rpar9 a_6128_4494.t0 a_6128_4494.t3 124.2658
Rpar10 a_6128_4494.t2 a_6128_4494.t3 29.5110
Rpar11 ib ib.t0 15.2709
Rpar12 ib ib.t1 13.8997
Rpar13 ib.t0 ib.t1 32.1235
Rpar14 inn inn.t0 3.5938
Rpar15 inp inp.t0 3.6424
Rpar16 out out.t0 68.0003
Rpar17 out out.t10 83.0753
Rpar18 out out.t12 20.7644
Rpar19 out.t0 out.t10 76.4070
Rpar20 vdd vdd.t0 108.9635
Rpar21 vdd vdd.t1 158.0249
Rpar22 vdd.t0 vdd.t1 4.1462
Rpar23 vss vss.t0 59.6940
Rpar24 vss vss.t1 231.6315
Rpar25 vss vss.t24 131.4976
Rpar26 vss vss.t25 46.9646
Rpar27 vss.t0 vss.t1 32.1947
Rpar28 vss.t0 vss.t24 18.6916
Rpar29 vss.t0 vss.t25 3.9532
Rpar30 vss.t1 vss.t24 94.5963
Rpar31 vss.t1 vss.t25 26.5567
Rpar32 vss.t24 vss.t25 9.7555
Cpar0 a_1004_8193.t0 vss 2.67700e-15
Cpar1 a_1004_8193.t2 vss 2.21182e-15
Cpar2 a_1004_8193.t3 vss 2.92170e-15
Cpar3 a_1004_8193.t5 vss 6.21857e-15
Cpar4 a_1004_8713.t0 vss 3.72200e-17
Cpar5 a_3563_1249.t0 vss 1.31478e-14
Cpar6 a_3563_1249.t4 vss 6.61541e-15
Cpar7 a_4354_8193.t0 vss 4.14400e-17
Cpar8 a_4354_9233.t0 vss 1.63696e-16
Cpar9 a_4354_9233.t1 vss 6.39987e-15
Cpar10 a_6128_4494.t0 vss 2.71556e-15
Cpar11 a_6128_4494.t2 vss 3.39195e-15
Cpar12 a_6128_4494.t3 vss 1.98664e-15
Cpar13 ib out 2.26630e-15
Cpar14 ib vss 4.75116e-14
Cpar15 ib.t0 vss 8.04544e-15
Cpar16 ib.t1 vss 6.57657e-16
Cpar17 inn inp 5.16000e-17
Cpar18 inn vdd 1.62120e-16
Cpar19 inn vss 4.95276e-15
Cpar20 inn.t0 vss 6.70136e-16
Cpar21 inp vdd 1.62200e-17
Cpar22 inp vss 4.97346e-15
Cpar23 inp.t0 vss 5.91822e-16
Cpar24 out vdd 6.51988e-15
Cpar25 out vss 2.35823e-14
Cpar26 out.t0 vss 5.84338e-15
Cpar27 out.t10 vss 1.82597e-15
Cpar28 out.t12 vss 1.09913e-14
Cpar29 vdd vss 4.33405e-14
Cpar30 vdd.t0 vss 1.06172e-14
Cpar31 vdd.t1 vss 5.55327e-15
.ends opamp_dut

Vdd vdd 0 1.800000
Vss vss 0 0
Ibias vdd ib 2.857000e-07
Vinp inp 0 DC 0.895000 AC 1 PWL(0 0.895000 1.335009e-07 0.895000 1.468510e-07 0.905000)
Rfb out inn 1m
Cload out 0 2.000000e-12
Xdut vdd vss inp inn out ib opamp_dut
.end
