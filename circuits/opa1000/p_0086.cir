* opa1000[0086]: 200f/current_reuse_1v8_i50n_weak (current_reuse, VDD=1.8V, CL=0.2pF, Iref=0.0093uA)
.include "pdk_opa.inc"
.temp 27
.option gmin=1e-12 rshunt=1e12 reltol=1e-3 abstol=1e-12 vntol=1e-5 method=gear
* Post-PEX R+C extracted netlist for current_reuse_1v8_i50n_weak
.subckt opamp_dut vdd vss inp inn out ib
XMpar0 a_3394_1294.t0 inp.t0 a_5437_4516.t1 vss.t1 nfet_03v3 w=0.4u l=8.13u ad=2.4000e-13 pd=2.0000e-06 as=1.1200e-13 ps=9.6000e-07 nf=1 m=2 par=2
XMpar1 a_4222_12120.t0 inp.t2 a_5437_4516.t0 vdd.t2 pfet_03v3 w=0.4u l=8.13u ad=2.4000e-13 pd=2.0000e-06 as=1.1200e-13 ps=9.6000e-07 nf=1 m=2 par=2
XMpar2 out.t11 ib.t0 vss.t17 vss.t16 nfet_03v3 w=0.4u l=3u ad=1.8880e-13 pd=1.5840e-06 as=1.6320e-13 ps=1.3760e-06 nf=1 m=10 par=10
XMpar3 out.t0 a_5437_4516.t6 vdd.t1 vdd.t0 pfet_03v3 w=0.4u l=4u ad=1.3760e-13 pd=1.1680e-06 as=1.6320e-13 ps=1.3760e-06 nf=1 m=10 par=10
XMpar4 a_5437_4516.t4 a_7204_8502.t4 vdd.t1 vdd.t0 pfet_03v3 w=0.4u l=4u ad=2.4000e-13 pd=2.0000e-06 as=1.1200e-13 ps=9.6000e-07 nf=1 m=1
XMpar5 a_3394_1294.t4 ib.t0 vss.t17 vss.t16 nfet_03v3 w=0.4u l=3u ad=2.4000e-13 pd=2.0000e-06 as=1.1200e-13 ps=9.6000e-07 nf=1 m=4 par=4
XMpar6 a_4222_12120.t4 a_7204_8502.t4 vdd.t1 vdd.t0 pfet_03v3 w=0.4u l=4u ad=1.1200e-13 pd=9.6000e-07 as=2.4000e-13 ps=2.0000e-06 nf=1 m=2 par=2
XMpar7 a_7204_8502.t5 a_7204_8502.t4 vdd.t1 vdd.t0 pfet_03v3 w=0.4u l=4u ad=2.4000e-13 pd=2.0000e-06 as=1.1200e-13 ps=9.6000e-07 nf=1 m=1
XMpar8 ib.t1 ib.t0 vss.t17 vss.t16 nfet_03v3 w=0.4u l=3u ad=2.4000e-13 pd=2.0000e-06 as=1.1200e-13 ps=9.6000e-07 nf=1 m=2 par=2
XMpar9 a_3394_1294.t0 inn.t0 a_7204_8502.t0 vss.t1 nfet_03v3 w=0.4u l=8.13u ad=2.4000e-13 pd=2.0000e-06 as=1.1200e-13 ps=9.6000e-07 nf=1 m=2 par=2
XMpar10 a_4222_12120.t0 inn.t2 a_7204_8502.t2 vdd.t2 pfet_03v3 w=0.4u l=8.13u ad=2.4000e-13 pd=2.0000e-06 as=1.1200e-13 ps=9.6000e-07 nf=1 m=2 par=2
X1 a_10715_4930.t0 a_14693_5450.t0 vss.t0 ppolyf_u_1k r_width=1u r_length=19.23u
X3 a_10715_1810.t0 a_14693_2330.t0 vss.t0 ppolyf_u_1k r_width=1u r_length=19.23u
X6 a_10715_4930.t0 a_14693_4410.t0 vss.t0 ppolyf_u_1k r_width=1u r_length=19.23u
X8 a_10715_1810.t0 a_14693_1290.t0 vss.t0 ppolyf_u_1k r_width=1u r_length=19.23u
X11 a_10715_7010.t0 a_14693_7530.t0 vss.t0 ppolyf_u_1k r_width=1u r_length=19.23u
X12 a_10715_3890.t0 a_14693_4410.t0 vss.t0 ppolyf_u_1k r_width=1u r_length=19.23u
X18 a_10715_7010.t0 a_14693_6490.t0 vss.t0 ppolyf_u_1k r_width=1u r_length=19.23u
X23 a_5437_4516.t5 a_14693_1290.t0 vss.t0 ppolyf_u_1k r_width=1u r_length=19.23u
X29 a_10715_3890.t0 a_14693_3370.t0 vss.t0 ppolyf_u_1k r_width=1u r_length=19.23u
X35 a_14693_7530.t1 out.t8 cap_mim_2f0fF c_width=12.99u c_length=12.99u
X36 a_10715_5970.t0 a_14693_6490.t0 vss.t0 ppolyf_u_1k r_width=1u r_length=19.23u
X37 a_10715_2850.t0 a_14693_3370.t0 vss.t0 ppolyf_u_1k r_width=1u r_length=19.23u
X40 a_10715_5970.t0 a_14693_5450.t0 vss.t0 ppolyf_u_1k r_width=1u r_length=19.23u
X46 a_10715_2850.t0 a_14693_2330.t0 vss.t0 ppolyf_u_1k r_width=1u r_length=19.23u
Rpar0 a_14693_7530.t0 a_14693_7530.t1 82.7953
Rpar1 a_3394_1294.t0 a_3394_1294.t4 69.1525
Rpar2 a_4222_12120.t0 a_4222_12120.t4 68.5899
Rpar3 a_5437_4516.t0 a_5437_4516.t1 85.1207
Rpar4 a_5437_4516.t0 a_5437_4516.t6 613.4794
Rpar5 a_5437_4516.t0 a_5437_4516.t4 180.0017
Rpar6 a_5437_4516.t0 a_5437_4516.t5 656.7033
Rpar7 a_5437_4516.t1 a_5437_4516.t6 432.5094
Rpar8 a_5437_4516.t1 a_5437_4516.t4 126.9031
Rpar9 a_5437_4516.t1 a_5437_4516.t5 462.9827
Rpar10 a_5437_4516.t6 a_5437_4516.t4 472.4005
Rpar11 a_5437_4516.t6 a_5437_4516.t5 53.9264
Rpar12 a_5437_4516.t4 a_5437_4516.t5 505.6844
Rpar13 a_7204_8502.t0 a_7204_8502.t2 77.7478
Rpar14 a_7204_8502.t0 a_7204_8502.t4 140.5452
Rpar15 a_7204_8502.t0 a_7204_8502.t5 930.1605
Rpar16 a_7204_8502.t2 a_7204_8502.t4 143.5073
Rpar17 a_7204_8502.t2 a_7204_8502.t5 949.7640
Rpar18 a_7204_8502.t4 a_7204_8502.t5 27.4526
Rpar19 ib ib.t0 13.8488
Rpar20 ib ib.t1 14.4754
Rpar21 ib.t0 ib.t1 34.3535
Rpar22 inn inn.t0 3.3504
Rpar23 inn inn.t2 42.2907
Rpar24 inp inp.t0 3.3990
Rpar25 inp inp.t2 42.2421
Rpar26 out out.t0 60.5454
Rpar27 out out.t11 67.1090
Rpar28 out out.t8 20.1928
Rpar29 out.t0 out.t11 178.7524
Rpar30 out.t0 out.t8 846.2542
Rpar31 out.t11 out.t8 937.9951
Rpar32 vdd vdd.t0 244.5329
Rpar33 vdd vdd.t1 745.6153
Rpar34 vdd vdd.t2 38.2561
Rpar35 vdd.t0 vdd.t1 6.2415
Rpar36 vdd.t0 vdd.t2 104.7722
Rpar37 vdd.t1 vdd.t2 319.4652
Rpar38 vss vss.t0 50.3462
Rpar39 vss vss.t1 574.2508
Rpar40 vss vss.t16 197.2747
Rpar41 vss vss.t17 68.1604
Rpar42 vss.t0 vss.t1 354.3657
Rpar43 vss.t0 vss.t16 115.1593
Rpar44 vss.t0 vss.t17 79.5766
Rpar45 vss.t1 vss.t16 8.1436
Rpar46 vss.t1 vss.t17 85.5837
Rpar47 vss.t16 vss.t17 13.1266
Cpar0 a_10715_1810.t0 vss 3.94400e-17
Cpar1 a_10715_2850.t0 vss 3.69400e-17
Cpar2 a_10715_3890.t0 vss 3.84200e-17
Cpar3 a_10715_4930.t0 vss 3.60600e-17
Cpar4 a_10715_5970.t0 vss 3.16400e-17
Cpar5 a_10715_7010.t0 vss 3.73400e-17
Cpar6 a_14693_1290.t0 vss 2.64400e-17
Cpar7 a_14693_2330.t0 vss 3.00800e-17
Cpar8 a_14693_3370.t0 vss 2.93600e-17
Cpar9 a_14693_4410.t0 vss 2.93600e-17
Cpar10 a_14693_5450.t0 vss 2.93600e-17
Cpar11 a_14693_6490.t0 vss 3.20200e-17
Cpar12 a_14693_7530.t0 vss 2.99950e-16
Cpar13 a_14693_7530.t1 vss 4.35973e-15
Cpar14 a_3394_1294.t0 vss 8.77823e-15
Cpar15 a_3394_1294.t4 vss 1.35519e-14
Cpar16 a_4222_12120.t0 vss 7.62341e-15
Cpar17 a_4222_12120.t4 vss 3.43005e-15
Cpar18 a_5437_4516.t0 vss 4.16706e-15
Cpar19 a_5437_4516.t1 vss 4.79085e-15
Cpar20 a_5437_4516.t4 vss 3.86017e-15
Cpar21 a_5437_4516.t5 vss 4.95347e-15
Cpar22 a_5437_4516.t6 vss 2.26844e-14
Cpar23 a_7204_8502.t0 vss 3.68276e-15
Cpar24 a_7204_8502.t2 vss 3.93727e-15
Cpar25 a_7204_8502.t4 vss 1.25373e-14
Cpar26 a_7204_8502.t5 vss 1.83806e-15
Cpar27 ib out 2.26057e-15
Cpar28 ib vdd 4.10400e-17
Cpar29 ib vss 3.92785e-14
Cpar30 ib.t0 vss 6.86890e-15
Cpar31 ib.t1 vss 5.93681e-16
Cpar32 inn inp 1.03000e-16
Cpar33 inn vdd 7.53011e-15
Cpar34 inn vss 1.18727e-14
Cpar35 inn.t0 vss 2.40753e-15
Cpar36 inn.t2 vss 5.31658e-15
Cpar37 inp vdd 7.93753e-15
Cpar38 inp vss 1.20073e-14
Cpar39 inp.t0 vss 2.64260e-15
Cpar40 inp.t2 vss 5.71398e-15
Cpar41 out vdd 1.49124e-14
Cpar42 out vss 2.03477e-14
Cpar43 out.t0 vss 7.83393e-15
Cpar44 out.t11 vss 8.93947e-15
Cpar45 out.t8 vss 8.55380e-15
Cpar46 vdd vss 1.26473e-13
Cpar47 vdd.t0 vss 3.82485e-14
Cpar48 vdd.t1 vss 1.32136e-14
Cpar49 vdd.t2 vss 1.71383e-14
.ends opamp_dut

Vdd vdd 0 1.800000
Vss vss 0 0
Ibias vdd ib 9.300000e-09
Vinp inp 0 DC 0.895000 AC 1 PWL(0 0.895000 8.201968e-07 0.895000 9.022164e-07 0.905000)
Rfb out inn 1m
Cload out 0 2.000000e-13
Xdut vdd vss inp inn out ib opamp_dut
.end
