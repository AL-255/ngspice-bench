* opa1000[0682]: 200f/rail_to_rail_1v8_i20u_subth (rail_to_rail, VDD=1.8V, CL=0.2pF, Iref=2.5uA)
.include "pdk_opa.inc"
.temp 27
.option gmin=1e-12 rshunt=1e12 reltol=1e-3 abstol=1e-12 vntol=1e-5 method=gear
* Post-PEX R+C extracted netlist for rail_to_rail_1v8_i20u_subth
.subckt opamp_dut vdd vss inp inn out ib
XMpar0 a_1201_9178.t1 a_1201_9178.t0 vdd.t21 vdd.t20 pfet_03v3 w=10u l=1.5u ad=2.8000e-12 pd=1.0560e-05 as=2.8000e-12 ps=1.0560e-05 nf=1 m=2 par=2
XMpar1 a_1081_9386.t0 inn.t6 a_7620_7468.t4 vdd.t4 pfet_03v3 w=2.02u l=0.65u ad=6.4640e-13 pd=2.9125e-06 as=5.6560e-13 ps=2.5800e-06 nf=1 m=48 par=48
XMpar2 out.t1 a_1055_3933.t11 vdd.t1 vdd.t0 pfet_03v3 w=10u l=0.6u ad=2.8000e-12 pd=1.0560e-05 as=3.6000e-12 ps=1.3220e-05 nf=1 m=8 par=8
XMpar3 a_2581_1249.t0 inn.t0 a_7812_3933.t0 vss.t2 nfet_03v3 w=2.14u l=0.65u ad=8.2747e-13 pd=3.6267e-06 as=5.9920e-13 ps=2.7000e-06 nf=1 m=6 par=6
XMpar4 a_1055_3933.t3 inp.t0 a_2581_1249.t0 vss.t2 nfet_03v3 w=2.14u l=0.65u ad=5.9920e-13 pd=2.7000e-06 as=8.2747e-13 ps=3.6267e-06 nf=1 m=6 par=6
XMpar5 a_1081_9386.t0 inp.t6 a_4236_13035.t4 vdd.t4 pfet_03v3 w=2.02u l=0.65u ad=6.4640e-13 pd=2.9125e-06 as=5.6560e-13 ps=2.5800e-06 nf=1 m=48 par=48
XMpar6 out.t8 ib.t0 vss.t24 vss.t23 nfet_03v3 w=4.96u l=1.5u ad=1.3888e-12 pd=5.5200e-06 as=1.7856e-12 ps=6.9200e-06 nf=1 m=8 par=8
XMpar7 a_7812_3933.t7 a_7812_3933.t6 vdd.t1 vdd.t0 pfet_03v3 w=10u l=0.6u ad=2.8000e-12 pd=1.0560e-05 as=2.8000e-12 ps=1.0560e-05 nf=1 m=2 par=2
XMpar8 a_2581_1249.t12 ib.t0 vss.t24 vss.t23 nfet_03v3 w=4.96u l=1.5u ad=2.9760e-12 pd=1.1120e-05 as=1.3888e-12 ps=5.5200e-06 nf=1 m=2 par=2
XMpar9 a_7620_7468.t1 a_7620_7468.t0 vss.t1 vss.t0 nfet_03v3 w=1.1u l=1.08u ad=3.0800e-13 pd=1.6600e-06 as=3.0800e-13 ps=1.6600e-06 nf=1 m=2 par=2
XMpar10 a_1201_9178.t4 ib.t0 vss.t24 vss.t23 nfet_03v3 w=4.96u l=1.5u ad=1.3888e-12 pd=5.5200e-06 as=1.3888e-12 ps=5.5200e-06 nf=1 m=2 par=2
XMpar11 a_1055_3933.t9 a_7620_7468.t0 vss.t1 vss.t0 nfet_03v3 w=1.1u l=1.08u ad=6.6000e-13 pd=3.4000e-06 as=3.0800e-13 ps=1.6600e-06 nf=1 m=2 par=2
XMpar12 a_4236_13035.t1 a_4236_13035.t0 vss.t1 vss.t0 nfet_03v3 w=1.1u l=1.08u ad=6.6000e-13 pd=3.4000e-06 as=3.0800e-13 ps=1.6600e-06 nf=1 m=2 par=2
XMpar13 a_7812_3933.t10 a_4236_13035.t0 vss.t1 vss.t0 nfet_03v3 w=1.1u l=1.08u ad=3.0800e-13 pd=1.6600e-06 as=3.0800e-13 ps=1.6600e-06 nf=1 m=2 par=2
XMpar14 a_1055_3933.t1 a_7812_3933.t6 vdd.t1 vdd.t0 pfet_03v3 w=10u l=0.6u ad=6.0000e-12 pd=2.1200e-05 as=2.8000e-12 ps=1.0560e-05 nf=1 m=2 par=2
XMpar15 ib.t1 ib.t0 vss.t24 vss.t23 nfet_03v3 w=4.96u l=1.5u ad=2.9760e-12 pd=1.1120e-05 as=1.3888e-12 ps=5.5200e-06 nf=1 m=2 par=2
XMpar16 a_1081_9386.t96 a_1201_9178.t0 vdd.t21 vdd.t20 pfet_03v3 w=10u l=1.5u ad=6.0000e-12 pd=2.1200e-05 as=2.8000e-12 ps=1.0560e-05 nf=1 m=2 par=2
X87 a_1055_3933.t0 a_10551_1290.t0 vss.t10 ppolyf_u_1k r_width=1u r_length=7.11u
X145 a_10551_1290.t1 out.t0 cap_mim_2f0fF c_width=17.43u c_length=17.43u
Rpar0 a_10551_1290.t0 a_10551_1290.t1 58.5051
Rpar1 a_1055_3933.t0 a_1055_3933.t1 131.0575
Rpar2 a_1055_3933.t0 a_1055_3933.t9 183.5034
Rpar3 a_1055_3933.t0 a_1055_3933.t11 518.8933
Rpar4 a_1055_3933.t0 a_1055_3933.t3 491.5709
Rpar5 a_1055_3933.t1 a_1055_3933.t9 64.6441
Rpar6 a_1055_3933.t1 a_1055_3933.t11 182.7942
Rpar7 a_1055_3933.t1 a_1055_3933.t3 173.1692
Rpar8 a_1055_3933.t9 a_1055_3933.t11 255.9439
Rpar9 a_1055_3933.t9 a_1055_3933.t3 104.3591
Rpar10 a_1055_3933.t11 a_1055_3933.t3 685.6252
Rpar11 a_1081_9386.t0 a_1081_9386.t96 66.1574
Rpar12 a_1201_9178.t0 a_1201_9178.t1 29.3017
Rpar13 a_1201_9178.t0 a_1201_9178.t4 228.2001
Rpar14 a_1201_9178.t1 a_1201_9178.t4 81.8304
Rpar15 a_2581_1249.t0 a_2581_1249.t12 63.5944
Rpar16 a_4236_13035.t0 a_4236_13035.t1 21.5574
Rpar17 a_4236_13035.t0 a_4236_13035.t4 205.2915
Rpar18 a_4236_13035.t1 a_4236_13035.t4 102.0926
Rpar19 a_7620_7468.t0 a_7620_7468.t1 29.6308
Rpar20 a_7620_7468.t0 a_7620_7468.t4 144.8671
Rpar21 a_7620_7468.t1 a_7620_7468.t4 121.6549
Rpar22 a_7812_3933.t0 a_7812_3933.t10 105.4941
Rpar23 a_7812_3933.t0 a_7812_3933.t6 601.6459
Rpar24 a_7812_3933.t0 a_7812_3933.t7 107.0667
Rpar25 a_7812_3933.t10 a_7812_3933.t6 558.6548
Rpar26 a_7812_3933.t10 a_7812_3933.t7 99.4162
Rpar27 a_7812_3933.t6 a_7812_3933.t7 45.0967
Rpar28 ib ib.t0 13.1927
Rpar29 ib ib.t1 5.3935
Rpar30 inn inn.t0 5.1287
Rpar31 inn inn.t6 44.6523
Rpar32 inp inp.t0 5.5045
Rpar33 inp inp.t6 120.2278
Rpar34 out out.t0 288.4632
Rpar35 out out.t1 1.8089
Rpar36 out out.t8 108.4169
Rpar37 out.t0 out.t1 635.6353
Rpar38 out.t0 out.t8 83.4113
Rpar39 out.t1 out.t8 238.8992
Rpar40 vdd vdd.t0 157.9103
Rpar41 vdd vdd.t1 461.3237
Rpar42 vdd vdd.t4 30.7491
Rpar43 vdd vdd.t20 449.5408
Rpar44 vdd vdd.t21 1159.1904
Rpar45 vdd.t0 vdd.t1 3.9023
Rpar46 vdd.t0 vdd.t4 204.6139
Rpar47 vdd.t0 vdd.t20 108.9449
Rpar48 vdd.t0 vdd.t21 280.9263
Rpar49 vdd.t1 vdd.t4 597.7650
Rpar50 vdd.t1 vdd.t20 310.4678
Rpar51 vdd.t1 vdd.t21 800.5756
Rpar52 vdd.t4 vdd.t20 582.4971
Rpar53 vdd.t4 vdd.t21 1502.0331
Rpar54 vdd.t20 vdd.t21 9.0207
Rpar55 vss vss.t0 266.2109
Rpar56 vss vss.t1 390.9333
Rpar57 vss vss.t10 133.0956
Rpar58 vss vss.t2 88.9651
Rpar59 vss vss.t23 51.5348
Rpar60 vss vss.t24 149.8527
Rpar61 vss.t0 vss.t1 15.7162
Rpar62 vss.t0 vss.t10 24.1424
Rpar63 vss.t0 vss.t2 3.5243
Rpar64 vss.t0 vss.t23 473.1734
Rpar65 vss.t1 vss.t10 43.0138
Rpar66 vss.t1 vss.t2 8.3107
Rpar67 vss.t1 vss.t23 723.9932
Rpar68 vss.t10 vss.t2 7.6487
Rpar69 vss.t10 vss.t23 264.6538
Rpar70 vss.t10 vss.t24 802.0457
Rpar71 vss.t2 vss.t23 164.5244
Rpar72 vss.t2 vss.t24 530.4951
Rpar73 vss.t23 vss.t24 4.8925
Cpar0 a_10551_1290.t0 vss 8.27900e-17
Cpar1 a_10551_1290.t1 vss 3.36419e-15
Cpar2 a_1055_3933.t0 vss 2.49302e-15
Cpar3 a_1055_3933.t1 vss 7.43388e-15
Cpar4 a_1055_3933.t11 vss 9.68436e-15
Cpar5 a_1055_3933.t3 vss 3.89904e-15
Cpar6 a_1055_3933.t9 vss 3.19284e-15
Cpar7 a_1081_9386.t0 vss 6.07340e-14
Cpar8 a_1081_9386.t96 vss 1.07856e-14
Cpar9 a_1201_9178.t0 vss 8.68833e-15
Cpar10 a_1201_9178.t1 vss 5.10414e-15
Cpar11 a_1201_9178.t4 vss 4.11345e-15
Cpar12 a_2581_1249.t0 vss 9.83981e-15
Cpar13 a_2581_1249.t12 vss 8.27221e-15
Cpar14 a_4236_13035.t0 vss 5.13599e-15
Cpar15 a_4236_13035.t1 vss 4.79206e-15
Cpar16 a_4236_13035.t4 vss 3.24128e-14
Cpar17 a_7620_7468.t0 vss 5.41635e-15
Cpar18 a_7620_7468.t1 vss 2.95770e-15
Cpar19 a_7620_7468.t4 vss 3.17597e-14
Cpar20 a_7812_3933.t0 vss 3.94576e-15
Cpar21 a_7812_3933.t10 vss 1.86137e-15
Cpar22 a_7812_3933.t6 vss 4.24205e-15
Cpar23 a_7812_3933.t7 vss 5.38481e-15
Cpar24 ib out 2.18089e-15
Cpar25 ib vss 2.06316e-14
Cpar26 ib.t0 vss 7.89591e-15
Cpar27 ib.t1 vss 1.18642e-15
Cpar28 inn inp 3.09374e-15
Cpar29 inn vdd 2.02559e-14
Cpar30 inn vss 9.03389e-15
Cpar31 inn.t0 vss 1.75021e-15
Cpar32 inn.t6 vss 3.29285e-14
Cpar33 inp vdd 2.64854e-14
Cpar34 inp vss 1.77439e-14
Cpar35 inp.t0 vss 1.83343e-15
Cpar36 inp.t6 vss 3.82467e-14
Cpar37 out vdd 1.40456e-14
Cpar38 out vss 1.68084e-14
Cpar39 out.t0 vss 9.86202e-15
Cpar40 out.t1 vss 7.66901e-15
Cpar41 out.t8 vss 7.41814e-15
Cpar42 vdd vss 2.11427e-13
Cpar43 vdd.t0 vss 2.08376e-14
Cpar44 vdd.t1 vss 1.26029e-14
Cpar45 vdd.t20 vss 1.20166e-14
Cpar46 vdd.t21 vss 5.28486e-15
Cpar47 vdd.t4 vss 6.03794e-14
.ends opamp_dut

Vdd vdd 0 1.800000
Vss vss 0 0
Ibias vdd ib 2.500000e-06
Vinp inp 0 DC 0.895000 AC 1 PWL(0 0.895000 7.972379e-09 0.895000 8.769617e-09 0.905000)
Rfb out inn 1m
Cload out 0 2.000000e-13
Xdut vdd vss inp inn out ib opamp_dut
.end
