* opa1000[0145]: 2p/current_reuse_1v8_i500u_weak (current_reuse, VDD=1.8V, CL=2.0pF, Iref=50.0uA)
.include "pdk_opa.inc"
.temp 27
.option gmin=1e-12 rshunt=1e12 reltol=1e-3 abstol=1e-12 vntol=1e-5 method=gear
* Post-PEX R+C extracted netlist for current_reuse_1v8_i500u_weak
.subckt opamp_dut vdd vss inp inn out ib
XMpar0 a_12959_3589.t0 inn.t0 a_2485_4186.t0 vss.t0 nfet_03v3 w=1.99u l=0.45u ad=5.5720e-13 pd=2.5500e-06 as=6.2088e-13 ps=2.8130e-06 nf=1 m=40 par=40
XMpar1 a_12959_3589.t40 inn.t40 a_9814_16344.t2 vdd.t32 pfet_03v3 w=2.39u l=0.45u ad=6.9310e-13 pd=3.0447e-06 as=7.1700e-13 ps=3.1394e-06 nf=1 m=64 par=64
XMpar2 out.t0 a_10024_16344.t113 vdd.t0 vdd.t0 pfet_03v3 w=5.19u l=0.35u ad=1.4532e-12 pd=5.7500e-06 as=1.4947e-12 ps=5.8958e-06 nf=1 m=80 par=80
XMpar3 a_10024_16344.t46 inp.t40 a_9814_16344.t2 vdd.t32 pfet_03v3 w=2.39u l=0.45u ad=6.9310e-13 pd=3.0447e-06 as=7.1700e-13 ps=3.1394e-06 nf=1 m=64 par=64
XMpar4 a_10024_16344.t6 inp.t0 a_2485_4186.t0 vss.t0 nfet_03v3 w=1.99u l=0.45u ad=5.5720e-13 pd=2.5500e-06 as=6.2088e-13 ps=2.8130e-06 nf=1 m=40 par=40
XMpar5 a_9814_16344.t0 a_12959_3589.t104 vdd.t0 vdd.t0 pfet_03v3 w=5.19u l=0.35u ad=1.4532e-12 pd=5.7500e-06 as=1.6608e-12 ps=6.4787e-06 nf=1 m=16 par=16
XMpar6 out.t11 ib.t0 vss.t21 vss.t20 nfet_03v3 w=0.95u l=0.35u ad=3.1160e-13 pd=1.7485e-06 as=2.6600e-13 ps=1.5100e-06 nf=1 m=80 par=80
XMpar7 a_10024_16344.t0 a_12959_3589.t104 vdd.t0 vdd.t0 pfet_03v3 w=5.19u l=0.35u ad=1.4532e-12 pd=5.7500e-06 as=1.6608e-12 ps=6.4787e-06 nf=1 m=8 par=8
XMpar8 a_2485_4186.t40 ib.t0 vss.t21 vss.t20 nfet_03v3 w=0.95u l=0.35u ad=2.8500e-13 pd=1.6094e-06 as=3.0400e-13 ps=1.7087e-06 nf=1 m=32 par=32
XMpar9 ib.t1 ib.t0 vss.t21 vss.t20 nfet_03v3 w=0.95u l=0.35u ad=2.6600e-13 pd=1.5100e-06 as=3.4200e-13 ps=1.9075e-06 nf=1 m=16 par=16
XMpar10 a_12959_3589.t105 a_12959_3589.t104 vdd.t0 vdd.t0 pfet_03v3 w=5.19u l=0.35u ad=1.4532e-12 pd=5.7500e-06 as=1.6608e-12 ps=6.4787e-06 nf=1 m=8 par=8
X4 a_10024_16344.t111 a_11482_1290.t0 vss.t250 ppolyf_u_1k r_width=1u r_length=1u
X74 a_11482_1290.t1 out.t24 cap_mim_2f0fF c_width=18.91u c_length=18.91u
X341 a_11482_1290.t1 out.t24 cap_mim_2f0fF c_width=18.91u c_length=18.91u
X418 a_11482_1290.t1 out.t24 cap_mim_2f0fF c_width=18.91u c_length=18.91u
X444 a_11482_1290.t1 out.t24 cap_mim_2f0fF c_width=18.91u c_length=18.91u
Rpar0 a_10024_16344.t0 a_10024_16344.t6 152.8018
Rpar1 a_10024_16344.t0 a_10024_16344.t46 85.6002
Rpar2 a_10024_16344.t0 a_10024_16344.t111 928.9534
Rpar3 a_10024_16344.t0 a_10024_16344.t113 956.7864
Rpar4 a_10024_16344.t6 a_10024_16344.t46 86.7088
Rpar5 a_10024_16344.t6 a_10024_16344.t111 289.9918
Rpar6 a_10024_16344.t6 a_10024_16344.t113 298.6804
Rpar7 a_10024_16344.t46 a_10024_16344.t111 527.1431
Rpar8 a_10024_16344.t46 a_10024_16344.t113 542.9372
Rpar9 a_10024_16344.t111 a_10024_16344.t113 78.6467
Rpar10 a_11482_1290.t0 a_11482_1290.t1 89.5062
Rpar11 a_12959_3589.t0 a_12959_3589.t40 84.6145
Rpar12 a_12959_3589.t0 a_12959_3589.t104 131.7233
Rpar13 a_12959_3589.t0 a_12959_3589.t105 219.7652
Rpar14 a_12959_3589.t40 a_12959_3589.t104 195.9398
Rpar15 a_12959_3589.t40 a_12959_3589.t105 50.3742
Rpar16 a_12959_3589.t104 a_12959_3589.t105 18.6094
Rpar17 a_2485_4186.t0 a_2485_4186.t40 74.9614
Rpar18 a_9814_16344.t0 a_9814_16344.t2 55.5096
Rpar19 ib ib.t0 15.8201
Rpar20 ib ib.t1 3.4319
Rpar21 ib.t0 ib.t1 13.0808
Rpar22 inn inn.t0 2.2301
Rpar23 inn inn.t40 32.9191
Rpar24 inp inp.t0 2.2301
Rpar25 inp inp.t40 32.8705
Rpar26 out out.t0 377.8061
Rpar27 out out.t11 2.3223
Rpar28 out out.t24 1646.4490
Rpar29 out.t0 out.t11 57.2813
Rpar30 out.t0 out.t24 67.2445
Rpar31 out.t11 out.t24 249.6273
Rpar32 vdd vdd.t0 20.4780
Rpar33 vdd vdd.t32 63.6911
Rpar34 vdd.t0 vdd.t32 79.7168
Rpar35 vss vss.t0 52.6805
Rpar36 vss vss.t20 1291.7498
Rpar37 vss vss.t21 61.2418
Rpar38 vss vss.t250 1132.7469
Rpar39 vss.t0 vss.t20 7.9468
Rpar40 vss.t0 vss.t21 26.7788
Rpar41 vss.t0 vss.t250 1.7729
Rpar42 vss.t20 vss.t21 4.8342
Rpar43 vss.t20 vss.t250 325.0440
Rpar44 vss.t21 vss.t250 736.5900
Cpar0 a_10024_16344.t0 vss 1.39391e-14
Cpar1 a_10024_16344.t111 vss 4.59950e-15
Cpar2 a_10024_16344.t113 vss 5.95720e-14
Cpar3 a_10024_16344.t46 vss 4.54600e-14
Cpar4 a_10024_16344.t6 vss 2.93116e-14
Cpar5 a_11482_1290.t0 vss 1.66973e-16
Cpar6 a_11482_1290.t1 vss 1.50755e-14
Cpar7 a_12959_3589.t0 vss 2.94863e-14
Cpar8 a_12959_3589.t104 vss 2.99043e-14
Cpar9 a_12959_3589.t105 vss 1.61544e-14
Cpar10 a_12959_3589.t40 vss 4.77059e-14
Cpar11 a_2485_4186.t0 vss 4.48732e-14
Cpar12 a_2485_4186.t40 vss 2.52032e-14
Cpar13 a_9814_16344.t0 vss 2.82800e-14
Cpar14 a_9814_16344.t2 vss 1.00543e-13
Cpar15 ib out 5.35386e-15
Cpar16 ib vss 7.45912e-14
Cpar17 ib.t0 vss 4.55577e-15
Cpar18 ib.t1 vss 5.49595e-16
Cpar19 inn inp 2.08980e-16
Cpar20 inn out 2.71900e-17
Cpar21 inn vdd 2.24526e-14
Cpar22 inn vss 2.22400e-14
Cpar23 inn.t0 vss 1.26011e-14
Cpar24 inn.t40 vss 3.04396e-14
Cpar25 inp vdd 2.38682e-14
Cpar26 inp vss 2.20782e-14
Cpar27 inp.t0 vss 1.26777e-14
Cpar28 inp.t40 vss 3.06230e-14
Cpar29 out vdd 1.08540e-13
Cpar30 out vss 5.93727e-14
Cpar31 out.t0 vss 6.86629e-14
Cpar32 out.t11 vss 2.12399e-14
Cpar33 out.t24 vss 5.33555e-14
Cpar34 vdd vss 3.34681e-13
Cpar35 vdd.t0 vss 1.66003e-13
Cpar36 vdd.t32 vss 1.00862e-13
.ends opamp_dut

Vdd vdd 0 1.800000
Vss vss 0 0
Ibias vdd ib 5.000000e-05
Vinp inp 0 DC 0.895000 AC 1 PWL(0 0.895000 3.000000e-09 0.895000 3.300000e-09 0.905000)
Rfb out inn 1m
Cload out 0 2.000000e-12
Xdut vdd vss inp inn out ib opamp_dut
.end
