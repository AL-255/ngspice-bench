* opa1000[0681]: 200f/rail_to_rail_1v8_i10u_weak (rail_to_rail, VDD=1.8V, CL=0.2pF, Iref=1.625uA)
.include "pdk_opa.inc"
.temp 27
.option gmin=1e-12 rshunt=1e12 reltol=1e-3 abstol=1e-12 vntol=1e-5 method=gear
* Post-PEX R+C extracted netlist for rail_to_rail_1v8_i10u_weak
.subckt opamp_dut vdd vss inp inn out ib
XMpar0 a_6182_5593.t0 inp.t0 a_941_7758.t3 vss.t2 nfet_03v3 w=1.17u l=1.63u ad=7.0200e-13 pd=3.5400e-06 as=3.2760e-13 ps=1.7300e-06 nf=1 m=2 par=2
XMpar1 a_6352_11482.t7 a_6352_11482.t6 vss.t1 vss.t0 nfet_03v3 w=0.6u l=2.25u ad=1.6800e-13 pd=1.1600e-06 as=1.6800e-13 ps=1.1600e-06 nf=1 m=2 par=2
XMpar2 a_5744_8859.t0 inn.t2 a_6352_11482.t0 vdd.t6 pfet_03v3 w=1.76u l=1.63u ad=6.8053e-13 pd=3.1200e-06 as=6.8053e-13 ps=3.1200e-06 nf=1 m=6 par=6
XMpar3 out.t0 a_941_7758.t7 vdd.t3 vdd.t2 pfet_03v3 w=3.3u l=0.75u ad=9.2400e-13 pd=3.8600e-06 as=1.1880e-12 ps=4.8450e-06 nf=1 m=8 par=8
XMpar4 out.t8 ib.t0 vss.t22 vss.t21 nfet_03v3 w=1.69u l=2.25u ad=4.7320e-13 pd=2.2500e-06 as=6.0840e-13 ps=2.8325e-06 nf=1 m=8 par=8
XMpar5 a_941_7758.t1 a_6952_3234.t3 vdd.t3 vdd.t2 pfet_03v3 w=3.3u l=0.75u ad=1.9800e-12 pd=7.8000e-06 as=9.2400e-13 ps=3.8600e-06 nf=1 m=2 par=2
XMpar6 a_941_7758.t5 a_6352_11482.t6 vss.t1 vss.t0 nfet_03v3 w=0.6u l=2.25u ad=3.6000e-13 pd=2.4000e-06 as=1.6800e-13 ps=1.1600e-06 nf=1 m=2 par=2
XMpar7 a_5744_8859.t0 inp.t2 a_6190_8859.t4 vdd.t6 pfet_03v3 w=1.76u l=1.63u ad=6.8053e-13 pd=3.1200e-06 as=6.8053e-13 ps=3.1200e-06 nf=1 m=6 par=6
XMpar8 a_6952_3234.t4 a_6952_3234.t3 vdd.t3 vdd.t2 pfet_03v3 w=3.3u l=0.75u ad=9.2400e-13 pd=3.8600e-06 as=9.2400e-13 ps=3.8600e-06 nf=1 m=2 par=2
XMpar9 a_9075_1249.t0 ib.t0 vss.t22 vss.t21 nfet_03v3 w=1.69u l=2.25u ad=4.7320e-13 pd=2.2500e-06 as=4.7320e-13 ps=2.2500e-06 nf=1 m=2 par=2
XMpar10 a_6190_8859.t1 a_6190_8859.t0 vss.t1 vss.t0 nfet_03v3 w=0.6u l=2.25u ad=3.6000e-13 pd=2.4000e-06 as=1.6800e-13 ps=1.1600e-06 nf=1 m=2 par=2
XMpar11 a_5744_8859.t12 a_9075_1249.t2 vdd.t1 vdd.t0 pfet_03v3 w=7.09u l=2.25u ad=4.2540e-12 pd=1.5380e-05 as=1.9852e-12 ps=7.6500e-06 nf=1 m=2 par=2
XMpar12 a_9075_1249.t3 a_9075_1249.t2 vdd.t1 vdd.t0 pfet_03v3 w=7.09u l=2.25u ad=1.9852e-12 pd=7.6500e-06 as=1.9852e-12 ps=7.6500e-06 nf=1 m=2 par=2
XMpar13 a_6182_5593.t0 inn.t0 a_6952_3234.t0 vss.t2 nfet_03v3 w=1.17u l=1.63u ad=7.0200e-13 pd=3.5400e-06 as=3.2760e-13 ps=1.7300e-06 nf=1 m=2 par=2
XMpar14 ib.t1 ib.t0 vss.t22 vss.t21 nfet_03v3 w=1.69u l=2.25u ad=1.0140e-12 pd=4.5800e-06 as=4.7320e-13 ps=2.2500e-06 nf=1 m=2 par=2
XMpar15 a_6952_3234.t2 a_6190_8859.t0 vss.t1 vss.t0 nfet_03v3 w=0.6u l=2.25u ad=1.6800e-13 pd=1.1600e-06 as=1.6800e-13 ps=1.1600e-06 nf=1 m=2 par=2
XMpar16 a_6182_5593.t4 ib.t0 vss.t22 vss.t21 nfet_03v3 w=1.69u l=2.25u ad=1.0140e-12 pd=4.5800e-06 as=4.7320e-13 ps=2.2500e-06 nf=1 m=2 par=2
X26 a_3365_7758.t1 out.t16 cap_mim_2f0fF c_width=12.99u c_length=12.99u
X48 a_941_7758.t0 a_3365_7758.t0 vss.t10 ppolyf_u_1k r_width=1u r_length=11.46u
Rpar0 a_3365_7758.t0 a_3365_7758.t1 60.0699
Rpar1 a_5744_8859.t0 a_5744_8859.t12 47.3276
Rpar2 a_6182_5593.t0 a_6182_5593.t4 100.9893
Rpar3 a_6190_8859.t0 a_6190_8859.t1 20.8215
Rpar4 a_6190_8859.t0 a_6190_8859.t4 148.8459
Rpar5 a_6190_8859.t1 a_6190_8859.t4 96.0041
Rpar6 a_6352_11482.t0 a_6352_11482.t6 104.0815
Rpar7 a_6352_11482.t0 a_6352_11482.t7 101.4186
Rpar8 a_6352_11482.t6 a_6352_11482.t7 29.6614
Rpar9 a_6952_3234.t0 a_6952_3234.t2 85.1632
Rpar10 a_6952_3234.t0 a_6952_3234.t3 363.0665
Rpar11 a_6952_3234.t0 a_6952_3234.t4 119.9864
Rpar12 a_6952_3234.t2 a_6952_3234.t3 285.8100
Rpar13 a_6952_3234.t2 a_6952_3234.t4 94.4547
Rpar14 a_6952_3234.t3 a_6952_3234.t4 30.4091
Rpar15 a_9075_1249.t0 a_9075_1249.t2 196.3905
Rpar16 a_9075_1249.t0 a_9075_1249.t3 69.2573
Rpar17 a_9075_1249.t2 a_9075_1249.t3 25.0642
Rpar18 a_941_7758.t0 a_941_7758.t1 248.6739
Rpar19 a_941_7758.t0 a_941_7758.t7 166.8380
Rpar20 a_941_7758.t0 a_941_7758.t3 231.3675
Rpar21 a_941_7758.t0 a_941_7758.t5 84.1090
Rpar22 a_941_7758.t1 a_941_7758.t7 213.6690
Rpar23 a_941_7758.t1 a_941_7758.t3 109.1812
Rpar24 a_941_7758.t1 a_941_7758.t5 327.6488
Rpar25 a_941_7758.t7 a_941_7758.t3 198.7987
Rpar26 a_941_7758.t7 a_941_7758.t5 219.8230
Rpar27 a_941_7758.t3 a_941_7758.t5 304.8461
Rpar28 ib ib.t0 11.6362
Rpar29 ib ib.t1 7.4487
Rpar30 inn inn.t0 5.5443
Rpar31 inn inn.t2 45.0879
Rpar32 inp inp.t0 5.5929
Rpar33 inp inp.t2 55.0383
Rpar34 out out.t0 238.3901
Rpar35 out out.t8 4.2508
Rpar36 out out.t16 212.4794
Rpar37 out.t0 out.t8 103.0438
Rpar38 out.t0 out.t16 206.7139
Rpar39 out.t8 out.t16 91.8439
Rpar40 vdd vdd.t0 503.5885
Rpar41 vdd vdd.t1 855.9559
Rpar42 vdd vdd.t3 260.8458
Rpar43 vdd vdd.t2 186.3764
Rpar44 vdd vdd.t6 50.0204
Rpar45 vdd.t0 vdd.t1 9.5907
Rpar46 vdd.t0 vdd.t6 112.7229
Rpar47 vdd.t1 vdd.t6 191.5966
Rpar48 vdd.t3 vdd.t2 3.5951
Rpar49 vdd.t3 vdd.t6 333.4856
Rpar50 vdd.t2 vdd.t6 238.2781
Rpar51 vss vss.t0 439.1918
Rpar52 vss vss.t1 894.4461
Rpar53 vss vss.t10 3173.1621
Rpar54 vss vss.t2 465.9614
Rpar55 vss vss.t21 67.8211
Rpar56 vss vss.t22 241.2785
Rpar57 vss.t0 vss.t1 12.7193
Rpar58 vss.t0 vss.t10 153.6374
Rpar59 vss.t0 vss.t2 15.4214
Rpar60 vss.t0 vss.t21 4.4422
Rpar61 vss.t0 vss.t22 61.7267
Rpar62 vss.t1 vss.t10 226.5805
Rpar63 vss.t1 vss.t2 33.9735
Rpar64 vss.t1 vss.t21 21.0055
Rpar65 vss.t1 vss.t22 116.4776
Rpar66 vss.t10 vss.t2 175.1728
Rpar67 vss.t10 vss.t21 90.1592
Rpar68 vss.t10 vss.t22 423.3218
Rpar69 vss.t2 vss.t21 11.6792
Rpar70 vss.t2 vss.t22 63.0514
Rpar71 vss.t21 vss.t22 5.8300
Cpar0 a_3365_7758.t0 vss 1.29700e-16
Cpar1 a_3365_7758.t1 vss 2.73080e-15
Cpar2 a_5744_8859.t0 vss 1.01233e-14
Cpar3 a_5744_8859.t12 vss 9.75654e-15
Cpar4 a_6182_5593.t0 vss 6.09044e-15
Cpar5 a_6182_5593.t4 vss 8.29387e-15
Cpar6 a_6190_8859.t0 vss 4.87827e-15
Cpar7 a_6190_8859.t1 vss 2.08251e-15
Cpar8 a_6190_8859.t4 vss 4.33816e-15
Cpar9 a_6352_11482.t0 vss 4.12618e-15
Cpar10 a_6352_11482.t6 vss 4.74746e-15
Cpar11 a_6352_11482.t7 vss 1.27242e-15
Cpar12 a_6952_3234.t0 vss 1.66748e-15
Cpar13 a_6952_3234.t2 vss 2.06193e-15
Cpar14 a_6952_3234.t3 vss 3.53669e-15
Cpar15 a_6952_3234.t4 vss 3.16727e-15
Cpar16 a_9075_1249.t0 vss 3.25499e-15
Cpar17 a_9075_1249.t2 vss 9.69005e-15
Cpar18 a_9075_1249.t3 vss 3.83060e-15
Cpar19 a_941_7758.t0 vss 3.11891e-15
Cpar20 a_941_7758.t1 vss 4.12705e-15
Cpar21 a_941_7758.t3 vss 2.18083e-15
Cpar22 a_941_7758.t5 vss 3.37962e-15
Cpar23 a_941_7758.t7 vss 7.91840e-15
Cpar24 ib out 1.40837e-15
Cpar25 ib vss 2.37264e-14
Cpar26 ib.t0 vss 8.00413e-15
Cpar27 ib.t1 vss 7.37484e-16
Cpar28 inn inp 1.56400e-16
Cpar29 inn vdd 6.52694e-15
Cpar30 inn vss 6.97691e-15
Cpar31 inn.t0 vss 9.17575e-16
Cpar32 inn.t2 vss 8.13355e-15
Cpar33 inp vdd 7.54508e-15
Cpar34 inp vss 6.49728e-15
Cpar35 inp.t0 vss 1.13984e-15
Cpar36 inp.t2 vss 1.01763e-14
Cpar37 out vdd 7.59935e-15
Cpar38 out vss 1.24048e-14
Cpar39 out.t0 vss 4.24991e-15
Cpar40 out.t16 vss 7.40179e-15
Cpar41 out.t8 vss 2.68836e-15
Cpar42 vdd vss 1.19848e-13
Cpar43 vdd.t0 vss 1.00937e-14
Cpar44 vdd.t1 vss 5.98066e-15
Cpar45 vdd.t2 vss 1.12319e-14
Cpar46 vdd.t3 vss 7.50434e-15
Cpar47 vdd.t6 vss 1.98334e-14
.ends opamp_dut

Vdd vdd 0 1.800000
Vss vss 0 0
Ibias vdd ib 1.625000e-06
Vinp inp 0 DC 0.895000 AC 1 PWL(0 0.895000 1.070019e-08 0.895000 1.177021e-08 0.905000)
Rfb out inn 1m
Cload out 0 2.000000e-13
Xdut vdd vss inp inn out ib opamp_dut
.end
