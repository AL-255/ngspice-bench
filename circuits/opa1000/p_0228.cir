* opa1000[0228]: 2p/folded_cascode_nmos_1v8_i500u_subth (folded_cascode_nmos, VDD=1.8V, CL=2.0pF, Iref=77.7778uA)
.include "pdk_opa.inc"
.temp 27
.option gmin=1e-12 rshunt=1e12 reltol=1e-3 abstol=1e-12 vntol=1e-5 method=gear
* Post-PEX R+C extracted netlist for folded_cascode_nmos_1v8_i500u_subth
.subckt opamp_dut vdd vss inp inn out ib
XMpar0 a_6642_12515.t0 a_1151_9467.t16 vdd.t1 vdd.t0 pfet_03v3 w=10u l=0.5u ad=2.8000e-12 pd=1.0560e-05 as=3.0000e-12 ps=1.1225e-05 nf=1 m=32 par=32
XMpar1 a_14254_1250.t180 ib.t80 out.t16 vdd.t84 pfet_03v3 w=4.73u l=0.28u ad=2.1285e-12 pd=5.9256e-06 as=2.0339e-12 ps=5.5900e-06 nf=1 m=160 par=160
XMpar2 a_6642_12515.t173 ib.t80 a_6848_12515.t0 vdd.t84 pfet_03v3 w=4.73u l=0.28u ad=2.1285e-12 pd=5.9256e-06 as=2.0339e-12 ps=5.5900e-06 nf=1 m=160 par=160
XMpar3 a_1151_9467.t17 a_1151_9467.t16 vdd.t1 vdd.t0 pfet_03v3 w=10u l=0.5u ad=2.8000e-12 pd=1.0560e-05 as=3.2000e-12 ps=1.1890e-05 nf=1 m=16 par=16
XMpar4 a_6642_12515.t1 inp.t0 a_6704_9466.t0 vss.t0 nfet_03v3 w=2.72u l=0.28u ad=1.1914e-12 pd=3.6640e-06 as=1.2131e-12 ps=3.7480e-06 nf=1 m=160 par=160
XMpar5 a_14254_1250.t20 inn.t0 a_6704_9466.t0 vss.t0 nfet_03v3 w=2.72u l=0.28u ad=1.1914e-12 pd=3.6640e-06 as=1.2131e-12 ps=3.7480e-06 nf=1 m=160 par=160
XMpar6 a_1151_9467.t0 ib.t0 vss.t0 vss.t0 nfet_03v3 w=7.34u l=0.68u ad=2.0552e-12 pd=7.9000e-06 as=2.3488e-12 ps=8.8975e-06 nf=1 m=16 par=16
XMpar7 a_6704_9466.t320 ib.t0 vss.t0 vss.t0 nfet_03v3 w=7.34u l=0.68u ad=2.0552e-12 pd=7.9000e-06 as=2.2020e-12 ps=8.3987e-06 nf=1 m=32 par=32
XMpar8 ib.t1 ib.t0 vss.t0 vss.t0 nfet_03v3 w=7.34u l=0.68u ad=2.0552e-12 pd=7.9000e-06 as=2.0552e-12 ps=7.9000e-06 nf=1 m=16 par=16
XMpar9 out.t0 a_6848_12515.t160 vss.t0 vss.t0 nfet_03v3 w=7.34u l=0.68u ad=2.0552e-12 pd=7.9000e-06 as=2.0552e-12 ps=7.9000e-06 nf=1 m=16 par=16
XMpar10 a_6848_12515.t161 a_6848_12515.t160 vss.t0 vss.t0 nfet_03v3 w=7.34u l=0.68u ad=2.0552e-12 pd=7.9000e-06 as=2.3488e-12 ps=8.8975e-06 nf=1 m=16 par=16
XMpar11 a_14254_1250.t0 a_1151_9467.t16 vdd.t1 vdd.t0 pfet_03v3 w=10u l=0.5u ad=2.8000e-12 pd=1.0560e-05 as=3.0000e-12 ps=1.1225e-05 nf=1 m=32 par=32
X474 out.t176 vss.t97 cap_mim_2f0fF c_width=17.43u c_length=17.43u
Rpar0 a_1151_9467.t0 a_1151_9467.t16 71.7873
Rpar1 a_1151_9467.t0 a_1151_9467.t17 122.7078
Rpar2 a_1151_9467.t16 a_1151_9467.t17 14.6573
Rpar3 a_14254_1250.t0 a_14254_1250.t20 252.4906
Rpar4 a_14254_1250.t0 a_14254_1250.t180 56.7310
Rpar5 a_14254_1250.t20 a_14254_1250.t180 75.4964
Rpar6 a_6642_12515.t0 a_6642_12515.t1 252.4906
Rpar7 a_6642_12515.t0 a_6642_12515.t173 56.7310
Rpar8 a_6642_12515.t1 a_6642_12515.t173 75.4964
Rpar9 a_6704_9466.t0 a_6704_9466.t320 47.0013
Rpar10 a_6848_12515.t0 a_6848_12515.t160 491.1614
Rpar11 a_6848_12515.t0 a_6848_12515.t161 98.1311
Rpar12 a_6848_12515.t160 a_6848_12515.t161 16.0434
Rpar13 ib ib.t0 68.7001
Rpar14 ib ib.t1 77.4462
Rpar15 ib ib.t80 1.6961
Rpar16 ib.t0 ib.t1 13.8718
Rpar17 inn inn.t0 2.1334
Rpar18 inp inp.t0 2.1334
Rpar19 out out.t0 60.0204
Rpar20 out out.t16 1.9603
Rpar21 out out.t176 66.2183
Rpar22 out.t0 out.t176 292.5608
Rpar23 vdd vdd.t0 188.3763
Rpar24 vdd vdd.t1 71.4480
Rpar25 vdd vdd.t84 192.8739
Rpar26 vdd.t0 vdd.t1 2.3390
Rpar27 vdd.t0 vdd.t84 98.7914
Rpar28 vdd.t1 vdd.t84 63.2941
Rpar29 vss vss.t0 49.7858
Rpar30 vss vss.t97 1917.2459
Rpar31 vss.t0 vss.t97 55.2927
Cpar0 a_1151_9467.t0 vss 1.67722e-14
Cpar1 a_1151_9467.t16 vss 6.96852e-14
Cpar2 a_1151_9467.t17 vss 2.26679e-14
Cpar3 a_14254_1250.t0 vss 5.78796e-14
Cpar4 a_14254_1250.t180 vss 1.73873e-13
Cpar5 a_14254_1250.t20 vss 1.18602e-13
Cpar6 a_6642_12515.t0 vss 5.85728e-14
Cpar7 a_6642_12515.t1 vss 1.20021e-13
Cpar8 a_6642_12515.t173 vss 1.75955e-13
Cpar9 a_6704_9466.t0 vss 1.90982e-13
Cpar10 a_6704_9466.t320 vss 3.91921e-14
Cpar11 a_6848_12515.t0 vss 1.34034e-13
Cpar12 a_6848_12515.t160 vss 3.34760e-14
Cpar13 a_6848_12515.t161 vss 2.24649e-14
Cpar14 ib out 2.77968e-14
Cpar15 ib vdd 1.10880e-13
Cpar16 ib vss 9.43236e-14
Cpar17 ib.t0 vss 6.21842e-14
Cpar18 ib.t1 vss 2.08350e-14
Cpar19 ib.t80 vss 1.21901e-13
Cpar20 inn inp 2.50900e-16
Cpar21 inn vss 6.02298e-14
Cpar22 inn.t0 vss 3.45004e-14
Cpar23 inp vss 6.03031e-14
Cpar24 inp.t0 vss 3.45071e-14
Cpar25 out vdd 1.58381e-14
Cpar26 out vss 4.07903e-14
Cpar27 out.t0 vss 1.56333e-14
Cpar28 out.t16 vss 9.64040e-14
Cpar29 out.t176 vss 7.26198e-14
Cpar30 vdd vss 6.55339e-13
Cpar31 vdd.t0 vss 9.01035e-14
Cpar32 vdd.t1 vss 4.37868e-14
Cpar33 vdd.t84 vss 2.13326e-13
.ends opamp_dut

Vdd vdd 0 1.800000
Vss vss 0 0
Ibias vdd ib 7.777780e-05
Vinp inp 0 DC 0.985000 AC 1 PWL(0 0.985000 3.000000e-09 0.985000 3.300000e-09 0.995000)
Rfb out inn 1m
Cload out 0 2.000000e-12
Xdut vdd vss inp inn out ib opamp_dut
.end
