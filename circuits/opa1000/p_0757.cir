* opa1000[0757]: 200f/symmetrical_ota_1v8_i1u_weak (symmetrical_ota, VDD=1.8V, CL=0.2pF, Iref=0.1417uA)
.include "pdk_opa.inc"
.temp 27
.option gmin=1e-12 rshunt=1e12 reltol=1e-3 abstol=1e-12 vntol=1e-5 method=gear
* Post-PEX R+C extracted netlist for symmetrical_ota_1v8_i1u_weak
.subckt opamp_dut vdd vss inp inn out ib
XMpar0 out.t2 a_1604_5776.t2 vdd.t1 vdd.t0 pfet_03v3 w=0.53u l=2.7u ad=3.1800e-13 pd=2.2600e-06 as=2.3320e-13 ps=1.6750e-06 nf=1 m=4 par=4
XMpar1 a_5396_5776.t3 a_5396_5776.t2 vdd.t1 vdd.t0 pfet_03v3 w=0.53u l=2.7u ad=3.1800e-13 pd=2.2600e-06 as=1.4840e-13 ps=1.0900e-06 nf=1 m=2 par=2
XMpar2 a_2148_4205.t1 a_2148_4205.t0 vss.t1 vss.t0 nfet_03v3 w=0.4u l=2.7u ad=1.1200e-13 pd=9.6000e-07 as=1.1200e-13 ps=9.6000e-07 nf=1 m=4 par=4
XMpar3 a_2148_4205.t8 a_5396_5776.t2 vdd.t1 vdd.t0 pfet_03v3 w=0.53u l=2.7u ad=3.1800e-13 pd=2.2600e-06 as=2.3320e-13 ps=1.6750e-06 nf=1 m=4 par=4
XMpar4 a_1714_2776.t4 ib.t0 vss.t19 vss.t18 nfet_03v3 w=0.4u l=4.38u ad=1.1200e-13 pd=9.6000e-07 as=1.7600e-13 ps=1.4800e-06 nf=1 m=4 par=4
XMpar5 a_1604_5776.t3 a_1604_5776.t2 vdd.t1 vdd.t0 pfet_03v3 w=0.53u l=2.7u ad=3.1800e-13 pd=2.2600e-06 as=1.4840e-13 ps=1.0900e-06 nf=1 m=2 par=2
XMpar6 out.t0 a_2148_4205.t0 vss.t1 vss.t0 nfet_03v3 w=0.4u l=2.7u ad=1.1200e-13 pd=9.6000e-07 as=1.7600e-13 ps=1.4800e-06 nf=1 m=4 par=4
XMpar7 a_1714_2776.t0 inn.t0 a_5396_5776.t0 vss.t4 nfet_03v3 w=1.53u l=6u ad=9.1800e-13 pd=4.2600e-06 as=4.2840e-13 ps=2.0900e-06 nf=1 m=2 par=2
XMpar8 a_1604_5776.t0 inp.t0 a_1714_2776.t0 vss.t4 nfet_03v3 w=1.53u l=6u ad=4.2840e-13 pd=2.0900e-06 as=9.1800e-13 ps=4.2600e-06 nf=1 m=2 par=2
XMpar9 ib.t1 ib.t0 vss.t19 vss.t18 nfet_03v3 w=0.4u l=4.38u ad=1.1200e-13 pd=9.6000e-07 as=1.1200e-13 ps=9.6000e-07 nf=1 m=2 par=2
Rpar0 a_1604_5776.t0 a_1604_5776.t2 102.1276
Rpar1 a_1604_5776.t0 a_1604_5776.t3 129.8927
Rpar2 a_1604_5776.t2 a_1604_5776.t3 14.6129
Rpar3 a_1714_2776.t0 a_1714_2776.t4 42.0837
Rpar4 a_2148_4205.t0 a_2148_4205.t1 21.7765
Rpar5 a_2148_4205.t0 a_2148_4205.t8 159.1102
Rpar6 a_2148_4205.t1 a_2148_4205.t8 76.4940
Rpar7 a_5396_5776.t0 a_5396_5776.t2 102.1272
Rpar8 a_5396_5776.t0 a_5396_5776.t3 129.8932
Rpar9 a_5396_5776.t2 a_5396_5776.t3 14.6129
Rpar10 ib ib.t0 11.2614
Rpar11 ib ib.t1 16.2850
Rpar12 inn inn.t0 3.5333
Rpar13 inp inp.t0 3.5819
Rpar14 out out.t0 47.7912
Rpar15 out out.t2 5.7207
Rpar16 vdd vdd.t0 79.4772
Rpar17 vdd vdd.t1 22.0252
Rpar18 vdd.t0 vdd.t1 9.5775
Rpar19 vss vss.t0 129.0286
Rpar20 vss vss.t1 722.6296
Rpar21 vss vss.t4 301.3221
Rpar22 vss vss.t18 101.9313
Rpar23 vss vss.t19 510.4504
Rpar24 vss.t0 vss.t1 14.9980
Rpar25 vss.t0 vss.t4 3.4377
Rpar26 vss.t0 vss.t18 3.0345
Rpar27 vss.t0 vss.t19 19.5109
Rpar28 vss.t1 vss.t4 34.4795
Rpar29 vss.t1 vss.t18 13.2444
Rpar30 vss.t1 vss.t19 113.6059
Rpar31 vss.t4 vss.t18 7.0517
Rpar32 vss.t4 vss.t19 40.8384
Rpar33 vss.t18 vss.t19 15.0972
Cpar0 a_1604_5776.t0 vss 3.90336e-15
Cpar1 a_1604_5776.t2 vss 1.35580e-14
Cpar2 a_1604_5776.t3 vss 4.36757e-15
Cpar3 a_1714_2776.t0 vss 4.35338e-15
Cpar4 a_1714_2776.t4 vss 3.21648e-15
Cpar5 a_2148_4205.t0 vss 7.21230e-15
Cpar6 a_2148_4205.t1 vss 2.02653e-15
Cpar7 a_2148_4205.t8 vss 4.04048e-15
Cpar8 a_5396_5776.t0 vss 3.92198e-15
Cpar9 a_5396_5776.t2 vss 1.36227e-14
Cpar10 a_5396_5776.t3 vss 4.38838e-15
Cpar11 ib inn 2.32400e-17
Cpar12 ib inp 2.69700e-17
Cpar13 ib vss 1.92778e-14
Cpar14 ib.t0 vss 2.22720e-15
Cpar15 ib.t1 vss 1.03802e-16
Cpar16 inn inp 5.19700e-17
Cpar17 inn vss 6.35772e-15
Cpar18 inn.t0 vss 7.29804e-16
Cpar19 inp vss 6.23938e-15
Cpar20 inp.t0 vss 7.16444e-16
Cpar21 out vdd 4.93199e-15
Cpar22 out vss 1.12138e-14
Cpar23 out.t0 vss 4.49370e-15
Cpar24 out.t2 vss 2.77363e-15
Cpar25 vdd vss 6.71652e-14
Cpar26 vdd.t0 vss 2.34641e-14
Cpar27 vdd.t1 vss 1.01771e-14
.ends opamp_dut

Vdd vdd 0 1.800000
Vss vss 0 0
Ibias vdd ib 1.417000e-07
Vinp inp 0 DC 0.895000 AC 1 PWL(0 0.895000 3.350256e-08 0.895000 3.685281e-08 0.905000)
Rfb out inn 1m
Cload out 0 2.000000e-13
Xdut vdd vss inp inn out ib opamp_dut
.end
