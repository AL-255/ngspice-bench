* opa1000[0132]: 2p/current_reuse_1v8_i1u_weak (current_reuse, VDD=1.8V, CL=2.0pF, Iref=0.1429uA)
.include "pdk_opa.inc"
.temp 27
.option gmin=1e-12 rshunt=1e12 reltol=1e-3 abstol=1e-12 vntol=1e-5 method=gear
* Post-PEX R+C extracted netlist for current_reuse_1v8_i1u_weak
.subckt opamp_dut vdd vss inp inn out ib
XMpar0 a_5394_4380.t0 ib.t0 vss.t2 vss.t1 nfet_03v3 w=0.4u l=5.25u ad=2.4000e-13 pd=2.0000e-06 as=1.1200e-13 ps=9.6000e-07 nf=1 m=4 par=4
XMpar1 out.t0 ib.t0 vss.t2 vss.t1 nfet_03v3 w=0.4u l=5.25u ad=1.8880e-13 pd=1.5840e-06 as=1.6320e-13 ps=1.3760e-06 nf=1 m=10 par=10
XMpar2 a_3654_9398.t0 inp.t4 a_5394_4380.t4 vss.t26 nfet_03v3 w=2.11u l=6u ad=5.9080e-13 pd=2.6700e-06 as=1.2660e-12 ps=5.4200e-06 nf=1 m=2 par=2
XMpar3 a_1496_6267.t0 inp.t0 a_3654_9398.t2 vdd.t6 pfet_03v3 w=2.06u l=6u ad=1.2360e-12 pd=5.3200e-06 as=5.7680e-13 ps=2.6200e-06 nf=1 m=4 par=4
XMpar4 a_1496_6267.t4 a_1136_6059.t0 vdd.t1 vdd.t0 pfet_03v3 w=0.73u l=1.8u ad=2.0440e-13 pd=1.2900e-06 as=4.3800e-13 ps=2.6600e-06 nf=1 m=2 par=2
XMpar5 a_1136_6059.t4 inn.t0 a_1496_6267.t0 vdd.t6 pfet_03v3 w=2.06u l=6u ad=5.7680e-13 pd=2.6200e-06 as=1.2360e-12 ps=5.3200e-06 nf=1 m=4 par=4
XMpar6 out.t12 a_3654_9398.t8 vdd.t1 vdd.t0 pfet_03v3 w=0.73u l=1.8u ad=2.0440e-13 pd=1.2900e-06 as=2.5112e-13 ps=1.5640e-06 nf=1 m=10 par=10
XMpar7 ib.t1 ib.t0 vss.t2 vss.t1 nfet_03v3 w=0.4u l=5.25u ad=2.4000e-13 pd=2.0000e-06 as=1.1200e-13 ps=9.6000e-07 nf=1 m=2 par=2
XMpar8 a_1136_6059.t1 a_1136_6059.t0 vdd.t1 vdd.t0 pfet_03v3 w=0.73u l=1.8u ad=4.3800e-13 pd=2.6600e-06 as=2.0440e-13 ps=1.2900e-06 nf=1 m=1
XMpar9 a_1136_6059.t2 inn.t4 a_5394_4380.t4 vss.t26 nfet_03v3 w=2.11u l=6u ad=5.9080e-13 pd=2.6700e-06 as=1.2660e-12 ps=5.4200e-06 nf=1 m=2 par=2
XMpar10 a_3654_9398.t6 a_1136_6059.t0 vdd.t1 vdd.t0 pfet_03v3 w=0.73u l=1.8u ad=4.3800e-13 pd=2.6600e-06 as=2.0440e-13 ps=1.2900e-06 nf=1 m=1
X1 a_15284_15418.t1 out.t10 cap_mim_2f0fF c_width=15.62u c_length=15.61u
X3 a_11552_14898.t0 a_15284_15418.t0 vss.t0 ppolyf_u_1k r_width=1u r_length=18u
X13 a_11552_11778.t0 a_15284_12298.t0 vss.t0 ppolyf_u_1k r_width=1u r_length=18u
X14 a_15284_15418.t1 out.t10 cap_mim_2f0fF c_width=15.62u c_length=15.61u
X18 a_11552_14898.t0 a_15284_14378.t0 vss.t0 ppolyf_u_1k r_width=1u r_length=18u
X21 a_11552_11778.t0 a_15284_11258.t0 vss.t0 ppolyf_u_1k r_width=1u r_length=18u
X26 a_11552_13858.t0 a_15284_14378.t0 vss.t0 ppolyf_u_1k r_width=1u r_length=18u
X30 a_3654_9398.t7 a_15284_11258.t0 vss.t0 ppolyf_u_1k r_width=1u r_length=18u
X34 a_11552_13858.t0 a_15284_13338.t0 vss.t0 ppolyf_u_1k r_width=1u r_length=18u
X44 a_11552_12818.t0 a_15284_13338.t0 vss.t0 ppolyf_u_1k r_width=1u r_length=18u
X51 a_11552_12818.t0 a_15284_12298.t0 vss.t0 ppolyf_u_1k r_width=1u r_length=18u
Rpar0 a_1136_6059.t0 a_1136_6059.t1 27.5336
Rpar1 a_1136_6059.t0 a_1136_6059.t2 131.7628
Rpar2 a_1136_6059.t0 a_1136_6059.t4 181.3699
Rpar3 a_1136_6059.t1 a_1136_6059.t2 943.1816
Rpar4 a_1136_6059.t1 a_1136_6059.t4 1298.2787
Rpar5 a_1136_6059.t2 a_1136_6059.t4 69.0794
Rpar6 a_1496_6267.t0 a_1496_6267.t4 71.1354
Rpar7 a_15284_15418.t0 a_15284_15418.t1 71.4839
Rpar8 a_3654_9398.t0 a_3654_9398.t8 193.3965
Rpar9 a_3654_9398.t0 a_3654_9398.t2 70.6808
Rpar10 a_3654_9398.t0 a_3654_9398.t6 553.1589
Rpar11 a_3654_9398.t0 a_3654_9398.t7 993.1847
Rpar12 a_3654_9398.t8 a_3654_9398.t2 177.9575
Rpar13 a_3654_9398.t8 a_3654_9398.t6 113.6740
Rpar14 a_3654_9398.t8 a_3654_9398.t7 204.0992
Rpar15 a_3654_9398.t2 a_3654_9398.t6 508.9997
Rpar16 a_3654_9398.t2 a_3654_9398.t7 913.8978
Rpar17 a_3654_9398.t6 a_3654_9398.t7 118.2846
Rpar18 a_5394_4380.t0 a_5394_4380.t4 51.9215
Rpar19 ib ib.t0 16.7817
Rpar20 ib ib.t1 15.3928
Rpar21 ib.t0 ib.t1 34.2241
Rpar22 inn inn.t0 42.6020
Rpar23 inn inn.t4 3.7115
Rpar24 inp inp.t0 42.5534
Rpar25 inp inp.t4 3.7600
Rpar26 out out.t0 104.9244
Rpar27 out out.t10 200.0959
Rpar28 out out.t12 3.7105
Rpar29 out.t0 out.t10 75.8816
Rpar30 out.t0 out.t12 96.3898
Rpar31 out.t10 out.t12 183.8200
Rpar32 vdd vdd.t0 71.1257
Rpar33 vdd vdd.t1 124.8278
Rpar34 vdd vdd.t6 428.1826
Rpar35 vdd.t0 vdd.t1 3.8785
Rpar36 vdd.t0 vdd.t6 150.9906
Rpar37 vdd.t1 vdd.t6 139.6546
Rpar38 vss vss.t0 356.2760
Rpar39 vss vss.t1 82.4252
Rpar40 vss vss.t2 602.9253
Rpar41 vss vss.t26 224.9913
Rpar42 vss.t0 vss.t1 20.8940
Rpar43 vss.t0 vss.t2 146.5270
Rpar44 vss.t0 vss.t26 57.7089
Rpar45 vss.t1 vss.t2 18.9926
Rpar46 vss.t1 vss.t26 5.2773
Rpar47 vss.t2 vss.t26 52.4340
Cpar0 a_1136_6059.t0 vss 1.00508e-14
Cpar1 a_1136_6059.t1 vss 2.43318e-15
Cpar2 a_1136_6059.t2 vss 4.89316e-15
Cpar3 a_1136_6059.t4 vss 6.88269e-15
Cpar4 a_11552_11778.t0 vss 3.21000e-17
Cpar5 a_11552_12818.t0 vss 3.36000e-17
Cpar6 a_11552_13858.t0 vss 3.64600e-17
Cpar7 a_11552_14898.t0 vss 3.28000e-17
Cpar8 a_1496_6267.t0 vss 1.47581e-14
Cpar9 a_1496_6267.t4 vss 3.48147e-15
Cpar10 a_15284_11258.t0 vss 2.64400e-17
Cpar11 a_15284_12298.t0 vss 3.00800e-17
Cpar12 a_15284_13338.t0 vss 2.93600e-17
Cpar13 a_15284_14378.t0 vss 3.20200e-17
Cpar14 a_15284_15418.t0 vss 1.03715e-16
Cpar15 a_15284_15418.t1 vss 4.88761e-15
Cpar16 a_3654_9398.t0 vss 4.33098e-15
Cpar17 a_3654_9398.t2 vss 7.74912e-15
Cpar18 a_3654_9398.t6 vss 3.88912e-15
Cpar19 a_3654_9398.t7 vss 4.95868e-15
Cpar20 a_3654_9398.t8 vss 1.38451e-14
Cpar21 a_5394_4380.t0 vss 1.68783e-14
Cpar22 a_5394_4380.t4 vss 1.01915e-14
Cpar23 ib inn 1.97800e-17
Cpar24 ib inp 1.56800e-17
Cpar25 ib out 2.26705e-15
Cpar26 ib vdd 5.70900e-17
Cpar27 ib vss 6.00056e-14
Cpar28 ib.t0 vss 9.94861e-15
Cpar29 ib.t1 vss 7.57185e-16
Cpar30 inn inp 1.55910e-16
Cpar31 inn vdd 1.04838e-14
Cpar32 inn vss 1.01484e-14
Cpar33 inn.t0 vss 1.07526e-14
Cpar34 inn.t4 vss 3.27312e-15
Cpar35 inp vdd 1.11032e-14
Cpar36 inp vss 9.43420e-15
Cpar37 inp.t0 vss 1.12451e-14
Cpar38 inp.t4 vss 3.44610e-15
Cpar39 out vdd 9.24480e-15
Cpar40 out vss 2.31956e-14
Cpar41 out.t0 vss 7.89601e-15
Cpar42 out.t10 vss 1.57045e-14
Cpar43 out.t12 vss 1.53173e-15
Cpar44 vdd vss 1.26874e-13
Cpar45 vdd.t0 vss 1.71115e-14
Cpar46 vdd.t1 vss 9.96976e-15
Cpar47 vdd.t6 vss 3.27043e-14
.ends opamp_dut

Vdd vdd 0 1.800000
Vss vss 0 0
Ibias vdd ib 1.429000e-07
Vinp inp 0 DC 0.895000 AC 1 PWL(0 0.895000 1.905714e-07 0.895000 2.096286e-07 0.905000)
Rfb out inn 1m
Cload out 0 2.000000e-12
Xdut vdd vss inp inn out ib opamp_dut
.end
