* opa1000[0853]: 200f/telescopic_nmos_1v8_i500u_subth (telescopic_nmos, VDD=1.8V, CL=0.2pF, Iref=143.75uA)
.include "pdk_opa.inc"
.temp 27
.option gmin=1e-12 rshunt=1e12 reltol=1e-3 abstol=1e-12 vntol=1e-5 method=gear
* Post-PEX R+C extracted netlist for telescopic_nmos_1v8_i500u_subth
.subckt opamp_dut vdd vss inp inn out ib
XMpar0 a_3925_22651.t119 a_3393_22443.t0 out.t156 vdd.t0 pfet_03v3 w=14u l=0.38u ad=5.9360e-12 pd=2.1148e-05 as=4.9280e-12 ps=1.7854e-05 nf=1 m=160 par=160
XMpar1 a_3273_22651.t12 a_3393_22443.t640 vdd.t13 vdd.t12 pfet_03v3 w=11.01u l=0.63u ad=3.7434e-12 pd=1.3754e-05 as=3.1709e-12 ps=1.1861e-05 nf=1 m=160 par=160
XMpar2 a_11218_10311.t0 inp.t0 a_1669_1204.t64 vss.t120 nfet_03v3 w=7.07u l=0.38u ad=1.9796e-12 pd=7.6300e-06 as=2.0927e-12 ps=8.0155e-06 nf=1 m=160 par=160
XMpar3 a_3925_22651.t0 a_3393_22443.t640 vdd.t13 vdd.t12 pfet_03v3 w=11.01u l=0.63u ad=3.6994e-12 pd=1.3609e-05 as=3.2590e-12 ps=1.2152e-05 nf=1 m=160 par=160
XMpar4 a_3273_22651.t0 a_3393_22443.t0 a_3393_22443.t1 vdd.t0 pfet_03v3 w=14u l=0.38u ad=6.2160e-12 pd=2.2063e-05 as=4.8160e-12 ps=1.7488e-05 nf=1 m=160 par=160
XMpar5 a_1669_1204.t64 inn.t0 a_19054_10311.t160 vss.t120 nfet_03v3 w=7.07u l=0.38u ad=2.0927e-12 pd=8.0155e-06 as=1.9796e-12 ps=7.6300e-06 nf=1 m=160 par=160
XMpar6 a_11218_10311.t160 vdd.t740 a_3393_22443.t320 vss.t120 nfet_03v3 w=5.76u l=0.38u ad=1.7050e-12 pd=6.6400e-06 as=1.6128e-12 ps=6.3200e-06 nf=1 m=160 par=160
XMpar7 a_19054_10311.t0 vdd.t740 out.t0 vss.t120 nfet_03v3 w=5.76u l=0.38u ad=1.7050e-12 pd=6.6400e-06 as=1.6128e-12 ps=6.3200e-06 nf=1 m=160 par=160
XMpar8 a_1669_1204.t0 ib.t0 vss.t1 vss.t0 nfet_03v3 w=8.26u l=0.36u ad=2.3128e-12 pd=8.8200e-06 as=2.4780e-12 ps=9.3763e-06 nf=1 m=64 par=64
XMpar9 ib.t1 ib.t0 vss.t1 vss.t0 nfet_03v3 w=8.26u l=0.36u ad=2.3128e-12 pd=8.8200e-06 as=2.3128e-12 ps=8.8200e-06 nf=1 m=16 par=16
X1071 out.t320 vss.t200 cap_mim_2f0fF c_width=11.18u c_length=11.18u
Rpar0 a_11218_10311.t0 a_11218_10311.t160 45.9942
Rpar1 a_1669_1204.t0 a_1669_1204.t64 41.3886
Rpar2 a_19054_10311.t0 a_19054_10311.t160 45.9942
Rpar3 a_3273_22651.t0 a_3273_22651.t12 60.0551
Rpar4 a_3393_22443.t0 a_3393_22443.t1 6.9076
Rpar5 a_3393_22443.t0 a_3393_22443.t320 562.1572
Rpar6 a_3393_22443.t0 a_3393_22443.t640 478.6502
Rpar7 a_3393_22443.t1 a_3393_22443.t320 68.4607
Rpar8 a_3393_22443.t1 a_3393_22443.t640 58.2910
Rpar9 a_3393_22443.t320 a_3393_22443.t640 163.6745
Rpar10 a_3925_22651.t0 a_3925_22651.t119 46.0202
Rpar11 ib ib.t0 17.3886
Rpar12 ib ib.t1 4.4453
Rpar13 ib.t0 ib.t1 15.0832
Rpar14 inn inn.t0 2.2939
Rpar15 inp inp.t0 2.2939
Rpar16 out out.t0 113.7229
Rpar17 out out.t156 2.8956
Rpar18 out out.t320 75.2167
Rpar19 out.t0 out.t320 89.3987
Rpar20 vdd vdd.t0 259.3948
Rpar21 vdd vdd.t12 20.1277
Rpar22 vdd vdd.t740 791.8888
Rpar23 vdd.t0 vdd.t12 90.6912
Rpar24 vdd.t0 vdd.t740 106.7817
Rpar25 vdd.t12 vdd.t740 276.8650
Rpar26 vdd.t12 vdd.t13 12.2791
Rpar27 vss vss.t0 4092.2143
Rpar28 vss vss.t1 43.9665
Rpar29 vss vss.t120 85.8177
Rpar30 vss vss.t200 259.8713
Rpar31 vss.t0 vss.t1 10.7137
Rpar32 vss.t0 vss.t120 228.7518
Rpar33 vss.t1 vss.t120 423.0603
Rpar34 vss.t1 vss.t200 1320.2296
Rpar35 vss.t120 vss.t200 63.0092
Cpar0 a_11218_10311.t0 vss 2.65793e-13
Cpar1 a_11218_10311.t160 vss 2.21669e-13
Cpar2 a_1669_1204.t0 vss 1.02303e-13
Cpar3 a_1669_1204.t64 vss 4.32203e-13
Cpar4 a_19054_10311.t0 vss 2.21731e-13
Cpar5 a_19054_10311.t160 vss 2.65866e-13
Cpar6 a_3273_22651.t0 vss 6.41215e-13
Cpar7 a_3273_22651.t12 vss 4.24287e-13
Cpar8 a_3393_22443.t0 vss 3.57347e-13
Cpar9 a_3393_22443.t1 vss 4.33818e-13
Cpar10 a_3393_22443.t320 vss 1.45625e-13
Cpar11 a_3393_22443.t640 vss 4.77595e-13
Cpar12 a_3925_22651.t0 vss 4.31579e-13
Cpar13 a_3925_22651.t119 vss 6.54590e-13
Cpar14 ib vss 8.44151e-14
Cpar15 ib.t0 vss 1.12605e-14
Cpar16 ib.t1 vss 5.68341e-15
Cpar17 inn inp 2.04550e-16
Cpar18 inn vdd 3.16800e-17
Cpar19 inn vss 5.87776e-14
Cpar20 inn.t0 vss 5.09280e-14
Cpar21 inp vdd 3.16800e-17
Cpar22 inp vss 5.85337e-14
Cpar23 inp.t0 vss 5.09519e-14
Cpar24 out vdd 1.09160e-13
Cpar25 out vss 3.67812e-14
Cpar26 out.t0 vss 2.00318e-13
Cpar27 out.t156 vss 5.95888e-13
Cpar28 out.t320 vss 6.48649e-14
Cpar29 vdd vss 2.27217e-12
Cpar30 vdd.t0 vss 5.83605e-13
Cpar31 vdd.t12 vss 4.50172e-13
Cpar32 vdd.t13 vss 1.55463e-13
Cpar33 vdd.t740 vss 6.06103e-14
.ends opamp_dut

Vdd vdd 0 1.800000
Vss vss 0 0
Ibias vdd ib 1.437500e-04
Vinp inp 0 DC 0.931000 AC 1 PWL(0 0.931000 3.000000e-09 0.931000 3.300000e-09 0.941000)
Rfb out inn 1m
Cload out 0 2.000000e-13
Xdut vdd vss inp inn out ib opamp_dut
.end
