* opa1000[0286]: 200f/folded_cascode_pmos_3v3_10u_100u_subth (folded_cascode_pmos, VDD=3.3V, CL=0.2pF, Iref=14.4444uA)
.include "pdk_opa.inc"
.temp 27
.option gmin=1e-12 rshunt=1e12 reltol=1e-3 abstol=1e-12 vntol=1e-5 method=gear
* Post-PEX R+C extracted netlist for folded_cascode_pmos_3v3_10u_100u_subth
.subckt opamp_dut vdd vss inp inn out ib
XMpar0 a_1528_10219.t0 inp.t0 a_3714_13799.t19 vdd.t0 pfet_03v3 w=8u l=0.6u ad=2.4000e-12 pd=9.1000e-06 as=2.2400e-12 ps=8.5600e-06 nf=1 m=64 par=64
XMpar1 a_11214_19126.t1 inn.t0 a_1528_10219.t0 vdd.t0 pfet_03v3 w=8u l=0.6u ad=2.2400e-12 pd=8.5600e-06 as=2.4000e-12 ps=9.1000e-06 nf=1 m=64 par=64
XMpar2 a_11214_19126.t0 a_1278_10011.t10 out.t0 vss.t0 nfet_03v3 w=1.96u l=0.45u ad=6.3840e-13 pd=2.8914e-06 as=5.9360e-13 ps=2.7057e-06 nf=1 m=28 par=28
XMpar3 ib.t1 ib.t0 vss.t24 vss.t23 nfet_03v3 w=9.75u l=0.6u ad=5.8500e-12 pd=2.0700e-05 as=2.7300e-12 ps=1.0310e-05 nf=1 m=2 par=2
XMpar4 a_3714_13799.t0 a_1278_10011.t10 a_9088_19126.t0 vss.t0 nfet_03v3 w=1.96u l=0.45u ad=6.3840e-13 pd=2.8914e-06 as=5.9360e-13 ps=2.7057e-06 nf=1 m=28 par=28
XMpar5 a_1278_10011.t0 ib.t0 vss.t24 vss.t23 nfet_03v3 w=9.75u l=0.6u ad=2.7300e-12 pd=1.0310e-05 as=2.7300e-12 ps=1.0310e-05 nf=1 m=2 par=2
XMpar6 a_1278_10011.t3 a_1278_10011.t2 vdd.t33 vdd.t32 pfet_03v3 w=10u l=1.25u ad=2.8000e-12 pd=1.0560e-05 as=2.8000e-12 ps=1.0560e-05 nf=1 m=2 par=2
XMpar7 a_1528_10219.t64 a_1278_10011.t2 vdd.t33 vdd.t32 pfet_03v3 w=10u l=1.25u ad=2.8000e-12 pd=1.0560e-05 as=4.4000e-12 ps=1.5880e-05 nf=1 m=4 par=4
XMpar8 a_11214_19126.t80 ib.t0 vss.t24 vss.t23 nfet_03v3 w=9.75u l=0.6u ad=2.7300e-12 pd=1.0310e-05 as=4.2900e-12 ps=1.5505e-05 nf=1 m=4 par=4
XMpar9 a_3714_13799.t10 ib.t0 vss.t24 vss.t23 nfet_03v3 w=9.75u l=0.6u ad=2.7300e-12 pd=1.0310e-05 as=4.2900e-12 ps=1.5505e-05 nf=1 m=4 par=4
XMpar10 a_9088_19126.t2 a_9088_19126.t1 vdd.t33 vdd.t32 pfet_03v3 w=10u l=1.25u ad=6.0000e-12 pd=2.1200e-05 as=2.8000e-12 ps=1.0560e-05 nf=1 m=2 par=2
XMpar11 out.t23 a_9088_19126.t1 vdd.t33 vdd.t32 pfet_03v3 w=10u l=1.25u ad=2.8000e-12 pd=1.0560e-05 as=2.8000e-12 ps=1.0560e-05 nf=1 m=2 par=2
X17 out.t30 vss.t47 cap_mim_2f0fF c_width=17.5u c_length=17.5u
X29 out.t30 vss.t47 cap_mim_2f0fF c_width=17.5u c_length=17.5u
X188 out.t30 vss.t47 cap_mim_2f0fF c_width=17.5u c_length=17.5u
X204 out.t30 vss.t47 cap_mim_2f0fF c_width=17.5u c_length=17.5u
Rpar0 a_11214_19126.t0 a_11214_19126.t1 45.1487
Rpar1 a_11214_19126.t0 a_11214_19126.t80 94.5302
Rpar2 a_11214_19126.t1 a_11214_19126.t80 219.1341
Rpar3 a_1278_10011.t0 a_1278_10011.t10 176.7365
Rpar4 a_1278_10011.t0 a_1278_10011.t2 299.7803
Rpar5 a_1278_10011.t0 a_1278_10011.t3 92.5512
Rpar6 a_1278_10011.t10 a_1278_10011.t2 1458.3499
Rpar7 a_1278_10011.t10 a_1278_10011.t3 450.2364
Rpar8 a_1278_10011.t2 a_1278_10011.t3 27.6785
Rpar9 a_1528_10219.t0 a_1528_10219.t64 128.9679
Rpar10 a_3714_13799.t0 a_3714_13799.t10 94.5302
Rpar11 a_3714_13799.t0 a_3714_13799.t19 45.1487
Rpar12 a_3714_13799.t10 a_3714_13799.t19 219.1341
Rpar13 a_9088_19126.t0 a_9088_19126.t1 721.2507
Rpar14 a_9088_19126.t0 a_9088_19126.t2 112.3031
Rpar15 a_9088_19126.t1 a_9088_19126.t2 25.4140
Rpar16 ib ib.t0 10.7813
Rpar17 ib ib.t1 45.8091
Rpar18 ib.t0 ib.t1 38.5107
Rpar19 inn inn.t0 2.4374
Rpar20 inp inp.t0 2.4374
Rpar21 out out.t0 102.2516
Rpar22 out out.t23 52.5349
Rpar23 out out.t30 16.9360
Rpar24 out.t0 out.t23 424.2124
Rpar25 vdd vdd.t0 52.4384
Rpar26 vdd vdd.t32 122.1532
Rpar27 vdd vdd.t33 474.4567
Rpar28 vdd.t0 vdd.t32 131.5425
Rpar29 vdd.t0 vdd.t33 510.9259
Rpar30 vdd.t32 vdd.t33 3.7362
Rpar31 vss vss.t0 172.0178
Rpar32 vss vss.t23 45.3164
Rpar33 vss vss.t24 73.4905
Rpar34 vss vss.t47 64.0894
Rpar35 vss.t0 vss.t23 234.1870
Rpar36 vss.t0 vss.t24 379.1857
Rpar37 vss.t0 vss.t47 1709.2927
Rpar38 vss.t23 vss.t24 3.7735
Rpar39 vss.t23 vss.t47 450.2962
Rpar40 vss.t24 vss.t47 730.2545
Cpar0 a_11214_19126.t0 vss 2.14880e-14
Cpar1 a_11214_19126.t1 vss 9.04910e-14
Cpar2 a_11214_19126.t80 vss 1.39577e-14
Cpar3 a_1278_10011.t0 vss 8.60053e-15
Cpar4 a_1278_10011.t10 vss 2.29907e-14
Cpar5 a_1278_10011.t2 vss 1.07342e-14
Cpar6 a_1278_10011.t3 vss 6.45300e-15
Cpar7 a_1528_10219.t0 vss 1.87291e-13
Cpar8 a_1528_10219.t64 vss 1.88586e-14
Cpar9 a_3714_13799.t0 vss 2.22619e-14
Cpar10 a_3714_13799.t10 vss 1.44605e-14
Cpar11 a_3714_13799.t19 vss 9.37503e-14
Cpar12 a_9088_19126.t0 vss 2.28210e-14
Cpar13 a_9088_19126.t1 vss 1.07705e-14
Cpar14 a_9088_19126.t2 vss 1.60856e-14
Cpar15 ib out 6.14800e-17
Cpar16 ib vss 1.84953e-14
Cpar17 ib.t0 vss 2.10314e-15
Cpar18 ib.t1 vss 1.54078e-15
Cpar19 inn inp 1.03940e-16
Cpar20 inn out 1.30880e-16
Cpar21 inn vdd 2.68339e-14
Cpar22 inn vss 1.18076e-14
Cpar23 inn.t0 vss 4.79720e-14
Cpar24 inp vdd 2.73231e-14
Cpar25 inp vss 1.18406e-14
Cpar26 inp.t0 vss 4.81454e-14
Cpar27 out vdd 3.77680e-15
Cpar28 out vss 3.79287e-14
Cpar29 out.t0 vss 1.69658e-15
Cpar30 out.t23 vss 4.94522e-16
Cpar31 out.t30 vss 3.69652e-14
Cpar32 vdd vss 3.48564e-13
Cpar33 vdd.t0 vss 8.52712e-14
Cpar34 vdd.t32 vss 1.72040e-14
Cpar35 vdd.t33 vss 8.07356e-15
.ends opamp_dut

Vdd vdd 0 3.300000
Vss vss 0 0
Ibias vdd ib 1.444440e-05
Vinp inp 0 DC 1.381000 AC 1 PWL(0 1.381000 5.063744e-09 1.381000 5.570118e-09 1.391000)
Rfb out inn 1m
Cload out 0 2.000000e-13
Xdut vdd vss inp inn out ib opamp_dut
.end
