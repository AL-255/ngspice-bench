* opa1000[0868]: 200f/telescopic_nmos_3v3_i20u_subth (telescopic_nmos, VDD=3.3V, CL=0.2pF, Iref=5.0uA)
.include "pdk_opa.inc"
.temp 27
.option gmin=1e-12 rshunt=1e12 reltol=1e-3 abstol=1e-12 vntol=1e-5 method=gear
* Post-PEX R+C extracted netlist for telescopic_nmos_3v3_i20u_subth
.subckt opamp_dut vdd vss inp inn out ib
XMpar0 a_2114_16045.t11 a_1666_15837.t76 out.t0 vdd.t0 pfet_03v3 w=7.36u l=0.9u ad=2.6496e-12 pd=9.9200e-06 as=2.0608e-12 ps=7.9200e-06 nf=1 m=64 par=64
XMpar1 a_4927_5155.t52 a_1666_15837.t0 out.t10 vss.t0 nfet_03v3 w=2u l=0.9u ad=8.6316e-13 pd=3.8105e-06 as=6.6105e-13 ps=2.9768e-06 nf=1 m=38 par=38
XMpar2 a_2114_16045.t0 a_1666_15837.t242 vdd.t4 vdd.t0 pfet_03v3 w=2.09u l=1.69u ad=5.8520e-13 pd=2.6500e-06 as=5.8520e-13 ps=2.6500e-06 nf=1 m=64 par=64
XMpar3 a_1416_1204.t8 inp.t0 a_6371_5155.t4 vss.t0 nfet_03v3 w=2.01u l=0.65u ad=6.1228e-13 pd=2.7738e-06 as=5.8754e-13 ps=2.6719e-06 nf=1 m=52 par=52
XMpar4 a_1546_16045.t3 a_1666_15837.t242 vdd.t4 vdd.t0 pfet_03v3 w=2.09u l=1.69u ad=5.8520e-13 pd=2.6500e-06 as=6.6880e-13 ps=2.9912e-06 nf=1 m=64 par=64
XMpar5 a_1416_1204.t0 ib.t0 vss.t3 vss.t2 nfet_03v3 w=7.36u l=1.2u ad=2.0608e-12 pd=7.9200e-06 as=2.6496e-12 ps=9.9200e-06 nf=1 m=8 par=8
XMpar6 a_1666_15837.t1 a_1666_15837.t0 a_6371_5155.t0 vss.t0 nfet_03v3 w=2u l=0.9u ad=6.6105e-13 pd=2.9768e-06 as=8.6316e-13 ps=3.8105e-06 nf=1 m=38 par=38
XMpar7 a_1416_1204.t8 inn.t0 a_4927_5155.t0 vss.t0 nfet_03v3 w=2.01u l=0.65u ad=6.1228e-13 pd=2.7738e-06 as=5.8754e-13 ps=2.6719e-06 nf=1 m=52 par=52
XMpar8 a_1546_16045.t0 a_1666_15837.t76 a_1666_15837.t77 vdd.t0 pfet_03v3 w=7.36u l=0.9u ad=2.5024e-12 pd=9.4200e-06 as=2.3552e-12 ps=8.9200e-06 nf=1 m=64 par=64
XMpar9 ib.t1 ib.t0 vss.t3 vss.t2 nfet_03v3 w=7.36u l=1.2u ad=2.0608e-12 pd=7.9200e-06 as=2.0608e-12 ps=7.9200e-06 nf=1 m=2 par=2
Rpar0 a_1416_1204.t0 a_1416_1204.t8 42.7255
Rpar1 a_1546_16045.t0 a_1546_16045.t3 50.5841
Rpar2 a_1666_15837.t0 a_1666_15837.t1 8.1303
Rpar3 a_1666_15837.t0 a_1666_15837.t77 1002.0556
Rpar4 a_1666_15837.t0 a_1666_15837.t242 286.5153
Rpar5 a_1666_15837.t1 a_1666_15837.t76 1404.9696
Rpar6 a_1666_15837.t1 a_1666_15837.t77 321.5115
Rpar7 a_1666_15837.t1 a_1666_15837.t242 91.9290
Rpar8 a_1666_15837.t76 a_1666_15837.t77 8.6190
Rpar9 a_1666_15837.t76 a_1666_15837.t242 399.8620
Rpar10 a_1666_15837.t77 a_1666_15837.t242 91.5039
Rpar11 a_2114_16045.t0 a_2114_16045.t11 57.3932
Rpar12 a_4927_5155.t0 a_4927_5155.t52 37.2113
Rpar13 a_6371_5155.t0 a_6371_5155.t4 59.0904
Rpar14 ib ib.t0 14.5859
Rpar15 ib ib.t1 7.7760
Rpar16 inn inn.t0 2.0592
Rpar17 inp inp.t0 2.0592
Rpar18 out out.t0 2.9831
Rpar19 out out.t10 277.1245
Rpar20 out.t0 out.t10 87.4978
Rpar21 vdd vdd.t0 54.2702
Rpar22 vdd.t0 vdd.t4 8.8923
Rpar23 vss vss.t0 20.3613
Rpar24 vss vss.t2 197.5310
Rpar25 vss vss.t3 676.3967
Rpar26 vss.t0 vss.t2 3.2501
Rpar27 vss.t0 vss.t3 24.1531
Rpar28 vss.t2 vss.t3 6.2138
Cpar0 a_1416_1204.t0 vss 1.17754e-14
Cpar1 a_1416_1204.t8 vss 5.37012e-14
Cpar2 a_1546_16045.t0 vss 1.27620e-13
Cpar3 a_1546_16045.t3 vss 6.65061e-14
Cpar4 a_1666_15837.t0 vss 4.48158e-14
Cpar5 a_1666_15837.t1 vss 2.72027e-14
Cpar6 a_1666_15837.t242 vss 1.33857e-13
Cpar7 a_1666_15837.t76 vss 1.61564e-13
Cpar8 a_1666_15837.t77 vss 8.38179e-14
Cpar9 a_2114_16045.t0 vss 7.31812e-14
Cpar10 a_2114_16045.t11 vss 1.42551e-13
Cpar11 a_4927_5155.t0 vss 3.21057e-14
Cpar12 a_4927_5155.t52 vss 3.88828e-14
Cpar13 a_6371_5155.t0 vss 4.69549e-14
Cpar14 a_6371_5155.t4 vss 3.66460e-14
Cpar15 ib vss 1.60045e-14
Cpar16 ib.t0 vss 3.16398e-15
Cpar17 ib.t1 vss 3.74030e-16
Cpar18 inn inp 1.00770e-16
Cpar19 inn vss 2.47197e-14
Cpar20 inn.t0 vss 1.22069e-14
Cpar21 inp vss 2.49318e-14
Cpar22 inp.t0 vss 1.22101e-14
Cpar23 out vdd 2.83847e-14
Cpar24 out vss 1.77942e-14
Cpar25 out.t0 vss 1.16775e-13
Cpar26 out.t10 vss 4.28225e-14
Cpar27 vdd vss 7.08182e-13
Cpar28 vdd.t0 vss 3.52071e-13
Cpar29 vdd.t4 vss 1.95894e-14
.ends opamp_dut

Vdd vdd 0 3.300000
Vss vss 0 0
Ibias vdd ib 5.000000e-06
Vinp inp 0 DC 1.711000 AC 1 PWL(0 1.711000 4.250627e-09 1.711000 4.675690e-09 1.721000)
Rfb out inn 1m
Cload out 0 2.000000e-13
Xdut vdd vss inp inn out ib opamp_dut
.end
