* opa1000[0895]: 2p/telescopic_nmos_1v8_i500u_subth (telescopic_nmos, VDD=1.8V, CL=2.0pF, Iref=162.5uA)
.include "pdk_opa.inc"
.temp 27
.option gmin=1e-12 rshunt=1e12 reltol=1e-3 abstol=1e-12 vntol=1e-5 method=gear
* Post-PEX R+C extracted netlist for telescopic_nmos_1v8_i500u_subth
.subckt opamp_dut vdd vss inp inn out ib
XMpar0 a_5718_27027.t21 a_5838_26819.t640 vdd.t21 vdd.t20 pfet_03v3 w=5.47u l=0.35u ad=1.7066e-12 pd=6.6410e-06 as=1.5316e-12 ps=6.0300e-06 nf=1 m=160 par=160
XMpar1 a_6338_27027.t0 a_5838_26819.t640 vdd.t21 vdd.t20 pfet_03v3 w=5.47u l=0.35u ad=1.7066e-12 pd=6.6410e-06 as=1.6191e-12 ps=6.3355e-06 nf=1 m=160 par=160
XMpar2 a_20654_12393.t0 inn.t0 a_9430_1204.t0 vss.t0 nfet_03v3 w=14u l=0.45u ad=3.9760e-12 pd=1.4743e-05 as=4.0320e-12 ps=1.4926e-05 nf=1 m=160 par=160
XMpar3 a_5838_26819.t0 vdd.t614 a_9640_1204.t160 vss.t0 nfet_03v3 w=6.15u l=0.3u ad=1.7220e-12 pd=6.7100e-06 as=1.8450e-12 ps=7.1344e-06 nf=1 m=160 par=160
XMpar4 a_9430_1204.t0 inp.t0 a_9640_1204.t0 vss.t0 nfet_03v3 w=14u l=0.45u ad=4.0320e-12 pd=1.4926e-05 as=3.9760e-12 ps=1.4743e-05 nf=1 m=160 par=160
XMpar5 a_6338_27027.t12 a_5838_26819.t160 out.t0 vdd.t0 pfet_03v3 w=14u l=0.3u ad=5.9360e-12 pd=2.1148e-05 as=4.9280e-12 ps=1.7854e-05 nf=1 m=160 par=160
XMpar6 a_5718_27027.t0 a_5838_26819.t160 a_5838_26819.t161 vdd.t0 pfet_03v3 w=14u l=0.3u ad=6.2160e-12 pd=2.2063e-05 as=4.8160e-12 ps=1.7488e-05 nf=1 m=160 par=160
XMpar7 a_20654_12393.t160 vdd.t614 out.t30 vss.t0 nfet_03v3 w=6.15u l=0.3u ad=1.8450e-12 pd=7.1344e-06 as=1.7220e-12 ps=6.7100e-06 nf=1 m=160 par=160
XMpar8 a_9430_1204.t320 ib.t0 vss.t279 vss.t278 nfet_03v3 w=10u l=0.45u ad=3.0000e-12 pd=1.1225e-05 as=3.0000e-12 ps=1.1225e-05 nf=1 m=64 par=64
XMpar9 ib.t1 ib.t0 vss.t279 vss.t278 nfet_03v3 w=10u l=0.45u ad=4.0000e-12 pd=1.4550e-05 as=2.8000e-12 ps=1.0560e-05 nf=1 m=16 par=16
Rpar0 a_20654_12393.t0 a_20654_12393.t160 44.2178
Rpar1 a_5718_27027.t0 a_5718_27027.t21 64.0911
Rpar2 a_5838_26819.t0 a_5838_26819.t160 848.0713
Rpar3 a_5838_26819.t0 a_5838_26819.t161 98.2197
Rpar4 a_5838_26819.t0 a_5838_26819.t640 267.9594
Rpar5 a_5838_26819.t160 a_5838_26819.t161 6.9911
Rpar6 a_5838_26819.t160 a_5838_26819.t640 786.4584
Rpar7 a_5838_26819.t161 a_5838_26819.t640 91.0840
Rpar8 a_6338_27027.t0 a_6338_27027.t12 40.4341
Rpar9 a_9430_1204.t0 a_9430_1204.t320 23.3769
Rpar10 a_9640_1204.t0 a_9640_1204.t160 44.2178
Rpar11 ib ib.t0 51.1055
Rpar12 ib ib.t1 2.6357
Rpar13 ib.t0 ib.t1 7.5296
Rpar14 inn inn.t0 2.5985
Rpar15 inp inp.t0 2.5985
Rpar16 out out.t0 4.0625
Rpar17 out.t0 out.t30 51.0714
Rpar18 vdd vdd.t0 120.9297
Rpar19 vdd vdd.t20 30.1165
Rpar20 vdd vdd.t614 622.2623
Rpar21 vdd.t0 vdd.t20 72.6317
Rpar22 vdd.t0 vdd.t614 110.0335
Rpar23 vdd.t20 vdd.t21 9.1929
Rpar24 vdd.t20 vdd.t614 373.7374
Rpar25 vss vss.t0 20.2544
Rpar26 vss vss.t278 2340.2595
Rpar27 vss vss.t279 154.7081
Rpar28 vss.t0 vss.t278 137.1278
Rpar29 vss.t0 vss.t279 49.7480
Rpar30 vss.t278 vss.t279 11.3890
Cpar0 a_20654_12393.t0 vss 4.70742e-13
Cpar1 a_20654_12393.t160 vss 2.28243e-13
Cpar2 a_5718_27027.t0 vss 7.67983e-13
Cpar3 a_5718_27027.t21 vss 2.66424e-13
Cpar4 a_5838_26819.t0 vss 2.02741e-13
Cpar5 a_5838_26819.t160 vss 3.71852e-13
Cpar6 a_5838_26819.t161 vss 5.57035e-13
Cpar7 a_5838_26819.t640 vss 2.35045e-13
Cpar8 a_6338_27027.t0 vss 2.67436e-13
Cpar9 a_6338_27027.t12 vss 7.84121e-13
Cpar10 a_9430_1204.t0 vss 7.47346e-13
Cpar11 a_9430_1204.t320 vss 1.21516e-13
Cpar12 a_9640_1204.t0 vss 4.71574e-13
Cpar13 a_9640_1204.t160 vss 2.28646e-13
Cpar14 ib inn 1.86300e-17
Cpar15 ib vss 1.03239e-13
Cpar16 ib.t0 vss 1.52711e-14
Cpar17 ib.t1 vss 9.00454e-15
Cpar18 inn inp 1.05030e-16
Cpar19 inn vdd 2.43000e-17
Cpar20 inn vss 7.04693e-14
Cpar21 inn.t0 vss 8.72727e-14
Cpar22 inp vdd 2.43000e-17
Cpar23 inp vss 7.06997e-14
Cpar24 inp.t0 vss 8.72419e-14
Cpar25 out vdd 9.97980e-14
Cpar26 out vss 2.82036e-14
Cpar27 out.t0 vss 7.19355e-13
Cpar28 out.t30 vss 2.63418e-13
Cpar29 vdd vss 1.77906e-12
Cpar30 vdd.t0 vss 6.03536e-13
Cpar31 vdd.t20 vss 2.63818e-13
Cpar32 vdd.t21 vss 8.67962e-14
Cpar33 vdd.t614 vss 5.87446e-14
.ends opamp_dut

Vdd vdd 0 1.800000
Vss vss 0 0
Ibias vdd ib 1.625000e-04
Vinp inp 0 DC 0.931000 AC 1 PWL(0 0.931000 3.000000e-09 0.931000 3.300000e-09 0.941000)
Rfb out inn 1m
Cload out 0 2.000000e-12
Xdut vdd vss inp inn out ib opamp_dut
.end
