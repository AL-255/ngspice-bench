* opa1000[0303]: 2p/folded_cascode_pmos_1v8_1u_10u_weak (folded_cascode_pmos, VDD=1.8V, CL=2.0pF, Iref=1.4444uA)
.include "pdk_opa.inc"
.temp 27
.option gmin=1e-12 rshunt=1e12 reltol=1e-3 abstol=1e-12 vntol=1e-5 method=gear
* Post-PEX R+C extracted netlist for folded_cascode_pmos_1v8_1u_10u_weak
.subckt opamp_dut vdd vss inp inn out ib
XMpar0 a_1634_11595.t4 inn.t0 a_7214_6323.t2 vdd.t6 pfet_03v3 w=2u l=3.2u ad=6.7294e-13 pd=3.0259e-06 as=6.3529e-13 ps=2.8706e-06 nf=1 m=34 par=34
XMpar1 a_1856_4784.t1 a_1856_4784.t0 vdd.t1 vdd.t0 pfet_03v3 w=10u l=3.75u ad=2.8000e-12 pd=1.0560e-05 as=2.8000e-12 ps=1.0560e-05 nf=1 m=2 par=2
XMpar2 a_1856_4784.t4 ib.t0 vss.t2 vss.t1 nfet_03v3 w=1.03u l=1.6u ad=2.8840e-13 pd=1.5900e-06 as=2.8840e-13 ps=1.5900e-06 nf=1 m=2 par=2
XMpar3 a_7214_6323.t36 ib.t0 vss.t2 vss.t1 nfet_03v3 w=1.03u l=1.6u ad=2.8840e-13 pd=1.5900e-06 as=4.5320e-13 ps=2.4250e-06 nf=1 m=4 par=4
XMpar4 a_1634_11595.t4 inp.t0 a_2394_11595.t2 vdd.t6 pfet_03v3 w=2u l=3.2u ad=6.7294e-13 pd=3.0259e-06 as=6.3529e-13 ps=2.8706e-06 nf=1 m=34 par=34
XMpar5 a_1634_11595.t0 a_1856_4784.t0 vdd.t1 vdd.t0 pfet_03v3 w=10u l=3.75u ad=2.8000e-12 pd=1.0560e-05 as=4.4000e-12 ps=1.5880e-05 nf=1 m=4 par=4
XMpar6 a_7214_6323.t0 a_1856_4784.t6 out.t0 vss.t0 nfet_03v3 w=1.59u l=1.3u ad=9.5400e-13 pd=4.3800e-06 as=4.4520e-13 ps=2.1500e-06 nf=1 m=2 par=2
XMpar7 out.t1 a_5472_1249.t0 vdd.t1 vdd.t0 pfet_03v3 w=10u l=3.75u ad=2.8000e-12 pd=1.0560e-05 as=2.8000e-12 ps=1.0560e-05 nf=1 m=2 par=2
XMpar8 a_2394_11595.t0 a_1856_4784.t6 a_5472_1249.t4 vss.t0 nfet_03v3 w=1.59u l=1.3u ad=9.5400e-13 pd=4.3800e-06 as=4.4520e-13 ps=2.1500e-06 nf=1 m=2 par=2
XMpar9 a_5472_1249.t1 a_5472_1249.t0 vdd.t1 vdd.t0 pfet_03v3 w=10u l=3.75u ad=6.0000e-12 pd=2.1200e-05 as=2.8000e-12 ps=1.0560e-05 nf=1 m=2 par=2
XMpar10 ib.t1 ib.t0 vss.t2 vss.t1 nfet_03v3 w=1.03u l=1.6u ad=6.1800e-13 pd=3.2600e-06 as=2.8840e-13 ps=1.5900e-06 nf=1 m=2 par=2
XMpar11 a_2394_11595.t36 ib.t0 vss.t2 vss.t1 nfet_03v3 w=1.03u l=1.6u ad=2.8840e-13 pd=1.5900e-06 as=4.5320e-13 ps=2.4250e-06 nf=1 m=4 par=4
Rpar0 a_1634_11595.t0 a_1634_11595.t4 60.0379
Rpar1 a_1856_4784.t0 a_1856_4784.t1 25.8724
Rpar2 a_1856_4784.t0 a_1856_4784.t4 428.0663
Rpar3 a_1856_4784.t0 a_1856_4784.t6 184.9897
Rpar4 a_1856_4784.t1 a_1856_4784.t4 258.1490
Rpar5 a_1856_4784.t1 a_1856_4784.t6 111.5596
Rpar6 a_1856_4784.t4 a_1856_4784.t6 94.4256
Rpar7 a_2394_11595.t0 a_2394_11595.t2 79.3676
Rpar8 a_2394_11595.t0 a_2394_11595.t36 50.5836
Rpar9 a_2394_11595.t2 a_2394_11595.t36 150.3436
Rpar10 a_5472_1249.t0 a_5472_1249.t1 20.0461
Rpar11 a_5472_1249.t0 a_5472_1249.t4 332.6301
Rpar12 a_5472_1249.t1 a_5472_1249.t4 78.4084
Rpar13 a_7214_6323.t0 a_7214_6323.t2 79.3676
Rpar14 a_7214_6323.t0 a_7214_6323.t36 50.5836
Rpar15 a_7214_6323.t2 a_7214_6323.t36 150.3436
Rpar16 ib ib.t0 10.4361
Rpar17 ib ib.t1 6.9133
Rpar18 ib.t0 ib.t1 484.9009
Rpar19 inn inn.t0 1.4805
Rpar20 inp inp.t0 1.4805
Rpar21 out out.t0 9.2197
Rpar22 out out.t1 58.2401
Rpar23 vdd vdd.t0 220.2692
Rpar24 vdd vdd.t1 672.1894
Rpar25 vdd vdd.t6 21.1454
Rpar26 vdd.t0 vdd.t1 4.0753
Rpar27 vdd.t0 vdd.t6 82.7887
Rpar28 vdd.t1 vdd.t6 252.6441
Rpar29 vss vss.t0 209.9199
Rpar30 vss vss.t1 65.8083
Rpar31 vss vss.t2 72.7084
Rpar32 vss.t0 vss.t1 4.3732
Rpar33 vss.t0 vss.t2 14.6968
Rpar34 vss.t1 vss.t2 6.3261
Cpar0 a_1634_11595.t0 vss 1.22574e-14
Cpar1 a_1634_11595.t4 vss 6.62472e-14
Cpar2 a_1856_4784.t0 vss 2.25897e-14
Cpar3 a_1856_4784.t1 vss 3.61349e-15
Cpar4 a_1856_4784.t4 vss 1.23679e-15
Cpar5 a_1856_4784.t6 vss 2.91177e-15
Cpar6 a_2394_11595.t0 vss 4.86294e-15
Cpar7 a_2394_11595.t2 vss 3.76792e-14
Cpar8 a_2394_11595.t36 vss 3.97518e-15
Cpar9 a_5472_1249.t0 vss 1.53219e-14
Cpar10 a_5472_1249.t1 vss 5.49954e-15
Cpar11 a_5472_1249.t4 vss 1.17223e-15
Cpar12 a_7214_6323.t0 vss 4.95108e-15
Cpar13 a_7214_6323.t2 vss 3.83621e-14
Cpar14 a_7214_6323.t36 vss 4.04722e-15
Cpar15 ib out 3.34300e-17
Cpar16 ib vdd 1.54970e-16
Cpar17 ib vss 1.77928e-14
Cpar18 ib.t0 vss 3.17500e-15
Cpar19 ib.t1 vss 1.26311e-16
Cpar20 inn inp 2.16880e-16
Cpar21 inn vdd 4.12570e-14
Cpar22 inn vss 5.25170e-15
Cpar23 inn.t0 vss 6.09815e-14
Cpar24 inp vdd 4.08413e-14
Cpar25 inp vss 5.23314e-15
Cpar26 inp.t0 vss 6.06976e-14
Cpar27 out vdd 4.58611e-15
Cpar28 out vss 4.62972e-15
Cpar29 out.t0 vss 2.25128e-16
Cpar30 out.t1 vss 6.51958e-15
Cpar31 vdd vss 3.56545e-13
Cpar32 vdd.t0 vss 3.70668e-14
Cpar33 vdd.t1 vss 1.72025e-14
Cpar34 vdd.t6 vss 9.48637e-14
.ends opamp_dut

Vdd vdd 0 1.800000
Vss vss 0 0
Ibias vdd ib 1.444400e-06
Vinp inp 0 DC 0.751000 AC 1 PWL(0 0.751000 5.492822e-08 0.751000 6.042105e-08 0.761000)
Rfb out inn 1m
Cload out 0 2.000000e-12
Xdut vdd vss inp inn out ib opamp_dut
.end
