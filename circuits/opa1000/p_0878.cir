* opa1000[0878]: 2p/telescopic_nmos_1v8_i50n_weak (telescopic_nmos, VDD=1.8V, CL=2.0pF, Iref=0.0163uA)
.include "pdk_opa.inc"
.temp 27
.option gmin=1e-12 rshunt=1e12 reltol=1e-3 abstol=1e-12 vntol=1e-5 method=gear
* Post-PEX R+C extracted netlist for telescopic_nmos_1v8_i50n_weak
.subckt opamp_dut vdd vss inp inn out ib
XMpar0 a_6226_4314.t4 ib.t0 vss.t8 vss.t7 nfet_03v3 w=0.4u l=7.5u ad=1.1200e-13 pd=9.6000e-07 as=2.0800e-13 ps=1.7400e-06 nf=1 m=8 par=8
XMpar1 a_6688_8012.t2 a_5544_7804.t8 vdd.t4 vdd.t3 pfet_03v3 w=0.4u l=9.75u ad=2.4000e-13 pd=2.0000e-06 as=1.1200e-13 ps=9.6000e-07 nf=1 m=2 par=2
XMpar2 a_5402_6601.t0 inp.t0 a_6226_4314.t0 vss.t0 nfet_03v3 w=0.4u l=5.2u ad=2.4000e-13 pd=2.0000e-06 as=2.4000e-13 ps=2.0000e-06 nf=1 m=2 par=2
XMpar3 a_5424_8012.t2 a_5544_7804.t8 vdd.t4 vdd.t3 pfet_03v3 w=0.4u l=9.75u ad=2.4000e-13 pd=2.0000e-06 as=1.1200e-13 ps=9.6000e-07 nf=1 m=2 par=2
XMpar4 a_6226_4314.t0 inn.t0 a_7694_4314.t0 vss.t0 nfet_03v3 w=0.4u l=5.2u ad=2.4000e-13 pd=2.0000e-06 as=2.4000e-13 ps=2.0000e-06 nf=1 m=2 par=2
XMpar5 ib.t1 ib.t0 vss.t8 vss.t7 nfet_03v3 w=0.4u l=7.5u ad=2.4000e-13 pd=2.0000e-06 as=1.1200e-13 ps=9.6000e-07 nf=1 m=2 par=2
XMpar6 a_7694_4314.t2 vdd.t10 out.t1 vss.t2 nfet_03v3 w=0.4u l=4.38u ad=2.4000e-13 pd=2.0000e-06 as=1.1200e-13 ps=9.6000e-07 nf=1 m=2 par=2
XMpar7 a_5424_8012.t0 a_5544_7804.t2 a_5544_7804.t3 vdd.t0 pfet_03v3 w=0.59u l=4.38u ad=3.5400e-13 pd=2.3800e-06 as=3.5400e-13 ps=2.3800e-06 nf=1 m=2 par=2
XMpar8 a_5402_6601.t2 vdd.t10 a_5544_7804.t0 vss.t2 nfet_03v3 w=0.4u l=4.38u ad=2.4000e-13 pd=2.0000e-06 as=1.1200e-13 ps=9.6000e-07 nf=1 m=2 par=2
XMpar9 a_6688_8012.t0 a_5544_7804.t2 out.t0 vdd.t0 pfet_03v3 w=0.59u l=4.38u ad=3.5400e-13 pd=2.3800e-06 as=1.6520e-13 ps=1.1500e-06 nf=1 m=2 par=2
X22 out.t4 vss.t6 cap_mim_2f0fF c_width=15u c_length=15u
Rpar0 a_5402_6601.t0 a_5402_6601.t2 57.3598
Rpar1 a_5424_8012.t0 a_5424_8012.t2 56.8411
Rpar2 a_5544_7804.t0 a_5544_7804.t8 146.8349
Rpar3 a_5544_7804.t0 a_5544_7804.t2 153.5437
Rpar4 a_5544_7804.t0 a_5544_7804.t3 109.9178
Rpar5 a_5544_7804.t8 a_5544_7804.t2 151.5503
Rpar6 a_5544_7804.t8 a_5544_7804.t3 108.4908
Rpar7 a_5544_7804.t2 a_5544_7804.t3 24.7226
Rpar8 a_6226_4314.t0 a_6226_4314.t4 42.8114
Rpar9 a_6688_8012.t0 a_6688_8012.t2 52.9910
Rpar10 a_7694_4314.t0 a_7694_4314.t2 57.3598
Rpar11 ib ib.t0 15.3064
Rpar12 ib ib.t1 14.9591
Rpar13 ib.t0 ib.t1 33.4708
Rpar14 inn inn.t0 4.3032
Rpar15 inp inp.t0 4.3027
Rpar16 out out.t0 14.1258
Rpar17 out out.t1 68.6665
Rpar18 out out.t4 108.5899
Rpar19 out.t1 out.t4 126.9969
Rpar20 vdd vdd.t0 150.4811
Rpar21 vdd vdd.t10 239.0886
Rpar22 vdd vdd.t3 208.2797
Rpar23 vdd vdd.t4 68.6838
Rpar24 vdd.t0 vdd.t10 71.3723
Rpar25 vdd.t0 vdd.t3 540.7073
Rpar26 vdd.t0 vdd.t4 178.3076
Rpar27 vdd.t10 vdd.t3 859.0909
Rpar28 vdd.t10 vdd.t4 283.3001
Rpar29 vdd.t3 vdd.t4 28.0985
Rpar30 vss vss.t0 1008.8958
Rpar31 vss vss.t8 99.5972
Rpar32 vss vss.t7 240.8263
Rpar33 vss vss.t2 389.1536
Rpar34 vss vss.t6 78.0868
Rpar35 vss.t0 vss.t8 104.4321
Rpar36 vss.t0 vss.t7 8.1770
Rpar37 vss.t0 vss.t2 9.3720
Rpar38 vss.t0 vss.t6 1397.2081
Rpar39 vss.t8 vss.t7 21.0800
Rpar40 vss.t8 vss.t2 35.2402
Rpar41 vss.t8 vss.t6 137.9310
Rpar42 vss.t7 vss.t2 2.8305
Rpar43 vss.t7 vss.t6 333.5176
Rpar44 vss.t2 vss.t6 538.9344
Cpar0 a_5402_6601.t0 vss 3.47473e-15
Cpar1 a_5402_6601.t2 vss 2.53252e-15
Cpar2 a_5424_8012.t0 vss 7.10704e-15
Cpar3 a_5424_8012.t2 vss 1.13116e-14
Cpar4 a_5544_7804.t0 vss 2.60189e-15
Cpar5 a_5544_7804.t2 vss 1.20315e-14
Cpar6 a_5544_7804.t3 vss 4.27843e-15
Cpar7 a_5544_7804.t8 vss 2.32296e-14
Cpar8 a_6226_4314.t0 vss 5.83262e-15
Cpar9 a_6226_4314.t4 vss 9.84277e-15
Cpar10 a_6688_8012.t0 vss 8.21942e-15
Cpar11 a_6688_8012.t2 vss 1.17141e-14
Cpar12 a_7694_4314.t0 vss 3.68223e-15
Cpar13 a_7694_4314.t2 vss 2.68377e-15
Cpar14 ib inn 1.02100e-17
Cpar15 ib vss 5.21894e-14
Cpar16 ib.t0 vss 7.22633e-15
Cpar17 ib.t1 vss 5.58003e-16
Cpar18 inn inp 1.04540e-16
Cpar19 inn vdd 1.04000e-17
Cpar20 inn vss 6.23806e-15
Cpar21 inn.t0 vss 1.01729e-15
Cpar22 inp vdd 1.04000e-17
Cpar23 inp vss 6.20475e-15
Cpar24 inp.t0 vss 1.03336e-15
Cpar25 out vdd 4.86924e-15
Cpar26 out vss 1.13214e-14
Cpar27 out.t0 vss 4.35021e-17
Cpar28 out.t1 vss 3.05914e-16
Cpar29 out.t4 vss 9.32818e-15
Cpar30 vdd vss 9.68035e-14
Cpar31 vdd.t0 vss 1.48562e-14
Cpar32 vdd.t10 vss 3.52189e-15
Cpar33 vdd.t3 vss 1.71150e-14
Cpar34 vdd.t4 vss 8.85246e-15
.ends opamp_dut

Vdd vdd 0 1.800000
Vss vss 0 0
Ibias vdd ib 1.630000e-08
Vinp inp 0 DC 0.931000 AC 1 PWL(0 0.931000 2.585286e-06 0.931000 2.843815e-06 0.941000)
Rfb out inn 1m
Cload out 0 2.000000e-12
Xdut vdd vss inp inn out ib opamp_dut
.end
