* opa1000[0383]: 2p/nmos_5t_1v8_i1u_subth (nmos_5t, VDD=1.8V, CL=2.0pF, Iref=0.325uA)
.include "pdk_opa.inc"
.temp 27
.option gmin=1e-12 rshunt=1e12 reltol=1e-3 abstol=1e-12 vntol=1e-5 method=gear
* Post-PEX R+C extracted netlist for nmos_5t_1v8_i1u_subth
.subckt opamp_dut vdd vss inp inn out ib
XMpar0 out.t0 a_2326_1204.t64 vdd.t1 vdd.t0 pfet_03v3 w=2.03u l=6.75u ad=5.6840e-13 pd=2.5900e-06 as=5.6840e-13 ps=2.5900e-06 nf=1 m=16 par=16
XMpar1 a_2326_1204.t65 a_2326_1204.t64 vdd.t1 vdd.t0 pfet_03v3 w=2.03u l=6.75u ad=5.6840e-13 pd=2.5900e-06 as=8.9320e-13 ps=3.9250e-06 nf=1 m=16 par=16
XMpar2 a_1556_1204.t0 inp.t0 a_2326_1204.t0 vss.t0 nfet_03v3 w=3.1u l=3.25u ad=9.9200e-13 pd=4.1275e-06 as=9.3000e-13 ps=3.8937e-06 nf=1 m=64 par=64
XMpar3 a_1556_1204.t0 inn.t0 out.t11 vss.t0 nfet_03v3 w=3.1u l=3.25u ad=9.9200e-13 pd=4.1275e-06 as=9.3000e-13 ps=3.8937e-06 nf=1 m=64 par=64
XMpar4 a_1556_1204.t128 ib.t0 vss.t43 vss.t0 nfet_03v3 w=0.94u l=2.1u ad=2.6320e-13 pd=1.5000e-06 as=3.3840e-13 ps=1.8950e-06 nf=1 m=8 par=8
XMpar5 ib.t1 ib.t0 vss.t43 vss.t0 nfet_03v3 w=0.94u l=2.1u ad=2.6320e-13 pd=1.5000e-06 as=2.6320e-13 ps=1.5000e-06 nf=1 m=2 par=2
X100 out.t80 vss.t62 cap_mim_2f0fF c_width=7.75u c_length=7.75u
Rpar0 a_1556_1204.t0 a_1556_1204.t128 103.1691
Rpar1 a_2326_1204.t0 a_2326_1204.t64 168.1690
Rpar2 a_2326_1204.t0 a_2326_1204.t65 97.2795
Rpar3 a_2326_1204.t64 a_2326_1204.t65 4.5133
Rpar4 ib ib.t0 18.8143
Rpar5 ib ib.t1 16.9624
Rpar6 ib.t0 ib.t1 94.1807
Rpar7 inn inn.t0 1.3298
Rpar8 inp inp.t0 1.3298
Rpar9 out out.t0 41.6589
Rpar10 out out.t11 203.2643
Rpar11 out out.t80 14.9031
Rpar12 out.t0 out.t11 134.2042
Rpar13 out.t0 out.t80 652.0601
Rpar14 out.t11 out.t80 3181.5628
Rpar15 vdd vdd.t0 20.5788
Rpar16 vdd vdd.t1 348.9036
Rpar17 vdd.t0 vdd.t1 9.6946
Rpar18 vss vss.t0 57.8660
Rpar19 vss vss.t43 627.5287
Rpar20 vss vss.t62 281.2880
Rpar21 vss.t0 vss.t43 4.6320
Rpar22 vss.t0 vss.t62 48.2902
Rpar23 vss.t43 vss.t62 523.6838
Cpar0 a_1556_1204.t0 vss 1.08659e-13
Cpar1 a_1556_1204.t128 vss 1.21017e-14
Cpar2 a_2326_1204.t0 vss 6.10800e-14
Cpar3 a_2326_1204.t64 vss 1.48632e-13
Cpar4 a_2326_1204.t65 vss 2.85130e-14
Cpar5 ib inp 4.65800e-17
Cpar6 ib out 1.00200e-17
Cpar7 ib vdd 1.63000e-17
Cpar8 ib vss 1.75630e-14
Cpar9 ib.t0 vss 2.65773e-15
Cpar10 ib.t1 vss 1.08102e-16
Cpar11 inn inp 2.31350e-16
Cpar12 inn out 3.03902e-14
Cpar13 inn vss 7.74436e-14
Cpar14 inn.t0 vss 5.14511e-14
Cpar15 inp vss 7.77681e-14
Cpar16 inp.t0 vss 5.11980e-14
Cpar17 out vdd 3.10528e-14
Cpar18 out vss 3.30093e-14
Cpar19 out.t0 vss 3.58828e-14
Cpar20 out.t11 vss 6.47690e-14
Cpar21 out.t80 vss 2.22590e-14
Cpar22 vdd vss 2.77775e-13
Cpar23 vdd.t0 vss 1.41822e-13
Cpar24 vdd.t1 vss 1.73624e-14
.ends opamp_dut

Vdd vdd 0 1.800000
Vss vss 0 0
Ibias vdd ib 3.250000e-07
Vinp inp 0 DC 0.895000 AC 1 PWL(0 0.895000 1.136497e-07 0.895000 1.250147e-07 0.905000)
Rfb out inn 1m
Cload out 0 2.000000e-12
Xdut vdd vss inp inn out ib opamp_dut
.end
