* opa1000[0638]: 2p/pmos_miller_1v8_i10u_subth (pmos_miller, VDD=1.8V, CL=2.0pF, Iref=1.4375uA)
.include "pdk_opa.inc"
.temp 27
.option gmin=1e-12 rshunt=1e12 reltol=1e-3 abstol=1e-12 vntol=1e-5 method=gear
* Post-PEX R+C extracted netlist for pmos_miller_1v8_i10u_subth
.subckt opamp_dut vdd vss inp inn out ib
XMpar0 out.t1 a_1134_5812.t35 vss.t1 vss.t0 nfet_03v3 w=3.79u l=0.94u ad=1.0612e-12 pd=4.3500e-06 as=1.3038e-12 ps=5.2360e-06 nf=1 m=10 par=10
XMpar1 a_1134_5812.t0 inp.t0 a_2002_11760.t4 vdd.t2 pfet_03v3 w=2.02u l=0.72u ad=5.6560e-13 pd=2.5800e-06 as=6.4640e-13 ps=2.9125e-06 nf=1 m=32 par=32
XMpar2 a_1134_5812.t32 a_5916_5518.t32 vss.t1 vss.t0 nfet_03v3 w=3.79u l=0.94u ad=2.2740e-12 pd=8.7800e-06 as=1.0612e-12 ps=4.3500e-06 nf=1 m=2 par=2
XMpar3 ib.t1 ib.t0 vss.t24 vss.t23 nfet_03v3 w=2.12u l=1.2u ad=1.2720e-12 pd=5.4400e-06 as=5.9360e-13 ps=2.6800e-06 nf=1 m=2 par=2
XMpar4 a_2002_11760.t0 a_5987_7812.t0 vdd.t1 vdd.t0 pfet_03v3 w=10u l=1.2u ad=2.8000e-12 pd=1.0560e-05 as=2.8000e-12 ps=1.0560e-05 nf=1 m=4 par=4
XMpar5 a_2002_11760.t4 inn.t0 a_5916_5518.t0 vdd.t2 pfet_03v3 w=2.02u l=0.72u ad=6.4640e-13 pd=2.9125e-06 as=5.6560e-13 ps=2.5800e-06 nf=1 m=32 par=32
XMpar6 out.t0 a_5987_7812.t0 vdd.t1 vdd.t0 pfet_03v3 w=10u l=1.2u ad=3.4400e-12 pd=1.2688e-05 as=2.8000e-12 ps=1.0560e-05 nf=1 m=10 par=10
XMpar7 a_5987_7812.t4 ib.t0 vss.t24 vss.t23 nfet_03v3 w=2.12u l=1.2u ad=5.9360e-13 pd=2.6800e-06 as=5.9360e-13 ps=2.6800e-06 nf=1 m=2 par=2
XMpar8 a_5916_5518.t33 a_5916_5518.t32 vss.t1 vss.t0 nfet_03v3 w=3.79u l=0.94u ad=1.0612e-12 pd=4.3500e-06 as=1.0612e-12 ps=4.3500e-06 nf=1 m=2 par=2
XMpar9 a_5987_7812.t1 a_5987_7812.t0 vdd.t1 vdd.t0 pfet_03v3 w=10u l=1.2u ad=2.8000e-12 pd=1.0560e-05 as=2.8000e-12 ps=1.0560e-05 nf=1 m=2 par=2
X54 a_3006_5812.t1 out.t14 cap_mim_2f0fF c_width=14.37u c_length=14.36u
X69 a_3006_5812.t1 out.t14 cap_mim_2f0fF c_width=14.37u c_length=14.36u
X80 a_1134_5812.t34 a_3006_5812.t0 vss.t22 ppolyf_u_1k r_width=1u r_length=8.7u
Rpar0 a_1134_5812.t0 a_1134_5812.t32 261.7251
Rpar1 a_1134_5812.t0 a_1134_5812.t34 349.9706
Rpar2 a_1134_5812.t0 a_1134_5812.t35 79.2190
Rpar3 a_1134_5812.t32 a_1134_5812.t34 83.7099
Rpar4 a_1134_5812.t32 a_1134_5812.t35 109.8973
Rpar5 a_1134_5812.t34 a_1134_5812.t35 146.9512
Rpar6 a_2002_11760.t0 a_2002_11760.t4 37.3911
Rpar7 a_3006_5812.t0 a_3006_5812.t1 49.9847
Rpar8 a_5916_5518.t0 a_5916_5518.t32 243.0618
Rpar9 a_5916_5518.t0 a_5916_5518.t33 87.7570
Rpar10 a_5916_5518.t32 a_5916_5518.t33 26.8763
Rpar11 a_5987_7812.t0 a_5987_7812.t1 24.8328
Rpar12 a_5987_7812.t0 a_5987_7812.t4 245.1061
Rpar13 a_5987_7812.t1 a_5987_7812.t4 153.8318
Rpar14 ib ib.t0 18.3419
Rpar15 ib ib.t1 4.4041
Rpar16 ib.t0 ib.t1 114.8721
Rpar17 inn inn.t0 2.1139
Rpar18 inp inp.t0 2.1139
Rpar19 out out.t0 138.1220
Rpar20 out out.t1 1.8564
Rpar21 out out.t14 211.0640
Rpar22 out.t0 out.t1 145.4060
Rpar23 out.t0 out.t14 189.1129
Rpar24 out.t1 out.t14 222.1947
Rpar25 vdd vdd.t0 118.0892
Rpar26 vdd vdd.t1 1048.5173
Rpar27 vdd vdd.t2 22.1400
Rpar28 vdd.t0 vdd.t1 5.3331
Rpar29 vdd.t0 vdd.t2 44.4215
Rpar30 vdd.t1 vdd.t2 394.4201
Rpar31 vss vss.t0 168.3863
Rpar32 vss vss.t1 204.8976
Rpar33 vss vss.t22 246.8097
Rpar34 vss vss.t23 72.1991
Rpar35 vss vss.t24 141.9281
Rpar36 vss.t0 vss.t1 3.8720
Rpar37 vss.t0 vss.t22 30.2948
Rpar38 vss.t0 vss.t23 794.1269
Rpar39 vss.t0 vss.t24 1562.5530
Rpar40 vss.t1 vss.t22 45.7941
Rpar41 vss.t1 vss.t23 943.4209
Rpar42 vss.t22 vss.t23 2134.0252
Rpar43 vss.t23 vss.t24 8.8220
Cpar0 a_1134_5812.t0 vss 1.35887e-14
Cpar1 a_1134_5812.t32 vss 4.20181e-15
Cpar2 a_1134_5812.t34 vss 2.06015e-15
Cpar3 a_1134_5812.t35 vss 9.90177e-15
Cpar4 a_2002_11760.t0 vss 1.20545e-14
Cpar5 a_2002_11760.t4 vss 4.21083e-14
Cpar6 a_3006_5812.t0 vss 8.68222e-17
Cpar7 a_3006_5812.t1 vss 4.85929e-15
Cpar8 a_5916_5518.t0 vss 1.83726e-14
Cpar9 a_5916_5518.t32 vss 5.17504e-15
Cpar10 a_5916_5518.t33 vss 4.84315e-15
Cpar11 a_5987_7812.t0 vss 2.85454e-14
Cpar12 a_5987_7812.t1 vss 7.09806e-15
Cpar13 a_5987_7812.t4 vss 5.16792e-15
Cpar14 ib vss 6.85064e-15
Cpar15 ib.t0 vss 6.02386e-16
Cpar16 ib.t1 vss 1.97453e-16
Cpar17 inn inp 1.03350e-16
Cpar18 inn vdd 1.52899e-14
Cpar19 inn vss 5.89151e-15
Cpar20 inn.t0 vss 1.84072e-14
Cpar21 inp vdd 1.50815e-14
Cpar22 inp vss 5.93127e-15
Cpar23 inp.t0 vss 1.82877e-14
Cpar24 out vdd 1.31807e-14
Cpar25 out vss 1.91891e-14
Cpar26 out.t0 vss 1.21857e-14
Cpar27 out.t1 vss 3.78890e-15
Cpar28 out.t14 vss 1.43242e-14
Cpar29 vdd vss 1.66448e-13
Cpar30 vdd.t0 vss 3.12024e-14
Cpar31 vdd.t1 vss 1.01550e-14
Cpar32 vdd.t2 vss 4.17069e-14
.ends opamp_dut

Vdd vdd 0 1.800000
Vss vss 0 0
Ibias vdd ib 1.437500e-06
Vinp inp 0 DC 0.805000 AC 1 PWL(0 0.805000 1.955056e-08 0.805000 2.150561e-08 0.815000)
Rfb out inn 1m
Cload out 0 2.000000e-12
Xdut vdd vss inp inn out ib opamp_dut
.end
