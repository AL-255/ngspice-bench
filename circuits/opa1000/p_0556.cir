* opa1000[0556]: 2p/pmos_5t_1v8_i10u_subth (pmos_5t, VDD=1.8V, CL=2.0pF, Iref=2.6uA)
.include "pdk_opa.inc"
.temp 27
.option gmin=1e-12 rshunt=1e12 reltol=1e-3 abstol=1e-12 vntol=1e-5 method=gear
* Post-PEX R+C extracted netlist for pmos_5t_1v8_i10u_subth
.subckt opamp_dut vdd vss inp inn out ib
XMpar0 a_1906_8530.t0 inp.t0 a_2296_8530.t32 vdd.t6 pfet_03v3 w=8u l=1.35u ad=2.5600e-12 pd=9.6400e-06 as=2.2400e-12 ps=8.5600e-06 nf=1 m=64 par=64
XMpar1 a_1906_8530.t0 inn.t0 out.t0 vdd.t6 pfet_03v3 w=8u l=1.35u ad=2.5600e-12 pd=9.6400e-06 as=2.2400e-12 ps=8.5600e-06 nf=1 m=64 par=64
XMpar2 a_1906_8530.t128 a_1878_4994.t2 vdd.t1 vdd.t0 pfet_03v3 w=10u l=1.2u ad=2.8000e-12 pd=1.0560e-05 as=3.6000e-12 ps=1.3220e-05 nf=1 m=8 par=8
XMpar3 out.t1 a_2296_8530.t0 vss.t1 vss.t0 nfet_03v3 w=1.99u l=2.7u ad=5.5720e-13 pd=2.5500e-06 as=6.3680e-13 ps=2.8787e-06 nf=1 m=16 par=16
XMpar4 a_2296_8530.t1 a_2296_8530.t0 vss.t1 vss.t0 nfet_03v3 w=1.99u l=2.7u ad=5.5720e-13 pd=2.5500e-06 as=6.3680e-13 ps=2.8787e-06 nf=1 m=16 par=16
XMpar5 ib.t1 ib.t0 vss.t19 vss.t18 nfet_03v3 w=3.83u l=1.2u ad=2.2980e-12 pd=8.8600e-06 as=1.0724e-12 ps=4.3900e-06 nf=1 m=2 par=2
XMpar6 a_1878_4994.t0 ib.t0 vss.t19 vss.t18 nfet_03v3 w=3.83u l=1.2u ad=1.0724e-12 pd=4.3900e-06 as=1.0724e-12 ps=4.3900e-06 nf=1 m=2 par=2
XMpar7 a_1878_4994.t3 a_1878_4994.t2 vdd.t1 vdd.t0 pfet_03v3 w=10u l=1.2u ad=2.8000e-12 pd=1.0560e-05 as=2.8000e-12 ps=1.0560e-05 nf=1 m=2 par=2
X95 out.t80 vss.t13 cap_mim_2f0fF c_width=9u c_length=9u
Rpar0 a_1878_4994.t0 a_1878_4994.t2 124.8091
Rpar1 a_1878_4994.t0 a_1878_4994.t3 62.9853
Rpar2 a_1878_4994.t2 a_1878_4994.t3 26.9619
Rpar3 a_1906_8530.t0 a_1906_8530.t128 51.0403
Rpar4 a_2296_8530.t0 a_2296_8530.t1 8.0046
Rpar5 a_2296_8530.t0 a_2296_8530.t32 203.3233
Rpar6 a_2296_8530.t1 a_2296_8530.t32 91.9678
Rpar7 ib ib.t0 16.2673
Rpar8 ib ib.t1 3.6227
Rpar9 inn inn.t0 1.9812
Rpar10 inp inp.t0 1.9812
Rpar11 out out.t0 105.5971
Rpar12 out out.t1 56.0212
Rpar13 out out.t80 14.9993
Rpar14 out.t0 out.t1 86.6872
Rpar15 out.t0 out.t80 1479.2613
Rpar16 out.t1 out.t80 784.7751
Rpar17 vdd vdd.t0 394.8374
Rpar18 vdd vdd.t1 1436.5400
Rpar19 vdd vdd.t6 47.3115
Rpar20 vdd.t0 vdd.t1 5.7226
Rpar21 vdd.t0 vdd.t6 53.7984
Rpar22 vdd.t1 vdd.t6 195.7353
Rpar23 vss vss.t0 130.4010
Rpar24 vss vss.t1 1874.8709
Rpar25 vss vss.t13 337.6889
Rpar26 vss vss.t18 154.9165
Rpar27 vss vss.t19 186.4381
Rpar28 vss.t0 vss.t1 10.9383
Rpar29 vss.t0 vss.t13 51.0635
Rpar30 vss.t0 vss.t18 154.6060
Rpar31 vss.t0 vss.t19 221.7132
Rpar32 vss.t1 vss.t13 734.2121
Rpar33 vss.t13 vss.t18 481.9654
Rpar34 vss.t13 vss.t19 584.1794
Rpar35 vss.t18 vss.t19 10.4343
Cpar0 a_1878_4994.t0 vss 1.98079e-15
Cpar1 a_1878_4994.t2 vss 1.68513e-14
Cpar2 a_1878_4994.t3 vss 4.09804e-15
Cpar3 a_1906_8530.t0 vss 1.67390e-13
Cpar4 a_1906_8530.t128 vss 1.33530e-14
Cpar5 a_2296_8530.t0 vss 3.90533e-14
Cpar6 a_2296_8530.t1 vss 1.12169e-14
Cpar7 a_2296_8530.t32 vss 5.67665e-14
Cpar8 ib vss 7.81018e-15
Cpar9 ib.t0 vss 6.97462e-16
Cpar10 ib.t1 vss 2.94790e-16
Cpar11 inn inp 2.09090e-16
Cpar12 inn out 3.12987e-14
Cpar13 inn vdd 4.18069e-14
Cpar14 inn vss 1.08323e-14
Cpar15 inn.t0 vss 9.01163e-14
Cpar16 inp vdd 4.14447e-14
Cpar17 inp vss 1.07091e-14
Cpar18 inp.t0 vss 8.98024e-14
Cpar19 out vdd 1.46857e-14
Cpar20 out vss 2.77148e-14
Cpar21 out.t0 vss 6.93382e-14
Cpar22 out.t1 vss 1.44760e-14
Cpar23 out.t80 vss 2.24250e-14
Cpar24 vdd vss 4.90264e-13
Cpar25 vdd.t0 vss 1.20309e-14
Cpar26 vdd.t1 vss 5.49719e-15
Cpar27 vdd.t6 vss 1.21251e-13
.ends opamp_dut

Vdd vdd 0 1.800000
Vss vss 0 0
Ibias vdd ib 2.600000e-06
Vinp inp 0 DC 0.805000 AC 1 PWL(0 0.805000 1.523990e-08 0.805000 1.676390e-08 0.815000)
Rfb out inn 1m
Cload out 0 2.000000e-12
Xdut vdd vss inp inn out ib opamp_dut
.end
