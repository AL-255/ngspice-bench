* opa1000[0322]: 2p/folded_cascode_pmos_3v3_1u_10u_subth (folded_cascode_pmos, VDD=3.3V, CL=2.0pF, Iref=1.4444uA)
.include "pdk_opa.inc"
.temp 27
.option gmin=1e-12 rshunt=1e12 reltol=1e-3 abstol=1e-12 vntol=1e-5 method=gear
* Post-PEX R+C extracted netlist for folded_cascode_pmos_3v3_1u_10u_subth
.subckt opamp_dut vdd vss inp inn out ib
XMpar0 a_1426_12201.t0 inn.t0 a_8654_8186.t10 vdd.t4 pfet_03v3 w=3.01u l=1.6u ad=9.6320e-13 pd=4.0262e-06 as=8.4280e-13 ps=3.5700e-06 nf=1 m=64 par=64
XMpar1 a_1426_12201.t0 inp.t0 a_1866_12201.t4 vdd.t4 pfet_03v3 w=3.01u l=1.6u ad=9.6320e-13 pd=4.0262e-06 as=8.4280e-13 ps=3.5700e-06 nf=1 m=64 par=64
XMpar2 a_1426_12201.t64 a_1120_4487.t2 vdd.t1 vdd.t0 pfet_03v3 w=10u l=3.75u ad=2.8000e-12 pd=1.0560e-05 as=4.4000e-12 ps=1.5880e-05 nf=1 m=4 par=4
XMpar3 a_8654_8186.t0 ib.t0 vss.t4 vss.t0 nfet_03v3 w=5.13u l=2.5u ad=1.4364e-12 pd=5.6900e-06 as=2.2572e-12 ps=8.5750e-06 nf=1 m=4 par=4
XMpar4 a_1866_12201.t68 a_1120_4487.t10 a_6912_1204.t0 vss.t0 nfet_03v3 w=1.64u l=0.8u ad=6.3413e-13 pd=2.9600e-06 as=4.5920e-13 ps=2.2000e-06 nf=1 m=6 par=6
XMpar5 a_8654_8186.t4 a_1120_4487.t10 out.t0 vss.t0 nfet_03v3 w=1.64u l=0.8u ad=6.3413e-13 pd=2.9600e-06 as=4.5920e-13 ps=2.2000e-06 nf=1 m=6 par=6
XMpar6 a_1866_12201.t0 ib.t0 vss.t4 vss.t0 nfet_03v3 w=5.13u l=2.5u ad=1.4364e-12 pd=5.6900e-06 as=2.2572e-12 ps=8.5750e-06 nf=1 m=4 par=4
XMpar7 a_6912_1204.t7 a_6912_1204.t6 vdd.t1 vdd.t0 pfet_03v3 w=10u l=3.75u ad=6.0000e-12 pd=2.1200e-05 as=2.8000e-12 ps=1.0560e-05 nf=1 m=2 par=2
XMpar8 ib.t1 ib.t0 vss.t4 vss.t0 nfet_03v3 w=5.13u l=2.5u ad=3.0780e-12 pd=1.1460e-05 as=1.4364e-12 ps=5.6900e-06 nf=1 m=2 par=2
XMpar9 a_1120_4487.t0 ib.t0 vss.t4 vss.t0 nfet_03v3 w=5.13u l=2.5u ad=1.4364e-12 pd=5.6900e-06 as=1.4364e-12 ps=5.6900e-06 nf=1 m=2 par=2
XMpar10 out.t1 a_6912_1204.t6 vdd.t1 vdd.t0 pfet_03v3 w=10u l=3.75u ad=2.8000e-12 pd=1.0560e-05 as=2.8000e-12 ps=1.0560e-05 nf=1 m=2 par=2
XMpar11 a_1120_4487.t3 a_1120_4487.t2 vdd.t1 vdd.t0 pfet_03v3 w=10u l=3.75u ad=2.8000e-12 pd=1.0560e-05 as=2.8000e-12 ps=1.0560e-05 nf=1 m=2 par=2
Rpar0 a_1120_4487.t0 a_1120_4487.t10 62.6133
Rpar1 a_1120_4487.t0 a_1120_4487.t2 181.6743
Rpar2 a_1120_4487.t0 a_1120_4487.t3 64.3866
Rpar3 a_1120_4487.t10 a_1120_4487.t2 219.2108
Rpar4 a_1120_4487.t10 a_1120_4487.t3 77.6897
Rpar5 a_1120_4487.t2 a_1120_4487.t3 27.7377
Rpar6 a_1426_12201.t0 a_1426_12201.t64 51.4009
Rpar7 a_1866_12201.t0 a_1866_12201.t4 81.4837
Rpar8 a_1866_12201.t0 a_1866_12201.t68 56.6196
Rpar9 a_1866_12201.t4 a_1866_12201.t68 203.0302
Rpar10 a_6912_1204.t0 a_6912_1204.t6 405.8068
Rpar11 a_6912_1204.t0 a_6912_1204.t7 95.6578
Rpar12 a_6912_1204.t6 a_6912_1204.t7 19.8714
Rpar13 a_8654_8186.t0 a_8654_8186.t10 67.9657
Rpar14 a_8654_8186.t0 a_8654_8186.t4 77.9954
Rpar15 a_8654_8186.t10 a_8654_8186.t4 143.2336
Rpar16 ib ib.t0 11.5949
Rpar17 ib ib.t1 3.6761
Rpar18 ib.t0 ib.t1 176.0466
Rpar19 inn inn.t0 1.3351
Rpar20 inp inp.t0 1.3351
Rpar21 out out.t0 3.5659
Rpar22 out out.t1 49.7171
Rpar23 vdd vdd.t0 322.8678
Rpar24 vdd vdd.t1 853.7060
Rpar25 vdd vdd.t4 45.5617
Rpar26 vdd.t0 vdd.t1 4.0742
Rpar27 vdd.t0 vdd.t4 86.5745
Rpar28 vdd.t1 vdd.t4 228.9148
Rpar29 vss vss.t0 98.2715
Rpar30 vss vss.t4 222.6452
Rpar31 vss.t0 vss.t4 3.1304
Cpar0 a_1120_4487.t0 vss 1.67483e-15
Cpar1 a_1120_4487.t10 vss 3.70049e-15
Cpar2 a_1120_4487.t2 vss 2.14213e-14
Cpar3 a_1120_4487.t3 vss 2.97035e-15
Cpar4 a_1426_12201.t0 vss 1.01355e-13
Cpar5 a_1426_12201.t64 vss 1.09406e-14
Cpar6 a_1866_12201.t0 vss 8.53193e-15
Cpar7 a_1866_12201.t4 vss 5.38809e-14
Cpar8 a_1866_12201.t68 vss 3.89599e-15
Cpar9 a_6912_1204.t0 vss 2.76839e-15
Cpar10 a_6912_1204.t6 vss 1.49729e-14
Cpar11 a_6912_1204.t7 vss 6.30336e-15
Cpar12 a_8654_8186.t0 vss 8.23519e-15
Cpar13 a_8654_8186.t10 vss 5.71187e-14
Cpar14 a_8654_8186.t4 vss 4.26441e-15
Cpar15 ib inn 2.08600e-17
Cpar16 ib inp 1.04300e-17
Cpar17 ib out 3.76080e-16
Cpar18 ib vdd 1.88750e-15
Cpar19 ib vss 2.76816e-14
Cpar20 ib.t0 vss 6.06645e-15
Cpar21 ib.t1 vss 5.19860e-16
Cpar22 inn inp 2.09120e-16
Cpar23 inn vdd 4.46880e-14
Cpar24 inn vss 6.50149e-15
Cpar25 inn.t0 vss 7.36268e-14
Cpar26 inp vdd 4.42095e-14
Cpar27 inp vss 6.49573e-15
Cpar28 inp.t0 vss 7.32466e-14
Cpar29 out vdd 2.96892e-15
Cpar30 out vss 7.47266e-15
Cpar31 out.t0 vss 7.22558e-16
Cpar32 out.t1 vss 5.84910e-15
Cpar33 vdd vss 4.08435e-13
Cpar34 vdd.t0 vss 3.52765e-14
Cpar35 vdd.t1 vss 1.65302e-14
Cpar36 vdd.t4 vss 1.11714e-13
.ends opamp_dut

Vdd vdd 0 3.300000
Vss vss 0 0
Ibias vdd ib 1.444400e-06
Vinp inp 0 DC 1.381000 AC 1 PWL(0 1.381000 3.981174e-08 1.381000 4.379292e-08 1.391000)
Rfb out inn 1m
Cload out 0 2.000000e-12
Xdut vdd vss inp inn out ib opamp_dut
.end
