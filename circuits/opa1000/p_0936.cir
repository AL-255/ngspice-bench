* opa1000[0936]: 200f/telescopic_pmos_1v8_i150u_weak (telescopic_pmos, VDD=1.8V, CL=0.2pF, Iref=30.0uA)
.include "pdk_opa.inc"
.temp 27
.option gmin=1e-12 rshunt=1e12 reltol=1e-3 abstol=1e-12 vntol=1e-5 method=gear
* Post-PEX R+C extracted netlist for telescopic_pmos_1v8_i150u_weak
.subckt opamp_dut vdd vss inp inn out ib
XMpar0 a_11600_6538.t20 a_7204_14221.t166 vss.t36 vss.t0 nfet_03v3 w=1.81u l=0.42u ad=6.2264e-13 pd=2.8600e-06 as=5.0680e-13 ps=2.3700e-06 nf=1 m=10 par=10
XMpar1 a_1583_19254.t4 inp.t0 a_6970_14221.t0 vdd.t20 pfet_03v3 w=2.01u l=0.36u ad=6.0810e-13 pd=2.7566e-06 as=5.7186e-13 ps=2.6073e-06 nf=1 m=142 par=142
XMpar2 a_13614_14221.t0 inn.t0 a_1583_19254.t4 vdd.t20 pfet_03v3 w=2.01u l=0.36u ad=5.7186e-13 pd=2.6073e-06 as=6.0810e-13 ps=2.7566e-06 nf=1 m=142 par=142
XMpar3 a_11600_6538.t0 a_7204_14221.t0 out.t86 vss.t0 nfet_03v3 w=2u l=0.57u ad=8.3429e-13 pd=3.6914e-06 as=6.0571e-13 ps=2.7486e-06 nf=1 m=28 par=28
XMpar4 a_13614_14221.t142 vss.t89 out.t0 vdd.t2 pfet_03v3 w=1.98u l=0.57u ad=5.8896e-13 pd=2.6829e-06 as=5.6592e-13 ps=2.5876e-06 nf=1 m=110 par=110
XMpar5 a_1583_19254.t0 a_1703_19046.t0 vdd.t1 vdd.t0 pfet_03v3 w=10u l=0.98u ad=3.3333e-12 pd=1.2333e-05 as=3.0667e-12 ps=1.1447e-05 nf=1 m=24 par=24
XMpar6 a_6970_14221.t142 vss.t89 a_7204_14221.t56 vdd.t2 pfet_03v3 w=1.98u l=0.57u ad=5.8896e-13 pd=2.6829e-06 as=5.6592e-13 ps=2.5876e-06 nf=1 m=110 par=110
XMpar7 ib.t1 ib.t0 vss.t5 vss.t4 nfet_03v3 w=4.04u l=0.98u ad=1.5621e-12 pd=6.1600e-06 as=1.1312e-12 ps=4.6000e-06 nf=1 m=6 par=6
XMpar8 a_10872_6538.t1 a_7204_14221.t166 vss.t36 vss.t0 nfet_03v3 w=1.81u l=0.42u ad=6.2264e-13 pd=2.8600e-06 as=5.0680e-13 ps=2.3700e-06 nf=1 m=10 par=10
XMpar9 a_10872_6538.t0 a_7204_14221.t0 a_7204_14221.t1 vss.t0 nfet_03v3 w=2u l=0.57u ad=8.3429e-13 pd=3.6914e-06 as=6.5143e-13 ps=2.9371e-06 nf=1 m=28 par=28
XMpar10 a_1703_19046.t12 ib.t0 vss.t5 vss.t4 nfet_03v3 w=4.04u l=0.98u ad=1.5621e-12 pd=6.1600e-06 as=1.1312e-12 ps=4.6000e-06 nf=1 m=6 par=6
XMpar11 a_1703_19046.t1 a_1703_19046.t0 vdd.t1 vdd.t0 pfet_03v3 w=10u l=0.98u ad=3.8667e-12 pd=1.4107e-05 as=2.8000e-12 ps=1.0560e-05 nf=1 m=6 par=6
X59 out.t138 vss.t1 cap_mim_2f0fF c_width=16.65u c_length=16.65u
X302 out.t138 vss.t1 cap_mim_2f0fF c_width=16.65u c_length=16.65u
X409 out.t138 vss.t1 cap_mim_2f0fF c_width=16.65u c_length=16.65u
Rpar0 a_10872_6538.t0 a_10872_6538.t1 46.4895
Rpar1 a_11600_6538.t0 a_11600_6538.t20 55.9825
Rpar2 a_13614_14221.t0 a_13614_14221.t142 57.7154
Rpar3 a_1583_19254.t0 a_1583_19254.t4 42.5872
Rpar4 a_1703_19046.t0 a_1703_19046.t1 10.2930
Rpar5 a_1703_19046.t0 a_1703_19046.t12 821.4494
Rpar6 a_1703_19046.t1 a_1703_19046.t12 128.3246
Rpar7 a_6970_14221.t0 a_6970_14221.t142 57.7154
Rpar8 a_7204_14221.t0 a_7204_14221.t1 5.4761
Rpar9 a_7204_14221.t0 a_7204_14221.t56 494.8831
Rpar10 a_7204_14221.t0 a_7204_14221.t166 371.4773
Rpar11 a_7204_14221.t1 a_7204_14221.t56 119.2355
Rpar12 a_7204_14221.t1 a_7204_14221.t166 89.5026
Rpar13 a_7204_14221.t56 a_7204_14221.t166 238.7020
Rpar14 ib ib.t0 13.9607
Rpar15 ib ib.t1 3.2533
Rpar16 ib.t0 ib.t1 19.6126
Rpar17 inn inn.t0 1.9440
Rpar18 inp inp.t0 1.9440
Rpar19 out out.t0 113.7650
Rpar20 out out.t86 73.2092
Rpar21 out out.t138 17.8345
Rpar22 out.t0 out.t86 217.2412
Rpar23 out.t0 out.t138 498.1093
Rpar24 out.t86 out.t138 320.5396
Rpar25 vdd vdd.t1 104.9975
Rpar26 vdd vdd.t2 238.6131
Rpar27 vdd vdd.t20 29.8971
Rpar28 vdd.t0 vdd.t1 12.2339
Rpar29 vdd.t1 vdd.t2 465.4737
Rpar30 vdd.t1 vdd.t20 58.3216
Rpar31 vdd.t2 vdd.t20 60.7218
Rpar32 vss vss.t0 156.9954
Rpar33 vss vss.t1 123.8422
Rpar34 vss vss.t5 111.4242
Rpar35 vss vss.t89 305.4040
Rpar36 vss vss.t4 891.0115
Rpar37 vss vss.t36 154.4816
Rpar38 vss.t0 vss.t1 245.0423
Rpar39 vss.t0 vss.t5 264.8434
Rpar40 vss.t0 vss.t89 741.4160
Rpar41 vss.t0 vss.t4 977.8984
Rpar42 vss.t0 vss.t36 10.7439
Rpar43 vss.t1 vss.t5 213.4445
Rpar44 vss.t1 vss.t89 585.0341
Rpar45 vss.t1 vss.t4 1706.6007
Rpar46 vss.t1 vss.t36 241.1105
Rpar47 vss.t5 vss.t89 192.7585
Rpar48 vss.t5 vss.t4 12.8724
Rpar49 vss.t5 vss.t36 266.2071
Rpar50 vss.t89 vss.t4 1541.9689
Rpar51 vss.t89 vss.t36 729.7739
Rpar52 vss.t4 vss.t36 2108.8525
Cpar0 a_10872_6538.t0 vss 2.72442e-14
Cpar1 a_10872_6538.t1 vss 6.90046e-15
Cpar2 a_11600_6538.t0 vss 3.29488e-14
Cpar3 a_11600_6538.t20 vss 9.07129e-15
Cpar4 a_13614_14221.t0 vss 1.02122e-13
Cpar5 a_13614_14221.t142 vss 7.75077e-14
Cpar6 a_1583_19254.t0 vss 7.49534e-14
Cpar7 a_1583_19254.t4 vss 1.88208e-13
Cpar8 a_1703_19046.t0 vss 3.97140e-14
Cpar9 a_1703_19046.t1 vss 1.93606e-14
Cpar10 a_1703_19046.t12 vss 1.12619e-14
Cpar11 a_6970_14221.t0 vss 1.02410e-13
Cpar12 a_6970_14221.t142 vss 7.77246e-14
Cpar13 a_7204_14221.t0 vss 2.56683e-14
Cpar14 a_7204_14221.t1 vss 2.39710e-14
Cpar15 a_7204_14221.t166 vss 1.08809e-14
Cpar16 a_7204_14221.t56 vss 4.71779e-14
Cpar17 ib out 1.09000e-17
Cpar18 ib vss 2.01284e-14
Cpar19 ib.t0 vss 2.89505e-15
Cpar20 ib.t1 vss 1.51302e-15
Cpar21 inn inp 2.62260e-16
Cpar22 inn out 1.21600e-17
Cpar23 inn vdd 4.18314e-14
Cpar24 inn vss 8.85850e-15
Cpar25 inn.t0 vss 6.62255e-14
Cpar26 inp vdd 4.15938e-14
Cpar27 inp vss 8.81441e-15
Cpar28 inp.t0 vss 6.60740e-14
Cpar29 out vdd 1.24004e-14
Cpar30 out vss 6.02735e-14
Cpar31 out.t0 vss 1.28533e-14
Cpar32 out.t138 vss 7.31401e-14
Cpar33 out.t86 vss 5.89767e-15
Cpar34 vdd vss 6.80757e-13
Cpar35 vdd.t0 vss 4.57020e-14
Cpar36 vdd.t1 vss 1.30298e-14
Cpar37 vdd.t2 vss 8.19774e-14
Cpar38 vdd.t20 vss 8.79796e-14
.ends opamp_dut

Vdd vdd 0 1.800000
Vss vss 0 0
Ibias vdd ib 3.000000e-05
Vinp inp 0 DC 0.805000 AC 1 PWL(0 0.805000 3.000000e-09 0.805000 3.300000e-09 0.815000)
Rfb out inn 1m
Cload out 0 2.000000e-13
Xdut vdd vss inp inn out ib opamp_dut
.end
