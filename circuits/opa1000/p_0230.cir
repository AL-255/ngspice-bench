* opa1000[0230]: 2p/folded_cascode_nmos_3v3_i50n_subth (folded_cascode_nmos, VDD=3.3V, CL=2.0pF, Iref=0.0128uA)
.include "pdk_opa.inc"
.temp 27
.option gmin=1e-12 rshunt=1e12 reltol=1e-3 abstol=1e-12 vntol=1e-5 method=gear
* Post-PEX R+C extracted netlist for folded_cascode_nmos_3v3_i50n_subth
.subckt opamp_dut vdd vss inp inn out ib
XMpar0 a_1777_1249.t0 inn.t0 a_6414_7397.t2 vss.t0 nfet_03v3 w=1.7u l=4.4u ad=7.4800e-13 pd=3.4300e-06 as=4.7600e-13 ps=2.2600e-06 nf=1 m=8 par=8
XMpar1 a_6414_7397.t10 ib.t10 out.t0 vdd.t8 pfet_03v3 w=1.83u l=5.25u ad=1.0980e-12 pd=4.8600e-06 as=5.1240e-13 ps=2.3900e-06 nf=1 m=2 par=2
XMpar2 a_1777_1249.t0 inp.t0 a_3130_4590.t0 vss.t0 nfet_03v3 w=1.7u l=4.4u ad=7.4800e-13 pd=3.4300e-06 as=4.7600e-13 ps=2.2600e-06 nf=1 m=8 par=8
XMpar3 a_3130_4590.t8 a_1212_10591.t2 vdd.t1 vdd.t0 pfet_03v3 w=0.46u l=9.75u ad=1.2880e-13 pd=1.0200e-06 as=2.7600e-13 ps=2.1200e-06 nf=1 m=4 par=4
XMpar4 a_1212_10591.t3 a_1212_10591.t2 vdd.t1 vdd.t0 pfet_03v3 w=0.46u l=9.75u ad=1.2880e-13 pd=1.0200e-06 as=2.7600e-13 ps=2.1200e-06 nf=1 m=2 par=2
XMpar5 a_3172_9183.t3 a_3172_9183.t2 vss.t9 vss.t8 nfet_03v3 w=0.4u l=7.5u ad=2.4000e-13 pd=2.0000e-06 as=1.1200e-13 ps=9.6000e-07 nf=1 m=2 par=2
XMpar6 a_3130_4590.t10 ib.t10 a_3172_9183.t0 vdd.t8 pfet_03v3 w=1.83u l=5.25u ad=1.0980e-12 pd=4.8600e-06 as=5.1240e-13 ps=2.3900e-06 nf=1 m=2 par=2
XMpar7 a_1777_1249.t16 ib.t0 vss.t9 vss.t8 nfet_03v3 w=0.4u l=7.5u ad=2.4000e-13 pd=2.0000e-06 as=1.1200e-13 ps=9.6000e-07 nf=1 m=4 par=4
XMpar8 ib.t1 ib.t0 vss.t9 vss.t8 nfet_03v3 w=0.4u l=7.5u ad=2.4000e-13 pd=2.0000e-06 as=1.1200e-13 ps=9.6000e-07 nf=1 m=2 par=2
XMpar9 a_1212_10591.t0 ib.t0 vss.t9 vss.t8 nfet_03v3 w=0.4u l=7.5u ad=2.4000e-13 pd=2.0000e-06 as=1.1200e-13 ps=9.6000e-07 nf=1 m=2 par=2
XMpar10 out.t2 a_3172_9183.t2 vss.t9 vss.t8 nfet_03v3 w=0.4u l=7.5u ad=1.1200e-13 pd=9.6000e-07 as=1.1200e-13 ps=9.6000e-07 nf=1 m=2 par=2
XMpar11 a_6414_7397.t0 a_1212_10591.t2 vdd.t1 vdd.t0 pfet_03v3 w=0.46u l=9.75u ad=1.2880e-13 pd=1.0200e-06 as=2.7600e-13 ps=2.1200e-06 nf=1 m=4 par=4
X11 out.t4 vss.t10 cap_mim_2f0fF c_width=7.75u c_length=7.75u
Rpar0 a_1212_10591.t0 a_1212_10591.t2 87.9411
Rpar1 a_1212_10591.t0 a_1212_10591.t3 190.4535
Rpar2 a_1212_10591.t2 a_1212_10591.t3 26.6254
Rpar3 a_1777_1249.t0 a_1777_1249.t16 59.0169
Rpar4 a_3130_4590.t0 a_3130_4590.t10 49.1692
Rpar5 a_3130_4590.t0 a_3130_4590.t8 81.9049
Rpar6 a_3130_4590.t10 a_3130_4590.t8 153.6340
Rpar7 a_3172_9183.t0 a_3172_9183.t2 99.7961
Rpar8 a_3172_9183.t0 a_3172_9183.t3 79.1238
Rpar9 a_3172_9183.t2 a_3172_9183.t3 22.9637
Rpar10 a_6414_7397.t0 a_6414_7397.t10 153.6340
Rpar11 a_6414_7397.t0 a_6414_7397.t2 81.9049
Rpar12 a_6414_7397.t10 a_6414_7397.t2 49.1692
Rpar13 ib ib.t0 14.4709
Rpar14 ib ib.t1 15.2371
Rpar15 ib ib.t10 140.9688
Rpar16 ib.t0 ib.t1 31.6188
Rpar17 inn inn.t0 2.0591
Rpar18 inp inp.t0 2.0591
Rpar19 out out.t0 81.9672
Rpar20 out out.t2 17.5090
Rpar21 out out.t4 131.2976
Rpar22 out.t0 out.t2 372.5859
Rpar23 out.t0 out.t4 173.4450
Rpar24 out.t2 out.t4 596.8198
Rpar25 vdd vdd.t0 40.2193
Rpar26 vdd vdd.t1 46.4985
Rpar27 vdd vdd.t8 194.3446
Rpar28 vdd.t0 vdd.t1 8.1088
Rpar29 vdd.t0 vdd.t8 109.1364
Rpar30 vdd.t1 vdd.t8 112.7626
Rpar31 vss vss.t0 139.6405
Rpar32 vss vss.t10 56.5659
Rpar33 vss vss.t8 140.5819
Rpar34 vss vss.t9 67.0409
Rpar35 vss.t0 vss.t10 674.4643
Rpar36 vss.t0 vss.t8 2.6266
Rpar37 vss.t0 vss.t9 25.1161
Rpar38 vss.t10 vss.t8 758.9758
Rpar39 vss.t10 vss.t9 148.3010
Rpar40 vss.t8 vss.t9 9.4712
Cpar0 a_1212_10591.t0 vss 1.09144e-14
Cpar1 a_1212_10591.t2 vss 5.19086e-14
Cpar2 a_1212_10591.t3 vss 3.72860e-15
Cpar3 a_1777_1249.t0 vss 1.46525e-14
Cpar4 a_1777_1249.t16 vss 1.05107e-14
Cpar5 a_3130_4590.t0 vss 1.12729e-14
Cpar6 a_3130_4590.t10 vss 4.97324e-15
Cpar7 a_3130_4590.t8 vss 9.36665e-15
Cpar8 a_3172_9183.t0 vss 9.15882e-16
Cpar9 a_3172_9183.t2 vss 5.09807e-15
Cpar10 a_3172_9183.t3 vss 1.25537e-15
Cpar11 a_6414_7397.t0 vss 8.84850e-15
Cpar12 a_6414_7397.t10 vss 4.69814e-15
Cpar13 a_6414_7397.t2 vss 1.06493e-14
Cpar14 ib inn 1.85240e-16
Cpar15 ib inp 2.94160e-16
Cpar16 ib out 1.08781e-15
Cpar17 ib vdd 1.23725e-14
Cpar18 ib vss 5.46503e-14
Cpar19 ib.t0 vss 1.36554e-14
Cpar20 ib.t1 vss 1.17041e-15
Cpar21 ib.t10 vss 1.13952e-14
Cpar22 inn inp 1.02820e-16
Cpar23 inn out 1.01470e-16
Cpar24 inn vdd 1.19800e-17
Cpar25 inn vss 1.62677e-14
Cpar26 inn.t0 vss 4.77450e-15
Cpar27 inp vdd 1.12100e-17
Cpar28 inp vss 1.62409e-14
Cpar29 inp.t0 vss 4.78768e-15
Cpar30 out vdd 2.21299e-15
Cpar31 out vss 1.14034e-14
Cpar32 out.t0 vss 8.38750e-16
Cpar33 out.t2 vss 2.68364e-16
Cpar34 out.t4 vss 6.94797e-15
Cpar35 vdd vss 1.38435e-13
Cpar36 vdd.t0 vss 2.78164e-14
Cpar37 vdd.t1 vss 2.60868e-14
Cpar38 vdd.t8 vss 1.75969e-14
.ends opamp_dut

Vdd vdd 0 3.300000
Vss vss 0 0
Ibias vdd ib 1.280000e-08
Vinp inp 0 DC 1.810000 AC 1 PWL(0 1.810000 3.674729e-06 1.810000 4.042201e-06 1.820000)
Rfb out inn 1m
Cload out 0 2.000000e-12
Xdut vdd vss inp inn out ib opamp_dut
.end
