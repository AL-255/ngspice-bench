* opa1000[0428]: 200f/nmos_miller_1v8_1u_10u_subth (nmos_miller, VDD=1.8V, CL=0.2pF, Iref=0.8214uA)
.include "pdk_opa.inc"
.temp 27
.option gmin=1e-12 rshunt=1e12 reltol=1e-3 abstol=1e-12 vntol=1e-5 method=gear
* Post-PEX R+C extracted netlist for nmos_miller_1v8_1u_10u_subth
.subckt opamp_dut vdd vss inp inn out ib
XMpar0 out.t0 ib.t0 vss.t9 vss.t0 nfet_03v3 w=2.27u l=2u ad=1.0714e-12 pd=4.5760e-06 as=9.2616e-13 ps=3.9940e-06 nf=1 m=10 par=10
XMpar1 out.t2 a_1086_1086.t11 vdd.t1 vdd.t0 pfet_03v3 w=10u l=0.6u ad=2.8000e-12 pd=1.0560e-05 as=3.4400e-12 ps=1.2688e-05 nf=1 m=10 par=10
XMpar2 a_5572_1041.t9 a_5572_1041.t8 vdd.t1 vdd.t0 pfet_03v3 w=10u l=0.6u ad=2.8000e-12 pd=1.0560e-05 as=2.8000e-12 ps=1.0560e-05 nf=1 m=2 par=2
XMpar3 a_2162_4875.t0 inn.t0 a_5572_1041.t0 vss.t0 nfet_03v3 w=1.88u l=1.6u ad=6.7680e-13 pd=3.0700e-06 as=5.2640e-13 ps=2.4400e-06 nf=1 m=8 par=8
XMpar4 a_1086_1086.t0 inp.t0 a_2162_4875.t0 vss.t0 nfet_03v3 w=1.88u l=1.6u ad=5.2640e-13 pd=2.4400e-06 as=6.7680e-13 ps=3.0700e-06 nf=1 m=8 par=8
XMpar5 a_1086_1086.t9 a_5572_1041.t8 vdd.t1 vdd.t0 pfet_03v3 w=10u l=0.6u ad=6.0000e-12 pd=2.1200e-05 as=2.8000e-12 ps=1.0560e-05 nf=1 m=2 par=2
XMpar6 ib.t1 ib.t0 vss.t9 vss.t0 nfet_03v3 w=2.27u l=2u ad=1.3620e-12 pd=5.7400e-06 as=6.3560e-13 ps=2.8300e-06 nf=1 m=2 par=2
XMpar7 a_2162_4875.t8 ib.t0 vss.t9 vss.t0 nfet_03v3 w=2.27u l=2u ad=1.3620e-12 pd=5.7400e-06 as=6.3560e-13 ps=2.8300e-06 nf=1 m=4 par=4
X15 a_1086_1086.t8 a_8238_6756.t0 vss.t32 ppolyf_u_1k r_width=1u r_length=17.39u
X21 a_8238_6756.t1 out.t12 cap_mim_2f0fF c_width=11.46u c_length=11.46u
Rpar0 a_1086_1086.t0 a_1086_1086.t9 157.2473
Rpar1 a_1086_1086.t0 a_1086_1086.t11 138.9406
Rpar2 a_1086_1086.t0 a_1086_1086.t8 92.0640
Rpar3 a_1086_1086.t9 a_1086_1086.t11 122.3643
Rpar4 a_1086_1086.t9 a_1086_1086.t8 303.9945
Rpar5 a_1086_1086.t11 a_1086_1086.t8 268.6036
Rpar6 a_2162_4875.t0 a_2162_4875.t8 72.5276
Rpar7 a_5572_1041.t0 a_5572_1041.t8 334.8874
Rpar8 a_5572_1041.t0 a_5572_1041.t9 59.5953
Rpar9 a_5572_1041.t8 a_5572_1041.t9 44.3062
Rpar10 a_8238_6756.t0 a_8238_6756.t1 60.2293
Rpar11 ib ib.t0 15.4849
Rpar12 ib ib.t1 8.3607
Rpar13 ib.t0 ib.t1 23.0127
Rpar14 inn inn.t0 1.7148
Rpar15 inp inp.t0 1.7634
Rpar16 out out.t0 2.9442
Rpar17 out out.t2 686.6966
Rpar18 out out.t12 1466.8034
Rpar19 out.t0 out.t2 67.4524
Rpar20 out.t0 out.t12 144.0803
Rpar21 out.t2 out.t12 247.1598
Rpar22 vdd vdd.t0 97.6232
Rpar23 vdd vdd.t1 228.3080
Rpar24 vdd.t0 vdd.t1 3.6141
Rpar25 vss vss.t0 49.1724
Rpar26 vss vss.t9 1627.3254
Rpar27 vss vss.t32 1697.9730
Rpar28 vss.t0 vss.t9 11.6014
Rpar29 vss.t0 vss.t32 10.0471
Rpar30 vss.t9 vss.t32 286.3042
Cpar0 a_1086_1086.t0 vss 5.16754e-15
Cpar1 a_1086_1086.t11 vss 1.14106e-14
Cpar2 a_1086_1086.t8 vss 2.71331e-15
Cpar3 a_1086_1086.t9 vss 6.90810e-15
Cpar4 a_2162_4875.t0 vss 1.32717e-14
Cpar5 a_2162_4875.t8 vss 1.38255e-14
Cpar6 a_5572_1041.t0 vss 4.48600e-15
Cpar7 a_5572_1041.t8 vss 3.71692e-15
Cpar8 a_5572_1041.t9 vss 4.54266e-15
Cpar9 a_8238_6756.t0 vss 2.18650e-16
Cpar10 a_8238_6756.t1 vss 3.48930e-15
Cpar11 ib out 3.46290e-15
Cpar12 ib vdd 6.55400e-17
Cpar13 ib vss 3.14647e-14
Cpar14 ib.t0 vss 6.94079e-15
Cpar15 ib.t1 vss 9.57359e-16
Cpar16 inn inp 5.16800e-17
Cpar17 inn vdd 1.10700e-17
Cpar18 inn vss 8.64863e-15
Cpar19 inn.t0 vss 1.57174e-15
Cpar20 inp out 1.50700e-17
Cpar21 inp vdd 1.23350e-16
Cpar22 inp vss 8.46557e-15
Cpar23 inp.t0 vss 1.70459e-15
Cpar24 out vdd 1.80454e-14
Cpar25 out vss 1.92177e-14
Cpar26 out.t0 vss 1.01349e-14
Cpar27 out.t12 vss 9.66514e-15
Cpar28 out.t2 vss 1.54897e-14
Cpar29 vdd vss 6.67857e-14
Cpar30 vdd.t0 vss 2.29037e-14
Cpar31 vdd.t1 vss 1.33311e-14
.ends opamp_dut

Vdd vdd 0 1.800000
Vss vss 0 0
Ibias vdd ib 8.214000e-07
Vinp inp 0 DC 0.895000 AC 1 PWL(0 0.895000 1.162976e-08 0.895000 1.279273e-08 0.905000)
Rfb out inn 1m
Cload out 0 2.000000e-13
Xdut vdd vss inp inn out ib opamp_dut
.end
