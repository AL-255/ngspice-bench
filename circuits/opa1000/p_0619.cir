* opa1000[0619]: 200f/pmos_miller_3v3_i20u_weak (pmos_miller, VDD=3.3V, CL=0.2pF, Iref=3.25uA)
.include "pdk_opa.inc"
.temp 27
.option gmin=1e-12 rshunt=1e12 reltol=1e-3 abstol=1e-12 vntol=1e-5 method=gear
* Post-PEX R+C extracted netlist for pmos_miller_3v3_i20u_weak
.subckt opamp_dut vdd vss inp inn out ib
XMpar0 a_3578_10252.t0 inp.t0 a_980_4766.t1 vdd.t10 pfet_03v3 w=1.88u l=0.54u ad=6.4672e-13 pd=2.9440e-06 as=5.2640e-13 ps=2.4400e-06 nf=1 m=10 par=10
XMpar1 a_3578_10252.t10 a_5187_6554.t0 vdd.t1 vdd.t0 pfet_03v3 w=7.09u l=1.2u ad=1.9852e-12 pd=7.6500e-06 as=1.9852e-12 ps=7.6500e-06 nf=1 m=4 par=4
XMpar2 out.t0 a_5187_6554.t0 vdd.t1 vdd.t0 pfet_03v3 w=7.09u l=1.2u ad=2.4390e-12 pd=9.1960e-06 as=1.9852e-12 ps=7.6500e-06 nf=1 m=10 par=10
XMpar3 out.t2 a_980_4766.t13 vss.t2 vss.t1 nfet_03v3 w=2.12u l=0.9u ad=7.2928e-13 pd=3.2320e-06 as=7.2928e-13 ps=3.2320e-06 nf=1 m=10 par=10
XMpar4 a_3578_10252.t0 inn.t0 a_5612_1041.t0 vdd.t10 pfet_03v3 w=1.88u l=0.54u ad=6.4672e-13 pd=2.9440e-06 as=5.2640e-13 ps=2.4400e-06 nf=1 m=10 par=10
XMpar5 a_5187_6554.t1 a_5187_6554.t0 vdd.t1 vdd.t0 pfet_03v3 w=7.09u l=1.2u ad=1.9852e-12 pd=7.6500e-06 as=1.9852e-12 ps=7.6500e-06 nf=1 m=2 par=2
XMpar6 ib.t1 ib.t0 vss.t23 vss.t22 nfet_03v3 w=1.61u l=1.2u ad=9.6600e-13 pd=4.4200e-06 as=4.5080e-13 ps=2.1700e-06 nf=1 m=2 par=2
XMpar7 a_5612_1041.t11 a_5612_1041.t10 vss.t2 vss.t1 nfet_03v3 w=2.12u l=0.9u ad=5.9360e-13 pd=2.6800e-06 as=5.9360e-13 ps=2.6800e-06 nf=1 m=2 par=2
XMpar8 a_980_4766.t11 a_5612_1041.t10 vss.t2 vss.t1 nfet_03v3 w=2.12u l=0.9u ad=1.2720e-12 pd=5.4400e-06 as=5.9360e-13 ps=2.6800e-06 nf=1 m=2 par=2
XMpar9 a_5187_6554.t4 ib.t0 vss.t23 vss.t22 nfet_03v3 w=1.61u l=1.2u ad=4.5080e-13 pd=2.1700e-06 as=4.5080e-13 ps=2.1700e-06 nf=1 m=2 par=2
X42 a_980_4766.t0 a_2650_4766.t0 vss.t0 ppolyf_u_1k r_width=1u r_length=7.69u
X53 a_2650_4766.t1 out.t7 cap_mim_2f0fF c_width=11.46u c_length=11.46u
Rpar0 a_2650_4766.t0 a_2650_4766.t1 59.8341
Rpar1 a_3578_10252.t0 a_3578_10252.t10 46.5732
Rpar2 a_5187_6554.t0 a_5187_6554.t1 23.9184
Rpar3 a_5187_6554.t0 a_5187_6554.t4 231.4305
Rpar4 a_5187_6554.t1 a_5187_6554.t4 87.9309
Rpar5 a_5612_1041.t0 a_5612_1041.t10 213.6848
Rpar6 a_5612_1041.t0 a_5612_1041.t11 100.2246
Rpar7 a_5612_1041.t10 a_5612_1041.t11 26.0508
Rpar8 a_980_4766.t0 a_980_4766.t1 217.3590
Rpar9 a_980_4766.t0 a_980_4766.t11 156.2209
Rpar10 a_980_4766.t0 a_980_4766.t13 147.1323
Rpar11 a_980_4766.t1 a_980_4766.t11 447.2497
Rpar12 a_980_4766.t1 a_980_4766.t13 421.2294
Rpar13 a_980_4766.t11 a_980_4766.t13 58.7390
Rpar14 ib ib.t0 17.4474
Rpar15 ib ib.t1 5.0734
Rpar16 ib.t0 ib.t1 126.7421
Rpar17 inn inn.t0 3.8746
Rpar18 inp inp.t0 3.9232
Rpar19 out out.t0 63.6158
Rpar20 out out.t2 45.9351
Rpar21 out out.t7 20.1327
Rpar22 out.t0 out.t2 123.0687
Rpar23 out.t0 out.t7 982.5696
Rpar24 out.t2 out.t7 709.4848
Rpar25 vdd vdd.t0 127.0907
Rpar26 vdd vdd.t1 852.6997
Rpar27 vdd vdd.t10 22.9215
Rpar28 vdd.t0 vdd.t1 4.8815
Rpar29 vdd.t0 vdd.t10 55.6289
Rpar30 vdd.t1 vdd.t10 373.2355
Rpar31 vss vss.t0 999.9687
Rpar32 vss vss.t1 73.7594
Rpar33 vss vss.t2 55.7264
Rpar34 vss vss.t22 78.2177
Rpar35 vss vss.t23 217.1054
Rpar36 vss.t0 vss.t1 26.2065
Rpar37 vss.t0 vss.t2 98.8271
Rpar38 vss.t0 vss.t22 1020.1873
Rpar39 vss.t0 vss.t23 1936.8388
Rpar40 vss.t1 vss.t2 9.2386
Rpar41 vss.t1 vss.t22 6.0805
Rpar42 vss.t1 vss.t23 29.5376
Rpar43 vss.t2 vss.t22 14.1713
Rpar44 vss.t2 vss.t23 46.9043
Rpar45 vss.t22 vss.t23 15.0964
Cpar0 a_2650_4766.t0 vss 1.17870e-16
Cpar1 a_2650_4766.t1 vss 2.20524e-15
Cpar2 a_3578_10252.t0 vss 1.40290e-14
Cpar3 a_3578_10252.t10 vss 1.02760e-14
Cpar4 a_5187_6554.t0 vss 2.41566e-14
Cpar5 a_5187_6554.t1 vss 5.43536e-15
Cpar6 a_5187_6554.t4 vss 2.81572e-15
Cpar7 a_5612_1041.t0 vss 6.06674e-15
Cpar8 a_5612_1041.t10 vss 2.99445e-15
Cpar9 a_5612_1041.t11 vss 2.73304e-15
Cpar10 a_980_4766.t0 vss 2.75159e-15
Cpar11 a_980_4766.t1 vss 6.54725e-15
Cpar12 a_980_4766.t11 vss 2.93901e-15
Cpar13 a_980_4766.t13 vss 7.19878e-15
Cpar14 ib vss 6.51573e-15
Cpar15 ib.t0 vss 7.43691e-16
Cpar16 ib.t1 vss 1.17205e-16
Cpar17 inn inp 5.14600e-17
Cpar18 inn vdd 4.69263e-15
Cpar19 inn vss 3.51391e-15
Cpar20 inn.t0 vss 3.18040e-15
Cpar21 inp vdd 4.62489e-15
Cpar22 inp vss 3.47451e-15
Cpar23 inp.t0 vss 3.21755e-15
Cpar24 out vdd 1.07445e-14
Cpar25 out vss 1.63627e-14
Cpar26 out.t0 vss 1.04282e-14
Cpar27 out.t2 vss 5.13213e-15
Cpar28 out.t7 vss 5.64274e-15
Cpar29 vdd vss 9.62272e-14
Cpar30 vdd.t0 vss 2.73024e-14
Cpar31 vdd.t1 vss 9.03221e-15
Cpar32 vdd.t10 vss 1.43688e-14
.ends opamp_dut

Vdd vdd 0 3.300000
Vss vss 0 0
Ibias vdd ib 3.250000e-06
Vinp inp 0 DC 1.480000 AC 1 PWL(0 1.480000 3.000000e-09 1.480000 3.300000e-09 1.490000)
Rfb out inn 1m
Cload out 0 2.000000e-13
Xdut vdd vss inp inn out ib opamp_dut
.end
