* opa1000[0929]: 200f/telescopic_pmos_1v8_1u_10u_subth (telescopic_pmos, VDD=1.8V, CL=0.2pF, Iref=1.3uA)
.include "pdk_opa.inc"
.temp 27
.option gmin=1e-12 rshunt=1e12 reltol=1e-3 abstol=1e-12 vntol=1e-5 method=gear
* Post-PEX R+C extracted netlist for telescopic_pmos_1v8_1u_10u_subth
.subckt opamp_dut vdd vss inp inn out ib
XMpar0 a_14070_22441.t0 inn.t0 a_1439_20840.t3 vdd.t11 pfet_03v3 w=4.47u l=0.8u ad=1.2963e-12 pd=5.1897e-06 as=1.3410e-12 ps=5.3494e-06 nf=1 m=64 par=64
XMpar1 a_1439_20840.t3 inp.t0 a_7914_20841.t0 vdd.t11 pfet_03v3 w=4.47u l=0.8u ad=1.3410e-12 pd=5.3494e-06 as=1.2963e-12 ps=5.1897e-06 nf=1 m=64 par=64
XMpar2 a_6256_11024.t0 a_6376_10816.t0 a_6376_10816.t1 vss.t0 nfet_03v3 w=1.91u l=1.6u ad=9.0152e-13 pd=4.0000e-06 as=9.0152e-13 ps=4.0000e-06 nf=1 m=20 par=20
XMpar3 a_7768_11024.t4 a_6376_10816.t124 vss.t20 vss.t0 nfet_03v3 w=1.75u l=3.2u ad=4.9000e-13 pd=2.3100e-06 as=4.9000e-13 ps=2.3100e-06 nf=1 m=10 par=10
XMpar4 a_6376_10816.t40 vss.t60 a_7914_20841.t64 vdd.t0 pfet_03v3 w=3.82u l=1.6u ad=1.1460e-12 pd=4.6587e-06 as=1.1842e-12 ps=4.7981e-06 nf=1 m=64 par=64
XMpar5 a_14070_22441.t64 vss.t60 out.t0 vdd.t0 pfet_03v3 w=3.82u l=1.6u ad=1.1842e-12 pd=4.7981e-06 as=1.1460e-12 ps=4.6587e-06 nf=1 m=64 par=64
XMpar6 a_6256_11024.t10 a_6376_10816.t124 vss.t20 vss.t0 nfet_03v3 w=1.75u l=3.2u ad=6.0200e-13 pd=2.7880e-06 as=4.9000e-13 ps=2.3100e-06 nf=1 m=10 par=10
XMpar7 a_7768_11024.t0 a_6376_10816.t0 out.t2 vss.t0 nfet_03v3 w=1.91u l=1.6u ad=9.0152e-13 pd=4.0000e-06 as=9.0152e-13 ps=4.0000e-06 nf=1 m=20 par=20
XMpar8 a_1119_20632.t0 ib.t0 vss.t12 vss.t11 nfet_03v3 w=2.8u l=1.6u ad=7.8400e-13 pd=3.3600e-06 as=7.8400e-13 ps=3.3600e-06 nf=1 m=2 par=2
XMpar9 a_1439_20840.t0 a_1119_20632.t2 vdd.t2 vdd.t1 pfet_03v3 w=10u l=1.6u ad=2.8000e-12 pd=1.0560e-05 as=3.6000e-12 ps=1.3220e-05 nf=1 m=8 par=8
XMpar10 ib.t1 ib.t0 vss.t12 vss.t11 nfet_03v3 w=2.8u l=1.6u ad=1.6800e-12 pd=6.8000e-06 as=7.8400e-13 ps=3.3600e-06 nf=1 m=2 par=2
XMpar11 a_1119_20632.t3 a_1119_20632.t2 vdd.t2 vdd.t1 pfet_03v3 w=10u l=1.6u ad=2.8000e-12 pd=1.0560e-05 as=2.8000e-12 ps=1.0560e-05 nf=1 m=2 par=2
X89 out.t84 vss.t2 cap_mim_2f0fF c_width=19.63u c_length=19.62u
X114 out.t84 vss.t2 cap_mim_2f0fF c_width=19.63u c_length=19.62u
X290 out.t84 vss.t2 cap_mim_2f0fF c_width=19.63u c_length=19.62u
X327 out.t84 vss.t2 cap_mim_2f0fF c_width=19.63u c_length=19.62u
Rpar0 a_1119_20632.t0 a_1119_20632.t2 118.2353
Rpar1 a_1119_20632.t0 a_1119_20632.t3 66.3353
Rpar2 a_1119_20632.t2 a_1119_20632.t3 26.2824
Rpar3 a_14070_22441.t0 a_14070_22441.t64 48.4032
Rpar4 a_1439_20840.t0 a_1439_20840.t3 42.4759
Rpar5 a_6256_11024.t0 a_6256_11024.t10 52.0933
Rpar6 a_6376_10816.t0 a_6376_10816.t1 4.3554
Rpar7 a_6376_10816.t0 a_6376_10816.t40 900.9548
Rpar8 a_6376_10816.t0 a_6376_10816.t124 244.8799
Rpar9 a_6376_10816.t1 a_6376_10816.t40 274.9795
Rpar10 a_6376_10816.t1 a_6376_10816.t124 74.7395
Rpar11 a_6376_10816.t40 a_6376_10816.t124 56.6789
Rpar12 a_7768_11024.t0 a_7768_11024.t4 62.4646
Rpar13 a_7914_20841.t0 a_7914_20841.t64 48.4032
Rpar14 ib ib.t0 18.7334
Rpar15 ib ib.t1 4.1423
Rpar16 ib.t0 ib.t1 87.5581
Rpar17 inn inn.t0 1.8756
Rpar18 inp inp.t0 1.8756
Rpar19 out out.t0 181.7731
Rpar20 out out.t2 87.9327
Rpar21 out out.t84 18.4448
Rpar22 out.t0 out.t2 272.7721
Rpar23 out.t0 out.t84 702.0845
Rpar24 out.t2 out.t84 339.6330
Rpar25 vdd vdd.t0 117.3233
Rpar26 vdd vdd.t1 93.8677
Rpar27 vdd vdd.t11 32.5091
Rpar28 vdd vdd.t2 372.6815
Rpar29 vdd.t0 vdd.t1 81.2905
Rpar30 vdd.t0 vdd.t11 338.7374
Rpar31 vdd.t0 vdd.t2 322.7464
Rpar32 vdd.t1 vdd.t11 271.0162
Rpar33 vdd.t1 vdd.t2 5.7540
Rpar34 vdd.t11 vdd.t2 1076.0115
Rpar35 vss vss.t0 87.6426
Rpar36 vss vss.t60 326.0381
Rpar37 vss vss.t11 223.6226
Rpar38 vss vss.t12 516.7952
Rpar39 vss vss.t2 130.3473
Rpar40 vss vss.t20 2669.5366
Rpar41 vss.t0 vss.t60 129.1041
Rpar42 vss.t0 vss.t11 94.0573
Rpar43 vss.t0 vss.t12 217.4309
Rpar44 vss.t0 vss.t2 107.4632
Rpar45 vss.t0 vss.t20 4.7614
Rpar46 vss.t60 vss.t11 134.8527
Rpar47 vss.t60 vss.t12 311.6464
Rpar48 vss.t60 vss.t2 1225.5885
Rpar49 vss.t60 vss.t20 2671.6136
Rpar50 vss.t11 vss.t12 8.3182
Rpar51 vss.t11 vss.t2 840.9449
Rpar52 vss.t12 vss.t2 1943.4396
Rpar53 vss.t2 vss.t20 3976.4568
Cpar0 a_1119_20632.t0 vss 2.62627e-15
Cpar1 a_1119_20632.t2 vss 1.88086e-14
Cpar2 a_1119_20632.t3 vss 4.26319e-15
Cpar3 a_14070_22441.t0 vss 5.38618e-14
Cpar4 a_14070_22441.t64 vss 5.36105e-14
Cpar5 a_1439_20840.t0 vss 1.55406e-14
Cpar6 a_1439_20840.t3 vss 1.18240e-13
Cpar7 a_6256_11024.t0 vss 2.61045e-14
Cpar8 a_6256_11024.t10 vss 1.11128e-14
Cpar9 a_6376_10816.t0 vss 2.61178e-14
Cpar10 a_6376_10816.t1 vss 1.49529e-14
Cpar11 a_6376_10816.t124 vss 2.40654e-14
Cpar12 a_6376_10816.t40 vss 3.09707e-14
Cpar13 a_7768_11024.t0 vss 3.52153e-14
Cpar14 a_7768_11024.t4 vss 1.27160e-14
Cpar15 a_7914_20841.t0 vss 5.50175e-14
Cpar16 a_7914_20841.t64 vss 5.47605e-14
Cpar17 ib out 5.42900e-17
Cpar18 ib vss 8.21570e-15
Cpar19 ib.t0 vss 8.51992e-16
Cpar20 ib.t1 vss 2.57336e-16
Cpar21 inn inp 9.76300e-17
Cpar22 inn out 1.26100e-17
Cpar23 inn vdd 2.99803e-14
Cpar24 inn vss 7.59111e-15
Cpar25 inn.t0 vss 5.11559e-14
Cpar26 inp vdd 3.03769e-14
Cpar27 inp vss 7.62619e-15
Cpar28 inp.t0 vss 5.14897e-14
Cpar29 out vdd 1.03959e-14
Cpar30 out vss 8.35018e-14
Cpar31 out.t0 vss 6.93759e-15
Cpar32 out.t2 vss 3.50014e-15
Cpar33 out.t84 vss 6.36808e-14
Cpar34 vdd vss 7.13490e-13
Cpar35 vdd.t0 vss 7.25735e-14
Cpar36 vdd.t1 vss 1.11804e-14
Cpar37 vdd.t11 vss 5.21373e-14
Cpar38 vdd.t2 vss 4.63268e-15
.ends opamp_dut

Vdd vdd 0 1.800000
Vss vss 0 0
Ibias vdd ib 1.300000e-06
Vinp inp 0 DC 0.805000 AC 1 PWL(0 0.805000 4.010444e-08 0.805000 4.411489e-08 0.815000)
Rfb out inn 1m
Cload out 0 2.000000e-13
Xdut vdd vss inp inn out ib opamp_dut
.end
