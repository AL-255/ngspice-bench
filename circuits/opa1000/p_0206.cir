* opa1000[0206]: 200f/folded_cascode_nmos_3v3_i500u_subth (folded_cascode_nmos, VDD=3.3V, CL=0.2pF, Iref=127.7778uA)
.include "pdk_opa.inc"
.temp 27
.option gmin=1e-12 rshunt=1e12 reltol=1e-3 abstol=1e-12 vntol=1e-5 method=gear
* Post-PEX R+C extracted netlist for folded_cascode_nmos_3v3_i500u_subth
.subckt opamp_dut vdd vss inp inn out ib
XMpar0 a_1608_4521.t0 inp.t0 a_8350_20001.t0 vss.t0 nfet_03v3 w=8.01u l=0.3u ad=2.3069e-12 pd=8.7862e-06 as=2.2748e-12 ps=8.6781e-06 nf=1 m=160 par=160
XMpar1 a_952_13141.t17 a_952_13141.t16 vdd.t1 vdd.t0 pfet_03v3 w=10u l=0.5u ad=2.8000e-12 pd=1.0560e-05 as=3.2000e-12 ps=1.1890e-05 nf=1 m=16 par=16
XMpar2 a_10368_1249.t32 ib.t32 a_8350_20001.t160 vdd.t136 pfet_03v3 w=7.69u l=0.28u ad=3.3067e-12 pd=8.5500e-06 as=3.4605e-12 ps=9.0706e-06 nf=1 m=160 par=160
XMpar3 a_17774_1249.t160 ib.t32 out.t6 vdd.t136 pfet_03v3 w=7.69u l=0.28u ad=3.4605e-12 pd=9.0706e-06 as=3.3067e-12 ps=8.5500e-06 nf=1 m=160 par=160
XMpar4 a_1608_4521.t0 inn.t0 a_17774_1249.t0 vss.t0 nfet_03v3 w=8.01u l=0.3u ad=2.3069e-12 pd=8.7862e-06 as=2.2748e-12 ps=8.6781e-06 nf=1 m=160 par=160
XMpar5 a_8350_20001.t320 a_952_13141.t16 vdd.t1 vdd.t0 pfet_03v3 w=10u l=0.5u ad=2.8000e-12 pd=1.0560e-05 as=3.0000e-12 ps=1.1225e-05 nf=1 m=32 par=32
XMpar6 out.t0 a_10368_1249.t0 vss.t1 vss.t0 nfet_03v3 w=9.97u l=0.56u ad=2.7916e-12 pd=1.0530e-05 as=2.7916e-12 ps=1.0530e-05 nf=1 m=16 par=16
XMpar7 a_952_13141.t0 ib.t0 vss.t1 vss.t0 nfet_03v3 w=9.97u l=0.56u ad=2.7916e-12 pd=1.0530e-05 as=3.1904e-12 ps=1.1856e-05 nf=1 m=16 par=16
XMpar8 a_1608_4521.t320 ib.t0 vss.t1 vss.t0 nfet_03v3 w=9.97u l=0.56u ad=3.3898e-12 pd=1.2519e-05 as=3.3898e-12 ps=1.2519e-05 nf=1 m=32 par=32
XMpar9 ib.t1 ib.t0 vss.t1 vss.t0 nfet_03v3 w=9.97u l=0.56u ad=3.9880e-12 pd=1.4509e-05 as=3.1904e-12 ps=1.1856e-05 nf=1 m=16 par=16
XMpar10 a_10368_1249.t1 a_10368_1249.t0 vss.t1 vss.t0 nfet_03v3 w=9.97u l=0.56u ad=2.7916e-12 pd=1.0530e-05 as=3.1904e-12 ps=1.1856e-05 nf=1 m=16 par=16
XMpar11 a_17774_1249.t320 a_952_13141.t16 vdd.t1 vdd.t0 pfet_03v3 w=10u l=0.5u ad=2.8000e-12 pd=1.0560e-05 as=3.0000e-12 ps=1.1225e-05 nf=1 m=32 par=32
X96 out.t176 vss.t2 cap_mim_2f0fF c_width=17.5u c_length=17.5u
X229 out.t176 vss.t2 cap_mim_2f0fF c_width=17.5u c_length=17.5u
X557 out.t176 vss.t2 cap_mim_2f0fF c_width=17.5u c_length=17.5u
X685 out.t176 vss.t2 cap_mim_2f0fF c_width=17.5u c_length=17.5u
Rpar0 a_10368_1249.t0 a_10368_1249.t1 17.5769
Rpar1 a_10368_1249.t0 a_10368_1249.t32 370.9033
Rpar2 a_10368_1249.t1 a_10368_1249.t32 64.2610
Rpar3 a_1608_4521.t0 a_1608_4521.t320 74.5797
Rpar4 a_17774_1249.t0 a_17774_1249.t160 214.0533
Rpar5 a_17774_1249.t0 a_17774_1249.t320 62.0954
Rpar6 a_17774_1249.t160 a_17774_1249.t320 59.6472
Rpar7 a_8350_20001.t0 a_8350_20001.t160 214.0533
Rpar8 a_8350_20001.t0 a_8350_20001.t320 62.0954
Rpar9 a_8350_20001.t160 a_8350_20001.t320 59.6472
Rpar10 a_952_13141.t0 a_952_13141.t16 58.7315
Rpar11 a_952_13141.t0 a_952_13141.t17 189.3292
Rpar12 a_952_13141.t16 a_952_13141.t17 19.1570
Rpar13 ib ib.t0 36.8885
Rpar14 ib ib.t1 2.8316
Rpar15 ib ib.t32 346.4934
Rpar16 ib.t0 ib.t1 7.9136
Rpar17 ib.t0 ib.t32 143.6361
Rpar18 ib.t1 ib.t32 66.9824
Rpar19 inn inn.t0 2.4499
Rpar20 inp inp.t0 2.4499
Rpar21 out out.t0 348.3881
Rpar22 out out.t6 48.5752
Rpar23 out out.t176 18.3071
Rpar24 out.t0 out.t6 353.9929
Rpar25 out.t0 out.t176 1501.4478
Rpar26 out.t6 out.t176 209.3443
Rpar27 vdd vdd.t0 97.5029
Rpar28 vdd vdd.t1 1405.3206
Rpar29 vdd vdd.t136 976.2560
Rpar30 vdd.t0 vdd.t1 2.3628
Rpar31 vdd.t0 vdd.t136 47.9430
Rpar32 vdd.t1 vdd.t136 544.1752
Rpar33 vss vss.t0 89.9225
Rpar34 vss vss.t1 65.3394
Rpar35 vss vss.t2 85.6643
Rpar36 vss.t0 vss.t1 1.9149
Rpar37 vss.t0 vss.t2 179.4390
Rpar38 vss.t1 vss.t2 500.3001
Cpar0 a_10368_1249.t0 vss 3.41209e-14
Cpar1 a_10368_1249.t1 vss 2.75043e-14
Cpar2 a_10368_1249.t32 vss 2.00775e-13
Cpar3 a_1608_4521.t0 vss 5.79081e-13
Cpar4 a_1608_4521.t320 vss 1.02404e-13
Cpar5 a_17774_1249.t0 vss 2.60078e-13
Cpar6 a_17774_1249.t160 vss 3.07651e-13
Cpar7 a_17774_1249.t320 vss 6.90145e-14
Cpar8 a_8350_20001.t0 vss 2.63012e-13
Cpar9 a_8350_20001.t160 vss 3.11120e-13
Cpar10 a_8350_20001.t320 vss 6.97927e-14
Cpar11 a_952_13141.t0 vss 2.53348e-14
Cpar12 a_952_13141.t16 vss 6.25335e-14
Cpar13 a_952_13141.t17 vss 2.55443e-14
Cpar14 ib out 3.45600e-14
Cpar15 ib vdd 1.13760e-13
Cpar16 ib vss 1.07614e-13
Cpar17 ib.t0 vss 5.68426e-14
Cpar18 ib.t1 vss 3.39954e-14
Cpar19 ib.t32 vss 1.55521e-13
Cpar20 inn inp 1.09050e-16
Cpar21 inn vdd 6.30600e-17
Cpar22 inn vss 5.64335e-14
Cpar23 inn.t0 vss 4.39087e-14
Cpar24 inp out 3.30800e-17
Cpar25 inp vdd 2.91710e-16
Cpar26 inp vss 5.61400e-14
Cpar27 inp.t0 vss 4.40622e-14
Cpar28 out vdd 1.84038e-14
Cpar29 out vss 7.57114e-14
Cpar30 out.t0 vss 1.31886e-14
Cpar31 out.t176 vss 1.60505e-13
Cpar32 out.t6 vss 8.66643e-14
Cpar33 vdd vss 8.15693e-13
Cpar34 vdd.t0 vss 8.11738e-14
Cpar35 vdd.t1 vss 3.76487e-14
Cpar36 vdd.t136 vss 2.46420e-13
.ends opamp_dut

Vdd vdd 0 3.300000
Vss vss 0 0
Ibias vdd ib 1.277778e-04
Vinp inp 0 DC 1.810000 AC 1 PWL(0 1.810000 3.000000e-09 1.810000 3.300000e-09 1.820000)
Rfb out inn 1m
Cload out 0 2.000000e-13
Xdut vdd vss inp inn out ib opamp_dut
.end
