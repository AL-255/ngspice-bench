* opa1000[0458]: 2p/nmos_miller_1v8_ulp_lt0p1uw_subth (nmos_miller, VDD=1.8V, CL=2.0pF, Iref=0.0022uA)
.include "pdk_opa.inc"
.temp 27
.option gmin=1e-12 rshunt=1e12 reltol=1e-3 abstol=1e-12 vntol=1e-5 method=gear
* Post-PEX R+C extracted netlist for nmos_miller_1v8_ulp_lt0p1uw_subth
.subckt opamp_dut vdd vss inp inn out ib
XMpar0 out.t6 ib.t0 vss.t5 vss.t4 nfet_03v3 w=0.4u l=9.5u ad=1.8880e-13 pd=1.5840e-06 as=1.6320e-13 ps=1.3760e-06 nf=1 m=10 par=10
XMpar1 out.t0 a_1121_12539.t5 vdd.t1 vdd.t0 pfet_03v3 w=2.29u l=9.5u ad=7.8776e-13 pd=3.4360e-06 as=7.8776e-13 ps=3.4360e-06 nf=1 m=10 par=10
XMpar2 a_5966_1294.t2 ib.t0 vss.t5 vss.t4 nfet_03v3 w=0.4u l=9.5u ad=2.4000e-13 pd=2.0000e-06 as=1.1200e-13 ps=9.6000e-07 nf=1 m=4 par=4
XMpar3 ib.t1 ib.t0 vss.t5 vss.t4 nfet_03v3 w=0.4u l=9.5u ad=2.4000e-13 pd=2.0000e-06 as=1.1200e-13 ps=9.6000e-07 nf=1 m=2 par=2
XMpar4 a_5966_1294.t0 inn.t0 a_6492_6886.t0 vss.t3 nfet_03v3 w=0.5u l=9.5u ad=3.0000e-13 pd=2.2000e-06 as=3.0000e-13 ps=2.2000e-06 nf=1 m=2 par=2
XMpar5 a_6492_6886.t3 a_6492_6886.t2 vdd.t1 vdd.t0 pfet_03v3 w=2.29u l=9.5u ad=6.4120e-13 pd=2.8500e-06 as=6.4120e-13 ps=2.8500e-06 nf=1 m=2 par=2
XMpar6 a_1121_12539.t2 a_6492_6886.t2 vdd.t1 vdd.t0 pfet_03v3 w=2.29u l=9.5u ad=1.3740e-12 pd=5.7800e-06 as=6.4120e-13 ps=2.8500e-06 nf=1 m=2 par=2
XMpar7 a_1121_12539.t0 inp.t0 a_5966_1294.t0 vss.t3 nfet_03v3 w=0.5u l=9.5u ad=3.0000e-13 pd=2.2000e-06 as=3.0000e-13 ps=2.2000e-06 nf=1 m=2 par=2
X0 a_1121_15139.t0 a_5099_15659.t0 vss.t0 ppolyf_u_1k r_width=1u r_length=19.23u
X2 a_1121_12539.t4 a_5099_12539.t0 vss.t0 ppolyf_u_1k r_width=1u r_length=19.23u
X4 a_5099_18779.t1 out.t18 cap_mim_2f0fF c_width=17.92u c_length=17.91u
X5 a_1121_18259.t0 a_5099_17739.t0 vss.t0 ppolyf_u_1k r_width=1u r_length=19.23u
X9 a_1121_15139.t0 a_5099_14619.t0 vss.t0 ppolyf_u_1k r_width=1u r_length=19.23u
X11 a_1121_17219.t0 a_5099_17739.t0 vss.t0 ppolyf_u_1k r_width=1u r_length=19.23u
X12 a_1121_14099.t0 a_5099_14619.t0 vss.t0 ppolyf_u_1k r_width=1u r_length=19.23u
X17 a_1121_17219.t0 a_5099_16699.t0 vss.t0 ppolyf_u_1k r_width=1u r_length=19.23u
X33 a_1121_14099.t0 a_5099_13579.t0 vss.t0 ppolyf_u_1k r_width=1u r_length=19.23u
X37 a_1121_16179.t0 a_5099_16699.t0 vss.t0 ppolyf_u_1k r_width=1u r_length=19.23u
X38 a_1121_13059.t0 a_5099_13579.t0 vss.t0 ppolyf_u_1k r_width=1u r_length=19.23u
X42 a_1121_16179.t0 a_5099_15659.t0 vss.t0 ppolyf_u_1k r_width=1u r_length=19.23u
X45 a_5099_18779.t1 out.t18 cap_mim_2f0fF c_width=17.92u c_length=17.91u
X46 a_1121_13059.t0 a_5099_12539.t0 vss.t0 ppolyf_u_1k r_width=1u r_length=19.23u
X48 a_5099_18779.t1 out.t18 cap_mim_2f0fF c_width=17.92u c_length=17.91u
X49 a_1121_18259.t0 a_5099_18779.t0 vss.t0 ppolyf_u_1k r_width=1u r_length=19.23u
Rpar0 a_1121_12539.t0 a_1121_12539.t5 256.9778
Rpar1 a_1121_12539.t0 a_1121_12539.t2 86.3412
Rpar2 a_1121_12539.t0 a_1121_12539.t4 444.2770
Rpar3 a_1121_12539.t5 a_1121_12539.t2 167.0335
Rpar4 a_1121_12539.t5 a_1121_12539.t4 859.4871
Rpar5 a_1121_12539.t2 a_1121_12539.t4 265.0250
Rpar6 a_5099_18779.t0 a_5099_18779.t1 58.3683
Rpar7 a_5966_1294.t0 a_5966_1294.t2 59.5087
Rpar8 a_6492_6886.t0 a_6492_6886.t2 224.3387
Rpar9 a_6492_6886.t0 a_6492_6886.t3 100.9820
Rpar10 a_6492_6886.t2 a_6492_6886.t3 25.5072
Rpar11 ib ib.t0 22.9618
Rpar12 ib ib.t1 16.8747
Rpar13 ib.t0 ib.t1 35.3505
Rpar14 inn inn.t0 4.0917
Rpar15 inp inp.t0 4.0915
Rpar16 out out.t0 4.4467
Rpar17 out out.t6 47.0993
Rpar18 out out.t18 107.9836
Rpar19 out.t6 out.t18 402.9055
Rpar20 vdd vdd.t0 123.5960
Rpar21 vdd vdd.t1 67.1865
Rpar22 vdd.t0 vdd.t1 5.6674
Rpar23 vss vss.t0 368.9681
Rpar24 vss vss.t4 74.4401
Rpar25 vss vss.t5 715.5613
Rpar26 vss vss.t3 429.0732
Rpar27 vss.t0 vss.t4 157.3283
Rpar28 vss.t0 vss.t5 1522.0190
Rpar29 vss.t0 vss.t3 914.6056
Rpar30 vss.t4 vss.t5 15.7564
Rpar31 vss.t4 vss.t3 9.4749
Rpar32 vss.t5 vss.t3 92.5307
Cpar0 a_1121_12539.t0 vss 6.08183e-15
Cpar1 a_1121_12539.t2 vss 9.62049e-15
Cpar2 a_1121_12539.t4 vss 7.47652e-15
Cpar3 a_1121_12539.t5 vss 5.42232e-14
Cpar4 a_1121_13059.t0 vss 3.84200e-17
Cpar5 a_1121_14099.t0 vss 3.57600e-17
Cpar6 a_1121_15139.t0 vss 3.57600e-17
Cpar7 a_1121_16179.t0 vss 3.57600e-17
Cpar8 a_1121_17219.t0 vss 3.65000e-17
Cpar9 a_1121_18259.t0 vss 3.63200e-17
Cpar10 a_5099_12539.t0 vss 3.38800e-17
Cpar11 a_5099_13579.t0 vss 3.50800e-17
Cpar12 a_5099_14619.t0 vss 3.43400e-17
Cpar13 a_5099_15659.t0 vss 3.43400e-17
Cpar14 a_5099_16699.t0 vss 3.05800e-17
Cpar15 a_5099_17739.t0 vss 3.38800e-17
Cpar16 a_5099_18779.t0 vss 9.60300e-17
Cpar17 a_5099_18779.t1 vss 8.91048e-15
Cpar18 a_5966_1294.t0 vss 1.33697e-14
Cpar19 a_5966_1294.t2 vss 2.75103e-14
Cpar20 a_6492_6886.t0 vss 4.22610e-15
Cpar21 a_6492_6886.t2 vss 2.50477e-14
Cpar22 a_6492_6886.t3 vss 4.44384e-15
Cpar23 ib inn 1.50200e-17
Cpar24 ib inp 1.50200e-17
Cpar25 ib out 2.41377e-15
Cpar26 ib vss 9.88436e-14
Cpar27 ib.t0 vss 1.49607e-14
Cpar28 ib.t1 vss 1.09583e-15
Cpar29 inn inp 1.03420e-16
Cpar30 inn vdd 1.01800e-17
Cpar31 inn vss 9.33859e-15
Cpar32 inn.t0 vss 1.48687e-15
Cpar33 inp vdd 1.01800e-17
Cpar34 inp vss 9.28806e-15
Cpar35 inp.t0 vss 1.47961e-15
Cpar36 out vdd 2.45903e-14
Cpar37 out vss 4.46443e-14
Cpar38 out.t0 vss 7.34459e-15
Cpar39 out.t18 vss 3.13454e-14
Cpar40 out.t6 vss 1.39803e-14
Cpar41 vdd vss 1.83290e-13
Cpar42 vdd.t0 vss 7.08910e-14
Cpar43 vdd.t1 vss 2.16257e-14
.ends opamp_dut

Vdd vdd 0 1.800000
Vss vss 0 0
Ibias vdd ib 2.200000e-09
Vinp inp 0 DC 0.895000 AC 1 PWL(0 0.895000 2.399743e-05 0.895000 2.639717e-05 0.905000)
Rfb out inn 1m
Cload out 0 2.000000e-12
Xdut vdd vss inp inn out ib opamp_dut
.end
