* opa1000[0687]: 200f/rail_to_rail_1v8_i500u_weak (rail_to_rail, VDD=1.8V, CL=0.2pF, Iref=71.875uA)
.include "pdk_opa.inc"
.temp 27
.option gmin=1e-12 rshunt=1e12 reltol=1e-3 abstol=1e-12 vntol=1e-5 method=gear
* Post-PEX R+C extracted netlist for rail_to_rail_1v8_i500u_weak
.subckt opamp_dut vdd vss inp inn out ib
XMpar0 out a_1014_1290.t45 vdd.t1 vdd.t0 pfet_03v3 w=5.96u l=0.35u ad=1.6688e-12 pd=6.5200e-06 as=1.7880e-12 ps=6.9325e-06 nf=1 m=64 par=64
XMpar1 a_3352_1295.t35 a_3352_1295.t34 vss.t1 vss.t0 nfet_03v3 w=0.57u l=0.4u ad=1.5960e-13 pd=1.1300e-06 as=1.8240e-13 ps=1.2812e-06 nf=1 m=16 par=16
XMpar2 a_1765_8312.t0 ib.t0 vss.t41 vss.t0 nfet_03v3 w=1.37u l=0.35u ad=3.8360e-13 pd=1.9300e-06 as=4.9320e-13 ps=2.4325e-06 nf=1 m=16 par=16
XMpar3 a_10270_8059.t32 inn.t0 a_3146_1295.t0 vdd.t16 pfet_03v3 w=2.03u l=0.28u ad=8.7290e-13 pd=2.8900e-06 as=9.1111e-13 ps=3.0471e-06 nf=1 m=34 par=34
XMpar4 out.t2 ib.t0 vss.t41 vss.t0 nfet_03v3 w=1.37u l=0.35u ad=4.1100e-13 pd=2.0556e-06 as=3.8360e-13 ps=1.9300e-06 nf=1 m=64 par=64
XMpar5 a_1961_3211.t12 ib.t0 vss.t41 vss.t0 nfet_03v3 w=1.37u l=0.35u ad=6.0280e-13 pd=2.9350e-06 as=3.8360e-13 ps=1.9300e-06 nf=1 m=16 par=16
XMpar6 ib.t1 ib.t0 vss.t41 vss.t0 nfet_03v3 w=1.37u l=0.35u ad=3.8360e-13 pd=1.9300e-06 as=3.8360e-13 ps=1.9300e-06 nf=1 m=16 par=16
XMpar7 a_10270_8059.t1 a_10270_8059.t0 vss.t1 vss.t0 nfet_03v3 w=0.57u l=0.4u ad=1.8240e-13 pd=1.2812e-06 as=1.5960e-13 ps=1.1300e-06 nf=1 m=16 par=16
XMpar8 a_8404_16855.t0 a_3352_1295.t34 vss.t1 vss.t0 nfet_03v3 w=0.57u l=0.4u ad=1.5960e-13 pd=1.1300e-06 as=1.5960e-13 ps=1.1300e-06 nf=1 m=16 par=16
XMpar9 a_1014_1290.t0 a_10270_8059.t0 vss.t1 vss.t0 nfet_03v3 w=0.57u l=0.4u ad=2.0520e-13 pd=1.4325e-06 as=1.5960e-13 ps=1.1300e-06 nf=1 m=16 par=16
XMpar10 a_1961_3211.t0 inn.t34 a_8404_16855.t3 vss.t0 nfet_03v3 w=1.95u l=0.28u ad=1.0465e-12 pd=3.6733e-06 as=8.3850e-13 ps=2.8100e-06 nf=1 m=12 par=12
XMpar11 a_3146_1295.t34 a_1765_8312.t16 vdd.t3 vdd.t2 pfet_03v3 w=4.37u l=0.35u ad=1.2236e-12 pd=4.9300e-06 as=1.3984e-12 ps=5.5562e-06 nf=1 m=16 par=16
XMpar12 a_1014_1290.t16 a_8404_16855.t17 vdd.t1 vdd.t0 pfet_03v3 w=5.96u l=0.35u ad=1.6688e-12 pd=6.5200e-06 as=1.9072e-12 ps=7.3450e-06 nf=1 m=16 par=16
XMpar13 a_8404_16855.t18 a_8404_16855.t17 vdd.t1 vdd.t0 pfet_03v3 w=5.96u l=0.35u ad=1.6688e-12 pd=6.5200e-06 as=1.6688e-12 ps=6.5200e-06 nf=1 m=16 par=16
XMpar14 a_3146_1295.t0 inp.t0 a_3352_1295.t0 vdd.t16 pfet_03v3 w=2.03u l=0.28u ad=9.1111e-13 pd=3.0471e-06 as=8.7290e-13 ps=2.8900e-06 nf=1 m=34 par=34
XMpar15 a_1765_8312.t17 a_1765_8312.t16 vdd.t3 vdd.t2 pfet_03v3 w=4.37u l=0.35u ad=1.2236e-12 pd=4.9300e-06 as=1.2236e-12 ps=4.9300e-06 nf=1 m=16 par=16
XMpar16 a_1014_1290.t26 inp.t34 a_1961_3211.t0 vss.t0 nfet_03v3 w=1.95u l=0.28u ad=8.3850e-13 pd=2.8100e-06 as=1.0465e-12 ps=3.6733e-06 nf=1 m=12 par=12
X220 a_1014_1290.t40 a_1346_1290.t0 vss.t252 ppolyf_u_1k r_width=1u r_length=1u
X221 a_1346_1290.t1 out.t23 cap_mim_2f0fF c_width=19.84u c_length=19.85u
Rpar0 a_1014_1290.t0 a_1014_1290.t45 99.2372
Rpar1 a_1014_1290.t0 a_1014_1290.t16 227.6622
Rpar2 a_1014_1290.t0 a_1014_1290.t26 101.1108
Rpar3 a_1014_1290.t0 a_1014_1290.t40 480.9176
Rpar4 a_1014_1290.t45 a_1014_1290.t16 602.8487
Rpar5 a_1014_1290.t45 a_1014_1290.t26 267.7411
Rpar6 a_1014_1290.t45 a_1014_1290.t40 140.6809
Rpar7 a_1014_1290.t16 a_1014_1290.t26 77.3666
Rpar8 a_1014_1290.t16 a_1014_1290.t40 2921.4903
Rpar9 a_1014_1290.t26 a_1014_1290.t40 1297.5116
Rpar10 a_10270_8059.t0 a_10270_8059.t1 6.1734
Rpar11 a_10270_8059.t0 a_10270_8059.t32 332.2361
Rpar12 a_10270_8059.t1 a_10270_8059.t32 95.9316
Rpar13 a_1346_1290.t0 a_1346_1290.t1 88.0611
Rpar14 a_1765_8312.t0 a_1765_8312.t16 445.6775
Rpar15 a_1765_8312.t0 a_1765_8312.t17 75.0169
Rpar16 a_1765_8312.t16 a_1765_8312.t17 15.7036
Rpar17 a_1961_3211.t0 a_1961_3211.t12 116.8970
Rpar18 a_3146_1295.t0 a_3146_1295.t34 49.3867
Rpar19 a_3352_1295.t0 a_3352_1295.t34 363.1010
Rpar20 a_3352_1295.t0 a_3352_1295.t35 110.7341
Rpar21 a_3352_1295.t34 a_3352_1295.t35 14.6473
Rpar22 a_8404_16855.t0 a_8404_16855.t3 104.5908
Rpar23 a_8404_16855.t0 a_8404_16855.t17 1946.9329
Rpar24 a_8404_16855.t0 a_8404_16855.t18 43.0531
Rpar25 a_8404_16855.t3 a_8404_16855.t17 4206.8285
Rpar26 a_8404_16855.t3 a_8404_16855.t18 93.0268
Rpar27 a_8404_16855.t17 a_8404_16855.t18 16.1876
Rpar28 ib ib.t0 8.8975
Rpar29 ib ib.t1 6.8185
Rpar30 ib.t0 ib.t1 15.5421
Rpar31 inn inn.t0 67.7721
Rpar32 inn inn.t34 6.5584
Rpar33 inp inp.t0 67.7235
Rpar34 inp inp.t34 6.5584
Rpar35 out out.t2 36.7541
Rpar36 out out.t23 150.4557
Rpar37 out.t2 out.t23 165.5880
Rpar38 vdd vdd.t0 58.7537
Rpar39 vdd vdd.t1 269.6105
Rpar40 vdd vdd.t2 1951.6984
Rpar41 vdd vdd.t3 6645.6106
Rpar42 vdd vdd.t16 2325.7905
Rpar43 vdd.t0 vdd.t1 2.1360
Rpar44 vdd.t0 vdd.t2 441.5944
Rpar45 vdd.t0 vdd.t16 412.9461
Rpar46 vdd.t1 vdd.t2 131.9784
Rpar47 vdd.t1 vdd.t3 449.3916
Rpar48 vdd.t1 vdd.t16 54.5392
Rpar49 vdd.t2 vdd.t3 2.4895
Rpar50 vdd.t2 vdd.t16 416.1089
Rpar51 vdd.t3 vdd.t16 1416.8672
Rpar52 vss vss.t0 89.4681
Rpar53 vss vss.t1 979.9424
Rpar54 vss vss.t41 1377.8946
Rpar55 vss vss.t252 218.0190
Rpar56 vss.t0 vss.t1 2.0285
Rpar57 vss.t0 vss.t41 5.1939
Rpar58 vss.t0 vss.t252 137.0669
Rpar59 vss.t1 vss.t41 805.0850
Rpar60 vss.t1 vss.t252 2184.9920
Rpar61 vss.t41 vss.t252 2309.2890
Cpar0 a_1014_1290.t0 vss 1.33183e-14
Cpar1 a_1014_1290.t16 vss 2.06372e-14
Cpar2 a_1014_1290.t26 vss 1.07190e-14
Cpar3 a_1014_1290.t40 vss 5.05490e-15
Cpar4 a_1014_1290.t45 vss 4.75842e-14
Cpar5 a_10270_8059.t0 vss 1.03254e-14
Cpar6 a_10270_8059.t1 vss 9.88113e-15
Cpar7 a_10270_8059.t32 vss 1.78907e-14
Cpar8 a_1346_1290.t0 vss 3.36770e-16
Cpar9 a_1346_1290.t1 vss 9.81498e-15
Cpar10 a_1765_8312.t0 vss 8.49858e-15
Cpar11 a_1765_8312.t16 vss 1.65715e-14
Cpar12 a_1765_8312.t17 vss 1.91210e-14
Cpar13 a_1961_3211.t0 vss 2.02987e-14
Cpar14 a_1961_3211.t12 vss 1.69398e-14
Cpar15 a_3146_1295.t0 vss 4.71602e-14
Cpar16 a_3146_1295.t34 vss 2.24976e-14
Cpar17 a_3352_1295.t0 vss 2.01349e-14
Cpar18 a_3352_1295.t34 vss 9.53201e-15
Cpar19 a_3352_1295.t35 vss 8.52812e-15
Cpar20 a_8404_16855.t0 vss 7.13562e-15
Cpar21 a_8404_16855.t17 vss 2.02204e-14
Cpar22 a_8404_16855.t18 vss 2.29928e-14
Cpar23 a_8404_16855.t3 vss 9.13664e-15
Cpar24 ib inp 9.53650e-16
Cpar25 ib out 1.48455e-14
Cpar26 ib vdd 1.04600e-16
Cpar27 ib vss 7.51139e-14
Cpar28 ib.t0 vss 1.37200e-14
Cpar29 ib.t1 vss 3.67144e-15
Cpar30 inn inp 1.51600e-16
Cpar31 inn out 1.30150e-16
Cpar32 inn vdd 1.66864e-14
Cpar33 inn vss 2.14030e-14
Cpar34 inn.t0 vss 1.84834e-14
Cpar35 inn.t34 vss 2.82361e-15
Cpar36 inp out 1.45380e-15
Cpar37 inp vdd 1.57059e-14
Cpar38 inp vss 2.42266e-14
Cpar39 inp.t0 vss 1.79586e-14
Cpar40 inp.t34 vss 2.74429e-15
Cpar41 out vdd 9.92861e-14
Cpar42 out vss 1.27335e-13
Cpar43 out.t2 vss 2.95287e-14
Cpar44 out.t23 vss 2.36199e-14
Cpar45 vdd vss 3.06700e-13
Cpar46 vdd.t0 vss 1.21591e-13
Cpar47 vdd.t1 vss 5.24919e-14
Cpar48 vdd.t16 vss 7.05167e-14
Cpar49 vdd.t2 vss 3.48200e-14
Cpar50 vdd.t3 vss 1.60342e-14
.ends opamp_dut

Vdd vdd 0 1.800000
Vss vss 0 0
Ibias vdd ib 7.187500e-05
Vinp inp 0 DC 0.895000 AC 1 PWL(0 0.895000 3.000000e-09 0.895000 3.300000e-09 0.905000)
Rfb out inn 1m
Cload out 0 2.000000e-13
Xdut vdd vss inp inn out ib opamp_dut
.end
