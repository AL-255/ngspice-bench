* opa1000[0315]: 2p/folded_cascode_pmos_3v3_i200n_weak (folded_cascode_pmos, VDD=3.3V, CL=2.0pF, Iref=0.0578uA)
.include "pdk_opa.inc"
.temp 27
.option gmin=1e-12 rshunt=1e12 reltol=1e-3 abstol=1e-12 vntol=1e-5 method=gear
* Post-PEX R+C extracted netlist for folded_cascode_pmos_3v3_i200n_weak
.subckt opamp_dut vdd vss inp inn out ib
XMpar0 a_1494_9098.t0 inp.t0 a_2290_7688.t4 vdd.t8 pfet_03v3 w=2.08u l=9.75u ad=1.2480e-12 pd=5.3600e-06 as=9.1520e-13 ps=4.0000e-06 nf=1 m=4 par=4
XMpar1 a_5934_2776.t0 ib.t0 vss.t2 vss.t1 nfet_03v3 w=0.4u l=5u ad=1.1200e-13 pd=9.6000e-07 as=1.7600e-13 ps=1.4800e-06 nf=1 m=4 par=4
XMpar2 a_1726_4158.t0 ib.t0 vss.t2 vss.t1 nfet_03v3 w=0.4u l=5u ad=1.1200e-13 pd=9.6000e-07 as=1.1200e-13 ps=9.6000e-07 nf=1 m=2 par=2
XMpar3 a_1494_9098.t0 inn.t0 a_5934_2776.t4 vdd.t8 pfet_03v3 w=2.08u l=9.75u ad=1.2480e-12 pd=5.3600e-06 as=9.1520e-13 ps=4.0000e-06 nf=1 m=4 par=4
XMpar4 out.t0 a_3612_6117.t0 vdd.t1 vdd.t0 pfet_03v3 w=0.4u l=5.2u ad=1.1200e-13 pd=9.6000e-07 as=1.1200e-13 ps=9.6000e-07 nf=1 m=2 par=2
XMpar5 a_2290_7688.t0 ib.t0 vss.t2 vss.t1 nfet_03v3 w=0.4u l=5u ad=1.1200e-13 pd=9.6000e-07 as=1.7600e-13 ps=1.4800e-06 nf=1 m=4 par=4
XMpar6 a_1494_9098.t8 a_1726_4158.t2 vdd.t1 vdd.t0 pfet_03v3 w=0.4u l=5.2u ad=1.1200e-13 pd=9.6000e-07 as=1.7600e-13 ps=1.4800e-06 nf=1 m=4 par=4
XMpar7 a_1726_4158.t3 a_1726_4158.t2 vdd.t1 vdd.t0 pfet_03v3 w=0.4u l=5.2u ad=1.1200e-13 pd=9.6000e-07 as=1.1200e-13 ps=9.6000e-07 nf=1 m=2 par=2
XMpar8 ib.t1 ib.t0 vss.t2 vss.t1 nfet_03v3 w=0.4u l=5u ad=2.4000e-13 pd=2.0000e-06 as=1.1200e-13 ps=9.6000e-07 nf=1 m=2 par=2
XMpar9 a_3612_6117.t1 a_3612_6117.t0 vdd.t1 vdd.t0 pfet_03v3 w=0.4u l=5.2u ad=2.4000e-13 pd=2.0000e-06 as=1.1200e-13 ps=9.6000e-07 nf=1 m=2 par=2
XMpar10 a_5934_2776.t8 a_1726_4158.t6 out.t1 vss.t0 nfet_03v3 w=0.4u l=4.2u ad=2.4000e-13 pd=2.0000e-06 as=1.1200e-13 ps=9.6000e-07 nf=1 m=2 par=2
XMpar11 a_2290_7688.t8 a_1726_4158.t6 a_3612_6117.t4 vss.t0 nfet_03v3 w=0.4u l=4.2u ad=2.4000e-13 pd=2.0000e-06 as=1.1200e-13 ps=9.6000e-07 nf=1 m=2 par=2
Rpar0 a_1494_9098.t0 a_1494_9098.t8 56.3227
Rpar1 a_1726_4158.t0 a_1726_4158.t2 128.9929
Rpar2 a_1726_4158.t0 a_1726_4158.t3 187.3604
Rpar3 a_1726_4158.t0 a_1726_4158.t6 87.6345
Rpar4 a_1726_4158.t2 a_1726_4158.t3 32.0892
Rpar5 a_1726_4158.t2 a_1726_4158.t6 160.9924
Rpar6 a_1726_4158.t3 a_1726_4158.t6 233.8394
Rpar7 a_2290_7688.t0 a_2290_7688.t4 69.4679
Rpar8 a_2290_7688.t0 a_2290_7688.t8 81.3089
Rpar9 a_2290_7688.t4 a_2290_7688.t8 170.0716
Rpar10 a_3612_6117.t0 a_3612_6117.t1 21.1206
Rpar11 a_3612_6117.t0 a_3612_6117.t4 173.0737
Rpar12 a_3612_6117.t1 a_3612_6117.t4 127.8017
Rpar13 a_5934_2776.t0 a_5934_2776.t4 69.4679
Rpar14 a_5934_2776.t0 a_5934_2776.t8 81.3089
Rpar15 a_5934_2776.t4 a_5934_2776.t8 170.0716
Rpar16 ib ib.t0 9.0114
Rpar17 ib ib.t1 8.6641
Rpar18 inn inn.t0 4.1634
Rpar19 inp inp.t0 4.1640
Rpar20 out out.t0 15.1998
Rpar21 out out.t1 80.4943
Rpar22 out.t0 out.t1 475.1260
Rpar23 vdd vdd.t0 397.9713
Rpar24 vdd vdd.t1 638.3592
Rpar25 vdd vdd.t8 22.0965
Rpar26 vdd.t0 vdd.t1 5.6345
Rpar27 vdd.t0 vdd.t8 193.9525
Rpar28 vdd.t1 vdd.t8 311.1062
Rpar29 vss vss.t0 44.2213
Rpar30 vss vss.t1 57.7797
Rpar31 vss vss.t2 153.9929
Rpar32 vss.t0 vss.t1 5.1716
Rpar33 vss.t0 vss.t2 16.9998
Rpar34 vss.t1 vss.t2 7.0128
Cpar0 a_1494_9098.t0 vss 3.07158e-14
Cpar1 a_1494_9098.t8 vss 7.13723e-15
Cpar2 a_1726_4158.t0 vss 3.53133e-15
Cpar3 a_1726_4158.t2 vss 1.59838e-14
Cpar4 a_1726_4158.t3 vss 2.94802e-15
Cpar5 a_1726_4158.t6 vss 9.63330e-15
Cpar6 a_2290_7688.t0 vss 5.94507e-15
Cpar7 a_2290_7688.t4 vss 1.26763e-14
Cpar8 a_2290_7688.t8 vss 4.62262e-15
Cpar9 a_3612_6117.t0 vss 1.28532e-14
Cpar10 a_3612_6117.t1 vss 4.73525e-15
Cpar11 a_3612_6117.t4 vss 4.42716e-15
Cpar12 a_5934_2776.t0 vss 5.01471e-15
Cpar13 a_5934_2776.t4 vss 1.06926e-14
Cpar14 a_5934_2776.t8 vss 3.89921e-15
Cpar15 ib inn 4.15200e-17
Cpar16 ib inp 4.15700e-17
Cpar17 ib out 1.38000e-17
Cpar18 ib vdd 2.41660e-16
Cpar19 ib vss 3.86806e-14
Cpar20 ib.t0 vss 6.10973e-15
Cpar21 ib.t1 vss 9.60000e-17
Cpar22 inn inp 5.14300e-17
Cpar23 inn vdd 1.65042e-14
Cpar24 inn vss 4.48332e-15
Cpar25 inn.t0 vss 1.89225e-14
Cpar26 inp vdd 1.64633e-14
Cpar27 inp vss 4.47809e-15
Cpar28 inp.t0 vss 1.89007e-14
Cpar29 out vdd 3.36237e-15
Cpar30 out vss 8.64821e-15
Cpar31 out.t0 vss 7.25084e-16
Cpar32 out.t1 vss 2.47007e-15
Cpar33 vdd vss 2.02729e-13
Cpar34 vdd.t0 vss 2.04029e-14
Cpar35 vdd.t1 vss 1.18621e-14
Cpar36 vdd.t8 vss 5.11694e-14
.ends opamp_dut

Vdd vdd 0 3.300000
Vss vss 0 0
Ibias vdd ib 5.780000e-08
Vinp inp 0 DC 1.381000 AC 1 PWL(0 1.381000 1.160818e-06 1.381000 1.276900e-06 1.391000)
Rfb out inn 1m
Cload out 0 2.000000e-12
Xdut vdd vss inp inn out ib opamp_dut
.end
