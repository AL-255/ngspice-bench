* opa1000[0536]: 200f/pmos_5t_3v3_i20u_weak (pmos_5t, VDD=3.3V, CL=0.2pF, Iref=4.0uA)
.include "pdk_opa.inc"
.temp 27
.option gmin=1e-12 rshunt=1e12 reltol=1e-3 abstol=1e-12 vntol=1e-5 method=gear
* Post-PEX R+C extracted netlist for pmos_5t_3v3_i20u_weak
.subckt opamp_dut vdd vss inp inn out ib
XMpar0 a_1954_6653.t0 inn.t0 out.t0 vdd.t4 pfet_03v3 w=1.97u l=0.9u ad=6.2576e-13 pd=2.8371e-06 as=5.8868e-13 ps=2.6835e-06 nf=1 m=34 par=34
XMpar1 a_1954_6653.t68 a_1926_4631.t2 vdd.t1 vdd.t0 pfet_03v3 w=8.72u l=1.2u ad=2.4416e-12 pd=9.2800e-06 as=3.1392e-12 ps=1.1620e-05 nf=1 m=8 par=8
XMpar2 a_1954_6653.t0 inp.t0 a_2254_6653.t8 vdd.t4 pfet_03v3 w=1.97u l=0.9u ad=6.2576e-13 pd=2.8371e-06 as=5.8868e-13 ps=2.6835e-06 nf=1 m=34 par=34
XMpar3 ib.t1 ib.t0 vss.t16 vss.t15 nfet_03v3 w=1.98u l=1.2u ad=1.1880e-12 pd=5.1600e-06 as=5.5440e-13 ps=2.5400e-06 nf=1 m=2 par=2
XMpar4 a_1926_4631.t0 ib.t0 vss.t16 vss.t15 nfet_03v3 w=1.98u l=1.2u ad=5.5440e-13 pd=2.5400e-06 as=5.5440e-13 ps=2.5400e-06 nf=1 m=2 par=2
XMpar5 a_2254_6653.t1 a_2254_6653.t0 vss.t1 vss.t0 nfet_03v3 w=1.67u l=1.35u ad=4.6760e-13 pd=2.2300e-06 as=7.3480e-13 ps=3.3850e-06 nf=1 m=4 par=4
XMpar6 a_1926_4631.t3 a_1926_4631.t2 vdd.t1 vdd.t0 pfet_03v3 w=8.72u l=1.2u ad=2.4416e-12 pd=9.2800e-06 as=2.4416e-12 ps=9.2800e-06 nf=1 m=2 par=2
XMpar7 out.t4 a_2254_6653.t0 vss.t1 vss.t0 nfet_03v3 w=1.67u l=1.35u ad=4.6760e-13 pd=2.2300e-06 as=4.6760e-13 ps=2.2300e-06 nf=1 m=4 par=4
X43 out.t38 vss.t10 cap_mim_2f0fF c_width=8.66u c_length=8.66u
Rpar0 a_1926_4631.t0 a_1926_4631.t2 125.4216
Rpar1 a_1926_4631.t0 a_1926_4631.t3 65.8496
Rpar2 a_1926_4631.t2 a_1926_4631.t3 26.0785
Rpar3 a_1954_6653.t0 a_1954_6653.t68 37.1497
Rpar4 a_2254_6653.t0 a_2254_6653.t1 17.6853
Rpar5 a_2254_6653.t0 a_2254_6653.t8 371.8765
Rpar6 a_2254_6653.t1 a_2254_6653.t8 108.8696
Rpar7 ib ib.t0 14.4764
Rpar8 ib ib.t1 4.8133
Rpar9 inn inn.t0 1.9316
Rpar10 inp inp.t0 1.9316
Rpar11 out out.t0 134.8866
Rpar12 out out.t4 41.5855
Rpar13 out out.t38 14.5388
Rpar14 out.t0 out.t4 107.9335
Rpar15 vdd vdd.t0 185.0447
Rpar16 vdd vdd.t1 829.3286
Rpar17 vdd vdd.t4 21.0850
Rpar18 vdd.t0 vdd.t1 5.5219
Rpar19 vdd.t0 vdd.t4 68.1027
Rpar20 vdd.t1 vdd.t4 305.2211
Rpar21 vss vss.t0 171.4197
Rpar22 vss vss.t1 213.8098
Rpar23 vss vss.t10 53.1241
Rpar24 vss vss.t15 110.6897
Rpar25 vss vss.t16 212.3711
Rpar26 vss.t0 vss.t1 6.7970
Rpar27 vss.t0 vss.t10 445.5172
Rpar28 vss.t0 vss.t15 207.5494
Rpar29 vss.t0 vss.t16 398.3360
Rpar30 vss.t1 vss.t10 555.6883
Rpar31 vss.t1 vss.t15 258.8990
Rpar32 vss.t1 vss.t16 496.8878
Rpar33 vss.t10 vss.t15 287.6808
Rpar34 vss.t10 vss.t16 551.9491
Rpar35 vss.t15 vss.t16 9.9149
Cpar0 a_1926_4631.t0 vss 1.50505e-15
Cpar1 a_1926_4631.t2 vss 1.61099e-14
Cpar2 a_1926_4631.t3 vss 3.87998e-15
Cpar3 a_1954_6653.t0 vss 4.52392e-14
Cpar4 a_1954_6653.t68 vss 1.60589e-14
Cpar5 a_2254_6653.t0 vss 8.11362e-15
Cpar6 a_2254_6653.t1 vss 4.52383e-15
Cpar7 a_2254_6653.t8 vss 2.10916e-14
Cpar8 ib out 4.55300e-17
Cpar9 ib vss 6.81942e-15
Cpar10 ib.t0 vss 6.06795e-16
Cpar11 ib.t1 vss 1.70770e-16
Cpar12 inn inp 9.56800e-17
Cpar13 inn out 6.71906e-15
Cpar14 inn vdd 1.79135e-14
Cpar15 inn vss 4.99894e-15
Cpar16 inn.t0 vss 2.51207e-14
Cpar17 inp vdd 1.78037e-14
Cpar18 inp vss 4.99911e-15
Cpar19 inp.t0 vss 2.50492e-14
Cpar20 out vdd 7.54774e-15
Cpar21 out vss 1.37368e-14
Cpar22 out.t0 vss 1.28490e-14
Cpar23 out.t38 vss 1.64676e-14
Cpar24 out.t4 vss 2.73736e-15
Cpar25 vdd vss 1.61658e-13
Cpar26 vdd.t0 vss 1.76345e-14
Cpar27 vdd.t1 vss 7.99838e-15
Cpar28 vdd.t4 vss 4.98508e-14
.ends opamp_dut

Vdd vdd 0 3.300000
Vss vss 0 0
Ibias vdd ib 4.000000e-06
Vinp inp 0 DC 1.480000 AC 1 PWL(0 1.480000 3.000000e-09 1.480000 3.300000e-09 1.490000)
Rfb out inn 1m
Cload out 0 2.000000e-13
Xdut vdd vss inp inn out ib opamp_dut
.end
