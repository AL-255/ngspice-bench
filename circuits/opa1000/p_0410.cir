* opa1000[0410]: 2p/nmos_5t_3v3_i20u_subth (nmos_5t, VDD=3.3V, CL=2.0pF, Iref=6.5uA)
.include "pdk_opa.inc"
.temp 27
.option gmin=1e-12 rshunt=1e12 reltol=1e-3 abstol=1e-12 vntol=1e-5 method=gear
* Post-PEX R+C extracted netlist for nmos_5t_3v3_i20u_subth
.subckt opamp_dut vdd vss inp inn out ib
XMpar0 a_1510_4654.t0 inn.t0 out.t0 vss.t0 nfet_03v3 w=5.16u l=0.81u ad=1.5480e-12 pd=6.0825e-06 as=1.4964e-12 ps=5.9012e-06 nf=1 m=64 par=64
XMpar1 a_1510_4654.t0 inp.t0 a_1792_4654.t0 vss.t0 nfet_03v3 w=5.16u l=0.81u ad=1.5480e-12 pd=6.0825e-06 as=1.4964e-12 ps=5.9012e-06 nf=1 m=64 par=64
XMpar2 a_1792_4654.t65 a_1792_4654.t64 vdd.t1 vdd.t0 pfet_03v3 w=2u l=0.81u ad=5.6000e-13 pd=2.5600e-06 as=6.4000e-13 ps=2.8900e-06 nf=1 m=48 par=48
XMpar3 out.t64 a_1792_4654.t64 vdd.t1 vdd.t0 pfet_03v3 w=2u l=0.81u ad=5.6000e-13 pd=2.5600e-06 as=5.6000e-13 ps=2.5600e-06 nf=1 m=48 par=48
XMpar4 a_1510_4654.t128 ib.t0 vss.t87 vss.t0 nfet_03v3 w=7.39u l=0.96u ad=2.0692e-12 pd=7.9500e-06 as=2.6604e-12 ps=9.9575e-06 nf=1 m=8 par=8
XMpar5 ib.t1 ib.t0 vss.t87 vss.t0 nfet_03v3 w=7.39u l=0.96u ad=2.0692e-12 pd=7.9500e-06 as=2.0692e-12 ps=7.9500e-06 nf=1 m=2 par=2
X159 out.t112 vss.t106 cap_mim_2f0fF c_width=9u c_length=9u
Rpar0 a_1510_4654.t0 a_1510_4654.t128 46.8820
Rpar1 a_1792_4654.t0 a_1792_4654.t64 171.4302
Rpar2 a_1792_4654.t0 a_1792_4654.t65 46.9798
Rpar3 a_1792_4654.t64 a_1792_4654.t65 4.7121
Rpar4 ib ib.t0 15.3204
Rpar5 ib ib.t1 7.5214
Rpar6 inn inn.t0 1.9790
Rpar7 inp inp.t0 1.9790
Rpar8 out out.t0 141.9598
Rpar9 out out.t64 2.7489
Rpar10 out out.t112 102.8344
Rpar11 out.t0 out.t112 93.7473
Rpar12 vdd vdd.t0 19.3664
Rpar13 vdd vdd.t1 1319.1370
Rpar14 vdd.t0 vdd.t1 8.9564
Rpar15 vss vss.t0 31.3605
Rpar16 vss vss.t87 998.2924
Rpar17 vss vss.t106 65.8460
Rpar18 vss.t0 vss.t87 4.2978
Rpar19 vss.t0 vss.t106 74.4178
Rpar20 vss.t87 vss.t106 2368.9271
Cpar0 a_1510_4654.t0 vss 1.14150e-13
Cpar1 a_1510_4654.t128 vss 1.24405e-14
Cpar2 a_1792_4654.t0 vss 7.29799e-14
Cpar3 a_1792_4654.t64 vss 7.46260e-14
Cpar4 a_1792_4654.t65 vss 3.70909e-14
Cpar5 ib out 4.07600e-17
Cpar6 ib vss 1.46917e-14
Cpar7 ib.t0 vss 2.85479e-15
Cpar8 ib.t1 vss 4.06150e-16
Cpar9 inn inp 9.68900e-17
Cpar10 inn out 1.72006e-14
Cpar11 inn vdd 1.45600e-17
Cpar12 inn vss 3.48920e-14
Cpar13 inn.t0 vss 2.74670e-14
Cpar14 inp out 4.15230e-16
Cpar15 inp vdd 1.36900e-17
Cpar16 inp vss 3.49540e-14
Cpar17 inp.t0 vss 2.76430e-14
Cpar18 out vdd 3.17121e-14
Cpar19 out vss 3.02105e-14
Cpar20 out.t0 vss 5.81956e-14
Cpar21 out.t112 vss 3.00122e-14
Cpar22 out.t64 vss 2.53239e-14
Cpar23 vdd vss 1.64899e-13
Cpar24 vdd.t0 vss 1.04256e-13
Cpar25 vdd.t1 vss 1.62653e-14
.ends opamp_dut

Vdd vdd 0 3.300000
Vss vss 0 0
Ibias vdd ib 6.500000e-06
Vinp inp 0 DC 1.645000 AC 1 PWL(0 1.645000 5.410640e-09 1.645000 5.951704e-09 1.655000)
Rfb out inn 1m
Cload out 0 2.000000e-12
Xdut vdd vss inp inn out ib opamp_dut
.end
