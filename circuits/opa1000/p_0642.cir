* opa1000[0642]: 2p/pmos_miller_1v8_10u_100u_weak (pmos_miller, VDD=1.8V, CL=2.0pF, Iref=6.25uA)
.include "pdk_opa.inc"
.temp 27
.option gmin=1e-12 rshunt=1e12 reltol=1e-3 abstol=1e-12 vntol=1e-5 method=gear
* Post-PEX R+C extracted netlist for pmos_miller_1v8_10u_100u_weak
.subckt opamp_dut vdd vss inp inn out ib
XMpar0 out.t2 a_997_3862.t25 vss.t1 vss.t0 nfet_03v3 w=3.37u l=0.75u ad=9.4360e-13 pd=3.9300e-06 as=1.1593e-12 ps=4.7320e-06 nf=1 m=10 par=10
XMpar1 a_3226_1204.t0 inp.t0 a_997_3862.t0 vdd.t0 pfet_03v3 w=1.96u l=0.6u ad=6.0582e-13 pd=2.7564e-06 as=6.0582e-13 ps=2.7564e-06 nf=1 m=22 par=22
XMpar2 a_3226_1204.t0 inn.t0 a_5672_3817.t0 vdd.t0 pfet_03v3 w=1.96u l=0.6u ad=6.0582e-13 pd=2.7564e-06 as=6.0582e-13 ps=2.7564e-06 nf=1 m=22 par=22
XMpar3 out.t0 a_5263_6026.t2 vdd.t12 vdd.t11 pfet_03v3 w=10u l=1.25u ad=3.4400e-12 pd=1.2688e-05 as=2.8000e-12 ps=1.0560e-05 nf=1 m=10 par=10
XMpar4 a_3226_1204.t22 a_5263_6026.t2 vdd.t12 vdd.t11 pfet_03v3 w=10u l=1.25u ad=2.8000e-12 pd=1.0560e-05 as=2.8000e-12 ps=1.0560e-05 nf=1 m=4 par=4
XMpar5 a_5263_6026.t3 a_5263_6026.t2 vdd.t12 vdd.t11 pfet_03v3 w=10u l=1.25u ad=2.8000e-12 pd=1.0560e-05 as=2.8000e-12 ps=1.0560e-05 nf=1 m=2 par=2
XMpar6 a_997_3862.t23 a_5672_3817.t22 vss.t1 vss.t0 nfet_03v3 w=3.37u l=0.75u ad=2.0220e-12 pd=7.9400e-06 as=9.4360e-13 ps=3.9300e-06 nf=1 m=2 par=2
XMpar7 a_5672_3817.t23 a_5672_3817.t22 vss.t1 vss.t0 nfet_03v3 w=3.37u l=0.75u ad=9.4360e-13 pd=3.9300e-06 as=9.4360e-13 ps=3.9300e-06 nf=1 m=2 par=2
XMpar8 a_5263_6026.t0 ib.t0 vss.t21 vss.t20 nfet_03v3 w=3.45u l=1.25u ad=9.6600e-13 pd=4.0100e-06 as=9.6600e-13 ps=4.0100e-06 nf=1 m=2 par=2
XMpar9 ib.t1 ib.t0 vss.t21 vss.t20 nfet_03v3 w=3.45u l=1.25u ad=2.0700e-12 pd=8.1000e-06 as=9.6600e-13 ps=4.0100e-06 nf=1 m=2 par=2
X4 a_10065_12286.t1 out.t12 cap_mim_2f0fF c_width=16.59u c_length=16.58u
X42 a_997_3862.t22 a_10065_12286.t0 vss.t30 ppolyf_u_1k r_width=1u r_length=4.14u
X57 a_10065_12286.t1 out.t12 cap_mim_2f0fF c_width=16.59u c_length=16.58u
Rpar0 a_10065_12286.t0 a_10065_12286.t1 58.8158
Rpar1 a_3226_1204.t0 a_3226_1204.t22 50.5439
Rpar2 a_5263_6026.t0 a_5263_6026.t2 257.1670
Rpar3 a_5263_6026.t0 a_5263_6026.t3 163.6739
Rpar4 a_5263_6026.t2 a_5263_6026.t3 24.7366
Rpar5 a_5672_3817.t0 a_5672_3817.t22 158.4126
Rpar6 a_5672_3817.t0 a_5672_3817.t23 53.6078
Rpar7 a_5672_3817.t22 a_5672_3817.t23 30.8035
Rpar8 a_997_3862.t0 a_997_3862.t22 393.8469
Rpar9 a_997_3862.t0 a_997_3862.t23 258.9105
Rpar10 a_997_3862.t0 a_997_3862.t25 72.4275
Rpar11 a_997_3862.t22 a_997_3862.t23 133.9113
Rpar12 a_997_3862.t22 a_997_3862.t25 194.9531
Rpar13 a_997_3862.t23 a_997_3862.t25 128.1600
Rpar14 ib ib.t0 15.5451
Rpar15 ib ib.t1 3.7429
Rpar16 inn inn.t0 2.9959
Rpar17 inp inp.t0 2.9959
Rpar18 out out.t0 1.9693
Rpar19 out out.t2 370.9553
Rpar20 out out.t12 634.0682
Rpar21 out.t0 out.t2 97.5120
Rpar22 out.t0 out.t12 166.6757
Rpar23 out.t2 out.t12 92.5881
Rpar24 vdd vdd.t0 236.6403
Rpar25 vdd vdd.t11 141.4817
Rpar26 vdd vdd.t12 950.7274
Rpar27 vdd.t0 vdd.t11 67.1914
Rpar28 vdd.t0 vdd.t12 451.5122
Rpar29 vdd.t11 vdd.t12 5.3000
Rpar30 vss vss.t0 118.3708
Rpar31 vss vss.t1 144.2304
Rpar32 vss vss.t20 1129.6558
Rpar33 vss vss.t21 2817.9423
Rpar34 vss.t0 vss.t1 3.8173
Rpar35 vss.t0 vss.t20 169.6110
Rpar36 vss.t0 vss.t21 423.7114
Rpar37 vss.t0 vss.t30 2374.8139
Rpar38 vss.t1 vss.t20 145.9567
Rpar39 vss.t1 vss.t21 364.0342
Rpar40 vss.t1 vss.t30 2045.0144
Rpar41 vss.t20 vss.t21 8.7530
Rpar42 vss.t20 vss.t30 26.8393
Rpar43 vss.t21 vss.t30 141.6719
Cpar0 a_10065_12286.t0 vss 7.77677e-17
Cpar1 a_10065_12286.t1 vss 6.37769e-15
Cpar2 a_3226_1204.t0 vss 2.80095e-14
Cpar3 a_3226_1204.t22 vss 1.34842e-14
Cpar4 a_5263_6026.t0 vss 5.49517e-15
Cpar5 a_5263_6026.t2 vss 3.07647e-14
Cpar6 a_5263_6026.t3 vss 7.05169e-15
Cpar7 a_5672_3817.t0 vss 1.31538e-14
Cpar8 a_5672_3817.t22 vss 3.72612e-15
Cpar9 a_5672_3817.t23 vss 3.32485e-15
Cpar10 a_997_3862.t0 vss 9.47228e-15
Cpar11 a_997_3862.t22 vss 2.86215e-15
Cpar12 a_997_3862.t23 vss 4.29706e-15
Cpar13 a_997_3862.t25 vss 7.90718e-15
Cpar14 ib vdd 2.29300e-17
Cpar15 ib vss 7.80930e-15
Cpar16 ib.t0 vss 6.28427e-16
Cpar17 ib.t1 vss 2.49010e-16
Cpar18 inn inp 1.02380e-16
Cpar19 inn vdd 9.89182e-15
Cpar20 inn vss 5.00706e-15
Cpar21 inn.t0 vss 1.08534e-14
Cpar22 inp vdd 9.91181e-15
Cpar23 inp vss 5.11201e-15
Cpar24 inp.t0 vss 1.08417e-14
Cpar25 out vdd 1.50240e-14
Cpar26 out vss 1.71158e-14
Cpar27 out.t0 vss 1.01375e-14
Cpar28 out.t12 vss 1.48398e-14
Cpar29 out.t2 vss 4.51452e-15
Cpar30 vdd vss 1.49969e-13
Cpar31 vdd.t0 vss 3.16564e-14
Cpar32 vdd.t11 vss 3.37587e-14
Cpar33 vdd.t12 vss 1.05360e-14
.ends opamp_dut

Vdd vdd 0 1.800000
Vss vss 0 0
Ibias vdd ib 6.250000e-06
Vinp inp 0 DC 0.805000 AC 1 PWL(0 0.805000 7.209902e-09 0.805000 7.930892e-09 0.815000)
Rfb out inn 1m
Cload out 0 2.000000e-12
Xdut vdd vss inp inn out ib opamp_dut
.end
