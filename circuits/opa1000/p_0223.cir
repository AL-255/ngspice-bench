* opa1000[0223]: 2p/folded_cascode_nmos_1v8_i20u_weak (folded_cascode_nmos, VDD=1.8V, CL=2.0pF, Iref=5.1111uA)
.include "pdk_opa.inc"
.temp 27
.option gmin=1e-12 rshunt=1e12 reltol=1e-3 abstol=1e-12 vntol=1e-5 method=gear
* Post-PEX R+C extracted netlist for folded_cascode_nmos_1v8_i20u_weak
.subckt opamp_dut vdd vss inp inn out ib
XMpar0 a_1682_6007.t0 inn.t0 a_4334_10053.t0 vss.t0 nfet_03v3 w=2.03u l=0.9u ad=7.3080e-13 pd=3.2575e-06 as=5.6840e-13 ps=2.5900e-06 nf=1 m=8 par=8
XMpar1 a_1682_6007.t16 ib.t0 vss.t17 vss.t0 nfet_03v3 w=4.09u l=1.8u ad=1.1452e-12 pd=4.6500e-06 as=1.1452e-12 ps=4.6500e-06 nf=1 m=4 par=4
XMpar2 a_1982_6007.t14 a_1117_996.t2 vdd.t1 vdd.t0 pfet_03v3 w=5.01u l=0.81u ad=1.4028e-12 pd=5.5700e-06 as=2.2044e-12 ps=8.3950e-06 nf=1 m=4 par=4
XMpar3 a_1982_6007.t8 ib.t10 a_3106_10053.t4 vdd.t14 pfet_03v3 w=1.71u l=0.36u ad=6.6120e-13 pd=3.0533e-06 as=4.7880e-13 ps=2.2700e-06 nf=1 m=6 par=6
XMpar4 a_4334_10053.t8 ib.t10 out.t0 vdd.t14 pfet_03v3 w=1.71u l=0.36u ad=6.6120e-13 pd=3.0533e-06 as=4.7880e-13 ps=2.2700e-06 nf=1 m=6 par=6
XMpar5 out.t1 a_3106_10053.t0 vss.t17 vss.t0 nfet_03v3 w=4.09u l=1.8u ad=1.1452e-12 pd=4.6500e-06 as=1.1452e-12 ps=4.6500e-06 nf=1 m=2 par=2
XMpar6 a_1682_6007.t0 inp.t0 a_1982_6007.t0 vss.t0 nfet_03v3 w=2.03u l=0.9u ad=7.3080e-13 pd=3.2575e-06 as=5.6840e-13 ps=2.5900e-06 nf=1 m=8 par=8
XMpar7 a_4334_10053.t14 a_1117_996.t2 vdd.t1 vdd.t0 pfet_03v3 w=5.01u l=0.81u ad=1.4028e-12 pd=5.5700e-06 as=2.2044e-12 ps=8.3950e-06 nf=1 m=4 par=4
XMpar8 a_3106_10053.t1 a_3106_10053.t0 vss.t17 vss.t0 nfet_03v3 w=4.09u l=1.8u ad=2.4540e-12 pd=9.3800e-06 as=1.1452e-12 ps=4.6500e-06 nf=1 m=2 par=2
XMpar9 ib.t1 ib.t0 vss.t17 vss.t0 nfet_03v3 w=4.09u l=1.8u ad=2.4540e-12 pd=9.3800e-06 as=1.1452e-12 ps=4.6500e-06 nf=1 m=2 par=2
XMpar10 a_1117_996.t3 a_1117_996.t2 vdd.t1 vdd.t0 pfet_03v3 w=5.01u l=0.81u ad=1.4028e-12 pd=5.5700e-06 as=3.0060e-12 ps=1.1220e-05 nf=1 m=2 par=2
XMpar11 a_1117_996.t0 ib.t0 vss.t17 vss.t0 nfet_03v3 w=4.09u l=1.8u ad=1.1452e-12 pd=4.6500e-06 as=1.1452e-12 ps=4.6500e-06 nf=1 m=2 par=2
Rpar0 a_1117_996.t0 a_1117_996.t2 102.4687
Rpar1 a_1117_996.t0 a_1117_996.t3 90.9770
Rpar2 a_1117_996.t2 a_1117_996.t3 25.8979
Rpar3 a_1682_6007.t0 a_1682_6007.t16 26.7644
Rpar4 a_1982_6007.t0 a_1982_6007.t8 43.2612
Rpar5 a_1982_6007.t0 a_1982_6007.t14 87.2252
Rpar6 a_1982_6007.t8 a_1982_6007.t14 177.3165
Rpar7 a_3106_10053.t0 a_3106_10053.t1 19.2185
Rpar8 a_3106_10053.t0 a_3106_10053.t4 225.3272
Rpar9 a_3106_10053.t1 a_3106_10053.t4 56.9900
Rpar10 a_4334_10053.t0 a_4334_10053.t8 43.2612
Rpar11 a_4334_10053.t0 a_4334_10053.t14 87.2252
Rpar12 a_4334_10053.t8 a_4334_10053.t14 177.3165
Rpar13 ib ib.t0 235.8351
Rpar14 ib ib.t1 74.5173
Rpar15 ib ib.t10 4.6885
Rpar16 ib.t0 ib.t1 17.2805
Rpar17 inn inn.t0 2.6305
Rpar18 inp inp.t0 2.6791
Rpar19 out out.t0 51.1475
Rpar20 out out.t1 7.3649
Rpar21 vdd vdd.t0 199.2239
Rpar22 vdd vdd.t1 239.0246
Rpar23 vdd vdd.t14 28.8246
Rpar24 vdd.t0 vdd.t1 4.7955
Rpar25 vdd.t0 vdd.t14 102.4030
Rpar26 vdd.t1 vdd.t14 122.8610
Rpar27 vss vss.t0 40.6186
Rpar28 vss vss.t17 222.5751
Rpar29 vss.t0 vss.t17 2.7083
Cpar0 a_1117_996.t0 vss 3.43488e-15
Cpar1 a_1117_996.t2 vss 1.01344e-14
Cpar2 a_1117_996.t3 vss 3.45206e-15
Cpar3 a_1682_6007.t0 vss 8.81253e-15
Cpar4 a_1682_6007.t16 vss 4.52355e-15
Cpar5 a_1982_6007.t0 vss 7.58146e-15
Cpar6 a_1982_6007.t14 vss 6.63085e-15
Cpar7 a_1982_6007.t8 vss 3.70017e-15
Cpar8 a_3106_10053.t0 vss 4.38963e-15
Cpar9 a_3106_10053.t1 vss 2.69824e-15
Cpar10 a_3106_10053.t4 vss 1.29781e-15
Cpar11 a_4334_10053.t0 vss 6.13768e-15
Cpar12 a_4334_10053.t14 vss 5.36802e-15
Cpar13 a_4334_10053.t8 vss 2.99552e-15
Cpar14 ib inn 1.59800e-17
Cpar15 ib out 3.79050e-16
Cpar16 ib vdd 6.58467e-15
Cpar17 ib vss 1.88978e-14
Cpar18 ib.t0 vss 7.71317e-15
Cpar19 ib.t1 vss 3.09149e-15
Cpar20 ib.t10 vss 9.21044e-16
Cpar21 inn inp 5.16800e-17
Cpar22 inn vss 6.00273e-15
Cpar23 inn.t0 vss 1.09759e-15
Cpar24 inp vdd 3.67100e-17
Cpar25 inp vss 5.95603e-15
Cpar26 inp.t0 vss 1.11948e-15
Cpar27 out vdd 1.31195e-15
Cpar28 out vss 5.54643e-15
Cpar29 out.t0 vss 2.83932e-15
Cpar30 out.t1 vss 1.56281e-15
Cpar31 vdd vss 5.89348e-14
Cpar32 vdd.t0 vss 1.09434e-14
Cpar33 vdd.t1 vss 9.35217e-15
Cpar34 vdd.t14 vss 8.30277e-15
.ends opamp_dut

Vdd vdd 0 1.800000
Vss vss 0 0
Ibias vdd ib 5.111100e-06
Vinp inp 0 DC 0.985000 AC 1 PWL(0 0.985000 1.442000e-08 0.985000 1.586200e-08 0.995000)
Rfb out inn 1m
Cload out 0 2.000000e-12
Xdut vdd vss inp inn out ib opamp_dut
.end
