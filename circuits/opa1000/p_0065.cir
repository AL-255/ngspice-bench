* opa1000[0065]: 2p/cherry_hooper_3v3_i200n_weak (cherry_hooper, VDD=3.3V, CL=2.0pF, Iref=0.0164uA)
.include "pdk_opa.inc"
.temp 27
.option gmin=1e-12 rshunt=1e12 reltol=1e-3 abstol=1e-12 vntol=1e-5 method=gear
* Post-PEX R+C extracted netlist for cherry_hooper_3v3_i200n_weak
.subckt opamp_dut vdd vss inp inn out ib
XMpar0 a_1444_9318.t2 ib.t0 vss.t7 vss.t6 nfet_03v3 w=0.4u l=7.5u ad=2.4000e-13 pd=2.0000e-06 as=2.4000e-13 ps=2.0000e-06 nf=1 m=1
XMpar1 a_4114_9646.t4 ib.t0 vss.t7 vss.t6 nfet_03v3 w=0.4u l=7.5u ad=1.1200e-13 pd=9.6000e-07 as=1.1200e-13 ps=9.6000e-07 nf=1 m=2 par=2
XMpar2 a_3500_14249.t2 a_3500_14249.t1 vdd.t1 vdd.t0 pfet_03v3 w=0.58u l=4.8u ad=2.2427e-13 pd=1.5467e-06 as=1.6240e-13 ps=1.1400e-06 nf=1 m=3 par=3
XMpar3 a_6734_6410.t0 a_1444_9318.t3 a_6734_8000.t4 vdd.t2 pfet_03v3 w=0.4u l=8.95u ad=2.4000e-13 pd=2.0000e-06 as=2.4000e-13 ps=2.0000e-06 nf=1 m=1
XMpar4 a_2530_1249.t2 ib.t0 vss.t7 vss.t6 nfet_03v3 w=0.4u l=7.5u ad=1.1200e-13 pd=9.6000e-07 as=1.5467e-13 ps=1.3067e-06 nf=1 m=6 par=6
XMpar5 a_4114_9646.t0 inp.t0 a_5274_9646.t0 vss.t1 nfet_03v3 w=0.4u l=5.2u ad=2.4000e-13 pd=2.0000e-06 as=1.1200e-13 ps=9.6000e-07 nf=1 m=1
XMpar6 a_1339_4336.t0 ib.t0 vss.t7 vss.t6 nfet_03v3 w=0.4u l=7.5u ad=2.4000e-13 pd=2.0000e-06 as=1.1200e-13 ps=9.6000e-07 nf=1 m=1
XMpar7 a_1339_6246.t4 a_1444_9318.t3 a_5274_9646.t2 vdd.t2 pfet_03v3 w=0.4u l=8.95u ad=2.4000e-13 pd=2.0000e-06 as=2.4000e-13 ps=2.0000e-06 nf=1 m=1
XMpar8 ib.t1 ib.t0 vss.t7 vss.t6 nfet_03v3 w=0.4u l=7.5u ad=2.4000e-13 pd=2.0000e-06 as=1.1200e-13 ps=9.6000e-07 nf=1 m=1
XMpar9 out.t1 a_3500_14249.t1 vdd.t1 vdd.t0 pfet_03v3 w=0.58u l=4.8u ad=2.2427e-13 pd=1.5467e-06 as=1.6240e-13 ps=1.1400e-06 nf=1 m=3 par=3
XMpar10 a_2771_2794.t1 ib.t0 vss.t7 vss.t6 nfet_03v3 w=0.4u l=7.5u ad=1.1200e-13 pd=9.6000e-07 as=1.7600e-13 ps=1.4800e-06 nf=1 m=4 par=4
XMpar11 a_1160_7782.t2 a_1160_7782.t1 vdd.t1 vdd.t0 pfet_03v3 w=0.58u l=4.8u ad=3.4800e-13 pd=2.3600e-06 as=3.4800e-13 ps=2.3600e-06 nf=1 m=1
XMpar12 a_6734_8000.t1 a_6734_8000.t0 vdd.t1 vdd.t0 pfet_03v3 w=0.58u l=4.8u ad=1.6240e-13 pd=1.1400e-06 as=3.4800e-13 ps=2.3600e-06 nf=1 m=2 par=2
XMpar13 a_6734_6410.t3 a_1339_4336.t1 vdd.t16 vdd.t15 pfet_03v3 w=0.4u l=7.5u ad=2.4000e-13 pd=2.0000e-06 as=2.4000e-13 ps=2.0000e-06 nf=1 m=1
XMpar14 a_1160_7782.t0 a_1444_9318.t0 a_1444_9318.t1 vdd.t3 pfet_03v3 w=0.68u l=1u ad=4.0800e-13 pd=2.5600e-06 as=4.0800e-13 ps=2.5600e-06 nf=1 m=1
XMpar15 a_4114_9646.t0 inn.t0 a_6734_6410.t1 vss.t1 nfet_03v3 w=0.4u l=5.2u ad=2.4000e-13 pd=2.0000e-06 as=1.1200e-13 ps=9.6000e-07 nf=1 m=1
XMpar16 a_1339_6246.t1 a_1339_6246.t0 vdd.t1 vdd.t0 pfet_03v3 w=0.58u l=4.8u ad=1.6240e-13 pd=1.1400e-06 as=3.4800e-13 ps=2.3600e-06 nf=1 m=2 par=2
XMpar17 a_1339_4336.t2 a_1339_4336.t1 vdd.t16 vdd.t15 pfet_03v3 w=0.4u l=7.5u ad=2.4000e-13 pd=2.0000e-06 as=2.4000e-13 ps=2.0000e-06 nf=1 m=1
XMpar18 a_4114_9646.t0 inp.t0 a_5274_9646.t0 vss.t2 nfet_03v3 w=0.4u l=5.2u ad=2.4000e-13 pd=2.0000e-06 as=1.1200e-13 ps=9.6000e-07 nf=1 m=1
XMpar19 a_2530_1249.t0 a_6734_8000.t6 out.t0 vss.t0 nfet_03v3 w=0.68u l=5.2u ad=4.0800e-13 pd=2.5600e-06 as=4.0800e-13 ps=2.5600e-06 nf=1 m=1
XMpar20 a_1339_6246.t5 a_5274_9646.t4 a_2771_2794.t0 vss.t2 nfet_03v3 w=0.45u l=5.2u ad=2.7000e-13 pd=2.1000e-06 as=2.7000e-13 ps=2.1000e-06 nf=1 m=1
XMpar21 a_5274_9646.t3 a_1339_4336.t1 vdd.t16 vdd.t15 pfet_03v3 w=0.4u l=7.5u ad=2.4000e-13 pd=2.0000e-06 as=2.4000e-13 ps=2.0000e-06 nf=1 m=1
XMpar22 a_4114_9646.t0 inn.t0 a_6734_6410.t1 vss.t2 nfet_03v3 w=0.4u l=5.2u ad=2.4000e-13 pd=2.0000e-06 as=1.1200e-13 ps=9.6000e-07 nf=1 m=1
XMpar23 a_2530_1249.t0 a_1339_6246.t6 a_3500_14249.t0 vss.t0 nfet_03v3 w=0.68u l=5.2u ad=4.0800e-13 pd=2.5600e-06 as=4.0800e-13 ps=2.5600e-06 nf=1 m=1
XMpar24 a_2771_2794.t0 a_6734_6410.t4 a_6734_8000.t5 vss.t2 nfet_03v3 w=0.45u l=5.2u ad=2.7000e-13 pd=2.1000e-06 as=2.7000e-13 ps=2.1000e-06 nf=1 m=1
Rpar0 a_1160_7782.t0 a_1160_7782.t1 100.7429
Rpar1 a_1160_7782.t0 a_1160_7782.t2 99.1643
Rpar2 a_1160_7782.t1 a_1160_7782.t2 34.8265
Rpar3 a_1339_4336.t0 a_1339_4336.t1 53.7810
Rpar4 a_1339_4336.t0 a_1339_4336.t2 171.8231
Rpar5 a_1339_4336.t1 a_1339_4336.t2 30.2991
Rpar6 a_1339_6246.t0 a_1339_6246.t1 30.8371
Rpar7 a_1339_6246.t0 a_1339_6246.t4 350.8093
Rpar8 a_1339_6246.t0 a_1339_6246.t5 178.9137
Rpar9 a_1339_6246.t0 a_1339_6246.t6 357.4933
Rpar10 a_1339_6246.t1 a_1339_6246.t4 290.8874
Rpar11 a_1339_6246.t1 a_1339_6246.t5 148.3533
Rpar12 a_1339_6246.t1 a_1339_6246.t6 296.4297
Rpar13 a_1339_6246.t4 a_1339_6246.t5 394.8688
Rpar14 a_1339_6246.t4 a_1339_6246.t6 63.6916
Rpar15 a_1339_6246.t5 a_1339_6246.t6 402.3923
Rpar16 a_1444_9318.t0 a_1444_9318.t1 53.3910
Rpar17 a_1444_9318.t0 a_1444_9318.t2 779.4180
Rpar18 a_1444_9318.t0 a_1444_9318.t3 240.5649
Rpar19 a_1444_9318.t1 a_1444_9318.t2 322.2260
Rpar20 a_1444_9318.t1 a_1444_9318.t3 99.4540
Rpar21 a_1444_9318.t2 a_1444_9318.t3 276.9459
Rpar22 a_2530_1249.t0 a_2530_1249.t2 113.6287
Rpar23 a_2771_2794.t0 a_2771_2794.t1 73.5233
Rpar24 a_3500_14249.t0 a_3500_14249.t1 126.7025
Rpar25 a_3500_14249.t0 a_3500_14249.t2 83.1568
Rpar26 a_3500_14249.t1 a_3500_14249.t2 19.9618
Rpar27 a_4114_9646.t0 a_4114_9646.t4 105.6502
Rpar28 a_5274_9646.t0 a_5274_9646.t2 103.9018
Rpar29 a_5274_9646.t0 a_5274_9646.t3 177.7566
Rpar30 a_5274_9646.t0 a_5274_9646.t4 85.3851
Rpar31 a_5274_9646.t2 a_5274_9646.t3 274.5797
Rpar32 a_5274_9646.t2 a_5274_9646.t4 131.8939
Rpar33 a_5274_9646.t3 a_5274_9646.t4 96.9289
Rpar34 a_6734_6410.t0 a_6734_6410.t1 98.9680
Rpar35 a_6734_6410.t0 a_6734_6410.t3 401.5823
Rpar36 a_6734_6410.t0 a_6734_6410.t4 260.1542
Rpar37 a_6734_6410.t1 a_6734_6410.t3 210.9231
Rpar38 a_6734_6410.t1 a_6734_6410.t4 136.6408
Rpar39 a_6734_6410.t3 a_6734_6410.t4 65.5294
Rpar40 a_6734_8000.t0 a_6734_8000.t1 31.3117
Rpar41 a_6734_8000.t0 a_6734_8000.t4 248.0501
Rpar42 a_6734_8000.t0 a_6734_8000.t5 193.2880
Rpar43 a_6734_8000.t0 a_6734_8000.t6 341.1500
Rpar44 a_6734_8000.t1 a_6734_8000.t4 205.6815
Rpar45 a_6734_8000.t1 a_6734_8000.t5 160.2731
Rpar46 a_6734_8000.t1 a_6734_8000.t6 282.8794
Rpar47 a_6734_8000.t4 a_6734_8000.t5 277.7734
Rpar48 a_6734_8000.t4 a_6734_8000.t6 113.2653
Rpar49 a_6734_8000.t5 a_6734_8000.t6 382.0293
Rpar50 ib ib.t0 10.1411
Rpar51 ib ib.t1 15.5548
Rpar52 inn inn.t0 3.2828
Rpar53 inp inp.t0 3.3313
Rpar54 out out.t0 15.0210
Rpar55 out out.t1 47.3241
Rpar56 vdd vdd.t0 65.4976
Rpar57 vdd vdd.t1 111.3259
Rpar58 vdd vdd.t15 7303.7234
Rpar59 vdd vdd.t16 6860.5907
Rpar60 vdd vdd.t2 480.0997
Rpar61 vdd vdd.t3 2291.0905
Rpar62 vdd.t0 vdd.t1 4.0894
Rpar63 vdd.t0 vdd.t15 113.2213
Rpar64 vdd.t0 vdd.t16 105.7164
Rpar65 vdd.t0 vdd.t2 121.6040
Rpar66 vdd.t0 vdd.t3 298.0483
Rpar67 vdd.t1 vdd.t15 129.5567
Rpar68 vdd.t1 vdd.t16 121.0321
Rpar69 vdd.t1 vdd.t2 170.4188
Rpar70 vdd.t1 vdd.t3 343.9486
Rpar71 vdd.t15 vdd.t16 11.9557
Rpar72 vdd.t15 vdd.t2 813.3697
Rpar73 vdd.t15 vdd.t3 927.8814
Rpar74 vdd.t16 vdd.t2 764.0208
Rpar75 vdd.t16 vdd.t3 871.5848
Rpar76 vdd.t2 vdd.t3 255.1443
Rpar77 vss vss.t0 873.5438
Rpar78 vss vss.t1 760.4825
Rpar79 vss vss.t6 39.2075
Rpar80 vss vss.t7 188.3964
Rpar81 vss vss.t2 299.5881
Rpar82 vss.t0 vss.t1 474.9618
Rpar83 vss.t0 vss.t6 226.2206
Rpar84 vss.t0 vss.t7 1095.6238
Rpar85 vss.t0 vss.t2 187.4120
Rpar86 vss.t1 vss.t6 196.8427
Rpar87 vss.t1 vss.t7 953.3157
Rpar88 vss.t1 vss.t2 27.0661
Rpar89 vss.t6 vss.t7 3.0055
Rpar90 vss.t6 vss.t2 77.5529
Rpar91 vss.t7 vss.t2 375.5929
Cpar0 a_1160_7782.t0 vss 1.46336e-15
Cpar1 a_1160_7782.t1 vss 3.26300e-15
Cpar2 a_1160_7782.t2 vss 1.39014e-15
Cpar3 a_1339_4336.t0 vss 3.51236e-15
Cpar4 a_1339_4336.t1 vss 1.57446e-14
Cpar5 a_1339_4336.t2 vss 2.20351e-15
Cpar6 a_1339_6246.t0 vss 5.45058e-15
Cpar7 a_1339_6246.t1 vss 2.19472e-15
Cpar8 a_1339_6246.t4 vss 2.19408e-15
Cpar9 a_1339_6246.t5 vss 1.86894e-15
Cpar10 a_1339_6246.t6 vss 3.84307e-15
Cpar11 a_1444_9318.t0 vss 1.71547e-15
Cpar12 a_1444_9318.t1 vss 3.19040e-15
Cpar13 a_1444_9318.t2 vss 6.30796e-15
Cpar14 a_1444_9318.t3 vss 1.01863e-14
Cpar15 a_2530_1249.t0 vss 4.02030e-15
Cpar16 a_2530_1249.t2 vss 6.23316e-15
Cpar17 a_2771_2794.t0 vss 4.58977e-15
Cpar18 a_2771_2794.t1 vss 6.28994e-15
Cpar19 a_3500_14249.t0 vss 2.39759e-15
Cpar20 a_3500_14249.t1 vss 1.85729e-14
Cpar21 a_3500_14249.t2 vss 4.92005e-15
Cpar22 a_4114_9646.t0 vss 5.91131e-15
Cpar23 a_4114_9646.t4 vss 6.08348e-15
Cpar24 a_5274_9646.t0 vss 2.20328e-15
Cpar25 a_5274_9646.t2 vss 1.92203e-15
Cpar26 a_5274_9646.t3 vss 1.76601e-15
Cpar27 a_5274_9646.t4 vss 3.50748e-15
Cpar28 a_6734_6410.t0 vss 2.53573e-15
Cpar29 a_6734_6410.t1 vss 3.08182e-15
Cpar30 a_6734_6410.t3 vss 2.20786e-15
Cpar31 a_6734_6410.t4 vss 4.36711e-15
Cpar32 a_6734_8000.t0 vss 6.23231e-15
Cpar33 a_6734_8000.t1 vss 2.51077e-15
Cpar34 a_6734_8000.t4 vss 2.86106e-15
Cpar35 a_6734_8000.t5 vss 2.15358e-15
Cpar36 a_6734_8000.t6 vss 4.68516e-15
Cpar37 ib vdd 1.64300e-16
Cpar38 ib vss 7.35116e-14
Cpar39 ib.t0 vss 4.75908e-15
Cpar40 inn inp 5.19700e-17
Cpar41 inn vdd 4.60100e-17
Cpar42 inn vss 5.69230e-15
Cpar43 inn.t0 vss 4.49353e-16
Cpar44 inp vdd 4.45800e-17
Cpar45 inp vss 5.65254e-15
Cpar46 inp.t0 vss 4.87268e-16
Cpar47 out vdd 4.86734e-15
Cpar48 out vss 5.42843e-15
Cpar49 out.t0 vss 2.08180e-16
Cpar50 out.t1 vss 5.85715e-15
Cpar51 vdd vss 1.41029e-13
Cpar52 vdd.t0 vss 2.95731e-14
Cpar53 vdd.t1 vss 1.97123e-14
Cpar54 vdd.t15 vss 1.21014e-14
Cpar55 vdd.t16 vss 7.58995e-15
Cpar56 vdd.t2 vss 8.90679e-15
Cpar57 vdd.t3 vss 3.48814e-15
.ends opamp_dut

Vdd vdd 0 3.300000
Vss vss 0 0
Ibias vdd ib 1.640000e-08
Vinp inp 0 DC 2.070300 AC 1 PWL(0 2.070300 3.223891e-07 2.070300 3.546280e-07 2.080300)
Rfb out inn 1m
Cload out 0 2.000000e-12
Xdut vdd vss inp inn out ib opamp_dut
.end
