* opa1000[0082]: 2p/cherry_hooper_3v3_i500u_subth (cherry_hooper, VDD=3.3V, CL=2.0pF, Iref=47.9167uA)
.include "pdk_opa.inc"
.temp 27
.option gmin=1e-12 rshunt=1e12 reltol=1e-3 abstol=1e-12 vntol=1e-5 method=gear
* Post-PEX R+C extracted netlist for cherry_hooper_3v3_i500u_subth
.subckt opamp_dut vdd vss inp inn out ib
XMpar0 a_14894_4791.t15 inn.t0 a_1809_8302.t0 vss.t0 nfet_03v3 w=1.99u l=0.45u ad=5.7489e-13 pd=2.6231e-06 as=5.8373e-13 ps=2.6596e-06 nf=1 m=144 par=144
XMpar1 a_1809_8302.t0 inp.t0 a_8930_21309.t20 vss.t0 nfet_03v3 w=1.99u l=0.45u ad=5.8373e-13 pd=2.6596e-06 as=5.7489e-13 ps=2.6231e-06 nf=1 m=144 par=144
XMpar2 a_15014_14058.t6 a_15014_14058.t5 vdd.t2 vdd.t2 pfet_03v3 w=10u l=0.4u ad=2.8000e-12 pd=1.0560e-05 as=2.9333e-12 ps=1.1003e-05 nf=1 m=48 par=48
XMpar3 a_1433_8302.t0 a_14894_4791.t164 a_15014_14058.t101 vss.t116 nfet_03v3 w=10u l=0.45u ad=3.2000e-12 pd=1.1890e-05 as=2.8000e-12 ps=1.0560e-05 nf=1 m=16 par=16
XMpar4 a_11556_14266.t1 a_11556_14266.t0 vdd.t2 vdd.t2 pfet_03v3 w=10u l=0.4u ad=2.8000e-12 pd=1.0560e-05 as=3.2000e-12 ps=1.1890e-05 nf=1 m=16 par=16
XMpar5 a_1327_1086.t0 a_6133_1294.t0 a_6133_1294.t1 vdd.t2 pfet_03v3 w=10u l=0.4u ad=3.2000e-12 pd=1.1890e-05 as=2.8000e-12 ps=1.0560e-05 nf=1 m=16 par=16
XMpar6 a_1327_1086.t0 a_1327_1086.t15 vdd.t2 vdd.t2 pfet_03v3 w=10u l=0.4u ad=2.8000e-12 pd=1.0560e-05 as=3.2000e-12 ps=1.1890e-05 nf=1 m=16 par=16
XMpar7 a_1433_8302.t10 ib.t0 vss.t133 vss.t132 nfet_03v3 w=8.56u l=0.36u ad=2.9446e-12 pd=1.0960e-05 as=2.3968e-12 ps=9.1200e-06 nf=1 m=30 par=30
XMpar8 a_1327_4628.t101 a_8930_21309.t164 a_1433_8302.t0 vss.t116 nfet_03v3 w=10u l=0.45u ad=2.8000e-12 pd=1.0560e-05 as=3.2000e-12 ps=1.1890e-05 nf=1 m=16 par=16
XMpar9 out.t0 a_11556_14266.t0 vdd.t2 vdd.t2 pfet_03v3 w=10u l=0.4u ad=2.8000e-12 pd=1.0560e-05 as=2.8000e-12 ps=1.0560e-05 nf=1 m=16 par=16
XMpar10 a_1327_4628.t6 a_1327_4628.t5 vdd.t2 vdd.t2 pfet_03v3 w=10u l=0.4u ad=2.8000e-12 pd=1.0560e-05 as=2.9333e-12 ps=1.1003e-05 nf=1 m=48 par=48
XMpar11 a_1327_4628.t0 a_6133_1294.t37 a_8930_21309.t15 vdd.t52 pfet_03v3 w=6.5u l=0.4u ad=2.2360e-12 pd=8.4880e-06 as=2.2360e-12 ps=8.4880e-06 nf=1 m=5 par=5
XMpar12 a_7556_10845.t0 a_15014_14058.t117 out.t9 vss.t116 nfet_03v3 w=10u l=0.45u ad=3.2000e-12 pd=1.1890e-05 as=2.8000e-12 ps=1.0560e-05 nf=1 m=16 par=16
XMpar13 a_11556_14266.t32 a_1327_4628.t117 a_7556_10845.t0 vss.t116 nfet_03v3 w=10u l=0.45u ad=2.8000e-12 pd=1.0560e-05 as=3.2000e-12 ps=1.1890e-05 nf=1 m=16 par=16
XMpar14 a_1809_8302.t288 ib.t0 vss.t133 vss.t132 nfet_03v3 w=8.56u l=0.36u ad=2.9446e-12 pd=1.0960e-05 as=2.3968e-12 ps=9.1200e-06 nf=1 m=10 par=10
XMpar15 a_6777_1294.t1 a_6777_1294.t0 vdd.t1 vdd.t0 pfet_03v3 w=9.34u l=0.36u ad=2.8145e-12 pd=1.0565e-05 as=2.8145e-12 ps=1.0565e-05 nf=1 m=15 par=15
XMpar16 a_6133_1294.t32 ib.t0 vss.t133 vss.t132 nfet_03v3 w=8.56u l=0.36u ad=4.0403e-12 pd=1.4640e-05 as=2.3968e-12 ps=9.1200e-06 nf=1 m=5 par=5
XMpar17 a_8930_21309.t0 a_6777_1294.t0 vdd.t1 vdd.t0 pfet_03v3 w=9.34u l=0.36u ad=2.8145e-12 pd=1.0565e-05 as=2.8145e-12 ps=1.0565e-05 nf=1 m=15 par=15
XMpar18 a_7556_10845.t8 ib.t0 vss.t133 vss.t132 nfet_03v3 w=8.56u l=0.36u ad=2.3968e-12 pd=9.1200e-06 as=2.9446e-12 ps=1.0960e-05 nf=1 m=10 par=10
XMpar19 a_14894_4791.t159 a_6133_1294.t37 a_15014_14058.t0 vdd.t52 pfet_03v3 w=6.5u l=0.4u ad=2.2360e-12 pd=8.4880e-06 as=2.2360e-12 ps=8.4880e-06 nf=1 m=5 par=5
XMpar20 ib.t1 ib.t0 vss.t133 vss.t132 nfet_03v3 w=8.56u l=0.36u ad=4.0403e-12 pd=1.4640e-05 as=2.9446e-12 ps=1.0960e-05 nf=1 m=5 par=5
XMpar21 a_14894_4791.t0 a_6777_1294.t0 vdd.t1 vdd.t0 pfet_03v3 w=9.34u l=0.36u ad=2.8145e-12 pd=1.0565e-05 as=2.8145e-12 ps=1.0565e-05 nf=1 m=15 par=15
XMpar22 a_6777_1294.t30 ib.t0 vss.t133 vss.t132 nfet_03v3 w=8.56u l=0.36u ad=4.0403e-12 pd=1.4640e-05 as=2.3968e-12 ps=9.1200e-06 nf=1 m=5 par=5
X148 out.t32 vss.t57 cap_mim_2f0fF c_width=19.37u c_length=19.37u
X369 out.t32 vss.t57 cap_mim_2f0fF c_width=19.37u c_length=19.37u
X390 out.t32 vss.t57 cap_mim_2f0fF c_width=19.37u c_length=19.37u
X610 out.t32 vss.t57 cap_mim_2f0fF c_width=19.37u c_length=19.37u
Rpar0 a_11556_14266.t0 a_11556_14266.t1 18.6176
Rpar1 a_11556_14266.t0 a_11556_14266.t32 266.5965
Rpar2 a_11556_14266.t1 a_11556_14266.t32 39.6396
Rpar3 a_1327_1086.t0 a_1327_1086.t15 20.0698
Rpar4 a_1327_4628.t0 a_1327_4628.t6 84.5870
Rpar5 a_1327_4628.t0 a_1327_4628.t101 141.9080
Rpar6 a_1327_4628.t0 a_1327_4628.t5 1647.4694
Rpar7 a_1327_4628.t0 a_1327_4628.t117 211.9890
Rpar8 a_1327_4628.t6 a_1327_4628.t101 125.5366
Rpar9 a_1327_4628.t6 a_1327_4628.t5 15.1014
Rpar10 a_1327_4628.t6 a_1327_4628.t117 187.5325
Rpar11 a_1327_4628.t101 a_1327_4628.t5 2445.0274
Rpar12 a_1327_4628.t101 a_1327_4628.t117 33.6053
Rpar13 a_1327_4628.t5 a_1327_4628.t117 3652.4983
Rpar14 a_1433_8302.t0 a_1433_8302.t10 53.9314
Rpar15 a_14894_4791.t0 a_14894_4791.t15 174.0664
Rpar16 a_14894_4791.t0 a_14894_4791.t159 60.4274
Rpar17 a_14894_4791.t0 a_14894_4791.t164 51.4302
Rpar18 a_14894_4791.t15 a_14894_4791.t159 581.8631
Rpar19 a_14894_4791.t15 a_14894_4791.t164 117.6563
Rpar20 a_14894_4791.t159 a_14894_4791.t164 171.9190
Rpar21 a_15014_14058.t0 a_15014_14058.t6 84.5870
Rpar22 a_15014_14058.t0 a_15014_14058.t101 141.9080
Rpar23 a_15014_14058.t0 a_15014_14058.t5 1647.4690
Rpar24 a_15014_14058.t0 a_15014_14058.t117 211.9890
Rpar25 a_15014_14058.t6 a_15014_14058.t101 125.5366
Rpar26 a_15014_14058.t6 a_15014_14058.t5 15.1014
Rpar27 a_15014_14058.t6 a_15014_14058.t117 187.5325
Rpar28 a_15014_14058.t101 a_15014_14058.t5 2445.0268
Rpar29 a_15014_14058.t101 a_15014_14058.t117 33.6053
Rpar30 a_15014_14058.t5 a_15014_14058.t117 3652.4974
Rpar31 a_1809_8302.t0 a_1809_8302.t288 61.7983
Rpar32 a_6133_1294.t0 a_6133_1294.t1 21.0000
Rpar33 a_6133_1294.t0 a_6133_1294.t32 872.1606
Rpar34 a_6133_1294.t0 a_6133_1294.t37 859.3209
Rpar35 a_6133_1294.t1 a_6133_1294.t32 56.2601
Rpar36 a_6133_1294.t1 a_6133_1294.t37 55.4319
Rpar37 a_6133_1294.t32 a_6133_1294.t37 152.3025
Rpar38 a_6777_1294.t0 a_6777_1294.t1 18.8048
Rpar39 a_6777_1294.t0 a_6777_1294.t30 66.4238
Rpar40 a_6777_1294.t1 a_6777_1294.t30 221.5463
Rpar41 a_7556_10845.t0 a_7556_10845.t8 43.7642
Rpar42 a_8930_21309.t0 a_8930_21309.t20 174.0664
Rpar43 a_8930_21309.t0 a_8930_21309.t15 60.4274
Rpar44 a_8930_21309.t0 a_8930_21309.t164 51.4302
Rpar45 a_8930_21309.t20 a_8930_21309.t15 581.8631
Rpar46 a_8930_21309.t20 a_8930_21309.t164 117.6563
Rpar47 a_8930_21309.t15 a_8930_21309.t164 171.9190
Rpar48 ib ib.t0 5.3591
Rpar49 ib ib.t1 1133.3151
Rpar50 ib.t0 ib.t1 20.9086
Rpar51 inn inn.t0 1.6311
Rpar52 inp inp.t0 1.6311
Rpar53 out out.t0 39.4608
Rpar54 out out.t9 1.7149
Rpar55 out out.t32 100.6824
Rpar56 out.t0 out.t32 97.3648
Rpar57 vdd vdd.t0 494.4372
Rpar58 vdd vdd.t1 3330.5097
Rpar59 vdd vdd.t2 84.5906
Rpar60 vdd vdd.t52 5555.8483
Rpar61 vdd.t0 vdd.t1 2.2957
Rpar62 vdd.t0 vdd.t2 36.2386
Rpar63 vdd.t0 vdd.t52 367.2448
Rpar64 vdd.t1 vdd.t2 244.1017
Rpar65 vdd.t1 vdd.t52 2473.7471
Rpar66 vdd.t2 vdd.t52 25.0751
Rpar67 vss vss.t0 4702.2083
Rpar68 vss vss.t116 1890.6975
Rpar69 vss vss.t132 45.1439
Rpar70 vss vss.t133 119.7014
Rpar71 vss.t0 vss.t116 60.1196
Rpar72 vss.t0 vss.t132 162.2516
Rpar73 vss.t0 vss.t133 744.6783
Rpar74 vss.t0 vss.t57 1141.4370
Rpar75 vss.t116 vss.t132 73.4004
Rpar76 vss.t116 vss.t133 265.8263
Rpar77 vss.t116 vss.t57 73.0563
Rpar78 vss.t132 vss.t133 2.1231
Rpar79 vss.t132 vss.t57 1228.8835
Rpar80 vss.t133 vss.t57 4660.6018
Cpar0 a_11556_14266.t0 vss 3.14179e-14
Cpar1 a_11556_14266.t1 vss 3.20494e-14
Cpar2 a_11556_14266.t32 vss 2.81721e-14
Cpar3 a_1327_1086.t0 vss 6.58983e-14
Cpar4 a_1327_1086.t15 vss 1.50772e-14
Cpar5 a_1327_4628.t0 vss 9.47911e-15
Cpar6 a_1327_4628.t101 vss 2.86657e-14
Cpar7 a_1327_4628.t117 vss 1.72514e-14
Cpar8 a_1327_4628.t5 vss 4.43513e-14
Cpar9 a_1327_4628.t6 vss 8.21606e-14
Cpar10 a_1433_8302.t0 vss 3.94325e-14
Cpar11 a_1433_8302.t10 vss 3.68735e-14
Cpar12 a_14894_4791.t0 vss 3.44649e-14
Cpar13 a_14894_4791.t15 vss 8.78806e-14
Cpar14 a_14894_4791.t159 vss 1.06142e-14
Cpar15 a_14894_4791.t164 vss 2.41326e-14
Cpar16 a_15014_14058.t0 vss 9.34263e-15
Cpar17 a_15014_14058.t101 vss 2.82529e-14
Cpar18 a_15014_14058.t117 vss 1.70030e-14
Cpar19 a_15014_14058.t5 vss 4.37131e-14
Cpar20 a_15014_14058.t6 vss 8.09774e-14
Cpar21 a_1809_8302.t0 vss 1.60930e-13
Cpar22 a_1809_8302.t288 vss 3.09024e-14
Cpar23 a_6133_1294.t0 vss 1.27314e-14
Cpar24 a_6133_1294.t1 vss 2.70705e-14
Cpar25 a_6133_1294.t32 vss 1.20073e-14
Cpar26 a_6133_1294.t37 vss 6.99240e-15
Cpar27 a_6777_1294.t0 vss 3.53438e-14
Cpar28 a_6777_1294.t1 vss 2.71617e-14
Cpar29 a_6777_1294.t30 vss 1.45064e-14
Cpar30 a_7556_10845.t0 vss 5.25842e-14
Cpar31 a_7556_10845.t8 vss 1.38463e-14
Cpar32 a_8930_21309.t0 vss 3.50949e-14
Cpar33 a_8930_21309.t15 vss 1.08082e-14
Cpar34 a_8930_21309.t164 vss 2.45737e-14
Cpar35 a_8930_21309.t20 vss 8.94872e-14
Cpar36 ib vdd 1.57512e-15
Cpar37 ib vss 6.49301e-14
Cpar38 ib.t0 vss 1.28732e-14
Cpar39 ib.t1 vss 5.31259e-15
Cpar40 inn inp 2.33310e-16
Cpar41 inn out 3.72400e-17
Cpar42 inn vdd 8.77800e-17
Cpar43 inn vss 4.96653e-14
Cpar44 inn.t0 vss 3.14765e-14
Cpar45 inp vdd 1.51310e-16
Cpar46 inp vss 4.98118e-14
Cpar47 inp.t0 vss 3.15141e-14
Cpar48 out vdd 3.35034e-14
Cpar49 out vss 3.36478e-14
Cpar50 out.t0 vss 3.41213e-15
Cpar51 out.t32 vss 6.63912e-14
Cpar52 out.t9 vss 2.83118e-15
Cpar53 vdd vss 5.10065e-13
Cpar54 vdd.t0 vss 7.26335e-14
Cpar55 vdd.t1 vss 3.86952e-14
Cpar56 vdd.t2 vss 3.89502e-13
Cpar57 vdd.t52 vss 2.03579e-14
.ends opamp_dut

Vdd vdd 0 3.300000
Vss vss 0 0
Ibias vdd ib 4.791670e-05
Vinp inp 0 DC 2.062300 AC 1 PWL(0 2.062300 3.000000e-09 2.062300 3.300000e-09 2.072300)
Rfb out inn 1m
Cload out 0 2.000000e-12
Xdut vdd vss inp inn out ib opamp_dut
.end
