* opa1000[0362]: 200f/nmos_5t_3v3_i2u_weak (nmos_5t, VDD=3.3V, CL=0.2pF, Iref=0.5uA)
.include "pdk_opa.inc"
.temp 27
.option gmin=1e-12 rshunt=1e12 reltol=1e-3 abstol=1e-12 vntol=1e-5 method=gear
* Post-PEX R+C extracted netlist for nmos_5t_3v3_i2u_weak
.subckt opamp_dut vdd vss inp inn out ib
XMpar0 a_1462_2820.t0 ib.t0 vss.t1 vss.t0 nfet_03v3 w=0.62u l=2.6u ad=1.7360e-13 pd=1.1800e-06 as=2.2320e-13 ps=1.4950e-06 nf=1 m=8 par=8
XMpar1 a_1462_2820.t8 inn.t0 out.t5 vss.t20 nfet_03v3 w=1.98u l=4.5u ad=8.7120e-13 pd=3.8500e-06 as=7.1280e-13 ps=3.1950e-06 nf=1 m=8 par=8
XMpar2 a_2016_6751.t1 a_2016_6751.t0 vdd.t1 vdd.t0 pfet_03v3 w=1.77u l=4.25u ad=6.8440e-13 pd=3.1333e-06 as=4.9560e-13 ps=2.3300e-06 nf=1 m=6 par=6
XMpar3 ib.t1 ib.t0 vss.t1 vss.t0 nfet_03v3 w=0.62u l=2.6u ad=1.7360e-13 pd=1.1800e-06 as=1.7360e-13 ps=1.1800e-06 nf=1 m=2 par=2
XMpar4 a_1462_2820.t8 inp.t0 a_2016_6751.t12 vss.t20 nfet_03v3 w=1.98u l=4.5u ad=8.7120e-13 pd=3.8500e-06 as=7.1280e-13 ps=3.1950e-06 nf=1 m=8 par=8
XMpar5 out.t0 a_2016_6751.t0 vdd.t1 vdd.t0 pfet_03v3 w=1.77u l=4.25u ad=6.8440e-13 pd=3.1333e-06 as=4.9560e-13 ps=2.3300e-06 nf=1 m=6 par=6
Rpar0 a_1462_2820.t0 a_1462_2820.t8 38.4252
Rpar1 a_2016_6751.t0 a_2016_6751.t1 8.4995
Rpar2 a_2016_6751.t0 a_2016_6751.t12 123.7032
Rpar3 a_2016_6751.t1 a_2016_6751.t12 54.5627
Rpar4 ib ib.t0 19.9342
Rpar5 ib ib.t1 18.2314
Rpar6 ib.t0 ib.t1 88.6765
Rpar7 inn inn.t0 2.3318
Rpar8 inp inp.t0 2.3318
Rpar9 out out.t0 5.4722
Rpar10 out out.t5 208.6577
Rpar11 out.t0 out.t5 51.1281
Rpar12 vdd vdd.t0 22.2289
Rpar13 vdd vdd.t1 211.0723
Rpar14 vdd.t0 vdd.t1 12.7349
Rpar15 vss vss.t0 42.6996
Rpar16 vss vss.t1 118.6228
Rpar17 vss vss.t20 48.7481
Rpar18 vss.t0 vss.t1 10.2452
Rpar19 vss.t0 vss.t20 1.6685
Rpar20 vss.t1 vss.t20 11.1362
Cpar0 a_1462_2820.t0 vss 4.33644e-15
Cpar1 a_1462_2820.t8 vss 1.86168e-14
Cpar2 a_2016_6751.t0 vss 3.72118e-14
Cpar3 a_2016_6751.t1 vss 8.74954e-15
Cpar4 a_2016_6751.t12 vss 1.09518e-14
Cpar5 ib inn 2.56900e-17
Cpar6 ib inp 3.37400e-17
Cpar7 ib vss 2.01746e-14
Cpar8 ib.t0 vss 2.99068e-15
Cpar9 ib.t1 vss 1.28920e-16
Cpar10 inn inp 1.09030e-16
Cpar11 inn out 4.23330e-15
Cpar12 inn vss 1.67836e-14
Cpar13 inn.t0 vss 6.16055e-15
Cpar14 inp vss 1.66639e-14
Cpar15 inp.t0 vss 6.21640e-15
Cpar16 out vdd 8.74491e-15
Cpar17 out vss 1.25219e-14
Cpar18 out.t0 vss 8.07868e-15
Cpar19 out.t5 vss 1.44797e-14
Cpar20 vdd vss 7.95495e-14
Cpar21 vdd.t0 vss 3.39985e-14
Cpar22 vdd.t1 vss 5.55696e-15
.ends opamp_dut

Vdd vdd 0 3.300000
Vss vss 0 0
Ibias vdd ib 5.000000e-07
Vinp inp 0 DC 1.645000 AC 1 PWL(0 1.645000 1.325243e-08 1.645000 1.457767e-08 1.655000)
Rfb out inn 1m
Cload out 0 2.000000e-13
Xdut vdd vss inp inn out ib opamp_dut
.end
