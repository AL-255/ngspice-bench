* opa1000[0724]: 2p/rail_to_rail_1v8_10u_100u_weak (rail_to_rail, VDD=1.8V, CL=2.0pF, Iref=5.3125uA)
.include "pdk_opa.inc"
.temp 27
.option gmin=1e-12 rshunt=1e12 reltol=1e-3 abstol=1e-12 vntol=1e-5 method=gear
* Post-PEX R+C extracted netlist for rail_to_rail_1v8_10u_100u_weak
.subckt opamp_dut vdd vss inp inn out ib
XMpar0 a_1065_1204.t0 inp.t2 a_5618_15217.t4 vdd.t4 pfet_03v3 w=1.83u l=0.6u ad=6.2952e-13 pd=2.8840e-06 as=5.1240e-13 ps=2.3900e-06 nf=1 m=10 par=10
XMpar1 out.t1 ib.t0 vss.t14 vss.t13 nfet_03v3 w=3.76u l=1.5u ad=1.0528e-12 pd=4.3200e-06 as=1.9552e-12 ps=7.6200e-06 nf=1 m=8 par=8
XMpar2 ib.t1 ib.t0 vss.t14 vss.t13 nfet_03v3 w=3.76u l=1.5u ad=2.2560e-12 pd=8.7200e-06 as=1.0528e-12 ps=4.3200e-06 nf=1 m=2 par=2
XMpar3 a_7640_1041.t6 a_5618_15217.t0 vss.t1 vss.t0 nfet_03v3 w=1.07u l=1.25u ad=2.9960e-13 pd=1.6300e-06 as=2.9960e-13 ps=1.6300e-06 nf=1 m=2 par=2
XMpar4 a_5618_15217.t1 a_5618_15217.t0 vss.t1 vss.t0 nfet_03v3 w=1.07u l=1.25u ad=6.4200e-13 pd=3.3400e-06 as=2.9960e-13 ps=1.6300e-06 nf=1 m=2 par=2
XMpar5 a_1065_1204.t0 inn.t2 a_7392_13303.t4 vdd.t4 pfet_03v3 w=1.83u l=0.6u ad=6.2952e-13 pd=2.8840e-06 as=5.1240e-13 ps=2.3900e-06 nf=1 m=10 par=10
XMpar6 a_3250_4740.t0 inp.t0 a_832_13598.t4 vss.t4 nfet_03v3 w=2.07u l=0.6u ad=1.2420e-12 pd=5.3400e-06 as=5.7960e-13 ps=2.6300e-06 nf=1 m=2 par=2
XMpar7 out.t2 a_832_13598.t7 vdd.t1 vdd.t0 pfet_03v3 w=9.21u l=0.63u ad=2.5788e-12 pd=9.7700e-06 as=3.3156e-12 ps=1.2232e-05 nf=1 m=8 par=8
XMpar8 a_832_13598.t2 a_7392_13303.t0 vss.t1 vss.t0 nfet_03v3 w=1.07u l=1.25u ad=6.4200e-13 pd=3.3400e-06 as=2.9960e-13 ps=1.6300e-06 nf=1 m=2 par=2
XMpar9 a_832_13598.t0 a_7640_1041.t0 vdd.t1 vdd.t0 pfet_03v3 w=9.21u l=0.63u ad=5.5260e-12 pd=1.9620e-05 as=2.5788e-12 ps=9.7700e-06 nf=1 m=2 par=2
XMpar10 a_1185_996.t3 a_1185_996.t2 vdd.t19 vdd.t18 pfet_03v3 w=10u l=1.5u ad=2.8000e-12 pd=1.0560e-05 as=2.8000e-12 ps=1.0560e-05 nf=1 m=2 par=2
XMpar11 a_3250_4740.t0 inn.t0 a_7640_1041.t4 vss.t4 nfet_03v3 w=2.07u l=0.6u ad=1.2420e-12 pd=5.3400e-06 as=5.7960e-13 ps=2.6300e-06 nf=1 m=2 par=2
XMpar12 a_3250_4740.t2 ib.t0 vss.t14 vss.t13 nfet_03v3 w=3.76u l=1.5u ad=2.2560e-12 pd=8.7200e-06 as=1.0528e-12 ps=4.3200e-06 nf=1 m=2 par=2
XMpar13 a_1185_996.t0 ib.t0 vss.t14 vss.t13 nfet_03v3 w=3.76u l=1.5u ad=2.2560e-12 pd=8.7200e-06 as=1.0528e-12 ps=4.3200e-06 nf=1 m=2 par=2
XMpar14 a_7392_13303.t1 a_7392_13303.t0 vss.t1 vss.t0 nfet_03v3 w=1.07u l=1.25u ad=2.9960e-13 pd=1.6300e-06 as=2.9960e-13 ps=1.6300e-06 nf=1 m=2 par=2
XMpar15 a_7640_1041.t1 a_7640_1041.t0 vdd.t1 vdd.t0 pfet_03v3 w=9.21u l=0.63u ad=2.5788e-12 pd=9.7700e-06 as=2.5788e-12 ps=9.7700e-06 nf=1 m=2 par=2
XMpar16 a_1065_1204.t20 a_1185_996.t2 vdd.t19 vdd.t18 pfet_03v3 w=10u l=1.5u ad=6.0000e-12 pd=2.1200e-05 as=2.8000e-12 ps=1.0560e-05 nf=1 m=2 par=2
X52 a_832_13598.t6 a_2236_13598.t0 vss.t37 ppolyf_u_1k r_width=1u r_length=6.36u
X55 a_2236_13598.t1 out.t0 cap_mim_2f0fF c_width=18.03u c_length=18.03u
X60 a_2236_13598.t1 out.t0 cap_mim_2f0fF c_width=18.03u c_length=18.03u
Rpar0 a_1065_1204.t0 a_1065_1204.t20 74.7803
Rpar1 a_1185_996.t0 a_1185_996.t2 160.1590
Rpar2 a_1185_996.t0 a_1185_996.t3 57.4262
Rpar3 a_1185_996.t2 a_1185_996.t3 30.5251
Rpar4 a_2236_13598.t0 a_2236_13598.t1 83.9614
Rpar5 a_3250_4740.t0 a_3250_4740.t2 55.0675
Rpar6 a_5618_15217.t0 a_5618_15217.t1 21.4451
Rpar7 a_5618_15217.t0 a_5618_15217.t4 179.3078
Rpar8 a_5618_15217.t1 a_5618_15217.t4 92.0057
Rpar9 a_7392_13303.t0 a_7392_13303.t1 29.7107
Rpar10 a_7392_13303.t0 a_7392_13303.t4 128.9305
Rpar11 a_7392_13303.t1 a_7392_13303.t4 110.3968
Rpar12 a_7640_1041.t0 a_7640_1041.t1 40.5188
Rpar13 a_7640_1041.t0 a_7640_1041.t4 1240.1273
Rpar14 a_7640_1041.t0 a_7640_1041.t6 747.0109
Rpar15 a_7640_1041.t1 a_7640_1041.t4 234.1277
Rpar16 a_7640_1041.t1 a_7640_1041.t6 141.0307
Rpar17 a_7640_1041.t4 a_7640_1041.t6 73.3048
Rpar18 a_832_13598.t0 a_832_13598.t7 64.2570
Rpar19 a_832_13598.t0 a_832_13598.t2 883.9946
Rpar20 a_832_13598.t0 a_832_13598.t4 283.7671
Rpar21 a_832_13598.t0 a_832_13598.t6 1606.6660
Rpar22 a_832_13598.t7 a_832_13598.t2 1121.3059
Rpar23 a_832_13598.t7 a_832_13598.t4 359.9453
Rpar24 a_832_13598.t7 a_832_13598.t6 2037.9808
Rpar25 a_832_13598.t2 a_832_13598.t4 119.5843
Rpar26 a_832_13598.t2 a_832_13598.t6 80.2329
Rpar27 a_832_13598.t4 a_832_13598.t6 217.3452
Rpar28 ib ib.t0 16.1494
Rpar29 ib ib.t1 7.3644
Rpar30 ib.t0 ib.t1 21.1904
Rpar31 inn inn.t0 26.0329
Rpar32 inn inn.t2 35.9504
Rpar33 inp inp.t0 26.0816
Rpar34 inp inp.t2 35.9018
Rpar35 out out.t0 78.5302
Rpar36 out out.t1 3.6448
Rpar37 out out.t2 55.5783
Rpar38 out.t0 out.t2 85.5303
Rpar39 vdd vdd.t0 651.5874
Rpar40 vdd vdd.t1 1923.7029
Rpar41 vdd vdd.t4 55.1831
Rpar42 vdd vdd.t18 247.8955
Rpar43 vdd vdd.t19 839.9838
Rpar44 vdd.t0 vdd.t1 3.8715
Rpar45 vdd.t0 vdd.t4 1076.7669
Rpar46 vdd.t0 vdd.t18 46.3383
Rpar47 vdd.t0 vdd.t19 157.0153
Rpar48 vdd.t1 vdd.t4 3178.9740
Rpar49 vdd.t1 vdd.t18 136.8060
Rpar50 vdd.t1 vdd.t19 463.5615
Rpar51 vdd.t4 vdd.t18 409.6544
Rpar52 vdd.t4 vdd.t19 1388.0972
Rpar53 vdd.t18 vdd.t19 9.3152
Rpar54 vss vss.t0 161.2148
Rpar55 vss vss.t1 435.7451
Rpar56 vss vss.t13 622.0919
Rpar57 vss vss.t14 74.3528
Rpar58 vss vss.t4 309.5411
Rpar59 vss vss.t37 4310.5124
Rpar60 vss.t0 vss.t1 7.7114
Rpar61 vss.t0 vss.t13 92.8111
Rpar62 vss.t0 vss.t14 120.9397
Rpar63 vss.t0 vss.t4 2.7562
Rpar64 vss.t0 vss.t37 602.9612
Rpar65 vss.t1 vss.t13 296.7300
Rpar66 vss.t1 vss.t14 331.9145
Rpar67 vss.t1 vss.t4 14.8738
Rpar68 vss.t1 vss.t37 1966.8100
Rpar69 vss.t13 vss.t14 12.8529
Rpar70 vss.t13 vss.t4 177.5461
Rpar71 vss.t13 vss.t37 12.5678
Rpar72 vss.t14 vss.t4 232.1267
Rpar73 vss.t14 vss.t37 135.3485
Rpar74 vss.t4 vss.t37 1152.9947
Cpar0 a_1065_1204.t0 vss 1.11186e-14
Cpar1 a_1065_1204.t20 vss 1.51528e-14
Cpar2 a_1185_996.t0 vss 5.52212e-15
Cpar3 a_1185_996.t2 vss 7.94708e-15
Cpar4 a_1185_996.t3 vss 3.95911e-15
Cpar5 a_2236_13598.t0 vss 1.49035e-16
Cpar6 a_2236_13598.t1 vss 7.58553e-15
Cpar7 a_3250_4740.t0 vss 5.33338e-15
Cpar8 a_3250_4740.t2 vss 9.24408e-15
Cpar9 a_5618_15217.t0 vss 4.07618e-15
Cpar10 a_5618_15217.t1 vss 2.78303e-15
Cpar11 a_5618_15217.t4 vss 5.04122e-15
Cpar12 a_7392_13303.t0 vss 4.01964e-15
Cpar13 a_7392_13303.t1 vss 1.59973e-15
Cpar14 a_7392_13303.t4 vss 3.71796e-15
Cpar15 a_7640_1041.t0 vss 4.72080e-15
Cpar16 a_7640_1041.t1 vss 7.68009e-15
Cpar17 a_7640_1041.t4 vss 2.95757e-15
Cpar18 a_7640_1041.t6 vss 3.57845e-15
Cpar19 a_832_13598.t0 vss 8.73115e-15
Cpar20 a_832_13598.t2 vss 3.53005e-15
Cpar21 a_832_13598.t4 vss 5.36637e-15
Cpar22 a_832_13598.t6 vss 2.47155e-15
Cpar23 a_832_13598.t7 vss 1.03581e-14
Cpar24 ib out 2.95565e-15
Cpar25 ib vdd 2.16850e-16
Cpar26 ib vss 2.24696e-14
Cpar27 ib.t0 vss 8.96791e-15
Cpar28 ib.t1 vss 1.80886e-15
Cpar29 inn inp 1.11070e-16
Cpar30 inn vdd 4.94357e-15
Cpar31 inn vss 4.85201e-15
Cpar32 inn.t0 vss 5.15566e-16
Cpar33 inn.t2 vss 5.94246e-15
Cpar34 inp vdd 4.96007e-15
Cpar35 inp vss 5.23672e-15
Cpar36 inp.t0 vss 5.23704e-16
Cpar37 inp.t2 vss 6.02362e-15
Cpar38 out vdd 1.25137e-14
Cpar39 out vss 1.99066e-14
Cpar40 out.t0 vss 1.50087e-14
Cpar41 out.t1 vss 3.42284e-15
Cpar42 out.t2 vss 6.50557e-15
Cpar43 vdd vss 1.22782e-13
Cpar44 vdd.t0 vss 1.85404e-14
Cpar45 vdd.t1 vss 1.13291e-14
Cpar46 vdd.t18 vss 1.15703e-14
Cpar47 vdd.t19 vss 4.97759e-15
Cpar48 vdd.t4 vss 1.50239e-14
.ends opamp_dut

Vdd vdd 0 1.800000
Vss vss 0 0
Ibias vdd ib 5.312500e-06
Vinp inp 0 DC 0.895000 AC 1 PWL(0 0.895000 1.069065e-08 0.895000 1.175971e-08 0.905000)
Rfb out inn 1m
Cload out 0 2.000000e-12
Xdut vdd vss inp inn out ib opamp_dut
.end
