* opa1000[0409]: 2p/nmos_5t_3v3_i10u_weak (nmos_5t, VDD=3.3V, CL=2.0pF, Iref=3.25uA)
.include "pdk_opa.inc"
.temp 27
.option gmin=1e-12 rshunt=1e12 reltol=1e-3 abstol=1e-12 vntol=1e-5 method=gear
* Post-PEX R+C extracted netlist for nmos_5t_3v3_i10u_weak
.subckt opamp_dut vdd vss inp inn out ib
XMpar0 out.t0 a_1590_6285.t0 vdd.t1 vdd.t0 pfet_03v3 w=2u l=2.25u ad=6.2400e-13 pd=2.8240e-06 as=6.2400e-13 ps=2.8240e-06 nf=1 m=20 par=20
XMpar1 a_1566_2907.t16 ib.t0 vss.t17 vss.t0 nfet_03v3 w=3.38u l=2.25u ad=9.4640e-13 pd=3.9400e-06 as=1.2168e-12 ps=4.9450e-06 nf=1 m=8 par=8
XMpar2 a_1566_2907.t0 inp.t0 a_1590_6285.t40 vss.t0 nfet_03v3 w=1.86u l=1.63u ad=6.6960e-13 pd=3.0450e-06 as=5.2080e-13 ps=2.4200e-06 nf=1 m=8 par=8
XMpar3 a_1566_2907.t0 inn.t0 out.t12 vss.t0 nfet_03v3 w=1.86u l=1.63u ad=6.6960e-13 pd=3.0450e-06 as=5.2080e-13 ps=2.4200e-06 nf=1 m=8 par=8
XMpar4 a_1590_6285.t1 a_1590_6285.t0 vdd.t1 vdd.t0 pfet_03v3 w=2u l=2.25u ad=6.8800e-13 pd=3.0880e-06 as=6.2400e-13 ps=2.8240e-06 nf=1 m=20 par=20
XMpar5 ib.t1 ib.t0 vss.t17 vss.t0 nfet_03v3 w=3.38u l=2.25u ad=9.4640e-13 pd=3.9400e-06 as=9.4640e-13 ps=3.9400e-06 nf=1 m=2 par=2
X19 out.t28 vss.t36 cap_mim_2f0fF c_width=9.69u c_length=9.68u
Rpar0 a_1566_2907.t0 a_1566_2907.t16 45.6353
Rpar1 a_1590_6285.t0 a_1590_6285.t1 5.0269
Rpar2 a_1590_6285.t0 a_1590_6285.t40 182.1338
Rpar3 a_1590_6285.t1 a_1590_6285.t40 66.1807
Rpar4 ib ib.t0 22.5874
Rpar5 ib ib.t1 10.5421
Rpar6 ib.t0 ib.t1 60.2426
Rpar7 inn inn.t0 1.7341
Rpar8 inp inp.t0 1.7827
Rpar9 out out.t0 3.5514
Rpar10 out out.t12 1789.4383
Rpar11 out out.t28 1707.8308
Rpar12 out.t0 out.t12 104.6870
Rpar13 out.t0 out.t28 99.9128
Rpar14 out.t12 out.t28 66.4283
Rpar15 vdd vdd.t0 19.6055
Rpar16 vdd vdd.t1 969.2066
Rpar17 vdd.t0 vdd.t1 9.3570
Rpar18 vss vss.t0 43.2167
Rpar19 vss vss.t17 489.0269
Rpar20 vss vss.t36 289.7616
Rpar21 vss.t0 vss.t17 4.3530
Rpar22 vss.t0 vss.t36 44.2075
Rpar23 vss.t17 vss.t36 387.4873
Cpar0 a_1566_2907.t0 vss 8.07394e-15
Cpar1 a_1566_2907.t16 vss 6.34763e-15
Cpar2 a_1590_6285.t0 vss 6.89335e-14
Cpar3 a_1590_6285.t1 vss 2.33452e-14
Cpar4 a_1590_6285.t40 vss 6.41044e-15
Cpar5 ib inp 1.35900e-17
Cpar6 ib out 1.36000e-17
Cpar7 ib vss 1.97527e-14
Cpar8 ib.t0 vss 3.84515e-15
Cpar9 ib.t1 vss 2.84149e-16
Cpar10 inn inp 5.12600e-17
Cpar11 inn out 9.66530e-16
Cpar12 inn vss 8.81307e-15
Cpar13 inn.t0 vss 1.56431e-15
Cpar14 inp vss 8.57411e-15
Cpar15 inp.t0 vss 1.60136e-15
Cpar16 out vdd 1.83694e-14
Cpar17 out vss 1.39720e-14
Cpar18 out.t0 vss 1.18020e-14
Cpar19 out.t12 vss 3.71438e-15
Cpar20 out.t28 vss 2.20356e-14
Cpar21 vdd vss 1.47686e-13
Cpar22 vdd.t0 vss 7.99107e-14
Cpar23 vdd.t1 vss 8.34446e-15
.ends opamp_dut

Vdd vdd 0 3.300000
Vss vss 0 0
Ibias vdd ib 3.250000e-06
Vinp inp 0 DC 1.645000 AC 1 PWL(0 1.645000 1.552508e-08 1.645000 1.707759e-08 1.655000)
Rfb out inn 1m
Cload out 0 2.000000e-12
Xdut vdd vss inp inn out ib opamp_dut
.end
