* opa1000[0491]: 2p/nmos_miller_3v3_i10u_weak (nmos_miller, VDD=3.3V, CL=2.0pF, Iref=1.4286uA)
.include "pdk_opa.inc"
.temp 27
.option gmin=1e-12 rshunt=1e12 reltol=1e-3 abstol=1e-12 vntol=1e-5 method=gear
* Post-PEX R+C extracted netlist for nmos_miller_3v3_i10u_weak
.subckt opamp_dut vdd vss inp inn out ib
XMpar0 a_5938_3647.t0 inp.t0 a_928_5486.t0 vss.t0 nfet_03v3 w=2.11u l=1.04u ad=1.2660e-12 pd=5.4200e-06 as=5.9080e-13 ps=2.6700e-06 nf=1 m=2 par=2
XMpar1 out.t1 ib.t0 vss.t3 vss.t2 nfet_03v3 w=1.49u l=2.25u ad=7.0328e-13 pd=3.3280e-06 as=6.0792e-13 ps=2.9020e-06 nf=1 m=10 par=10
XMpar2 out.t0 a_928_5486.t5 vdd.t1 vdd.t0 pfet_03v3 w=4.31u l=0.94u ad=1.2068e-12 pd=4.8700e-06 as=1.4826e-12 ps=5.8600e-06 nf=1 m=10 par=10
XMpar3 a_928_5486.t3 a_6396_1041.t2 vdd.t1 vdd.t0 pfet_03v3 w=4.31u l=0.94u ad=2.5860e-12 pd=9.8200e-06 as=1.2068e-12 ps=4.8700e-06 nf=1 m=2 par=2
XMpar4 a_5938_3647.t0 inn.t0 a_6396_1041.t0 vss.t0 nfet_03v3 w=2.11u l=1.04u ad=1.2660e-12 pd=5.4200e-06 as=5.9080e-13 ps=2.6700e-06 nf=1 m=2 par=2
XMpar5 a_5938_3647.t2 ib.t0 vss.t3 vss.t2 nfet_03v3 w=1.49u l=2.25u ad=8.9400e-13 pd=4.1800e-06 as=4.1720e-13 ps=2.0500e-06 nf=1 m=4 par=4
XMpar6 a_6396_1041.t3 a_6396_1041.t2 vdd.t1 vdd.t0 pfet_03v3 w=4.31u l=0.94u ad=1.2068e-12 pd=4.8700e-06 as=1.2068e-12 ps=4.8700e-06 nf=1 m=2 par=2
XMpar7 ib.t1 ib.t0 vss.t3 vss.t2 nfet_03v3 w=1.49u l=2.25u ad=8.9400e-13 pd=4.1800e-06 as=4.1720e-13 ps=2.0500e-06 nf=1 m=2 par=2
X11 a_928_5486.t2 a_4560_5486.t0 vss.t26 ppolyf_u_1k r_width=1u r_length=17.5u
X26 a_4560_5486.t1 out.t5 cap_mim_2f0fF c_width=14.37u c_length=14.36u
X27 a_4560_5486.t1 out.t5 cap_mim_2f0fF c_width=14.37u c_length=14.36u
Rpar0 a_4560_5486.t0 a_4560_5486.t1 74.7171
Rpar1 a_5938_3647.t0 a_5938_3647.t2 67.3146
Rpar2 a_6396_1041.t0 a_6396_1041.t2 134.0548
Rpar3 a_6396_1041.t0 a_6396_1041.t3 44.8813
Rpar4 a_6396_1041.t2 a_6396_1041.t3 29.3173
Rpar5 a_928_5486.t0 a_928_5486.t5 186.6708
Rpar6 a_928_5486.t0 a_928_5486.t2 98.4563
Rpar7 a_928_5486.t0 a_928_5486.t3 85.1998
Rpar8 a_928_5486.t5 a_928_5486.t2 332.8856
Rpar9 a_928_5486.t5 a_928_5486.t3 93.1623
Rpar10 a_928_5486.t2 a_928_5486.t3 151.9347
Rpar11 ib ib.t0 13.8431
Rpar12 ib ib.t1 11.8271
Rpar13 ib.t0 ib.t1 30.0072
Rpar14 inn inn.t0 11.2477
Rpar15 inp inp.t0 11.2963
Rpar16 out out.t0 73.1064
Rpar17 out out.t1 77.5292
Rpar18 out out.t5 20.7981
Rpar19 out.t0 out.t1 137.6844
Rpar20 vdd vdd.t0 165.3409
Rpar21 vdd vdd.t1 229.2336
Rpar22 vdd.t0 vdd.t1 3.4925
Rpar23 vss vss.t0 127.1600
Rpar24 vss vss.t2 244.1095
Rpar25 vss vss.t3 145.0551
Rpar26 vss vss.t26 85.4453
Rpar27 vss.t0 vss.t2 2.1148
Rpar28 vss.t0 vss.t3 26.1755
Rpar29 vss.t0 vss.t26 116.6704
Rpar30 vss.t2 vss.t3 15.6877
Rpar31 vss.t2 vss.t26 232.3267
Rpar32 vss.t3 vss.t26 151.0972
Cpar0 a_4560_5486.t0 vss 1.90682e-16
Cpar1 a_4560_5486.t1 vss 6.28296e-15
Cpar2 a_5938_3647.t0 vss 6.54146e-15
Cpar3 a_5938_3647.t2 vss 1.01085e-14
Cpar4 a_6396_1041.t0 vss 1.76114e-15
Cpar5 a_6396_1041.t2 vss 4.52291e-15
Cpar6 a_6396_1041.t3 vss 3.05597e-15
Cpar7 a_928_5486.t0 vss 2.01356e-15
Cpar8 a_928_5486.t2 vss 2.07245e-15
Cpar9 a_928_5486.t3 vss 4.18392e-15
Cpar10 a_928_5486.t5 vss 9.45934e-15
Cpar11 ib out 2.87750e-15
Cpar12 ib vdd 4.10790e-16
Cpar13 ib vss 3.30877e-14
Cpar14 ib.t0 vss 7.09894e-15
Cpar15 ib.t1 vss 6.35854e-16
Cpar16 inn inp 5.25900e-17
Cpar17 inn vdd 1.10300e-17
Cpar18 inn vss 1.86822e-15
Cpar19 inn.t0 vss 3.26469e-16
Cpar20 inp vss 1.89523e-15
Cpar21 inp.t0 vss 3.25022e-16
Cpar22 out vdd 8.86481e-15
Cpar23 out vss 2.26015e-14
Cpar24 out.t0 vss 5.49317e-15
Cpar25 out.t1 vss 5.41167e-15
Cpar26 out.t5 vss 1.20785e-14
Cpar27 vdd vss 6.31987e-14
Cpar28 vdd.t0 vss 1.28402e-14
Cpar29 vdd.t1 vss 8.81242e-15
.ends opamp_dut

Vdd vdd 0 3.300000
Vss vss 0 0
Ibias vdd ib 1.428600e-06
Vinp inp 0 DC 1.645000 AC 1 PWL(0 1.645000 2.330864e-08 1.645000 2.563950e-08 1.655000)
Rfb out inn 1m
Cload out 0 2.000000e-12
Xdut vdd vss inp inn out ib opamp_dut
.end
