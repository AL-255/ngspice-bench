* opa1000[0578]: 2p/pmos_5t_3v3_10u_100u_subth (pmos_5t, VDD=3.3V, CL=2.0pF, Iref=11.5uA)
.include "pdk_opa.inc"
.temp 27
.option gmin=1e-12 rshunt=1e12 reltol=1e-3 abstol=1e-12 vntol=1e-5 method=gear
* Post-PEX R+C extracted netlist for pmos_5t_3v3_10u_100u_subth
.subckt opamp_dut vdd vss inp inn out ib
XMpar0 out.t21 a_2194_11199.t64 vss.t1 vss.t0 nfet_03v3 w=1.93u l=1.6u ad=5.7673e-13 pd=2.6412e-06 as=5.7673e-13 ps=2.6412e-06 nf=1 m=34 par=34
XMpar1 a_1954_11199.t0 inp.t0 a_2194_11199.t0 vdd.t4 pfet_03v3 w=8u l=0.6u ad=2.4000e-12 pd=9.1000e-06 as=2.3200e-12 ps=8.8300e-06 nf=1 m=64 par=64
XMpar2 a_2194_11199.t65 a_2194_11199.t64 vss.t1 vss.t0 nfet_03v3 w=1.93u l=1.6u ad=5.7673e-13 pd=2.6412e-06 as=6.1306e-13 ps=2.7924e-06 nf=1 m=34 par=34
XMpar3 ib.t1 ib.t0 vss.t88 vss.t87 nfet_03v3 w=7.76u l=0.65u ad=4.6560e-12 pd=1.6720e-05 as=2.1728e-12 ps=8.3200e-06 nf=1 m=2 par=2
XMpar4 a_1954_11199.t0 inn.t0 out.t0 vdd.t4 pfet_03v3 w=8u l=0.6u ad=2.4000e-12 pd=9.1000e-06 as=2.3200e-12 ps=8.8300e-06 nf=1 m=64 par=64
XMpar5 a_1954_11199.t128 a_1571_6502.t2 vdd.t1 vdd.t0 pfet_03v3 w=10u l=0.65u ad=2.8000e-12 pd=1.0560e-05 as=3.6000e-12 ps=1.3220e-05 nf=1 m=8 par=8
XMpar6 a_1571_6502.t3 a_1571_6502.t2 vdd.t1 vdd.t0 pfet_03v3 w=10u l=0.65u ad=2.8000e-12 pd=1.0560e-05 as=2.8000e-12 ps=1.0560e-05 nf=1 m=2 par=2
XMpar7 a_1571_6502.t0 ib.t0 vss.t88 vss.t87 nfet_03v3 w=7.76u l=0.65u ad=2.1728e-12 pd=8.3200e-06 as=2.1728e-12 ps=8.3200e-06 nf=1 m=2 par=2
X180 out.t98 vss.t19 cap_mim_2f0fF c_width=14.79u c_length=14.79u
Rpar0 a_1571_6502.t0 a_1571_6502.t2 112.1153
Rpar1 a_1571_6502.t0 a_1571_6502.t3 43.1056
Rpar2 a_1571_6502.t2 a_1571_6502.t3 32.2356
Rpar3 a_1954_11199.t0 a_1954_11199.t128 42.4180
Rpar4 a_2194_11199.t0 a_2194_11199.t64 233.7667
Rpar5 a_2194_11199.t0 a_2194_11199.t65 82.1548
Rpar6 a_2194_11199.t64 a_2194_11199.t65 4.9738
Rpar7 ib ib.t0 32.0794
Rpar8 ib ib.t1 3.3127
Rpar9 ib.t0 ib.t1 225.7554
Rpar10 inn inn.t0 2.9313
Rpar11 inp inp.t0 2.9313
Rpar12 out out.t0 2954.9934
Rpar13 out out.t21 3.5625
Rpar14 out out.t98 2553.8617
Rpar15 out.t0 out.t21 98.8630
Rpar16 out.t0 out.t98 73.5377
Rpar17 out.t21 out.t98 85.4427
Rpar18 vdd vdd.t0 221.6239
Rpar19 vdd vdd.t1 712.5344
Rpar20 vdd vdd.t4 59.6652
Rpar21 vdd.t0 vdd.t1 5.7438
Rpar22 vdd.t0 vdd.t4 62.5296
Rpar23 vdd.t1 vdd.t4 201.0365
Rpar24 vss vss.t0 4347.6922
Rpar25 vss vss.t1 35.8513
Rpar26 vss vss.t19 385.0258
Rpar27 vss vss.t87 166.0369
Rpar28 vss vss.t88 142.9444
Rpar29 vss.t0 vss.t1 9.0953
Rpar30 vss.t0 vss.t19 6746.4661
Rpar31 vss.t0 vss.t87 436.2891
Rpar32 vss.t0 vss.t88 741.3865
Rpar33 vss.t1 vss.t19 332.2722
Rpar34 vss.t1 vss.t87 142.2635
Rpar35 vss.t1 vss.t88 122.9919
Rpar36 vss.t19 vss.t87 125.7589
Rpar37 vss.t19 vss.t88 108.2678
Rpar38 vss.t87 vss.t88 12.8872
Cpar0 a_1571_6502.t0 vss 2.73212e-15
Cpar1 a_1571_6502.t2 vss 1.02994e-14
Cpar2 a_1571_6502.t3 vss 4.25418e-15
Cpar3 a_1954_11199.t0 vss 1.98874e-13
Cpar4 a_1954_11199.t128 vss 1.77499e-14
Cpar5 a_2194_11199.t0 vss 5.79857e-14
Cpar6 a_2194_11199.t64 vss 5.30366e-14
Cpar7 a_2194_11199.t65 vss 1.94256e-14
Cpar8 ib vss 8.98687e-15
Cpar9 ib.t0 vss 4.58424e-16
Cpar10 ib.t1 vss 4.93061e-16
Cpar11 inn inp 1.01040e-16
Cpar12 inn out 1.88106e-14
Cpar13 inn vdd 2.68730e-14
Cpar14 inn vss 1.07475e-14
Cpar15 inn.t0 vss 5.14577e-14
Cpar16 inp vdd 2.69700e-14
Cpar17 inp vss 1.07448e-14
Cpar18 inp.t0 vss 5.15991e-14
Cpar19 out vdd 1.01107e-14
Cpar20 out vss 4.17563e-14
Cpar21 out.t0 vss 5.63817e-14
Cpar22 out.t21 vss 1.81314e-14
Cpar23 out.t98 vss 5.21026e-14
Cpar24 vdd vss 3.33373e-13
Cpar25 vdd.t0 vss 1.09576e-14
Cpar26 vdd.t1 vss 5.76926e-15
Cpar27 vdd.t4 vss 9.35443e-14
.ends opamp_dut

Vdd vdd 0 3.300000
Vss vss 0 0
Ibias vdd ib 1.150000e-05
Vinp inp 0 DC 1.480000 AC 1 PWL(0 1.480000 3.595103e-09 1.480000 3.954614e-09 1.490000)
Rfb out inn 1m
Cload out 0 2.000000e-12
Xdut vdd vss inp inn out ib opamp_dut
.end
