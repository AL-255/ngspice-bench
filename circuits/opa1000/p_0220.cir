* opa1000[0220]: 2p/folded_cascode_nmos_1v8_1u_10u_subth (folded_cascode_nmos, VDD=1.8V, CL=2.0pF, Iref=1.4444uA)
.include "pdk_opa.inc"
.temp 27
.option gmin=1e-12 rshunt=1e12 reltol=1e-3 abstol=1e-12 vntol=1e-5 method=gear
* Post-PEX R+C extracted netlist for folded_cascode_nmos_1v8_1u_10u_subth
.subckt opamp_dut vdd vss inp inn out ib
XMpar0 a_1746_1249.t0 inp.t0 a_2266_1249.t0 vss.t0 nfet_03v3 w=8u l=2u ad=2.5600e-12 pd=9.6400e-06 as=2.2400e-12 ps=8.5600e-06 nf=1 m=64 par=64
XMpar1 a_10254_17213.t60 inn.t0 a_1746_1249.t0 vss.t0 nfet_03v3 w=8u l=2u ad=2.2400e-12 pd=8.5600e-06 as=2.5600e-12 ps=9.6400e-06 nf=1 m=64 par=64
XMpar2 a_2266_1249.t66 ib.t10 a_5110_17213.t0 vdd.t10 pfet_03v3 w=2.01u l=1.3u ad=6.5469e-13 pd=2.9486e-06 as=5.6280e-13 ps=2.5700e-06 nf=1 m=56 par=56
XMpar3 a_10254_17213.t1 ib.t10 out.t0 vdd.t10 pfet_03v3 w=2.01u l=1.3u ad=6.5469e-13 pd=2.9486e-06 as=5.6280e-13 ps=2.5700e-06 nf=1 m=56 par=56
XMpar4 a_2266_1249.t64 a_1290_17005.t2 vdd.t1 vdd.t0 pfet_03v3 w=10u l=1.63u ad=2.8000e-12 pd=1.0560e-05 as=4.4000e-12 ps=1.5880e-05 nf=1 m=4 par=4
XMpar5 out.t8 a_5110_17213.t56 vss.t17 vss.t16 nfet_03v3 w=5.12u l=2.5u ad=1.4336e-12 pd=5.6800e-06 as=1.4336e-12 ps=5.6800e-06 nf=1 m=2 par=2
XMpar6 a_10254_17213.t0 a_1290_17005.t2 vdd.t1 vdd.t0 pfet_03v3 w=10u l=1.63u ad=2.8000e-12 pd=1.0560e-05 as=4.4000e-12 ps=1.5880e-05 nf=1 m=4 par=4
XMpar7 a_1746_1249.t64 ib.t0 vss.t17 vss.t16 nfet_03v3 w=5.12u l=2.5u ad=1.4336e-12 pd=5.6800e-06 as=1.4336e-12 ps=5.6800e-06 nf=1 m=4 par=4
XMpar8 ib.t1 ib.t0 vss.t17 vss.t16 nfet_03v3 w=5.12u l=2.5u ad=3.0720e-12 pd=1.1440e-05 as=1.4336e-12 ps=5.6800e-06 nf=1 m=2 par=2
XMpar9 a_1290_17005.t0 ib.t0 vss.t17 vss.t16 nfet_03v3 w=5.12u l=2.5u ad=1.4336e-12 pd=5.6800e-06 as=1.4336e-12 ps=5.6800e-06 nf=1 m=2 par=2
XMpar10 a_1290_17005.t3 a_1290_17005.t2 vdd.t1 vdd.t0 pfet_03v3 w=10u l=1.63u ad=2.8000e-12 pd=1.0560e-05 as=6.0000e-12 ps=2.1200e-05 nf=1 m=2 par=2
XMpar11 a_5110_17213.t57 a_5110_17213.t56 vss.t17 vss.t16 nfet_03v3 w=5.12u l=2.5u ad=3.0720e-12 pd=1.1440e-05 as=1.4336e-12 ps=5.6800e-06 nf=1 m=2 par=2
Rpar0 a_10254_17213.t0 a_10254_17213.t1 64.3941
Rpar1 a_10254_17213.t0 a_10254_17213.t60 68.0475
Rpar2 a_10254_17213.t1 a_10254_17213.t60 205.9024
Rpar3 a_1290_17005.t0 a_1290_17005.t2 67.5989
Rpar4 a_1290_17005.t0 a_1290_17005.t3 95.3063
Rpar5 a_1290_17005.t2 a_1290_17005.t3 31.5304
Rpar6 a_1746_1249.t0 a_1746_1249.t64 49.8143
Rpar7 a_2266_1249.t0 a_2266_1249.t66 205.9024
Rpar8 a_2266_1249.t0 a_2266_1249.t64 68.0475
Rpar9 a_2266_1249.t66 a_2266_1249.t64 64.3941
Rpar10 a_5110_17213.t0 a_5110_17213.t56 297.3430
Rpar11 a_5110_17213.t0 a_5110_17213.t57 76.4164
Rpar12 a_5110_17213.t56 a_5110_17213.t57 18.5856
Rpar13 ib ib.t0 12.4490
Rpar14 ib ib.t1 3.9673
Rpar15 ib ib.t10 65.9102
Rpar16 inn inn.t0 1.6527
Rpar17 inp inp.t0 1.6527
Rpar18 out out.t0 56.8978
Rpar19 out out.t8 7.2769
Rpar20 vdd vdd.t0 82.4191
Rpar21 vdd vdd.t1 168.4178
Rpar22 vdd vdd.t10 36.0798
Rpar23 vdd.t0 vdd.t1 3.9917
Rpar24 vdd.t0 vdd.t10 111.3158
Rpar25 vdd.t1 vdd.t10 227.4664
Rpar26 vss vss.t0 97.7952
Rpar27 vss vss.t16 241.5853
Rpar28 vss vss.t17 322.5660
Rpar29 vss.t0 vss.t16 24.0057
Rpar30 vss.t0 vss.t17 44.1313
Rpar31 vss.t16 vss.t17 4.7451
Cpar0 a_10254_17213.t0 vss 1.02015e-14
Cpar1 a_10254_17213.t1 vss 3.06852e-14
Cpar2 a_10254_17213.t60 vss 8.70270e-14
Cpar3 a_1290_17005.t0 vss 4.17000e-15
Cpar4 a_1290_17005.t2 vss 2.17726e-14
Cpar5 a_1290_17005.t3 vss 4.53864e-15
Cpar6 a_1746_1249.t0 vss 1.51015e-13
Cpar7 a_1746_1249.t64 vss 5.50384e-15
Cpar8 a_2266_1249.t0 vss 8.90154e-14
Cpar9 a_2266_1249.t64 vss 1.04346e-14
Cpar10 a_2266_1249.t66 vss 3.13865e-14
Cpar11 a_5110_17213.t0 vss 3.24135e-14
Cpar12 a_5110_17213.t56 vss 1.28615e-14
Cpar13 a_5110_17213.t57 vss 7.54710e-15
Cpar14 ib inp 3.32800e-17
Cpar15 ib out 1.37426e-14
Cpar16 ib vdd 6.79818e-14
Cpar17 ib vss 2.77471e-14
Cpar18 ib.t0 vss 2.00458e-14
Cpar19 ib.t1 vss 2.67289e-15
Cpar20 ib.t10 vss 9.68681e-14
Cpar21 inn inp 2.09090e-16
Cpar22 inn vss 6.12971e-14
Cpar23 inn.t0 vss 6.45990e-14
Cpar24 inp vss 6.16803e-14
Cpar25 inp.t0 vss 6.46381e-14
Cpar26 out vdd 8.78506e-15
Cpar27 out vss 1.01242e-14
Cpar28 out.t0 vss 4.13358e-14
Cpar29 out.t8 vss 2.03187e-15
Cpar30 vdd vss 2.76438e-13
Cpar31 vdd.t0 vss 2.26974e-14
Cpar32 vdd.t1 vss 1.33884e-14
Cpar33 vdd.t10 vss 8.07044e-14
.ends opamp_dut

Vdd vdd 0 1.800000
Vss vss 0 0
Ibias vdd ib 1.444400e-06
Vinp inp 0 DC 0.985000 AC 1 PWL(0 0.985000 3.666416e-08 0.985000 4.033058e-08 0.995000)
Rfb out inn 1m
Cload out 0 2.000000e-12
Xdut vdd vss inp inn out ib opamp_dut
.end
