* opa1000[0751]: 200f/symmetrical_ota_1v8_ulp_lt0p1uw_weak (symmetrical_ota, VDD=1.8V, CL=0.2pF, Iref=0.0015uA)
.include "pdk_opa.inc"
.temp 27
.option gmin=1e-12 rshunt=1e12 reltol=1e-3 abstol=1e-12 vntol=1e-5 method=gear
* Post-PEX R+C extracted netlist for symmetrical_ota_1v8_ulp_lt0p1uw_weak
.subckt opamp_dut vdd vss inp inn out ib
XMpar0 a_5278_2567.t5 a_5278_2567.t4 vss.t1 vss.t0 nfet_03v3 w=0.4u l=10u ad=1.1200e-13 pd=9.6000e-07 as=1.1200e-13 ps=9.6000e-07 nf=1 m=4 par=4
XMpar1 out.t1 a_1729_5542.t2 vdd.t1 vdd.t0 pfet_03v3 w=0.4u l=10u ad=2.4000e-13 pd=2.0000e-06 as=1.7600e-13 ps=1.4800e-06 nf=1 m=4 par=4
XMpar2 a_5278_2567.t0 a_10171_5542.t2 vdd.t1 vdd.t0 pfet_03v3 w=0.4u l=10u ad=2.4000e-13 pd=2.0000e-06 as=1.7600e-13 ps=1.4800e-06 nf=1 m=4 par=4
XMpar3 a_1729_5542.t3 a_1729_5542.t2 vdd.t1 vdd.t0 pfet_03v3 w=0.4u l=10u ad=2.4000e-13 pd=2.0000e-06 as=1.1200e-13 ps=9.6000e-07 nf=1 m=2 par=2
XMpar4 a_10171_5542.t3 a_10171_5542.t2 vdd.t1 vdd.t0 pfet_03v3 w=0.4u l=10u ad=2.4000e-13 pd=2.0000e-06 as=1.1200e-13 ps=9.6000e-07 nf=1 m=2 par=2
XMpar5 out.t0 a_5278_2567.t4 vss.t1 vss.t0 nfet_03v3 w=0.4u l=10u ad=2.4000e-13 pd=2.0000e-06 as=1.1200e-13 ps=9.6000e-07 nf=1 m=4 par=4
XMpar6 a_10171_5542.t0 inn.t0 a_3021_1204.t0 vss.t7 nfet_03v3 w=0.4u l=8u ad=1.1200e-13 pd=9.6000e-07 as=2.4000e-13 ps=2.0000e-06 nf=1 m=2 par=2
XMpar7 a_1729_5542.t0 inp.t0 a_3021_1204.t0 vss.t7 nfet_03v3 w=0.4u l=8u ad=1.1200e-13 pd=9.6000e-07 as=2.4000e-13 ps=2.0000e-06 nf=1 m=2 par=2
XMpar8 a_3021_1204.t4 ib.t0 vss.t18 vss.t17 nfet_03v3 w=0.4u l=9.5u ad=1.1200e-13 pd=9.6000e-07 as=1.7600e-13 ps=1.4800e-06 nf=1 m=4 par=4
XMpar9 ib.t1 ib.t0 vss.t18 vss.t17 nfet_03v3 w=0.4u l=9.5u ad=1.1200e-13 pd=9.6000e-07 as=1.1200e-13 ps=9.6000e-07 nf=1 m=2 par=2
X5 out.t8 vss.t13 cap_mim_2f0fF c_width=19.27u c_length=19.27u
X31 out.t8 vss.t13 cap_mim_2f0fF c_width=19.27u c_length=19.27u
Rpar0 a_10171_5542.t0 a_10171_5542.t2 88.9878
Rpar1 a_10171_5542.t0 a_10171_5542.t3 138.7242
Rpar2 a_10171_5542.t2 a_10171_5542.t3 16.9382
Rpar3 a_1729_5542.t0 a_1729_5542.t2 88.9878
Rpar4 a_1729_5542.t0 a_1729_5542.t3 138.7242
Rpar5 a_1729_5542.t2 a_1729_5542.t3 16.9382
Rpar6 a_3021_1204.t0 a_3021_1204.t4 76.8591
Rpar7 a_5278_2567.t0 a_5278_2567.t4 121.3966
Rpar8 a_5278_2567.t0 a_5278_2567.t5 102.5306
Rpar9 a_5278_2567.t4 a_5278_2567.t5 15.7893
Rpar10 ib ib.t0 11.6360
Rpar11 ib ib.t1 19.0497
Rpar12 inn inn.t0 3.3924
Rpar13 inp inp.t0 3.4410
Rpar14 out out.t0 8.9800
Rpar15 out out.t1 109.0349
Rpar16 out out.t8 353.1811
Rpar17 out.t0 out.t1 105.1287
Rpar18 out.t0 out.t8 340.5284
Rpar19 out.t1 out.t8 96.0098
Rpar20 vdd vdd.t0 234.4408
Rpar21 vdd vdd.t1 80.2481
Rpar22 vdd.t0 vdd.t1 9.3972
Rpar23 vss vss.t0 193.7656
Rpar24 vss vss.t1 757.9741
Rpar25 vss vss.t7 497.7594
Rpar26 vss vss.t13 3621.9669
Rpar27 vss vss.t17 96.1061
Rpar28 vss vss.t18 362.8734
Rpar29 vss.t0 vss.t1 51.7945
Rpar30 vss.t0 vss.t7 107.1108
Rpar31 vss.t0 vss.t13 781.8727
Rpar32 vss.t0 vss.t17 7.0822
Rpar33 vss.t0 vss.t18 27.7828
Rpar34 vss.t1 vss.t7 395.1526
Rpar35 vss.t1 vss.t13 2884.4326
Rpar36 vss.t1 vss.t17 27.1274
Rpar37 vss.t1 vss.t18 112.2025
Rpar38 vss.t7 vss.t13 103.6928
Rpar39 vss.t7 vss.t17 55.5383
Rpar40 vss.t7 vss.t18 225.5783
Rpar41 vss.t13 vss.t17 405.4629
Rpar42 vss.t13 vss.t18 1647.5915
Rpar43 vss.t17 vss.t18 13.4745
Cpar0 a_10171_5542.t0 vss 4.71297e-15
Cpar1 a_10171_5542.t2 vss 3.75006e-14
Cpar2 a_10171_5542.t3 vss 7.80187e-15
Cpar3 a_1729_5542.t0 vss 4.79215e-15
Cpar4 a_1729_5542.t2 vss 3.81307e-14
Cpar5 a_1729_5542.t3 vss 7.93284e-15
Cpar6 a_3021_1204.t0 vss 6.31815e-15
Cpar7 a_3021_1204.t4 vss 6.54975e-15
Cpar8 a_5278_2567.t0 vss 5.56022e-15
Cpar9 a_5278_2567.t4 vss 1.83596e-14
Cpar10 a_5278_2567.t5 vss 3.55509e-15
Cpar11 ib vss 3.73108e-14
Cpar12 ib.t0 vss 4.24652e-15
Cpar13 ib.t1 vss 2.76572e-16
Cpar14 inn inp 5.19700e-17
Cpar15 inn vdd 5.17600e-17
Cpar16 inn vss 8.30553e-15
Cpar17 inn.t0 vss 5.56971e-16
Cpar18 inp vdd 1.49900e-16
Cpar19 inp vss 8.20607e-15
Cpar20 inp.t0 vss 6.07817e-16
Cpar21 out vdd 1.36465e-14
Cpar22 out vss 3.45154e-14
Cpar23 out.t0 vss 7.34087e-16
Cpar24 out.t1 vss 1.20841e-15
Cpar25 out.t8 vss 2.94679e-14
Cpar26 vdd vss 1.59554e-13
Cpar27 vdd.t0 vss 6.07976e-14
Cpar28 vdd.t1 vss 2.82285e-14
.ends opamp_dut

Vdd vdd 0 1.800000
Vss vss 0 0
Ibias vdd ib 1.500000e-09
Vinp inp 0 DC 0.895000 AC 1 PWL(0 0.895000 1.505889e-05 0.895000 1.656478e-05 0.905000)
Rfb out inn 1m
Cload out 0 2.000000e-13
Xdut vdd vss inp inn out ib opamp_dut
.end
