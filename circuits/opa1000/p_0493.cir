* opa1000[0493]: 2p/nmos_miller_3v3_i20u_subth (nmos_miller, VDD=3.3V, CL=2.0pF, Iref=2.8571uA)
.include "pdk_opa.inc"
.temp 27
.option gmin=1e-12 rshunt=1e12 reltol=1e-3 abstol=1e-12 vntol=1e-5 method=gear
* Post-PEX R+C extracted netlist for nmos_miller_3v3_i20u_subth
.subckt opamp_dut vdd vss inp inn out ib
XMpar0 a_3358_4740.t0 inn.t0 a_5732_996.t0 vss.t0 nfet_03v3 w=2.04u l=0.65u ad=6.6446e-13 pd=2.9829e-06 as=6.1783e-13 ps=2.7914e-06 nf=1 m=28 par=28
XMpar1 out.t0 ib.t0 vss.t20 vss.t0 nfet_03v3 w=4.23u l=1.2u ad=1.4551e-12 pd=5.7640e-06 as=1.1844e-12 ps=4.7900e-06 nf=1 m=10 par=10
XMpar2 a_3358_4740.t0 inp.t0 a_869_996.t0 vss.t0 nfet_03v3 w=2.04u l=0.65u ad=6.6446e-13 pd=2.9829e-06 as=6.1783e-13 ps=2.7914e-06 nf=1 m=28 par=28
XMpar3 out.t1 a_869_996.t31 vdd.t1 vdd.t0 pfet_03v3 w=10u l=0.6u ad=2.8000e-12 pd=1.0560e-05 as=3.4400e-12 ps=1.2688e-05 nf=1 m=10 par=10
XMpar4 ib.t1 ib.t0 vss.t20 vss.t0 nfet_03v3 w=4.23u l=1.2u ad=1.1844e-12 pd=4.7900e-06 as=1.1844e-12 ps=4.7900e-06 nf=1 m=2 par=2
XMpar5 a_3358_4740.t28 ib.t0 vss.t20 vss.t0 nfet_03v3 w=4.23u l=1.2u ad=1.1844e-12 pd=4.7900e-06 as=1.1844e-12 ps=4.7900e-06 nf=1 m=4 par=4
XMpar6 a_869_996.t29 a_5732_996.t28 vdd.t1 vdd.t0 pfet_03v3 w=10u l=0.6u ad=6.0000e-12 pd=2.1200e-05 as=2.8000e-12 ps=1.0560e-05 nf=1 m=2 par=2
XMpar7 a_5732_996.t29 a_5732_996.t28 vdd.t1 vdd.t0 pfet_03v3 w=10u l=0.6u ad=2.8000e-12 pd=1.0560e-05 as=2.8000e-12 ps=1.0560e-05 nf=1 m=2 par=2
X6 a_869_996.t28 a_1940_8838.t0 vss.t51 ppolyf_u_1k r_width=1u r_length=4.38u
X11 a_1940_8838.t1 out.t17 cap_mim_2f0fF c_width=16.58u c_length=16.59u
X61 a_1940_8838.t1 out.t17 cap_mim_2f0fF c_width=16.58u c_length=16.59u
Rpar0 a_1940_8838.t0 a_1940_8838.t1 73.0943
Rpar1 a_3358_4740.t0 a_3358_4740.t28 48.0718
Rpar2 a_5732_996.t0 a_5732_996.t28 402.4330
Rpar3 a_5732_996.t0 a_5732_996.t29 71.6155
Rpar4 a_5732_996.t28 a_5732_996.t29 43.4864
Rpar5 a_869_996.t0 a_869_996.t28 114.8961
Rpar6 a_869_996.t0 a_869_996.t29 49.8943
Rpar7 a_869_996.t0 a_869_996.t31 181.8752
Rpar8 a_869_996.t28 a_869_996.t29 275.6720
Rpar9 a_869_996.t28 a_869_996.t31 1004.8826
Rpar10 a_869_996.t29 a_869_996.t31 146.8884
Rpar11 ib ib.t0 23.5716
Rpar12 ib ib.t1 10.3536
Rpar13 ib.t0 ib.t1 60.0816
Rpar14 inn inn.t0 2.9632
Rpar15 inp inp.t0 2.9632
Rpar16 out out.t0 69.5276
Rpar17 out out.t1 75.3834
Rpar18 out out.t17 21.1533
Rpar19 out.t0 out.t1 128.6308
Rpar20 vdd vdd.t0 109.4960
Rpar21 vdd vdd.t1 234.9524
Rpar22 vdd.t0 vdd.t1 3.6129
Rpar23 vss vss.t0 86.7552
Rpar24 vss vss.t20 859.5577
Rpar25 vss vss.t51 167.0558
Rpar26 vss.t0 vss.t20 3.8886
Rpar27 vss.t0 vss.t51 40.8595
Rpar28 vss.t20 vss.t51 547.5180
Cpar0 a_1940_8838.t0 vss 1.30527e-16
Cpar1 a_1940_8838.t1 vss 7.03967e-15
Cpar2 a_3358_4740.t0 vss 3.60675e-14
Cpar3 a_3358_4740.t28 vss 7.74635e-15
Cpar4 a_5732_996.t0 vss 1.81445e-14
Cpar5 a_5732_996.t28 vss 5.48425e-15
Cpar6 a_5732_996.t29 vss 7.23062e-15
Cpar7 a_869_996.t0 vss 1.63016e-14
Cpar8 a_869_996.t28 vss 3.03169e-15
Cpar9 a_869_996.t29 vss 8.37491e-15
Cpar10 a_869_996.t31 vss 1.33331e-14
Cpar11 ib inn 1.12500e-17
Cpar12 ib inp 1.01100e-17
Cpar13 ib out 2.29159e-15
Cpar14 ib vss 2.10309e-14
Cpar15 ib.t0 vss 4.78171e-15
Cpar16 ib.t1 vss 4.21849e-16
Cpar17 inn inp 1.00980e-16
Cpar18 inn vdd 2.77600e-17
Cpar19 inn vss 1.51485e-14
Cpar20 inn.t0 vss 6.77835e-15
Cpar21 inp vdd 1.93800e-17
Cpar22 inp vss 1.52441e-14
Cpar23 inp.t0 vss 6.78337e-15
Cpar24 out vdd 1.61795e-14
Cpar25 out vss 2.11098e-14
Cpar26 out.t0 vss 6.00739e-15
Cpar27 out.t1 vss 9.06372e-15
Cpar28 out.t17 vss 1.34805e-14
Cpar29 vdd vss 7.14800e-14
Cpar30 vdd.t0 vss 2.18151e-14
Cpar31 vdd.t1 vss 1.26790e-14
.ends opamp_dut

Vdd vdd 0 3.300000
Vss vss 0 0
Ibias vdd ib 2.857100e-06
Vinp inp 0 DC 1.645000 AC 1 PWL(0 1.645000 1.141834e-08 1.645000 1.256017e-08 1.655000)
Rfb out inn 1m
Cload out 0 2.000000e-12
Xdut vdd vss inp inn out ib opamp_dut
.end
