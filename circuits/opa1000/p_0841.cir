* opa1000[0841]: 200f/telescopic_nmos_1v8_i1u_weak (telescopic_nmos, VDD=1.8V, CL=0.2pF, Iref=0.2875uA)
.include "pdk_opa.inc"
.temp 27
.option gmin=1e-12 rshunt=1e12 reltol=1e-3 abstol=1e-12 vntol=1e-5 method=gear
* Post-PEX R+C extracted netlist for telescopic_nmos_1v8_i1u_weak
.subckt opamp_dut vdd vss inp inn out ib
XMpar0 a_1328_10435.t3 a_1328_10435.t2 a_2678_10643.t3 vdd.t0 pfet_03v3 w=2u l=2.55u ad=7.7333e-13 pd=3.4400e-06 as=7.7333e-13 ps=3.4400e-06 nf=1 m=6 par=6
XMpar1 a_7214_1204.t0 vdd.t36 out.t4 vss.t5 nfet_03v3 w=1.46u l=2.55u ad=8.7600e-13 pd=4.1200e-06 as=4.0880e-13 ps=2.0200e-06 nf=1 m=2 par=2
XMpar2 a_1672_9028.t0 inp.t0 a_4282_1204.t0 vss.t0 nfet_03v3 w=2.12u l=6u ad=9.3280e-13 pd=4.0600e-06 as=7.6320e-13 ps=3.3700e-06 nf=1 m=8 par=8
XMpar3 a_1328_10435.t0 vdd.t36 a_4282_1204.t8 vss.t5 nfet_03v3 w=1.46u l=2.55u ad=4.0880e-13 pd=2.0200e-06 as=8.7600e-13 ps=4.1200e-06 nf=1 m=2 par=2
XMpar4 a_1672_9028.t0 inn.t0 a_7214_1204.t2 vss.t0 nfet_03v3 w=2.12u l=6u ad=9.3280e-13 pd=4.0600e-06 as=7.6320e-13 ps=3.3700e-06 nf=1 m=8 par=8
XMpar5 a_2678_10643.t0 a_1328_10435.t20 vdd.t2 vdd.t1 pfet_03v3 w=1.79u l=6.75u ad=5.0120e-13 pd=2.3500e-06 as=7.8760e-13 ps=3.5650e-06 nf=1 m=8 par=8
XMpar6 a_5330_6933.t1 a_1328_10435.t20 vdd.t2 vdd.t1 pfet_03v3 w=1.79u l=6.75u ad=5.0120e-13 pd=2.3500e-06 as=5.0120e-13 ps=2.3500e-06 nf=1 m=8 par=8
XMpar7 a_5330_6933.t0 a_1328_10435.t2 out.t0 vdd.t0 pfet_03v3 w=2u l=2.55u ad=7.7333e-13 pd=3.4400e-06 as=5.6000e-13 ps=2.5600e-06 nf=1 m=6 par=6
XMpar8 a_1672_9028.t8 ib.t0 vss.t10 vss.t9 nfet_03v3 w=0.4u l=2.1u ad=1.1200e-13 pd=9.6000e-07 as=1.4400e-13 ps=1.2200e-06 nf=1 m=8 par=8
XMpar9 ib.t1 ib.t0 vss.t10 vss.t9 nfet_03v3 w=0.4u l=2.1u ad=1.1200e-13 pd=9.6000e-07 as=1.1200e-13 ps=9.6000e-07 nf=1 m=2 par=2
Rpar0 a_1328_10435.t0 a_1328_10435.t2 381.9232
Rpar1 a_1328_10435.t0 a_1328_10435.t3 130.5864
Rpar2 a_1328_10435.t0 a_1328_10435.t20 165.6159
Rpar3 a_1328_10435.t2 a_1328_10435.t3 16.6970
Rpar4 a_1328_10435.t2 a_1328_10435.t20 230.4736
Rpar5 a_1328_10435.t3 a_1328_10435.t20 78.8031
Rpar6 a_1672_9028.t0 a_1672_9028.t8 52.3382
Rpar7 a_2678_10643.t0 a_2678_10643.t3 51.0825
Rpar8 a_4282_1204.t0 a_4282_1204.t8 43.7697
Rpar9 a_5330_6933.t0 a_5330_6933.t1 53.4918
Rpar10 a_7214_1204.t0 a_7214_1204.t2 43.7697
Rpar11 ib ib.t0 18.3432
Rpar12 ib ib.t1 18.4296
Rpar13 ib.t0 ib.t1 100.8899
Rpar14 inn inn.t0 2.2273
Rpar15 inp inp.t0 2.2273
Rpar16 out out.t0 5.7245
Rpar17 out out.t4 184.6575
Rpar18 out.t0 out.t4 108.8589
Rpar19 vdd vdd.t0 191.7888
Rpar20 vdd vdd.t1 26.9802
Rpar21 vdd vdd.t2 262.1379
Rpar22 vdd vdd.t36 1434.6776
Rpar23 vdd.t0 vdd.t1 76.4138
Rpar24 vdd.t0 vdd.t2 742.4307
Rpar25 vdd.t0 vdd.t36 57.8193
Rpar26 vdd.t1 vdd.t2 12.4852
Rpar27 vdd.t1 vdd.t36 571.6140
Rpar28 vdd.t2 vdd.t36 5553.7579
Rpar29 vss vss.t0 57.7941
Rpar30 vss vss.t10 644.8930
Rpar31 vss vss.t9 344.2480
Rpar32 vss vss.t5 252.8571
Rpar33 vss.t0 vss.t10 183.3947
Rpar34 vss.t0 vss.t9 96.8527
Rpar35 vss.t0 vss.t5 6.3195
Rpar36 vss.t10 vss.t9 6.9879
Rpar37 vss.t10 vss.t5 808.2229
Rpar38 vss.t9 vss.t5 427.1314
Cpar0 a_1328_10435.t0 vss 2.68204e-15
Cpar1 a_1328_10435.t2 vss 2.07964e-14
Cpar2 a_1328_10435.t20 vss 6.60703e-14
Cpar3 a_1328_10435.t3 vss 8.17473e-15
Cpar4 a_1672_9028.t0 vss 2.38349e-14
Cpar5 a_1672_9028.t8 vss 5.43051e-15
Cpar6 a_2678_10643.t0 vss 2.53157e-14
Cpar7 a_2678_10643.t3 vss 1.40147e-14
Cpar8 a_4282_1204.t0 vss 1.46048e-14
Cpar9 a_4282_1204.t8 vss 3.24028e-15
Cpar10 a_5330_6933.t0 vss 1.37789e-14
Cpar11 a_5330_6933.t1 vss 2.49792e-14
Cpar12 a_7214_1204.t0 vss 2.70934e-15
Cpar13 a_7214_1204.t2 vss 1.22117e-14
Cpar14 ib vdd 2.43010e-16
Cpar15 ib vss 1.72335e-14
Cpar16 ib.t0 vss 2.76712e-15
Cpar17 ib.t1 vss 1.22757e-16
Cpar18 inn inp 1.06580e-16
Cpar19 inn vss 2.10169e-14
Cpar20 inn.t0 vss 7.23797e-15
Cpar21 inp vdd 3.02700e-17
Cpar22 inp vss 2.08231e-14
Cpar23 inp.t0 vss 7.26854e-15
Cpar24 out vdd 5.40736e-15
Cpar25 out vss 7.64203e-15
Cpar26 out.t0 vss 6.16905e-15
Cpar27 out.t4 vss 3.21087e-15
Cpar28 vdd vss 2.04998e-13
Cpar29 vdd.t0 vss 2.95665e-14
Cpar30 vdd.t1 vss 6.37740e-14
Cpar31 vdd.t2 vss 1.02287e-14
Cpar32 vdd.t36 vss 3.01551e-15
.ends opamp_dut

Vdd vdd 0 1.800000
Vss vss 0 0
Ibias vdd ib 2.875000e-07
Vinp inp 0 DC 0.931000 AC 1 PWL(0 0.931000 2.640876e-08 0.931000 2.904963e-08 0.941000)
Rfb out inn 1m
Cload out 0 2.000000e-13
Xdut vdd vss inp inn out ib opamp_dut
.end
