* opa1000[0542]: 2p/pmos_5t_1v8_ulp_lt0p1uw_subth (pmos_5t, VDD=1.8V, CL=2.0pF, Iref=0.0022uA)
.include "pdk_opa.inc"
.temp 27
.option gmin=1e-12 rshunt=1e12 reltol=1e-3 abstol=1e-12 vntol=1e-5 method=gear
* Post-PEX R+C extracted netlist for pmos_5t_1v8_ulp_lt0p1uw_subth
.subckt opamp_dut vdd vss inp inn out ib
XMpar0 a_2994_1250.t0 a_1623_13955.t2 vdd.t1 vdd.t0 pfet_03v3 w=0.4u l=9.5u ad=1.1200e-13 pd=9.6000e-07 as=2.0800e-13 ps=1.7400e-06 nf=1 m=8 par=8
XMpar1 a_1638_11188.t0 inp.t0 a_2994_1250.t4 vdd.t7 pfet_03v3 w=8u l=8u ad=2.2400e-12 pd=8.5600e-06 as=4.8000e-12 ps=1.7200e-05 nf=1 m=8 par=8
XMpar2 a_1623_13955.t0 ib.t0 vss.t1 vss.t0 nfet_03v3 w=0.4u l=9.5u ad=2.4000e-13 pd=2.0000e-06 as=1.1200e-13 ps=9.6000e-07 nf=1 m=2 par=2
XMpar3 a_2994_1250.t4 inn.t0 out.t1 vdd.t7 pfet_03v3 w=8u l=8u ad=4.8000e-12 pd=1.7200e-05 as=2.2400e-12 ps=8.5600e-06 nf=1 m=8 par=8
XMpar4 a_1623_13955.t3 a_1623_13955.t2 vdd.t1 vdd.t0 pfet_03v3 w=0.4u l=9.5u ad=2.4000e-13 pd=2.0000e-06 as=1.1200e-13 ps=9.6000e-07 nf=1 m=2 par=2
XMpar5 ib.t1 ib.t0 vss.t1 vss.t0 nfet_03v3 w=0.4u l=9.5u ad=2.4000e-13 pd=2.0000e-06 as=1.1200e-13 ps=9.6000e-07 nf=1 m=2 par=2
XMpar6 out.t0 a_1638_11188.t8 vss.t1 vss.t0 nfet_03v3 w=0.4u l=9.5u ad=2.4000e-13 pd=2.0000e-06 as=1.1200e-13 ps=9.6000e-07 nf=1 m=2 par=2
XMpar7 a_1638_11188.t9 a_1638_11188.t8 vss.t1 vss.t0 nfet_03v3 w=0.4u l=9.5u ad=2.4000e-13 pd=2.0000e-06 as=1.1200e-13 ps=9.6000e-07 nf=1 m=2 par=2
Rpar0 a_1623_13955.t0 a_1623_13955.t2 106.9238
Rpar1 a_1623_13955.t0 a_1623_13955.t3 92.9258
Rpar2 a_1623_13955.t2 a_1623_13955.t3 17.6756
Rpar3 a_1638_11188.t0 a_1638_11188.t8 77.9288
Rpar4 a_1638_11188.t0 a_1638_11188.t9 93.5416
Rpar5 a_1638_11188.t8 a_1638_11188.t9 15.8838
Rpar6 a_2994_1250.t0 a_2994_1250.t4 54.0168
Rpar7 ib ib.t0 9.8121
Rpar8 ib ib.t1 11.7780
Rpar9 ib.t0 ib.t1 44.4999
Rpar10 inn inn.t0 3.4920
Rpar11 inp inp.t0 3.4921
Rpar12 out out.t0 12.6508
Rpar13 out out.t1 156.2143
Rpar14 out.t0 out.t1 166.1158
Rpar15 vdd vdd.t0 64.4657
Rpar16 vdd vdd.t1 444.7113
Rpar17 vdd vdd.t7 164.7694
Rpar18 vdd.t0 vdd.t1 14.0780
Rpar19 vdd.t0 vdd.t7 31.1278
Rpar20 vdd.t1 vdd.t7 214.7322
Rpar21 vss vss.t0 183.0097
Rpar22 vss vss.t1 80.6683
Rpar23 vss.t0 vss.t1 13.7132
Cpar0 a_1623_13955.t0 vss 9.47319e-15
Cpar1 a_1623_13955.t2 vss 5.80018e-14
Cpar2 a_1623_13955.t3 vss 9.76018e-15
Cpar3 a_1638_11188.t0 vss 1.64215e-14
Cpar4 a_1638_11188.t8 vss 1.34341e-14
Cpar5 a_1638_11188.t9 vss 3.34050e-15
Cpar6 a_2994_1250.t0 vss 1.34358e-14
Cpar7 a_2994_1250.t4 vss 5.78242e-14
Cpar8 ib inn 2.36400e-17
Cpar9 ib out 1.75980e-16
Cpar10 ib vdd 8.64500e-17
Cpar11 ib vss 2.83574e-14
Cpar12 ib.t0 vss 3.96417e-15
Cpar13 ib.t1 vss 4.04920e-16
Cpar14 inn inp 2.07870e-16
Cpar15 inn out 1.07545e-14
Cpar16 inn vdd 2.57485e-14
Cpar17 inn vss 5.90530e-15
Cpar18 inn.t0 vss 3.99536e-14
Cpar19 inp vdd 2.57485e-14
Cpar20 inp vss 5.54373e-15
Cpar21 inp.t0 vss 3.99725e-14
Cpar22 out vdd 6.30838e-15
Cpar23 out vss 1.86154e-14
Cpar24 out.t0 vss 3.58387e-15
Cpar25 out.t1 vss 2.41539e-14
Cpar26 vdd vss 3.85852e-13
Cpar27 vdd.t0 vss 4.06665e-14
Cpar28 vdd.t1 vss 6.87466e-15
Cpar29 vdd.t7 vss 9.30949e-14
.ends opamp_dut

Vdd vdd 0 1.800000
Vss vss 0 0
Ibias vdd ib 2.200000e-09
Vinp inp 0 DC 0.805000 AC 1 PWL(0 0.805000 1.116172e-05 0.805000 1.227789e-05 0.815000)
Rfb out inn 1m
Cload out 0 2.000000e-12
Xdut vdd vss inp inn out ib opamp_dut
.end
