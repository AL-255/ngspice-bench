* opa1000[0372]: 200f/nmos_5t_3v3_i150u_weak (nmos_5t, VDD=3.3V, CL=0.2pF, Iref=43.125uA)
.include "pdk_opa.inc"
.temp 27
.option gmin=1e-12 rshunt=1e12 reltol=1e-3 abstol=1e-12 vntol=1e-5 method=gear
* Post-PEX R+C extracted netlist for nmos_5t_3v3_i150u_weak
.subckt opamp_dut vdd vss inp inn out ib
XMpar0 a_2034_5813.t0 inn.t0 out.t0 vss.t0 nfet_03v3 w=1.98u l=0.56u ad=6.3360e-13 pd=2.8675e-06 as=5.5440e-13 ps=2.5400e-06 nf=1 m=48 par=48
XMpar1 a_1606_9535.t49 a_1606_9535.t48 vdd.t1 vdd.t0 pfet_03v3 w=1.96u l=0.7u ad=5.4880e-13 pd=2.5200e-06 as=5.4880e-13 ps=2.5200e-06 nf=1 m=54 par=54
XMpar2 a_2034_5813.t48 ib.t0 vss.t17 vss.t0 nfet_03v3 w=2.34u l=0.39u ad=6.5520e-13 pd=2.9000e-06 as=7.1760e-13 ps=3.1483e-06 nf=1 m=24 par=24
XMpar3 a_1606_9535.t0 inp.t0 a_2034_5813.t0 vss.t0 nfet_03v3 w=1.98u l=0.56u ad=5.5440e-13 pd=2.5400e-06 as=6.3360e-13 ps=2.8675e-06 nf=1 m=48 par=48
XMpar4 out.t48 a_1606_9535.t48 vdd.t1 vdd.t0 pfet_03v3 w=1.96u l=0.7u ad=6.1849e-13 pd=2.8089e-06 as=5.4880e-13 ps=2.5200e-06 nf=1 m=54 par=54
XMpar5 ib.t1 ib.t0 vss.t17 vss.t0 nfet_03v3 w=2.34u l=0.39u ad=6.5520e-13 pd=2.9000e-06 as=6.5520e-13 ps=2.9000e-06 nf=1 m=6 par=6
X164 out.t102 vss.t76 cap_mim_2f0fF c_width=14.79u c_length=14.79u
Rpar0 a_1606_9535.t0 a_1606_9535.t48 163.5929
Rpar1 a_1606_9535.t0 a_1606_9535.t49 45.2744
Rpar2 a_1606_9535.t48 a_1606_9535.t49 4.8697
Rpar3 a_2034_5813.t0 a_2034_5813.t48 36.4008
Rpar4 ib ib.t0 34.2336
Rpar5 ib ib.t1 4.5674
Rpar6 ib.t0 ib.t1 28.7385
Rpar7 inn inn.t0 2.1881
Rpar8 inp inp.t0 2.1881
Rpar9 out out.t0 5323.6215
Rpar10 out out.t48 2.4804
Rpar11 out.t0 out.t48 58.0540
Rpar12 out.t0 out.t102 114.7625
Rpar13 out.t48 out.t102 139.7965
Rpar14 vdd vdd.t0 19.3590
Rpar15 vdd vdd.t1 1318.0516
Rpar16 vdd.t0 vdd.t1 9.0277
Rpar17 vss vss.t0 39.0882
Rpar18 vss vss.t17 469.5354
Rpar19 vss vss.t76 103.8380
Rpar20 vss.t0 vss.t17 2.0034
Rpar21 vss.t0 vss.t76 57.9146
Rpar22 vss.t17 vss.t76 695.6809
Cpar0 a_1606_9535.t0 vss 3.04206e-14
Cpar1 a_1606_9535.t48 vss 8.23182e-14
Cpar2 a_1606_9535.t49 vss 4.64832e-14
Cpar3 a_2034_5813.t0 vss 5.00599e-14
Cpar4 a_2034_5813.t48 vss 1.35797e-14
Cpar5 ib out 1.47800e-17
Cpar6 ib vss 2.26953e-14
Cpar7 ib.t0 vss 3.13298e-15
Cpar8 ib.t1 vss 8.75672e-16
Cpar9 inn inp 1.55910e-16
Cpar10 inn out 7.53634e-15
Cpar11 inn vdd 1.34800e-17
Cpar12 inn vss 2.15971e-14
Cpar13 inn.t0 vss 1.03749e-14
Cpar14 inp out 8.14100e-17
Cpar15 inp vdd 1.34800e-17
Cpar16 inp vss 2.16171e-14
Cpar17 inp.t0 vss 1.03291e-14
Cpar18 out vdd 3.62041e-14
Cpar19 out vss 2.08324e-14
Cpar20 out.t0 vss 1.58002e-14
Cpar21 out.t102 vss 5.16077e-14
Cpar22 out.t48 vss 2.18498e-14
Cpar23 vdd vss 1.64387e-13
Cpar24 vdd.t0 vss 1.15881e-13
Cpar25 vdd.t1 vss 1.79909e-14
.ends opamp_dut

Vdd vdd 0 3.300000
Vss vss 0 0
Ibias vdd ib 4.312500e-05
Vinp inp 0 DC 1.645000 AC 1 PWL(0 1.645000 3.000000e-09 1.645000 3.300000e-09 1.655000)
Rfb out inn 1m
Cload out 0 2.000000e-13
Xdut vdd vss inp inn out ib opamp_dut
.end
