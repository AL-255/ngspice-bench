* opa1000[0835]: 200f/telescopic_nmos_1v8_i50n_subth (telescopic_nmos, VDD=1.8V, CL=0.2pF, Iref=0.0144uA)
.include "pdk_opa.inc"
.temp 27
.option gmin=1e-12 rshunt=1e12 reltol=1e-3 abstol=1e-12 vntol=1e-5 method=gear
* Post-PEX R+C extracted netlist for telescopic_nmos_1v8_i50n_subth
.subckt opamp_dut vdd vss inp inn out ib
XMpar0 a_2802_4134.t12 ib.t0 vss.t11 vss.t10 nfet_03v3 w=0.4u l=7.5u ad=1.1200e-13 pd=9.6000e-07 as=2.0800e-13 ps=1.7400e-06 nf=1 m=8 par=8
XMpar1 a_1271_8335.t0 vdd.t16 a_3454_7024.t6 vss.t6 nfet_03v3 w=0.94u l=5.25u ad=2.6320e-13 pd=1.5000e-06 as=5.6400e-13 ps=3.0800e-06 nf=1 m=2 par=2
XMpar2 a_3752_8543.t3 a_1271_8335.t14 vdd.t8 vdd.t7 pfet_03v3 w=0.62u l=5.2u ad=1.7360e-13 pd=1.1800e-06 as=1.7360e-13 ps=1.1800e-06 nf=1 m=2 par=2
XMpar3 a_2802_4134.t0 inp.t0 a_3454_7024.t0 vss.t0 nfet_03v3 w=2.13u l=4.4u ad=8.2360e-13 pd=3.6133e-06 as=8.2360e-13 ps=3.6133e-06 nf=1 m=6 par=6
XMpar4 a_3752_8543.t0 a_1271_8335.t2 out.t0 vdd.t0 pfet_03v3 w=2.06u l=5.25u ad=9.0640e-13 pd=3.9700e-06 as=5.7680e-13 ps=2.6200e-06 nf=1 m=4 par=4
XMpar5 a_2802_4134.t0 inn.t0 a_6094_4134.t0 vss.t0 nfet_03v3 w=2.13u l=4.4u ad=8.2360e-13 pd=3.6133e-06 as=8.2360e-13 ps=3.6133e-06 nf=1 m=6 par=6
XMpar6 a_1151_8543.t0 a_1271_8335.t2 a_1271_8335.t3 vdd.t0 pfet_03v3 w=2.06u l=5.25u ad=1.2360e-12 pd=5.3200e-06 as=5.7680e-13 ps=2.6200e-06 nf=1 m=4 par=4
XMpar7 a_6094_4134.t6 vdd.t16 out.t2 vss.t6 nfet_03v3 w=0.94u l=5.25u ad=5.6400e-13 pd=3.0800e-06 as=2.6320e-13 ps=1.5000e-06 nf=1 m=2 par=2
XMpar8 a_1151_8543.t4 a_1271_8335.t14 vdd.t8 vdd.t7 pfet_03v3 w=0.62u l=5.2u ad=3.7200e-13 pd=2.4400e-06 as=1.7360e-13 ps=1.1800e-06 nf=1 m=2 par=2
XMpar9 ib.t1 ib.t0 vss.t11 vss.t10 nfet_03v3 w=0.4u l=7.5u ad=2.4000e-13 pd=2.0000e-06 as=1.1200e-13 ps=9.6000e-07 nf=1 m=2 par=2
Rpar0 a_1151_8543.t0 a_1151_8543.t4 62.9189
Rpar1 a_1271_8335.t0 a_1271_8335.t2 224.1612
Rpar2 a_1271_8335.t0 a_1271_8335.t14 186.1367
Rpar3 a_1271_8335.t0 a_1271_8335.t3 117.3948
Rpar4 a_1271_8335.t2 a_1271_8335.t14 164.7005
Rpar5 a_1271_8335.t2 a_1271_8335.t3 20.5932
Rpar6 a_1271_8335.t14 a_1271_8335.t3 86.2548
Rpar7 a_2802_4134.t0 a_2802_4134.t12 42.0550
Rpar8 a_3454_7024.t0 a_3454_7024.t6 41.5412
Rpar9 a_3752_8543.t0 a_3752_8543.t3 61.8065
Rpar10 a_6094_4134.t0 a_6094_4134.t6 41.5412
Rpar11 ib ib.t0 15.3076
Rpar12 ib ib.t1 14.9602
Rpar13 ib.t0 ib.t1 33.4701
Rpar14 inn inn.t0 2.5212
Rpar15 inp inp.t0 2.5212
Rpar16 out out.t0 7.6694
Rpar17 out out.t2 54.9942
Rpar18 vdd vdd.t0 125.3019
Rpar19 vdd vdd.t8 130.2819
Rpar20 vdd vdd.t7 79.7489
Rpar21 vdd vdd.t16 228.4805
Rpar22 vdd.t0 vdd.t8 507.4672
Rpar23 vdd.t0 vdd.t7 310.6339
Rpar24 vdd.t0 vdd.t16 69.2779
Rpar25 vdd.t8 vdd.t7 14.4552
Rpar26 vdd.t8 vdd.t16 925.3359
Rpar27 vdd.t7 vdd.t16 566.4222
Rpar28 vss vss.t0 86.4765
Rpar29 vss vss.t10 108.1105
Rpar30 vss vss.t11 55.8337
Rpar31 vss vss.t6 176.4432
Rpar32 vss.t0 vss.t10 2.6283
Rpar33 vss.t0 vss.t11 31.6720
Rpar34 vss.t0 vss.t6 4.3354
Rpar35 vss.t10 vss.t11 30.4337
Rpar36 vss.t10 vss.t6 4.2429
Rpar37 vss.t11 vss.t6 62.4235
Cpar0 a_1151_8543.t0 vss 1.27334e-14
Cpar1 a_1151_8543.t4 vss 5.80415e-15
Cpar2 a_1271_8335.t0 vss 2.72015e-15
Cpar3 a_1271_8335.t14 vss 1.06382e-14
Cpar4 a_1271_8335.t2 vss 3.00536e-14
Cpar5 a_1271_8335.t3 vss 7.00159e-15
Cpar6 a_2802_4134.t0 vss 1.32708e-14
Cpar7 a_2802_4134.t12 vss 9.32589e-15
Cpar8 a_3454_7024.t0 vss 7.46923e-15
Cpar9 a_3454_7024.t6 vss 2.28039e-15
Cpar10 a_3752_8543.t0 vss 1.43889e-14
Cpar11 a_3752_8543.t3 vss 5.73982e-15
Cpar12 a_6094_4134.t0 vss 7.95122e-15
Cpar13 a_6094_4134.t6 vss 2.42755e-15
Cpar14 ib inn 2.83200e-17
Cpar15 ib inp 3.10100e-17
Cpar16 ib vss 5.21870e-14
Cpar17 ib.t0 vss 7.23364e-15
Cpar18 ib.t1 vss 5.58628e-16
Cpar19 inn inp 1.03380e-16
Cpar20 inn vdd 2.31000e-17
Cpar21 inn vss 1.28127e-14
Cpar22 inn.t0 vss 3.80324e-15
Cpar23 inp vdd 2.09500e-17
Cpar24 inp vss 1.27045e-14
Cpar25 inp.t0 vss 3.76753e-15
Cpar26 out vdd 8.55017e-15
Cpar27 out vss 9.93845e-15
Cpar28 out.t0 vss 4.92980e-15
Cpar29 out.t2 vss 3.57328e-15
Cpar30 vdd vss 1.12794e-13
Cpar31 vdd.t0 vss 2.93492e-14
Cpar32 vdd.t16 vss 4.11813e-15
Cpar33 vdd.t7 vss 7.82150e-15
Cpar34 vdd.t8 vss 4.40848e-15
.ends opamp_dut

Vdd vdd 0 1.800000
Vss vss 0 0
Ibias vdd ib 1.440000e-08
Vinp inp 0 DC 0.931000 AC 1 PWL(0 0.931000 2.856225e-07 0.931000 3.141847e-07 0.941000)
Rfb out inn 1m
Cload out 0 2.000000e-13
Xdut vdd vss inp inn out ib opamp_dut
.end
