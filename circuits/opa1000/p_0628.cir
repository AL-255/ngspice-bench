* opa1000[0628]: 2p/pmos_miller_1v8_i50n_weak (pmos_miller, VDD=1.8V, CL=2.0pF, Iref=0.0081uA)
.include "pdk_opa.inc"
.temp 27
.option gmin=1e-12 rshunt=1e12 reltol=1e-3 abstol=1e-12 vntol=1e-5 method=gear
* Post-PEX R+C extracted netlist for pmos_miller_1v8_i50n_weak
.subckt opamp_dut vdd vss inp inn out ib
XMpar0 ib.t1 ib.t0 vss.t16 vss.t15 nfet_03v3 w=0.4u l=3u ad=2.4000e-13 pd=2.0000e-06 as=1.1200e-13 ps=9.6000e-07 nf=1 m=2 par=2
XMpar1 a_5502_10556.t0 inn.t0 a_7572_8777.t4 vdd.t4 pfet_03v3 w=0.49u l=8.13u ad=2.9400e-13 pd=2.1800e-06 as=1.3720e-13 ps=1.0500e-06 nf=1 m=2 par=2
XMpar2 a_5502_10556.t2 a_2555_12030.t0 vdd.t1 vdd.t0 pfet_03v3 w=0.4u l=3u ad=1.1200e-13 pd=9.6000e-07 as=1.1200e-13 ps=9.6000e-07 nf=1 m=4 par=4
XMpar3 a_5502_10556.t0 inp.t0 a_891_1290.t0 vdd.t4 pfet_03v3 w=0.49u l=8.13u ad=2.9400e-13 pd=2.1800e-06 as=1.3720e-13 ps=1.0500e-06 nf=1 m=2 par=2
XMpar4 out.t2 a_2555_12030.t0 vdd.t1 vdd.t0 pfet_03v3 w=0.4u l=3u ad=1.3760e-13 pd=1.1680e-06 as=1.1200e-13 ps=9.6000e-07 nf=1 m=10 par=10
XMpar5 out.t0 a_891_1290.t5 vss.t1 vss.t0 nfet_03v3 w=0.4u l=4u ad=1.3760e-13 pd=1.1680e-06 as=1.3760e-13 ps=1.1680e-06 nf=1 m=10 par=10
XMpar6 a_7572_8777.t1 a_7572_8777.t0 vss.t1 vss.t0 nfet_03v3 w=0.4u l=4u ad=1.1200e-13 pd=9.6000e-07 as=1.1200e-13 ps=9.6000e-07 nf=1 m=2 par=2
XMpar7 a_2555_12030.t1 a_2555_12030.t0 vdd.t1 vdd.t0 pfet_03v3 w=0.4u l=3u ad=1.1200e-13 pd=9.6000e-07 as=1.1200e-13 ps=9.6000e-07 nf=1 m=2 par=2
XMpar8 a_2555_12030.t4 ib.t0 vss.t16 vss.t15 nfet_03v3 w=0.4u l=3u ad=1.1200e-13 pd=9.6000e-07 as=1.1200e-13 ps=9.6000e-07 nf=1 m=2 par=2
XMpar9 a_891_1290.t2 a_7572_8777.t0 vss.t1 vss.t0 nfet_03v3 w=0.4u l=4u ad=2.4000e-13 pd=2.0000e-06 as=1.1200e-13 ps=9.6000e-07 nf=1 m=2 par=2
X3 a_891_1290.t4 a_4869_1290.t0 vss.t6 ppolyf_u_1k r_width=1u r_length=19.23u
X6 a_891_3890.t0 a_4869_3370.t0 vss.t6 ppolyf_u_1k r_width=1u r_length=19.23u
X15 a_891_5970.t0 a_4869_6490.t0 vss.t6 ppolyf_u_1k r_width=1u r_length=19.23u
X19 a_891_2850.t0 a_4869_3370.t0 vss.t6 ppolyf_u_1k r_width=1u r_length=19.23u
X21 a_891_5970.t0 a_4869_5450.t0 vss.t6 ppolyf_u_1k r_width=1u r_length=19.23u
X22 a_891_2850.t0 a_4869_2330.t0 vss.t6 ppolyf_u_1k r_width=1u r_length=19.23u
X27 a_891_4930.t0 a_4869_5450.t0 vss.t6 ppolyf_u_1k r_width=1u r_length=19.23u
X28 a_891_1810.t0 a_4869_2330.t0 vss.t6 ppolyf_u_1k r_width=1u r_length=19.23u
X34 a_891_4930.t0 a_4869_4410.t0 vss.t6 ppolyf_u_1k r_width=1u r_length=19.23u
X38 a_891_1810.t0 a_4869_1290.t0 vss.t6 ppolyf_u_1k r_width=1u r_length=19.23u
X42 a_891_7010.t0 a_4869_7530.t0 vss.t6 ppolyf_u_1k r_width=1u r_length=19.23u
X43 a_4869_7530.t1 out.t14 cap_mim_2f0fF c_width=14.37u c_length=14.36u
X45 a_891_3890.t0 a_4869_4410.t0 vss.t6 ppolyf_u_1k r_width=1u r_length=19.23u
X49 a_891_7010.t0 a_4869_6490.t0 vss.t6 ppolyf_u_1k r_width=1u r_length=19.23u
X52 a_4869_7530.t1 out.t14 cap_mim_2f0fF c_width=14.37u c_length=14.36u
Rpar0 a_2555_12030.t0 a_2555_12030.t1 33.3616
Rpar1 a_2555_12030.t0 a_2555_12030.t4 80.0199
Rpar2 a_2555_12030.t1 a_2555_12030.t4 136.7726
Rpar3 a_4869_7530.t0 a_4869_7530.t1 59.0601
Rpar4 a_5502_10556.t0 a_5502_10556.t2 105.5638
Rpar5 a_7572_8777.t0 a_7572_8777.t1 30.3016
Rpar6 a_7572_8777.t0 a_7572_8777.t4 124.1274
Rpar7 a_7572_8777.t1 a_7572_8777.t4 124.1933
Rpar8 a_891_1290.t0 a_891_1290.t5 297.3867
Rpar9 a_891_1290.t0 a_891_1290.t2 103.4087
Rpar10 a_891_1290.t0 a_891_1290.t4 373.3116
Rpar11 a_891_1290.t5 a_891_1290.t2 142.1430
Rpar12 a_891_1290.t5 a_891_1290.t4 86.8513
Rpar13 a_891_1290.t2 a_891_1290.t4 178.4331
Rpar14 ib ib.t0 11.6450
Rpar15 ib ib.t1 8.3694
Rpar16 inn inn.t0 3.3711
Rpar17 inp inp.t0 3.4197
Rpar18 out out.t0 4.9355
Rpar19 out out.t2 207.4791
Rpar20 out out.t14 260.5045
Rpar21 out.t0 out.t2 138.7529
Rpar22 out.t0 out.t14 174.2140
Rpar23 out.t2 out.t14 439.2428
Rpar24 vdd vdd.t0 102.2033
Rpar25 vdd vdd.t1 414.3995
Rpar26 vdd vdd.t4 104.5426
Rpar27 vdd.t0 vdd.t1 6.2650
Rpar28 vdd.t0 vdd.t4 23.9428
Rpar29 vdd.t1 vdd.t4 97.0797
Rpar30 vss vss.t0 571.0753
Rpar31 vss vss.t1 154.7344
Rpar32 vss vss.t6 37.3959
Rpar33 vss vss.t15 164.1711
Rpar34 vss vss.t16 281.6914
Rpar35 vss.t0 vss.t1 23.4707
Rpar36 vss.t0 vss.t6 7.4824
Rpar37 vss.t0 vss.t15 362.0121
Rpar38 vss.t0 vss.t16 635.7305
Rpar39 vss.t1 vss.t6 17.4972
Rpar40 vss.t1 vss.t15 120.0434
Rpar41 vss.t1 vss.t16 209.4304
Rpar42 vss.t6 vss.t15 398.5955
Rpar43 vss.t6 vss.t16 688.0391
Rpar44 vss.t15 vss.t16 14.8675
Cpar0 a_2555_12030.t0 vss 3.37917e-14
Cpar1 a_2555_12030.t1 vss 4.96392e-15
Cpar2 a_2555_12030.t4 vss 3.51004e-15
Cpar3 a_4869_1290.t0 vss 3.82200e-17
Cpar4 a_4869_2330.t0 vss 4.33000e-17
Cpar5 a_4869_3370.t0 vss 4.25600e-17
Cpar6 a_4869_4410.t0 vss 3.97800e-17
Cpar7 a_4869_5450.t0 vss 3.79800e-17
Cpar8 a_4869_6490.t0 vss 4.05800e-17
Cpar9 a_4869_7530.t0 vss 1.30492e-16
Cpar10 a_4869_7530.t1 vss 5.15430e-15
Cpar11 a_5502_10556.t0 vss 1.08205e-14
Cpar12 a_5502_10556.t2 vss 1.19922e-14
Cpar13 a_7572_8777.t0 vss 4.49508e-15
Cpar14 a_7572_8777.t1 vss 1.08892e-15
Cpar15 a_7572_8777.t4 vss 1.59066e-15
Cpar16 a_891_1290.t0 vss 1.38885e-15
Cpar17 a_891_1290.t2 vss 1.91662e-15
Cpar18 a_891_1290.t4 vss 1.76690e-15
Cpar19 a_891_1290.t5 vss 7.74309e-15
Cpar20 a_891_1810.t0 vss 3.20200e-17
Cpar21 a_891_2850.t0 vss 2.93600e-17
Cpar22 a_891_3890.t0 vss 2.93600e-17
Cpar23 a_891_4930.t0 vss 2.93600e-17
Cpar24 a_891_5970.t0 vss 3.00800e-17
Cpar25 a_891_7010.t0 vss 2.64400e-17
Cpar26 ib vdd 1.92900e-17
Cpar27 ib vss 1.02776e-14
Cpar28 ib.t0 vss 9.99166e-16
Cpar29 ib.t1 vss 5.88000e-17
Cpar30 inn inp 5.15000e-17
Cpar31 inn vdd 7.42952e-15
Cpar32 inn vss 4.47983e-15
Cpar33 inn.t0 vss 4.47343e-15
Cpar34 inp out 1.43400e-17
Cpar35 inp vdd 7.45688e-15
Cpar36 inp vss 4.45849e-15
Cpar37 inp.t0 vss 4.54617e-15
Cpar38 out vdd 8.43828e-15
Cpar39 out vss 2.99474e-14
Cpar40 out.t0 vss 3.22875e-15
Cpar41 out.t14 vss 1.31110e-14
Cpar42 out.t2 vss 4.35088e-15
Cpar43 vdd vss 1.11174e-13
Cpar44 vdd.t0 vss 3.25607e-14
Cpar45 vdd.t1 vss 7.50353e-15
Cpar46 vdd.t4 vss 1.53085e-14
.ends opamp_dut

Vdd vdd 0 1.800000
Vss vss 0 0
Ibias vdd ib 8.100000e-09
Vinp inp 0 DC 0.805000 AC 1 PWL(0 0.805000 3.844709e-06 0.805000 4.229180e-06 0.815000)
Rfb out inn 1m
Cload out 0 2.000000e-12
Xdut vdd vss inp inn out ib opamp_dut
.end
