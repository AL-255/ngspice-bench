* opa1000[0024]: 200f/cherry_hooper_3v3_0p1u_1u_subth (cherry_hooper, VDD=3.3V, CL=0.2pF, Iref=0.0175uA)
.include "pdk_opa.inc"
.temp 27
.option gmin=1e-12 rshunt=1e12 reltol=1e-3 abstol=1e-12 vntol=1e-5 method=gear
* Post-PEX R+C extracted netlist for cherry_hooper_3v3_0p1u_1u_subth
.subckt opamp_dut vdd vss inp inn out ib
XMpar0 a_2640_4791.t1 ib vss.t2 vss.t1 nfet_03v3 w=0.41u l=7.5u ad=1.1480e-13 pd=9.7000e-07 as=1.4760e-13 ps=1.2325e-06 nf=1 m=8 par=8
XMpar1 a_16594_1295.t0 ib vss.t2 vss.t1 nfet_03v3 w=0.41u l=7.5u ad=2.4600e-13 pd=2.0200e-06 as=1.1480e-13 ps=9.7000e-07 nf=1 m=4 par=4
XMpar2 a_15539_2687.t1 a_15539_2687.t0 vdd.t1 vdd.t0 pfet_03v3 w=1.93u l=2.5u ad=7.4627e-13 pd=3.3467e-06 as=7.4627e-13 ps=3.3467e-06 nf=1 m=3 par=3
XMpar3 a_17186_12712.t0 ib vss.t2 vss.t1 nfet_03v3 w=0.41u l=7.5u ad=2.4600e-13 pd=2.0200e-06 as=1.5853e-13 ps=1.3200e-06 nf=1 m=6 par=6
XMpar4 out.t1 a_15748_20215.t1 vdd.t1 vdd.t0 pfet_03v3 w=1.93u l=2.5u ad=5.4040e-13 pd=2.4900e-06 as=5.4040e-13 ps=2.4900e-06 nf=1 m=4 par=4
XMpar5 ib.t1 ib vss.t2 vss.t1 nfet_03v3 w=0.41u l=7.5u ad=2.4600e-13 pd=2.0200e-06 as=1.1480e-13 ps=9.7000e-07 nf=1 m=1
XMpar6 a_23410_10519.t2 a_23410_10519.t1 vdd.t1 vdd.t0 pfet_03v3 w=1.93u l=2.5u ad=1.1580e-12 pd=5.0600e-06 as=1.1580e-12 ps=5.0600e-06 nf=1 m=1
XMpar7 a_16594_1295.t4 inn.t0 a_18094_18832.t3 vss.t42 nfet_03v3 w=0.45u l=2.4u ad=2.7000e-13 pd=2.1000e-06 as=1.2600e-13 ps=1.0100e-06 nf=1 m=2 par=2
XMpar8 a_18094_18832.t1 a_14674_10474.t1 vdd.t21 vdd.t20 pfet_03v3 w=1.7u l=7.5u ad=4.7600e-13 pd=2.2600e-06 as=1.0200e-12 ps=4.6000e-06 nf=1 m=2 par=2
XMpar9 a_2640_4791.t0 a_18094_12712.t8 out.t0 vss.t0 nfet_03v3 w=1.77u l=2.4u ad=1.0620e-12 pd=4.7400e-06 as=1.0620e-12 ps=4.7400e-06 nf=1 m=1
XMpar10 a_18094_12712.t1 a_16720_18624.t3 a_18094_18832.t0 vdd.t13 pfet_03v3 w=0.4u l=5.33u ad=2.4000e-13 pd=2.0000e-06 as=2.4000e-13 ps=2.0000e-06 nf=1 m=1
XMpar11 a_15748_20215.t2 a_15748_20215.t1 vdd.t1 vdd.t0 pfet_03v3 w=1.93u l=2.5u ad=5.4040e-13 pd=2.4900e-06 as=8.4920e-13 ps=3.7750e-06 nf=1 m=4 par=4
XMpar12 a_14674_10474.t2 a_14674_10474.t1 vdd.t21 vdd.t20 pfet_03v3 w=1.7u l=7.5u ad=1.0200e-12 pd=4.6000e-06 as=1.0200e-12 ps=4.6000e-06 nf=1 m=1
XMpar13 a_17186_12712.t6 a_18094_18832.t5 a_18094_12712.t0 vss.t40 nfet_03v3 w=1.33u l=2.4u ad=7.9800e-13 pd=3.8600e-06 as=7.9800e-13 ps=3.8600e-06 nf=1 m=1
XMpar14 a_16174_10682.t2 a_14674_10474.t1 vdd.t21 vdd.t20 pfet_03v3 w=1.7u l=7.5u ad=4.7600e-13 pd=2.2600e-06 as=1.0200e-12 ps=4.6000e-06 nf=1 m=2 par=2
XMpar15 a_16720_18624.t0 ib vss.t2 vss.t1 nfet_03v3 w=0.41u l=7.5u ad=2.4600e-13 pd=2.0200e-06 as=2.4600e-13 ps=2.0200e-06 nf=1 m=1
XMpar16 a_18094_12712.t3 a_18094_12712.t2 vdd.t1 vdd.t0 pfet_03v3 w=1.93u l=2.5u ad=7.4627e-13 pd=3.3467e-06 as=7.4627e-13 ps=3.3467e-06 nf=1 m=3 par=3
XMpar17 a_16720_18624.t2 a_16720_18624.t1 a_23410_10519.t0 vdd.t6 pfet_03v3 w=0.77u l=1u ad=4.6200e-13 pd=2.7400e-06 as=4.6200e-13 ps=2.7400e-06 nf=1 m=1
XMpar18 a_16174_10682.t0 inp.t0 a_16594_1295.t4 vss.t42 nfet_03v3 w=0.45u l=2.4u ad=1.2600e-13 pd=1.0100e-06 as=2.7000e-13 ps=2.1000e-06 nf=1 m=2 par=2
XMpar19 a_14674_10474.t0 ib vss.t2 vss.t1 nfet_03v3 w=0.41u l=7.5u ad=2.4600e-13 pd=2.0200e-06 as=1.1480e-13 ps=9.7000e-07 nf=1 m=1
XMpar20 a_15539_2687.t7 a_16720_18624.t3 a_16174_10682.t4 vdd.t13 pfet_03v3 w=0.4u l=5.33u ad=2.4000e-13 pd=2.0000e-06 as=2.4000e-13 ps=2.0000e-06 nf=1 m=1
XMpar21 a_15748_20215.t0 a_15539_2687.t8 a_2640_4791.t0 vss.t0 nfet_03v3 w=1.77u l=2.4u ad=1.0620e-12 pd=4.7400e-06 as=1.0620e-12 ps=4.7400e-06 nf=1 m=1
XMpar22 a_15539_2687.t6 a_16174_10682.t5 a_17186_12712.t6 vss.t40 nfet_03v3 w=1.33u l=2.4u ad=7.9800e-13 pd=3.8600e-06 as=7.9800e-13 ps=3.8600e-06 nf=1 m=1
X4 out.t5 vss.t44 cap_mim_2f0fF c_width=20u c_length=20u
X27 out.t5 vss.t44 cap_mim_2f0fF c_width=20u c_length=20u
X35 out.t5 vss.t44 cap_mim_2f0fF c_width=20u c_length=20u
X36 out.t5 vss.t44 cap_mim_2f0fF c_width=20u c_length=20u
Rpar0 a_14674_10474.t0 a_14674_10474.t1 54.0274
Rpar1 a_14674_10474.t0 a_14674_10474.t2 240.1815
Rpar2 a_14674_10474.t1 a_14674_10474.t2 25.3056
Rpar3 a_15539_2687.t0 a_15539_2687.t1 19.0853
Rpar4 a_15539_2687.t0 a_15539_2687.t6 1457.5278
Rpar5 a_15539_2687.t0 a_15539_2687.t7 1769.6267
Rpar6 a_15539_2687.t0 a_15539_2687.t8 717.0373
Rpar7 a_15539_2687.t1 a_15539_2687.t6 584.3069
Rpar8 a_15539_2687.t1 a_15539_2687.t7 709.4240
Rpar9 a_15539_2687.t1 a_15539_2687.t8 287.4524
Rpar10 a_15539_2687.t6 a_15539_2687.t7 87.7145
Rpar11 a_15539_2687.t6 a_15539_2687.t8 120.9243
Rpar12 a_15539_2687.t7 a_15539_2687.t8 146.8177
Rpar13 a_15748_20215.t0 a_15748_20215.t1 223.9209
Rpar14 a_15748_20215.t0 a_15748_20215.t2 110.8947
Rpar15 a_15748_20215.t1 a_15748_20215.t2 17.7795
Rpar16 a_16174_10682.t0 a_16174_10682.t2 315.4739
Rpar17 a_16174_10682.t0 a_16174_10682.t4 517.6202
Rpar18 a_16174_10682.t0 a_16174_10682.t5 196.4906
Rpar19 a_16174_10682.t2 a_16174_10682.t4 182.1524
Rpar20 a_16174_10682.t2 a_16174_10682.t5 69.1457
Rpar21 a_16174_10682.t4 a_16174_10682.t5 113.4523
Rpar22 a_16594_1295.t0 a_16594_1295.t4 63.4339
Rpar23 a_16720_18624.t0 a_16720_18624.t1 536.5977
Rpar24 a_16720_18624.t0 a_16720_18624.t2 228.0314
Rpar25 a_16720_18624.t0 a_16720_18624.t3 118.3134
Rpar26 a_16720_18624.t1 a_16720_18624.t2 49.4786
Rpar27 a_16720_18624.t1 a_16720_18624.t3 667.4180
Rpar28 a_16720_18624.t2 a_16720_18624.t3 283.6245
Rpar29 a_17186_12712.t0 a_17186_12712.t6 67.4187
Rpar30 a_18094_12712.t0 a_18094_12712.t1 87.7145
Rpar31 a_18094_12712.t0 a_18094_12712.t2 1457.5278
Rpar32 a_18094_12712.t0 a_18094_12712.t3 584.3069
Rpar33 a_18094_12712.t0 a_18094_12712.t8 120.9243
Rpar34 a_18094_12712.t1 a_18094_12712.t2 1769.6267
Rpar35 a_18094_12712.t1 a_18094_12712.t3 709.4240
Rpar36 a_18094_12712.t1 a_18094_12712.t8 146.8177
Rpar37 a_18094_12712.t2 a_18094_12712.t3 19.0853
Rpar38 a_18094_12712.t2 a_18094_12712.t8 717.0373
Rpar39 a_18094_12712.t3 a_18094_12712.t8 287.4524
Rpar40 a_18094_18832.t0 a_18094_18832.t1 182.1524
Rpar41 a_18094_18832.t0 a_18094_18832.t3 517.6202
Rpar42 a_18094_18832.t0 a_18094_18832.t5 113.4523
Rpar43 a_18094_18832.t1 a_18094_18832.t3 315.4739
Rpar44 a_18094_18832.t1 a_18094_18832.t5 69.1457
Rpar45 a_18094_18832.t3 a_18094_18832.t5 196.4906
Rpar46 a_23410_10519.t0 a_23410_10519.t1 345.8323
Rpar47 a_23410_10519.t0 a_23410_10519.t2 137.4246
Rpar48 a_23410_10519.t1 a_23410_10519.t2 32.2780
Rpar49 a_2640_4791.t0 a_2640_4791.t1 54.7441
Rpar50 ib ib.t1 24.5384
Rpar51 inn inn.t0 3.8625
Rpar52 inp inp.t0 3.9111
Rpar53 out out.t0 218.4572
Rpar54 out out.t1 107.9178
Rpar55 out out.t5 18.2730
Rpar56 out.t0 out.t1 129.4867
Rpar57 out.t0 out.t5 837.9558
Rpar58 out.t1 out.t5 413.9499
Rpar59 vdd vdd.t0 84.2084
Rpar60 vdd vdd.t1 104.2439
Rpar61 vdd vdd.t13 142.8024
Rpar62 vdd vdd.t20 592.0675
Rpar63 vdd vdd.t21 248.4188
Rpar64 vdd vdd.t6 10221.5145
Rpar65 vdd.t0 vdd.t1 3.3060
Rpar66 vdd.t0 vdd.t13 232.1489
Rpar67 vdd.t0 vdd.t20 271.6161
Rpar68 vdd.t0 vdd.t21 136.4816
Rpar69 vdd.t0 vdd.t6 476.7787
Rpar70 vdd.t1 vdd.t13 232.1043
Rpar71 vdd.t1 vdd.t20 170.1188
Rpar72 vdd.t1 vdd.t21 84.5522
Rpar73 vdd.t1 vdd.t6 314.3184
Rpar74 vdd.t13 vdd.t20 782.4192
Rpar75 vdd.t13 vdd.t21 328.2862
Rpar76 vdd.t13 vdd.t6 13507.7654
Rpar77 vdd.t20 vdd.t21 6.9330
Rpar78 vdd.t20 vdd.t6 500.9118
Rpar79 vdd.t21 vdd.t6 327.5063
Rpar80 vss vss.t0 268.2712
Rpar81 vss vss.t1 151.6426
Rpar82 vss vss.t2 415.1370
Rpar83 vss vss.t40 879.8762
Rpar84 vss vss.t42 95.0221
Rpar85 vss vss.t44 1807.0043
Rpar86 vss.t0 vss.t1 9.3334
Rpar87 vss.t0 vss.t2 18.6505
Rpar88 vss.t0 vss.t40 460.0457
Rpar89 vss.t0 vss.t42 113.6696
Rpar90 vss.t0 vss.t44 174.1168
Rpar91 vss.t1 vss.t2 3.8781
Rpar92 vss.t1 vss.t40 199.4644
Rpar93 vss.t1 vss.t42 112.3207
Rpar94 vss.t1 vss.t44 190.0121
Rpar95 vss.t2 vss.t40 896.0742
Rpar96 vss.t2 vss.t42 185.5400
Rpar97 vss.t2 vss.t44 525.7806
Rpar98 vss.t40 vss.t42 1023.5658
Rpar99 vss.t40 vss.t44 1116.1558
Rpar100 vss.t42 vss.t44 1589.6555
Cpar0 a_14674_10474.t0 vss 4.91286e-15
Cpar1 a_14674_10474.t1 vss 2.95863e-14
Cpar2 a_14674_10474.t2 vss 4.01895e-15
Cpar3 a_15539_2687.t0 vss 5.37525e-15
Cpar4 a_15539_2687.t1 vss 6.82822e-15
Cpar5 a_15539_2687.t6 vss 3.89480e-15
Cpar6 a_15539_2687.t7 vss 3.60694e-15
Cpar7 a_15539_2687.t8 vss 6.53128e-15
Cpar8 a_15748_20215.t0 vss 3.96679e-15
Cpar9 a_15748_20215.t1 vss 1.25965e-14
Cpar10 a_15748_20215.t2 vss 4.93016e-15
Cpar11 a_16174_10682.t0 vss 7.30674e-15
Cpar12 a_16174_10682.t2 vss 4.82766e-15
Cpar13 a_16174_10682.t4 vss 3.38362e-15
Cpar14 a_16174_10682.t5 vss 6.45634e-15
Cpar15 a_16594_1295.t0 vss 1.11968e-14
Cpar16 a_16594_1295.t4 vss 3.46484e-15
Cpar17 a_16720_18624.t0 vss 9.42078e-15
Cpar18 a_16720_18624.t1 vss 3.35774e-15
Cpar19 a_16720_18624.t2 vss 6.86159e-15
Cpar20 a_16720_18624.t3 vss 1.61202e-14
Cpar21 a_17186_12712.t0 vss 1.43352e-14
Cpar22 a_17186_12712.t6 vss 4.83375e-15
Cpar23 a_18094_12712.t0 vss 4.89935e-15
Cpar24 a_18094_12712.t1 vss 4.53724e-15
Cpar25 a_18094_12712.t2 vss 6.76164e-15
Cpar26 a_18094_12712.t3 vss 8.58933e-15
Cpar27 a_18094_12712.t8 vss 8.21583e-15
Cpar28 a_18094_18832.t0 vss 4.90300e-15
Cpar29 a_18094_18832.t1 vss 6.99547e-15
Cpar30 a_18094_18832.t3 vss 1.06111e-14
Cpar31 a_18094_18832.t5 vss 9.35552e-15
Cpar32 a_23410_10519.t0 vss 7.56123e-15
Cpar33 a_23410_10519.t1 vss 5.26361e-15
Cpar34 a_23410_10519.t2 vss 8.83141e-15
Cpar35 a_2640_4791.t0 vss 1.20994e-15
Cpar36 a_2640_4791.t1 vss 3.22085e-15
Cpar37 ib vdd 1.99310e-16
Cpar38 ib vss 1.09600e-13
Cpar39 ib.t1 vss 3.55119e-16
Cpar40 inn inp 5.19900e-17
Cpar41 inn vdd 2.13400e-17
Cpar42 inn vss 3.03869e-15
Cpar43 inn.t0 vss 2.86287e-16
Cpar44 inp vss 3.06629e-15
Cpar45 inp.t0 vss 2.75661e-16
Cpar46 out vdd 9.17088e-15
Cpar47 out vss 3.56092e-14
Cpar48 out.t0 vss 1.29002e-16
Cpar49 out.t1 vss 2.17775e-16
Cpar50 out.t5 vss 1.66586e-14
Cpar51 vdd vss 1.82597e-13
Cpar52 vdd.t0 vss 2.29606e-14
Cpar53 vdd.t1 vss 2.30921e-14
Cpar54 vdd.t13 vss 6.18296e-15
Cpar55 vdd.t20 vss 1.85878e-14
Cpar56 vdd.t21 vss 1.28361e-14
Cpar57 vdd.t6 vss 3.03442e-15
.ends opamp_dut

Vdd vdd 0 3.300000
Vss vss 0 0
Ibias vdd ib 1.750000e-08
Vinp inp 0 DC 2.071700 AC 1 PWL(0 2.071700 2.719587e-07 2.071700 2.991546e-07 2.081700)
Rfb out inn 1m
Cload out 0 2.000000e-13
Xdut vdd vss inp inn out ib opamp_dut
.end
