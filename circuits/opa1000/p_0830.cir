* opa1000[0830]: 2p/symmetrical_ota_3v3_i150u_subth (symmetrical_ota, VDD=3.3V, CL=2.0pF, Iref=17.5uA)
.include "pdk_opa.inc"
.temp 27
.option gmin=1e-12 rshunt=1e12 reltol=1e-3 abstol=1e-12 vntol=1e-5 method=gear
* Post-PEX R+C extracted netlist for symmetrical_ota_3v3_i150u_subth
.subckt opamp_dut vdd vss inp inn out ib
XMpar0 a_7038_996.t0 a_8288_11261.t0 vdd.t1 vdd.t0 pfet_03v3 w=10u l=0.56u ad=2.8000e-12 pd=1.0560e-05 as=3.3333e-12 ps=1.2333e-05 nf=1 m=12 par=12
XMpar1 a_2842_10087.t64 ib.t0 vss.t58 vss.t11 nfet_03v3 w=5.52u l=0.81u ad=2.1344e-12 pd=8.1333e-06 as=1.8400e-12 ps=7.1067e-06 nf=1 m=12 par=12
XMpar2 a_1216_996.t12 inp.t0 a_2842_10087.t0 vss.t11 nfet_03v3 w=2.34u l=0.28u ad=1.0296e-12 pd=3.2931e-06 as=1.0530e-12 ps=3.3862e-06 nf=1 m=64 par=64
XMpar3 ib.t1 ib.t0 vss.t58 vss.t11 nfet_03v3 w=5.52u l=0.81u ad=2.1344e-12 pd=8.1333e-06 as=1.5456e-12 ps=6.0800e-06 nf=1 m=6 par=6
XMpar4 a_2842_10087.t0 inn.t0 a_8288_11261.t12 vss.t11 nfet_03v3 w=2.34u l=0.28u ad=1.0530e-12 pd=3.3862e-06 as=1.0296e-12 ps=3.2931e-06 nf=1 m=64 par=64
XMpar5 a_8288_11261.t1 a_8288_11261.t0 vdd.t1 vdd.t0 pfet_03v3 w=10u l=0.56u ad=2.8000e-12 pd=1.0560e-05 as=2.8000e-12 ps=1.0560e-05 nf=1 m=6 par=6
XMpar6 out.t2 a_7038_996.t12 vss.t1 vss.t0 nfet_03v3 w=2.84u l=0.56u ad=1.0981e-12 pd=4.5600e-06 as=7.9520e-13 ps=3.4000e-06 nf=1 m=12 par=12
XMpar7 a_7038_996.t13 a_7038_996.t12 vss.t1 vss.t0 nfet_03v3 w=2.84u l=0.56u ad=7.9520e-13 pd=3.4000e-06 as=7.9520e-13 ps=3.4000e-06 nf=1 m=12 par=12
XMpar8 out.t0 a_1216_996.t0 vdd.t1 vdd.t0 pfet_03v3 w=10u l=0.56u ad=2.8000e-12 pd=1.0560e-05 as=3.3333e-12 ps=1.2333e-05 nf=1 m=12 par=12
XMpar9 a_1216_996.t1 a_1216_996.t0 vdd.t1 vdd.t0 pfet_03v3 w=10u l=0.56u ad=2.8000e-12 pd=1.0560e-05 as=2.8000e-12 ps=1.0560e-05 nf=1 m=6 par=6
X163 out.t24 vss.t92 cap_mim_2f0fF c_width=15.74u c_length=15.73u
X176 out.t24 vss.t92 cap_mim_2f0fF c_width=15.74u c_length=15.73u
Rpar0 a_1216_996.t0 a_1216_996.t1 21.5555
Rpar1 a_1216_996.t0 a_1216_996.t12 240.6558
Rpar2 a_1216_996.t1 a_1216_996.t12 50.5508
Rpar3 a_2842_10087.t0 a_2842_10087.t64 36.2660
Rpar4 a_7038_996.t0 a_7038_996.t12 202.8384
Rpar5 a_7038_996.t0 a_7038_996.t13 27.1062
Rpar6 a_7038_996.t12 a_7038_996.t13 9.0445
Rpar7 a_8288_11261.t0 a_8288_11261.t1 21.5556
Rpar8 a_8288_11261.t0 a_8288_11261.t12 240.6497
Rpar9 a_8288_11261.t1 a_8288_11261.t12 50.5512
Rpar10 ib ib.t0 21.8664
Rpar11 ib ib.t1 3.6640
Rpar12 ib.t0 ib.t1 16.1442
Rpar13 inn inn.t0 2.6154
Rpar14 inp inp.t0 2.6154
Rpar15 out out.t0 1.7863
Rpar16 out out.t2 79.5985
Rpar17 out out.t24 468.5220
Rpar18 out.t0 out.t2 37.6062
Rpar19 out.t0 out.t24 221.3524
Rpar20 out.t2 out.t24 155.4226
Rpar21 vdd vdd.t0 69.3256
Rpar22 vdd vdd.t1 367.6250
Rpar23 vdd.t0 vdd.t1 2.3854
Rpar24 vss vss.t0 651.0380
Rpar25 vss vss.t1 4612.8234
Rpar26 vss vss.t11 63.0901
Rpar27 vss vss.t58 434.7146
Rpar28 vss vss.t92 803.4805
Rpar29 vss.t0 vss.t1 15.3817
Rpar30 vss.t0 vss.t11 6.6830
Rpar31 vss.t0 vss.t58 235.6312
Rpar32 vss.t0 vss.t92 463.6684
Rpar33 vss.t1 vss.t11 47.9143
Rpar34 vss.t1 vss.t58 1668.3069
Rpar35 vss.t1 vss.t92 3281.5184
Rpar36 vss.t11 vss.t58 9.1934
Rpar37 vss.t11 vss.t92 69.9688
Rpar38 vss.t58 vss.t92 102.4193
Cpar0 a_1216_996.t0 vss 2.29096e-14
Cpar1 a_1216_996.t1 vss 1.57886e-14
Cpar2 a_1216_996.t12 vss 3.90425e-14
Cpar3 a_2842_10087.t0 vss 6.96572e-14
Cpar4 a_2842_10087.t64 vss 1.85832e-14
Cpar5 a_7038_996.t0 vss 1.32231e-14
Cpar6 a_7038_996.t12 vss 9.30957e-15
Cpar7 a_7038_996.t13 vss 7.63072e-15
Cpar8 a_8288_11261.t0 vss 2.16425e-14
Cpar9 a_8288_11261.t1 vss 1.49153e-14
Cpar10 a_8288_11261.t12 vss 3.68832e-14
Cpar11 ib inn 1.52200e-17
Cpar12 ib out 7.77200e-17
Cpar13 ib vss 2.72633e-14
Cpar14 ib.t0 vss 4.42123e-15
Cpar15 ib.t1 vss 2.17271e-15
Cpar16 inn inp 9.81400e-17
Cpar17 inn vdd 1.99700e-17
Cpar18 inn vss 2.81537e-14
Cpar19 inn.t0 vss 1.07829e-14
Cpar20 inp out 1.98380e-16
Cpar21 inp vdd 4.14100e-17
Cpar22 inp vss 2.80609e-14
Cpar23 inp.t0 vss 1.08864e-14
Cpar24 out vdd 2.25853e-14
Cpar25 out vss 3.37714e-14
Cpar26 out.t0 vss 3.00277e-15
Cpar27 out.t2 vss 2.22513e-15
Cpar28 out.t24 vss 2.79916e-14
Cpar29 vdd vss 1.29645e-13
Cpar30 vdd.t0 vss 5.77099e-14
Cpar31 vdd.t1 vss 2.67601e-14
.ends opamp_dut

Vdd vdd 0 3.300000
Vss vss 0 0
Ibias vdd ib 1.750000e-05
Vinp inp 0 DC 1.645000 AC 1 PWL(0 1.645000 3.000000e-09 1.645000 3.300000e-09 1.655000)
Rfb out inn 1m
Cload out 0 2.000000e-12
Xdut vdd vss inp inn out ib opamp_dut
.end
