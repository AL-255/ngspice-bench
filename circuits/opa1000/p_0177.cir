* opa1000[0177]: 200f/folded_cascode_nmos_1v8_1u_10u_weak (folded_cascode_nmos, VDD=1.8V, CL=0.2pF, Iref=0.9444uA)
.include "pdk_opa.inc"
.temp 27
.option gmin=1e-12 rshunt=1e12 reltol=1e-3 abstol=1e-12 vntol=1e-5 method=gear
* Post-PEX R+C extracted netlist for folded_cascode_nmos_1v8_1u_10u_weak
.subckt opamp_dut vdd vss inp inn out ib
XMpar0 a_2966_4859.t1 a_2966_4859.t0 vss.t1 vss.t0 nfet_03v3 w=1.13u l=2.5u ad=6.7800e-13 pd=3.4600e-06 as=3.1640e-13 ps=1.6900e-06 nf=1 m=2 par=2
XMpar1 ib.t1 ib.t0 vss.t1 vss.t0 nfet_03v3 w=1.13u l=2.5u ad=6.7800e-13 pd=3.4600e-06 as=3.1640e-13 ps=1.6900e-06 nf=1 m=2 par=2
XMpar2 a_2586_4859.t2 a_1986_8158.t2 vdd.t1 vdd.t0 pfet_03v3 w=4.97u l=3.13u ad=1.3916e-12 pd=5.5300e-06 as=2.1868e-12 ps=8.3350e-06 nf=1 m=4 par=4
XMpar3 a_2430_1249.t0 inp.t0 a_2586_4859.t0 vss.t2 nfet_03v3 w=1.78u l=1.3u ad=1.0680e-12 pd=4.7600e-06 as=4.9840e-13 ps=2.3400e-06 nf=1 m=2 par=2
XMpar4 a_5134_4859.t0 a_1986_8158.t2 vdd.t1 vdd.t0 pfet_03v3 w=4.97u l=3.13u ad=1.3916e-12 pd=5.5300e-06 as=2.1868e-12 ps=8.3350e-06 nf=1 m=4 par=4
XMpar5 a_5134_4859.t3 ib.t10 out.t2 vdd.t8 pfet_03v3 w=1.63u l=1.3u ad=6.3027e-13 pd=2.9467e-06 as=4.5640e-13 ps=2.1900e-06 nf=1 m=6 par=6
XMpar6 a_1986_8158.t0 ib.t0 vss.t1 vss.t0 nfet_03v3 w=1.13u l=2.5u ad=3.1640e-13 pd=1.6900e-06 as=3.1640e-13 ps=1.6900e-06 nf=1 m=2 par=2
XMpar7 out.t0 a_2966_4859.t0 vss.t1 vss.t0 nfet_03v3 w=1.13u l=2.5u ad=3.1640e-13 pd=1.6900e-06 as=3.1640e-13 ps=1.6900e-06 nf=1 m=2 par=2
XMpar8 a_2430_1249.t4 ib.t0 vss.t1 vss.t0 nfet_03v3 w=1.13u l=2.5u ad=3.1640e-13 pd=1.6900e-06 as=3.1640e-13 ps=1.6900e-06 nf=1 m=4 par=4
XMpar9 a_2586_4859.t3 ib.t10 a_2966_4859.t4 vdd.t8 pfet_03v3 w=1.63u l=1.3u ad=6.3027e-13 pd=2.9467e-06 as=4.5640e-13 ps=2.1900e-06 nf=1 m=6 par=6
XMpar10 a_2430_1249.t0 inn.t0 a_5134_4859.t1 vss.t2 nfet_03v3 w=1.78u l=1.3u ad=1.0680e-12 pd=4.7600e-06 as=4.9840e-13 ps=2.3400e-06 nf=1 m=2 par=2
XMpar11 a_1986_8158.t3 a_1986_8158.t2 vdd.t1 vdd.t0 pfet_03v3 w=4.97u l=3.13u ad=1.3916e-12 pd=5.5300e-06 as=2.9820e-12 ps=1.1140e-05 nf=1 m=2 par=2
Rpar0 a_1986_8158.t0 a_1986_8158.t2 157.1562
Rpar1 a_1986_8158.t0 a_1986_8158.t3 293.6571
Rpar2 a_1986_8158.t2 a_1986_8158.t3 20.7314
Rpar3 a_2430_1249.t0 a_2430_1249.t4 39.9379
Rpar4 a_2586_4859.t0 a_2586_4859.t2 192.3184
Rpar5 a_2586_4859.t0 a_2586_4859.t3 64.5482
Rpar6 a_2586_4859.t2 a_2586_4859.t3 60.6039
Rpar7 a_2966_4859.t0 a_2966_4859.t1 20.7167
Rpar8 a_2966_4859.t0 a_2966_4859.t4 128.9102
Rpar9 a_2966_4859.t1 a_2966_4859.t4 74.6537
Rpar10 a_5134_4859.t0 a_5134_4859.t1 192.3184
Rpar11 a_5134_4859.t0 a_5134_4859.t3 60.6039
Rpar12 a_5134_4859.t1 a_5134_4859.t3 64.5482
Rpar13 ib ib.t0 253.1106
Rpar14 ib ib.t1 168.6159
Rpar15 ib ib.t10 1.6681
Rpar16 ib.t0 ib.t1 19.8844
Rpar17 ib.t0 ib.t10 316.3236
Rpar18 ib.t1 ib.t10 210.7269
Rpar19 inn inn.t0 9.5361
Rpar20 inp inp.t0 9.5847
Rpar21 out out.t0 13.3164
Rpar22 out out.t2 33.7324
Rpar23 vdd vdd.t0 28.5770
Rpar24 vdd vdd.t1 78.9231
Rpar25 vdd vdd.t8 92.2590
Rpar26 vdd.t0 vdd.t1 4.4428
Rpar27 vdd.t0 vdd.t8 154.3742
Rpar28 vdd.t1 vdd.t8 179.9158
Rpar29 vss vss.t0 111.9227
Rpar30 vss vss.t1 270.7058
Rpar31 vss vss.t2 102.8123
Rpar32 vss.t0 vss.t1 7.5691
Rpar33 vss.t0 vss.t2 5.0199
Rpar34 vss.t1 vss.t2 14.5348
Cpar0 a_1986_8158.t0 vss 5.15229e-15
Cpar1 a_1986_8158.t2 vss 2.76150e-14
Cpar2 a_1986_8158.t3 vss 4.02563e-15
Cpar3 a_2430_1249.t0 vss 3.88172e-15
Cpar4 a_2430_1249.t4 vss 4.28014e-15
Cpar5 a_2586_4859.t0 vss 2.03423e-15
Cpar6 a_2586_4859.t2 vss 6.44465e-15
Cpar7 a_2586_4859.t3 vss 4.11008e-15
Cpar8 a_2966_4859.t0 vss 3.65677e-15
Cpar9 a_2966_4859.t1 vss 1.24936e-15
Cpar10 a_2966_4859.t4 vss 1.74509e-15
Cpar11 a_5134_4859.t0 vss 7.38167e-15
Cpar12 a_5134_4859.t1 vss 2.32999e-15
Cpar13 a_5134_4859.t3 vss 4.70768e-15
Cpar14 ib inn 1.10400e-17
Cpar15 ib out 6.15060e-16
Cpar16 ib vdd 9.60992e-15
Cpar17 ib vss 2.17233e-14
Cpar18 ib.t0 vss 7.55731e-15
Cpar19 ib.t1 vss 1.93507e-15
Cpar20 ib.t10 vss 4.96803e-15
Cpar21 inn inp 5.16000e-17
Cpar22 inn vss 2.07148e-15
Cpar23 inn.t0 vss 3.46916e-16
Cpar24 inp vss 2.07550e-15
Cpar25 inp.t0 vss 3.32342e-16
Cpar26 out vdd 2.79417e-15
Cpar27 out vss 6.40025e-15
Cpar28 out.t0 vss 3.69661e-16
Cpar29 out.t2 vss 3.50086e-15
Cpar30 vdd vss 1.02453e-13
Cpar31 vdd.t0 vss 2.22795e-14
Cpar32 vdd.t1 vss 1.34768e-14
Cpar33 vdd.t8 vss 1.42717e-14
.ends opamp_dut

Vdd vdd 0 1.800000
Vss vss 0 0
Ibias vdd ib 9.444000e-07
Vinp inp 0 DC 0.985000 AC 1 PWL(0 0.985000 9.461004e-09 0.985000 1.040710e-08 0.995000)
Rfb out inn 1m
Cload out 0 2.000000e-13
Xdut vdd vss inp inn out ib opamp_dut
.end
