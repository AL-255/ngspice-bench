* opa1000[0951]: 200f/telescopic_pmos_3v3_i10u_weak (telescopic_pmos, VDD=3.3V, CL=0.2pF, Iref=2.0uA)
.include "pdk_opa.inc"
.temp 27
.option gmin=1e-12 rshunt=1e12 reltol=1e-3 abstol=1e-12 vntol=1e-5 method=gear
* Post-PEX R+C extracted netlist for telescopic_pmos_3v3_i10u_weak
.subckt opamp_dut vdd vss inp inn out ib
XMpar0 a_3102_8011.t0 a_3264_9579.t8 a_3264_9579.t9 vdd.t0 pfet_03v3 w=1.88u l=1.13u ad=8.6062e-13 pd=3.8400e-06 as=5.9324e-13 ps=2.7200e-06 nf=1 m=18 par=18
XMpar1 a_2826_8011.t0 inn.t0 a_4096_9787.t4 vdd.t9 pfet_03v3 w=2u l=0.78u ad=6.5143e-13 pd=2.9371e-06 as=5.6000e-13 ps=2.5600e-06 nf=1 m=14 par=14
XMpar2 a_4096_9787.t0 a_3264_9579.t8 out.t0 vdd.t0 pfet_03v3 w=1.88u l=1.13u ad=8.6062e-13 pd=3.8400e-06 as=5.9324e-13 ps=2.7200e-06 nf=1 m=18 par=18
XMpar3 a_3264_9579.t1 a_3264_9579.t0 a_5248_1294.t1 vss.t4 nfet_03v3 w=1.83u l=1.13u ad=5.1240e-13 pd=2.3900e-06 as=1.0980e-12 ps=4.8600e-06 nf=1 m=4 par=4
XMpar4 a_2166_1294.t1 a_2166_1294.t0 vdd.t4 vdd.t3 pfet_03v3 w=5.68u l=1.5u ad=1.5904e-12 pd=6.2400e-06 as=1.5904e-12 ps=6.2400e-06 nf=1 m=2 par=2
XMpar5 a_6200_1294.t0 a_3264_9579.t48 vss.t1 vss.t0 nfet_03v3 w=2.02u l=1.8u ad=5.6560e-13 pd=2.5800e-06 as=5.6560e-13 ps=2.5800e-06 nf=1 m=2 par=2
XMpar6 a_6200_1294.t1 a_3264_9579.t0 out.t2 vss.t4 nfet_03v3 w=1.83u l=1.13u ad=8.0520e-13 pd=3.6250e-06 as=5.1240e-13 ps=2.3900e-06 nf=1 m=4 par=4
XMpar7 a_2826_8011.t0 inp.t0 a_3102_8011.t1 vdd.t9 pfet_03v3 w=2u l=0.78u ad=6.5143e-13 pd=2.9371e-06 as=5.6000e-13 ps=2.5600e-06 nf=1 m=14 par=14
XMpar8 a_2826_8011.t14 a_2166_1294.t0 vdd.t4 vdd.t3 pfet_03v3 w=5.68u l=1.5u ad=1.5904e-12 pd=6.2400e-06 as=2.0448e-12 ps=7.8200e-06 nf=1 m=8 par=8
XMpar9 a_2166_1294.t4 ib.t0 vss.t14 vss.t13 nfet_03v3 w=1.29u l=1.5u ad=3.6120e-13 pd=1.8500e-06 as=3.6120e-13 ps=1.8500e-06 nf=1 m=2 par=2
XMpar10 a_5248_1294.t0 a_3264_9579.t48 vss.t1 vss.t0 nfet_03v3 w=2.02u l=1.8u ad=1.2120e-12 pd=5.2400e-06 as=5.6560e-13 ps=2.5800e-06 nf=1 m=2 par=2
XMpar11 ib.t1 ib.t0 vss.t14 vss.t13 nfet_03v3 w=1.29u l=1.5u ad=7.7400e-13 pd=3.7800e-06 as=3.6120e-13 ps=1.8500e-06 nf=1 m=2 par=2
X12 out.t22 vss.t23 cap_mim_2f0fF c_width=14.37u c_length=14.36u
Rpar0 a_2166_1294.t0 a_2166_1294.t1 22.8060
Rpar1 a_2166_1294.t0 a_2166_1294.t4 206.5776
Rpar2 a_2166_1294.t1 a_2166_1294.t4 127.5527
Rpar3 a_2826_8011.t0 a_2826_8011.t14 34.9236
Rpar4 a_3102_8011.t0 a_3102_8011.t1 45.9700
Rpar5 a_3264_9579.t0 a_3264_9579.t1 21.1290
Rpar6 a_3264_9579.t0 a_3264_9579.t8 1523.0163
Rpar7 a_3264_9579.t0 a_3264_9579.t9 489.9304
Rpar8 a_3264_9579.t0 a_3264_9579.t48 139.3413
Rpar9 a_3264_9579.t1 a_3264_9579.t8 649.4721
Rpar10 a_3264_9579.t1 a_3264_9579.t9 208.9249
Rpar11 a_3264_9579.t1 a_3264_9579.t48 59.4204
Rpar12 a_3264_9579.t8 a_3264_9579.t9 8.1167
Rpar13 a_3264_9579.t8 a_3264_9579.t48 759.6255
Rpar14 a_3264_9579.t9 a_3264_9579.t48 244.3596
Rpar15 a_4096_9787.t0 a_4096_9787.t4 34.0508
Rpar16 a_5248_1294.t0 a_5248_1294.t1 60.1864
Rpar17 a_6200_1294.t0 a_6200_1294.t1 43.6123
Rpar18 ib ib.t0 12.8846
Rpar19 ib ib.t1 6.6499
Rpar20 inn inn.t0 2.1513
Rpar21 inp inp.t0 2.1999
Rpar22 out out.t0 3.5644
Rpar23 out out.t2 481.1894
Rpar24 out out.t22 277.6150
Rpar25 out.t0 out.t2 206.8468
Rpar26 out.t0 out.t22 119.3371
Rpar27 out.t2 out.t22 92.8444
Rpar28 vdd vdd.t0 22.2900
Rpar29 vdd vdd.t9 148.3570
Rpar30 vdd vdd.t3 404.7415
Rpar31 vdd vdd.t4 1427.8809
Rpar32 vdd.t0 vdd.t9 55.8149
Rpar33 vdd.t0 vdd.t3 152.2720
Rpar34 vdd.t0 vdd.t4 537.1980
Rpar35 vdd.t9 vdd.t3 50.7468
Rpar36 vdd.t9 vdd.t4 179.0289
Rpar37 vdd.t3 vdd.t4 5.1774
Rpar38 vss vss.t0 461.5058
Rpar39 vss vss.t1 314.1498
Rpar40 vss vss.t4 60.8718
Rpar41 vss vss.t13 218.3400
Rpar42 vss vss.t14 515.4652
Rpar43 vss vss.t23 252.2911
Rpar44 vss.t0 vss.t1 58.6405
Rpar45 vss.t0 vss.t4 8.2221
Rpar46 vss.t0 vss.t13 998.8942
Rpar47 vss.t0 vss.t23 827.1623
Rpar48 vss.t1 vss.t4 8.8139
Rpar49 vss.t1 vss.t13 581.5052
Rpar50 vss.t1 vss.t14 1373.6240
Rpar51 vss.t1 vss.t23 440.5476
Rpar52 vss.t4 vss.t13 136.5295
Rpar53 vss.t4 vss.t14 322.5762
Rpar54 vss.t4 vss.t23 115.7605
Rpar55 vss.t13 vss.t14 11.6563
Rpar56 vss.t13 vss.t23 168.0141
Rpar57 vss.t14 vss.t23 396.6380
Cpar0 a_2166_1294.t0 vss 1.79181e-14
Cpar1 a_2166_1294.t1 vss 4.43839e-15
Cpar2 a_2166_1294.t4 vss 2.36483e-15
Cpar3 a_2826_8011.t0 vss 1.73464e-14
Cpar4 a_2826_8011.t14 vss 1.15112e-14
Cpar5 a_3102_8011.t0 vss 2.44532e-14
Cpar6 a_3102_8011.t1 vss 1.05432e-14
Cpar7 a_3264_9579.t0 vss 7.68620e-15
Cpar8 a_3264_9579.t1 vss 4.23320e-15
Cpar9 a_3264_9579.t48 vss 7.04976e-15
Cpar10 a_3264_9579.t8 vss 3.16870e-14
Cpar11 a_3264_9579.t9 vss 1.81726e-14
Cpar12 a_4096_9787.t0 vss 2.91417e-14
Cpar13 a_4096_9787.t4 vss 1.14250e-14
Cpar14 a_5248_1294.t0 vss 3.82142e-15
Cpar15 a_5248_1294.t1 vss 3.79126e-15
Cpar16 a_6200_1294.t0 vss 3.52867e-15
Cpar17 a_6200_1294.t1 vss 5.21237e-15
Cpar18 ib vss 7.16343e-15
Cpar19 ib.t0 vss 7.16395e-16
Cpar20 ib.t1 vss 7.38300e-17
Cpar21 inn inp 5.18900e-17
Cpar22 inn vdd 8.10189e-15
Cpar23 inn vss 5.11200e-15
Cpar24 inn.t0 vss 6.28890e-15
Cpar25 inp out 9.49700e-17
Cpar26 inp vdd 7.85958e-15
Cpar27 inp vss 4.97358e-15
Cpar28 inp.t0 vss 6.29384e-15
Cpar29 out vdd 1.17471e-14
Cpar30 out vss 1.46936e-14
Cpar31 out.t0 vss 5.33805e-15
Cpar32 out.t2 vss 2.05823e-15
Cpar33 out.t22 vss 2.74392e-14
Cpar34 vdd vss 1.84736e-13
Cpar35 vdd.t0 vss 4.78166e-14
Cpar36 vdd.t3 vss 1.51100e-14
Cpar37 vdd.t4 vss 6.81619e-15
Cpar38 vdd.t9 vss 2.12796e-14
.ends opamp_dut

Vdd vdd 0 3.300000
Vss vss 0 0
Ibias vdd ib 2.000000e-06
Vinp inp 0 DC 1.480000 AC 1 PWL(0 1.480000 7.278906e-09 1.480000 8.006797e-09 1.490000)
Rfb out inn 1m
Cload out 0 2.000000e-13
Xdut vdd vss inp inn out ib opamp_dut
.end
