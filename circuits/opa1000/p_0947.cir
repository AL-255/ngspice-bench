* opa1000[0947]: 200f/telescopic_pmos_3v3_i2u_weak (telescopic_pmos, VDD=3.3V, CL=0.2pF, Iref=0.46uA)
.include "pdk_opa.inc"
.temp 27
.option gmin=1e-12 rshunt=1e12 reltol=1e-3 abstol=1e-12 vntol=1e-5 method=gear
* Post-PEX R+C extracted netlist for telescopic_pmos_3v3_i2u_weak
.subckt opamp_dut vdd vss inp inn out ib
XMpar0 a_7494_2995.t0 a_3824_7605.t20 vss.t1 vss.t0 nfet_03v3 w=1.5u l=4.25u ad=4.2000e-13 pd=2.0600e-06 as=4.2000e-13 ps=2.0600e-06 nf=1 m=2 par=2
XMpar1 a_1664_9867.t0 inp.t0 a_2534_9867.t0 vdd.t4 pfet_03v3 w=1.95u l=3.75u ad=6.5612e-13 pd=2.9671e-06 as=6.1941e-13 ps=2.8147e-06 nf=1 m=34 par=34
XMpar2 a_1664_9867.t0 inn.t0 a_5988_7813.t0 vdd.t4 pfet_03v3 w=1.95u l=3.75u ad=6.5612e-13 pd=2.9671e-06 as=6.1941e-13 ps=2.8147e-06 nf=1 m=34 par=34
XMpar3 a_2534_9867.t34 a_3824_7605.t0 a_3824_7605.t1 vdd.t0 pfet_03v3 w=1.79u l=1.95u ad=7.8760e-13 pd=3.5650e-06 as=5.0120e-13 ps=2.3500e-06 nf=1 m=8 par=8
XMpar4 a_1664_9867.t68 a_2546_1204.t0 vdd.t3 vdd.t2 pfet_03v3 w=2.98u l=3.25u ad=8.3440e-13 pd=3.5400e-06 as=1.0728e-12 ps=4.4450e-06 nf=1 m=8 par=8
XMpar5 a_5932_1204.t2 a_3824_7605.t20 vss.t1 vss.t0 nfet_03v3 w=1.5u l=4.25u ad=9.0000e-13 pd=4.2000e-06 as=4.2000e-13 ps=2.0600e-06 nf=1 m=2 par=2
XMpar6 ib.t1 ib.t0 vss.t14 vss.t13 nfet_03v3 w=0.75u l=3.25u ad=4.5000e-13 pd=2.7000e-06 as=2.1000e-13 ps=1.3100e-06 nf=1 m=2 par=2
XMpar7 a_5988_7813.t34 a_3824_7605.t0 out.t0 vdd.t0 pfet_03v3 w=1.79u l=1.95u ad=6.4440e-13 pd=2.9575e-06 as=5.0120e-13 ps=2.3500e-06 nf=1 m=8 par=8
XMpar8 a_7494_2995.t2 a_3824_7605.t12 out.t3 vss.t2 nfet_03v3 w=1.67u l=1.95u ad=1.0020e-12 pd=4.5400e-06 as=4.6760e-13 ps=2.2300e-06 nf=1 m=2 par=2
XMpar9 a_3824_7605.t13 a_3824_7605.t12 a_5932_1204.t0 vss.t2 nfet_03v3 w=1.67u l=1.95u ad=1.0020e-12 pd=4.5400e-06 as=1.0020e-12 ps=4.5400e-06 nf=1 m=2 par=2
XMpar10 a_2546_1204.t1 a_2546_1204.t0 vdd.t3 vdd.t2 pfet_03v3 w=2.98u l=3.25u ad=8.3440e-13 pd=3.5400e-06 as=8.3440e-13 ps=3.5400e-06 nf=1 m=2 par=2
XMpar11 a_2546_1204.t4 ib.t0 vss.t14 vss.t13 nfet_03v3 w=0.75u l=3.25u ad=2.1000e-13 pd=1.3100e-06 as=2.1000e-13 ps=1.3100e-06 nf=1 m=2 par=2
X35 out.t10 vss.t4 cap_mim_2f0fF c_width=16.58u c_length=16.59u
Rpar0 a_1664_9867.t0 a_1664_9867.t68 41.2024
Rpar1 a_2534_9867.t0 a_2534_9867.t34 49.3287
Rpar2 a_2546_1204.t0 a_2546_1204.t1 25.4411
Rpar3 a_2546_1204.t0 a_2546_1204.t4 87.9120
Rpar4 a_2546_1204.t1 a_2546_1204.t4 81.0315
Rpar5 a_3824_7605.t0 a_3824_7605.t1 16.0822
Rpar6 a_3824_7605.t0 a_3824_7605.t12 1989.9443
Rpar7 a_3824_7605.t0 a_3824_7605.t13 870.4904
Rpar8 a_3824_7605.t0 a_3824_7605.t20 352.8678
Rpar9 a_3824_7605.t1 a_3824_7605.t12 704.2577
Rpar10 a_3824_7605.t1 a_3824_7605.t13 308.0737
Rpar11 a_3824_7605.t1 a_3824_7605.t20 124.8828
Rpar12 a_3824_7605.t12 a_3824_7605.t13 20.9465
Rpar13 a_3824_7605.t12 a_3824_7605.t20 233.3745
Rpar14 a_3824_7605.t13 a_3824_7605.t20 102.0884
Rpar15 a_5932_1204.t0 a_5932_1204.t2 59.6828
Rpar16 a_5988_7813.t0 a_5988_7813.t34 60.6414
Rpar17 a_7494_2995.t0 a_7494_2995.t2 55.9547
Rpar18 ib ib.t0 11.7598
Rpar19 ib ib.t1 7.3882
Rpar20 inn inn.t0 1.4766
Rpar21 inp inp.t0 1.4766
Rpar22 out out.t0 153.5469
Rpar23 out out.t10 15.1417
Rpar24 out out.t3 68.6885
Rpar25 out.t0 out.t3 123.9564
Rpar26 vdd vdd.t0 161.5691
Rpar27 vdd vdd.t4 21.1709
Rpar28 vdd vdd.t2 1209.6522
Rpar29 vdd.t0 vdd.t4 59.5358
Rpar30 vdd.t0 vdd.t2 61.5108
Rpar31 vdd.t0 vdd.t3 197.9164
Rpar32 vdd.t4 vdd.t2 445.7384
Rpar33 vdd.t4 vdd.t3 1434.2024
Rpar34 vdd.t2 vdd.t3 5.2028
Rpar35 vss vss.t0 113.4286
Rpar36 vss vss.t1 573.8109
Rpar37 vss vss.t2 236.9166
Rpar38 vss vss.t13 108.2631
Rpar39 vss vss.t14 346.9147
Rpar40 vss vss.t4 184.7615
Rpar41 vss.t0 vss.t1 10.3723
Rpar42 vss.t0 vss.t2 5.4063
Rpar43 vss.t0 vss.t13 183.2141
Rpar44 vss.t0 vss.t14 587.3071
Rpar45 vss.t0 vss.t4 169.2166
Rpar46 vss.t1 vss.t2 34.1217
Rpar47 vss.t1 vss.t13 919.6542
Rpar48 vss.t1 vss.t4 856.1931
Rpar49 vss.t2 vss.t13 393.8476
Rpar50 vss.t2 vss.t14 1262.3470
Rpar51 vss.t2 vss.t4 353.1953
Rpar52 vss.t13 vss.t14 11.2233
Rpar53 vss.t13 vss.t4 324.3831
Rpar54 vss.t14 vss.t4 1039.4506
Cpar0 a_1664_9867.t0 vss 7.48529e-14
Cpar1 a_1664_9867.t68 vss 1.18007e-14
Cpar2 a_2534_9867.t0 vss 4.71137e-14
Cpar3 a_2534_9867.t34 vss 1.02310e-14
Cpar4 a_2546_1204.t0 vss 2.61267e-14
Cpar5 a_2546_1204.t1 vss 3.98853e-15
Cpar6 a_2546_1204.t4 vss 2.39847e-15
Cpar7 a_3824_7605.t0 vss 1.63074e-14
Cpar8 a_3824_7605.t1 vss 6.01345e-15
Cpar9 a_3824_7605.t12 vss 4.51923e-15
Cpar10 a_3824_7605.t13 vss 2.74685e-15
Cpar11 a_3824_7605.t20 vss 9.78351e-15
Cpar12 a_5932_1204.t0 vss 2.62621e-15
Cpar13 a_5932_1204.t2 vss 3.26151e-15
Cpar14 a_5988_7813.t0 vss 4.83219e-14
Cpar15 a_5988_7813.t34 vss 1.11300e-14
Cpar16 a_7494_2995.t0 vss 3.77920e-15
Cpar17 a_7494_2995.t2 vss 3.87820e-15
Cpar18 ib out 1.02600e-17
Cpar19 ib vss 1.10659e-14
Cpar20 ib.t0 vss 1.25583e-15
Cpar21 ib.t1 vss 7.92900e-17
Cpar22 inn inp 2.16750e-16
Cpar23 inn out 3.36300e-17
Cpar24 inn vdd 4.65095e-14
Cpar25 inn vss 5.52577e-15
Cpar26 inn.t0 vss 6.80090e-14
Cpar27 inp vdd 4.66819e-14
Cpar28 inp vss 5.55908e-15
Cpar29 inp.t0 vss 6.80793e-14
Cpar30 out vdd 7.23355e-15
Cpar31 out vss 1.46370e-14
Cpar32 out.t0 vss 1.30693e-15
Cpar33 out.t10 vss 1.70419e-14
Cpar34 out.t3 vss 7.62669e-16
Cpar35 vdd vss 3.79966e-13
Cpar36 vdd.t0 vss 2.88595e-14
Cpar37 vdd.t2 vss 2.07500e-14
Cpar38 vdd.t3 vss 8.19077e-15
Cpar39 vdd.t4 vss 1.17213e-13
.ends opamp_dut

Vdd vdd 0 3.300000
Vss vss 0 0
Ibias vdd ib 4.600000e-07
Vinp inp 0 DC 1.480000 AC 1 PWL(0 1.480000 3.043374e-08 1.480000 3.347711e-08 1.490000)
Rfb out inn 1m
Cload out 0 2.000000e-13
Xdut vdd vss inp inn out ib opamp_dut
.end
