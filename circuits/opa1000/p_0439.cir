* opa1000[0439]: 200f/nmos_miller_3v3_i50n_subth (nmos_miller, VDD=3.3V, CL=0.2pF, Iref=0.0093uA)
.include "pdk_opa.inc"
.temp 27
.option gmin=1e-12 rshunt=1e12 reltol=1e-3 abstol=1e-12 vntol=1e-5 method=gear
* Post-PEX R+C extracted netlist for nmos_miller_3v3_i50n_subth
.subckt opamp_dut vdd vss inp inn out ib
XMpar0 ib.t1 ib.t0 vss.t1 vss.t0 nfet_03v3 w=0.4u l=4u ad=2.4000e-13 pd=2.0000e-06 as=1.1200e-13 ps=9.6000e-07 nf=1 m=2 par=2
XMpar1 out.t1 ib.t0 vss.t1 vss.t0 nfet_03v3 w=0.4u l=4u ad=1.8880e-13 pd=1.5840e-06 as=1.6320e-13 ps=1.3760e-06 nf=1 m=10 par=10
XMpar2 a_6794_4377.t0 ib.t0 vss.t1 vss.t0 nfet_03v3 w=0.4u l=4u ad=2.4000e-13 pd=2.0000e-06 as=1.1200e-13 ps=9.6000e-07 nf=1 m=4 par=4
XMpar3 a_7750_1041.t3 a_7750_1041.t2 vdd.t1 vdd.t0 pfet_03v3 w=0.67u l=5u ad=4.0200e-13 pd=2.5400e-06 as=1.8760e-13 ps=1.2300e-06 nf=1 m=2 par=2
XMpar4 a_1114_1290.t0 inp.t0 a_6794_4377.t4 vss.t28 nfet_03v3 w=0.71u l=3.3u ad=1.9880e-13 pd=1.2700e-06 as=4.2600e-13 ps=2.6200e-06 nf=1 m=2 par=2
XMpar5 a_1114_1290.t3 a_7750_1041.t2 vdd.t1 vdd.t0 pfet_03v3 w=0.67u l=5u ad=4.0200e-13 pd=2.5400e-06 as=1.8760e-13 ps=1.2300e-06 nf=1 m=2 par=2
XMpar6 out.t11 a_1114_1290.t5 vdd.t1 vdd.t0 pfet_03v3 w=0.67u l=5u ad=2.3048e-13 pd=1.4920e-06 as=2.3048e-13 ps=1.4920e-06 nf=1 m=10 par=10
XMpar7 a_6794_4377.t4 inn.t0 a_7750_1041.t0 vss.t28 nfet_03v3 w=0.71u l=3.3u ad=4.2600e-13 pd=2.6200e-06 as=1.9880e-13 ps=1.2700e-06 nf=1 m=2 par=2
X0 a_1114_3890.t0 a_5092_4410.t0 vss.t24 ppolyf_u_1k r_width=1u r_length=19.23u
X5 a_1114_7010.t0 a_5092_6490.t0 vss.t24 ppolyf_u_1k r_width=1u r_length=19.23u
X7 a_5092_7530.t1 out.t0 cap_mim_2f0fF c_width=13.23u c_length=13.23u
X10 a_1114_1290.t2 a_5092_1290.t0 vss.t24 ppolyf_u_1k r_width=1u r_length=19.23u
X11 a_1114_3890.t0 a_5092_3370.t0 vss.t24 ppolyf_u_1k r_width=1u r_length=19.23u
X17 a_1114_5970.t0 a_5092_6490.t0 vss.t24 ppolyf_u_1k r_width=1u r_length=19.23u
X19 a_1114_2850.t0 a_5092_3370.t0 vss.t24 ppolyf_u_1k r_width=1u r_length=19.23u
X26 a_1114_5970.t0 a_5092_5450.t0 vss.t24 ppolyf_u_1k r_width=1u r_length=19.23u
X27 a_1114_2850.t0 a_5092_2330.t0 vss.t24 ppolyf_u_1k r_width=1u r_length=19.23u
X35 a_1114_4930.t0 a_5092_5450.t0 vss.t24 ppolyf_u_1k r_width=1u r_length=19.23u
X36 a_1114_1810.t0 a_5092_2330.t0 vss.t24 ppolyf_u_1k r_width=1u r_length=19.23u
X40 a_1114_4930.t0 a_5092_4410.t0 vss.t24 ppolyf_u_1k r_width=1u r_length=19.23u
X42 a_1114_1810.t0 a_5092_1290.t0 vss.t24 ppolyf_u_1k r_width=1u r_length=19.23u
X46 a_1114_7010.t0 a_5092_7530.t0 vss.t24 ppolyf_u_1k r_width=1u r_length=19.23u
Rpar0 a_1114_1290.t0 a_1114_1290.t5 295.3926
Rpar1 a_1114_1290.t0 a_1114_1290.t2 129.3012
Rpar2 a_1114_1290.t0 a_1114_1290.t3 101.3667
Rpar3 a_1114_1290.t5 a_1114_1290.t2 287.1888
Rpar4 a_1114_1290.t5 a_1114_1290.t3 235.6307
Rpar5 a_1114_1290.t2 a_1114_1290.t3 103.1418
Rpar6 a_5092_7530.t0 a_5092_7530.t1 62.1014
Rpar7 a_6794_4377.t0 a_6794_4377.t4 52.1729
Rpar8 a_7750_1041.t0 a_7750_1041.t2 103.1373
Rpar9 a_7750_1041.t0 a_7750_1041.t3 88.4770
Rpar10 a_7750_1041.t2 a_7750_1041.t3 15.3870
Rpar11 ib ib.t0 15.0825
Rpar12 ib ib.t1 14.9091
Rpar13 ib.t0 ib.t1 34.1143
Rpar14 inn inn.t0 3.4737
Rpar15 inp inp.t0 3.5223
Rpar16 out out.t0 20.3375
Rpar17 out out.t1 71.0530
Rpar18 out out.t11 46.8198
Rpar19 out.t0 out.t1 978.5355
Rpar20 out.t0 out.t11 644.7987
Rpar21 out.t1 out.t11 133.3648
Rpar22 vdd vdd.t0 49.3610
Rpar23 vdd vdd.t1 298.5067
Rpar24 vdd.t0 vdd.t1 7.6502
Rpar25 vss vss.t0 180.0828
Rpar26 vss vss.t1 220.1694
Rpar27 vss vss.t24 39.3791
Rpar28 vss vss.t28 335.5295
Rpar29 vss.t0 vss.t1 16.9769
Rpar30 vss.t0 vss.t24 7.9900
Rpar31 vss.t0 vss.t28 4.1832
Rpar32 vss.t1 vss.t24 62.2060
Rpar33 vss.t1 vss.t28 46.8460
Rpar34 vss.t24 vss.t28 9.7342
Cpar0 a_1114_1290.t0 vss 3.79402e-15
Cpar1 a_1114_1290.t2 vss 4.66481e-15
Cpar2 a_1114_1290.t3 vss 6.97498e-15
Cpar3 a_1114_1290.t5 vss 2.80323e-14
Cpar4 a_1114_1810.t0 vss 4.02400e-17
Cpar5 a_1114_2850.t0 vss 3.63400e-17
Cpar6 a_1114_3890.t0 vss 3.63400e-17
Cpar7 a_1114_4930.t0 vss 3.63400e-17
Cpar8 a_1114_5970.t0 vss 3.70800e-17
Cpar9 a_1114_7010.t0 vss 3.55600e-17
Cpar10 a_5092_1290.t0 vss 3.59400e-17
Cpar11 a_5092_2330.t0 vss 3.11400e-17
Cpar12 a_5092_3370.t0 vss 3.08000e-17
Cpar13 a_5092_4410.t0 vss 3.38000e-17
Cpar14 a_5092_5450.t0 vss 3.15800e-17
Cpar15 a_5092_6490.t0 vss 4.12000e-17
Cpar16 a_5092_7530.t0 vss 2.72520e-16
Cpar17 a_5092_7530.t1 vss 4.98882e-15
Cpar18 a_6794_4377.t0 vss 1.48529e-14
Cpar19 a_6794_4377.t4 vss 6.05913e-15
Cpar20 a_7750_1041.t0 vss 2.18100e-15
Cpar21 a_7750_1041.t2 vss 1.39037e-14
Cpar22 a_7750_1041.t3 vss 4.13876e-15
Cpar23 ib inn 1.05600e-17
Cpar24 ib out 2.18477e-15
Cpar25 ib vdd 1.80510e-16
Cpar26 ib vss 4.82534e-14
Cpar27 ib.t0 vss 8.07508e-15
Cpar28 ib.t1 vss 6.46916e-16
Cpar29 inn inp 5.16300e-17
Cpar30 inn vdd 2.45800e-17
Cpar31 inn vss 3.80483e-15
Cpar32 inn.t0 vss 3.92955e-16
Cpar33 inp vdd 8.35100e-17
Cpar34 inp vss 3.86767e-15
Cpar35 inp.t0 vss 4.25858e-16
Cpar36 out vdd 1.54985e-14
Cpar37 out vss 2.04309e-14
Cpar38 out.t0 vss 8.80441e-15
Cpar39 out.t1 vss 1.01999e-14
Cpar40 out.t11 vss 7.24416e-15
Cpar41 vdd vss 1.05059e-13
Cpar42 vdd.t0 vss 4.74135e-14
Cpar43 vdd.t1 vss 9.08505e-15
.ends opamp_dut

Vdd vdd 0 3.300000
Vss vss 0 0
Ibias vdd ib 9.300000e-09
Vinp inp 0 DC 1.645000 AC 1 PWL(0 1.645000 1.007428e-06 1.645000 1.108170e-06 1.655000)
Rfb out inn 1m
Cload out 0 2.000000e-13
Xdut vdd vss inp inn out ib opamp_dut
.end
