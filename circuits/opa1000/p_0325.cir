* opa1000[0325]: 2p/folded_cascode_pmos_3v3_i10u_subth (folded_cascode_pmos, VDD=3.3V, CL=2.0pF, Iref=2.8889uA)
.include "pdk_opa.inc"
.temp 27
.option gmin=1e-12 rshunt=1e12 reltol=1e-3 abstol=1e-12 vntol=1e-5 method=gear
* Post-PEX R+C extracted netlist for folded_cascode_pmos_3v3_i10u_subth
.subckt opamp_dut vdd vss inp inn out ib
XMpar0 a_1988_3730.t0 inp.t0 a_3436_9248.t4 vdd.t18 pfet_03v3 w=8u l=1.13u ad=2.5600e-12 pd=9.6400e-06 as=2.2400e-12 ps=8.5600e-06 nf=1 m=64 par=64
XMpar1 a_1988_3730.t0 inn.t0 a_8814_7400.t4 vdd.t18 pfet_03v3 w=8u l=1.13u ad=2.5600e-12 pd=9.6400e-06 as=2.2400e-12 ps=8.5600e-06 nf=1 m=64 par=64
XMpar2 a_8814_7400.t68 a_1448_3522.t10 out.t0 vss.t0 nfet_03v3 w=1.91u l=0.94u ad=6.3667e-13 pd=2.8950e-06 as=5.3480e-13 ps=2.4700e-06 nf=1 m=12 par=12
XMpar3 a_8814_7400.t0 ib.t0 vss.t3 vss.t2 nfet_03v3 w=4.28u l=1.2u ad=1.1984e-12 pd=4.8400e-06 as=1.8832e-12 ps=7.3000e-06 nf=1 m=4 par=4
XMpar4 a_3436_9248.t68 a_1448_3522.t10 a_5206_7400.t0 vss.t0 nfet_03v3 w=1.91u l=0.94u ad=6.3667e-13 pd=2.8950e-06 as=5.3480e-13 ps=2.4700e-06 nf=1 m=12 par=12
XMpar5 a_3436_9248.t0 ib.t0 vss.t3 vss.t2 nfet_03v3 w=4.28u l=1.2u ad=1.1984e-12 pd=4.8400e-06 as=1.8832e-12 ps=7.3000e-06 nf=1 m=4 par=4
XMpar6 a_1448_3522.t3 a_1448_3522.t2 vdd.t1 vdd.t0 pfet_03v3 w=10u l=2.7u ad=2.8000e-12 pd=1.0560e-05 as=2.8000e-12 ps=1.0560e-05 nf=1 m=2 par=2
XMpar7 ib.t1 ib.t0 vss.t3 vss.t2 nfet_03v3 w=4.28u l=1.2u ad=2.5680e-12 pd=9.7600e-06 as=1.1984e-12 ps=4.8400e-06 nf=1 m=2 par=2
XMpar8 out.t3 a_5206_7400.t11 vdd.t1 vdd.t0 pfet_03v3 w=10u l=2.7u ad=2.8000e-12 pd=1.0560e-05 as=2.8000e-12 ps=1.0560e-05 nf=1 m=2 par=2
XMpar9 a_1448_3522.t0 ib.t0 vss.t3 vss.t2 nfet_03v3 w=4.28u l=1.2u ad=1.1984e-12 pd=4.8400e-06 as=1.1984e-12 ps=4.8400e-06 nf=1 m=2 par=2
XMpar10 a_5206_7400.t12 a_5206_7400.t11 vdd.t1 vdd.t0 pfet_03v3 w=10u l=2.7u ad=6.0000e-12 pd=2.1200e-05 as=2.8000e-12 ps=1.0560e-05 nf=1 m=2 par=2
XMpar11 a_1988_3730.t128 a_1448_3522.t2 vdd.t1 vdd.t0 pfet_03v3 w=10u l=2.7u ad=2.8000e-12 pd=1.0560e-05 as=4.4000e-12 ps=1.5880e-05 nf=1 m=4 par=4
X93 out.t14 vss.t26 cap_mim_2f0fF c_width=9.69u c_length=9.68u
Rpar0 a_1448_3522.t0 a_1448_3522.t10 105.7250
Rpar1 a_1448_3522.t0 a_1448_3522.t2 269.8281
Rpar2 a_1448_3522.t0 a_1448_3522.t3 95.4362
Rpar3 a_1448_3522.t10 a_1448_3522.t2 653.9425
Rpar4 a_1448_3522.t10 a_1448_3522.t3 231.2947
Rpar5 a_1448_3522.t2 a_1448_3522.t3 25.2831
Rpar6 a_1988_3730.t0 a_1988_3730.t128 52.7443
Rpar7 a_3436_9248.t0 a_3436_9248.t4 207.1739
Rpar8 a_3436_9248.t0 a_3436_9248.t68 61.2317
Rpar9 a_3436_9248.t4 a_3436_9248.t68 63.4774
Rpar10 a_5206_7400.t0 a_5206_7400.t11 373.5792
Rpar11 a_5206_7400.t0 a_5206_7400.t12 80.4716
Rpar12 a_5206_7400.t11 a_5206_7400.t12 20.7702
Rpar13 a_8814_7400.t0 a_8814_7400.t4 207.1739
Rpar14 a_8814_7400.t0 a_8814_7400.t68 61.2317
Rpar15 a_8814_7400.t4 a_8814_7400.t68 63.4774
Rpar16 ib ib.t0 13.3380
Rpar17 ib ib.t1 3.5701
Rpar18 ib.t0 ib.t1 339.8538
Rpar19 inn inn.t0 2.1909
Rpar20 inp inp.t0 2.1909
Rpar21 out out.t0 62.7251
Rpar22 out out.t14 15.0554
Rpar23 out out.t3 74.2948
Rpar24 out.t0 out.t14 858.2999
Rpar25 out.t0 out.t3 117.2286
Rpar26 out.t14 out.t3 1016.6139
Rpar27 vdd vdd.t0 670.8217
Rpar28 vdd vdd.t1 2576.9985
Rpar29 vdd vdd.t18 32.5467
Rpar30 vdd.t0 vdd.t1 3.6569
Rpar31 vdd.t0 vdd.t18 132.7449
Rpar32 vdd.t1 vdd.t18 509.9468
Rpar33 vss vss.t0 119.9328
Rpar34 vss vss.t2 100.3309
Rpar35 vss vss.t3 62.8046
Rpar36 vss vss.t26 390.9640
Rpar37 vss.t0 vss.t2 7.6465
Rpar38 vss.t0 vss.t3 8.1482
Rpar39 vss.t0 vss.t26 101.1120
Rpar40 vss.t2 vss.t3 5.5885
Rpar41 vss.t2 vss.t26 617.6286
Rpar42 vss.t3 vss.t26 191.3441
Cpar0 a_1448_3522.t0 vss 2.61472e-15
Cpar1 a_1448_3522.t10 vss 9.34716e-15
Cpar2 a_1448_3522.t2 vss 1.59659e-14
Cpar3 a_1448_3522.t3 vss 3.67428e-15
Cpar4 a_1988_3730.t0 vss 1.70781e-13
Cpar5 a_1988_3730.t128 vss 9.13820e-15
Cpar6 a_3436_9248.t0 vss 6.38317e-15
Cpar7 a_3436_9248.t4 vss 9.00076e-14
Cpar8 a_3436_9248.t68 vss 9.43517e-15
Cpar9 a_5206_7400.t0 vss 4.65489e-15
Cpar10 a_5206_7400.t11 vss 1.40436e-14
Cpar11 a_5206_7400.t12 vss 6.77340e-15
Cpar12 a_8814_7400.t0 vss 6.46466e-15
Cpar13 a_8814_7400.t4 vss 9.11565e-14
Cpar14 a_8814_7400.t68 vss 9.55560e-15
Cpar15 ib vdd 3.08500e-17
Cpar16 ib vss 1.93549e-14
Cpar17 ib.t0 vss 2.43698e-15
Cpar18 ib.t1 vss 3.56784e-16
Cpar19 inn inp 2.05580e-16
Cpar20 inn out 2.54600e-17
Cpar21 inn vdd 3.75968e-14
Cpar22 inn vss 1.04331e-14
Cpar23 inn.t0 vss 8.07654e-14
Cpar24 inp vdd 3.73213e-14
Cpar25 inp vss 1.04427e-14
Cpar26 inp.t0 vss 8.06005e-14
Cpar27 out vdd 3.67721e-15
Cpar28 out vss 9.68951e-15
Cpar29 out.t0 vss 1.93127e-15
Cpar30 out.t14 vss 9.58010e-15
Cpar31 out.t3 vss 1.47627e-15
Cpar32 vdd vss 4.92813e-13
Cpar33 vdd.t0 vss 2.33667e-14
Cpar34 vdd.t1 vss 9.08903e-15
Cpar35 vdd.t18 vss 1.13436e-13
.ends opamp_dut

Vdd vdd 0 3.300000
Vss vss 0 0
Ibias vdd ib 2.888900e-06
Vinp inp 0 DC 1.381000 AC 1 PWL(0 1.381000 1.990438e-08 1.381000 2.189482e-08 1.391000)
Rfb out inn 1m
Cload out 0 2.000000e-12
Xdut vdd vss inp inn out ib opamp_dut
.end
