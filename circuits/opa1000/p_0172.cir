* opa1000[0172]: 200f/folded_cascode_nmos_1v8_0p1u_1u_subth (folded_cascode_nmos, VDD=1.8V, CL=0.2pF, Iref=0.1111uA)
.include "pdk_opa.inc"
.temp 27
.option gmin=1e-12 rshunt=1e12 reltol=1e-3 abstol=1e-12 vntol=1e-5 method=gear
* Post-PEX R+C extracted netlist for folded_cascode_nmos_1v8_0p1u_1u_subth
.subckt opamp_dut vdd vss inp inn out ib
XMpar0 a_3992_13351.t1 a_3992_13351.t0 vss.t1 vss.t0 nfet_03v3 w=1.13u l=6.25u ad=6.7800e-13 pd=3.4600e-06 as=3.1640e-13 ps=1.6900e-06 nf=1 m=2 par=2
XMpar1 ib.t1 ib.t0 vss.t1 vss.t0 nfet_03v3 w=1.13u l=6.25u ad=6.7800e-13 pd=3.4600e-06 as=3.1640e-13 ps=1.6900e-06 nf=1 m=2 par=2
XMpar2 a_3826_11585.t5 ib.t4 a_3992_13351.t4 vdd.t11 pfet_03v3 w=1.73u l=1.6u ad=6.6893e-13 pd=3.0800e-06 as=4.8440e-13 ps=2.2900e-06 nf=1 m=6 par=6
XMpar3 a_6734_11585.t8 ib.t4 out.t0 vdd.t11 pfet_03v3 w=1.73u l=1.6u ad=6.6893e-13 pd=3.0800e-06 as=4.8440e-13 ps=2.2900e-06 nf=1 m=6 par=6
XMpar4 a_3826_11585.t0 inp.t0 a_4000_15158.t0 vss.t2 nfet_03v3 w=2.02u l=3.2u ad=5.6560e-13 pd=2.5800e-06 as=1.2120e-12 ps=5.2400e-06 nf=1 m=4 par=4
XMpar5 a_3826_11585.t4 a_1176_9169.t2 vdd.t1 vdd.t0 pfet_03v3 w=4.16u l=9.75u ad=1.8304e-12 pd=7.1200e-06 as=2.4960e-12 ps=9.5200e-06 nf=1 m=4 par=4
XMpar6 a_4000_15158.t0 inn.t0 a_6734_11585.t3 vss.t2 nfet_03v3 w=2.02u l=3.2u ad=1.2120e-12 pd=5.2400e-06 as=5.6560e-13 ps=2.5800e-06 nf=1 m=4 par=4
XMpar7 a_6734_11585.t0 a_1176_9169.t2 vdd.t1 vdd.t0 pfet_03v3 w=4.16u l=9.75u ad=1.8304e-12 pd=7.1200e-06 as=2.4960e-12 ps=9.5200e-06 nf=1 m=4 par=4
XMpar8 a_1176_9169.t0 ib.t0 vss.t1 vss.t0 nfet_03v3 w=1.13u l=6.25u ad=3.1640e-13 pd=1.6900e-06 as=3.1640e-13 ps=1.6900e-06 nf=1 m=2 par=2
XMpar9 out.t1 a_3992_13351.t0 vss.t1 vss.t0 nfet_03v3 w=1.13u l=6.25u ad=3.1640e-13 pd=1.6900e-06 as=3.1640e-13 ps=1.6900e-06 nf=1 m=2 par=2
XMpar10 a_1176_9169.t3 a_1176_9169.t2 vdd.t1 vdd.t0 pfet_03v3 w=4.16u l=9.75u ad=1.1648e-12 pd=4.7200e-06 as=2.4960e-12 ps=9.5200e-06 nf=1 m=2 par=2
XMpar11 a_4000_15158.t8 ib.t0 vss.t1 vss.t0 nfet_03v3 w=1.13u l=6.25u ad=3.1640e-13 pd=1.6900e-06 as=3.1640e-13 ps=1.6900e-06 nf=1 m=4 par=4
Rpar0 a_1176_9169.t0 a_1176_9169.t2 131.5309
Rpar1 a_1176_9169.t0 a_1176_9169.t3 157.7825
Rpar2 a_1176_9169.t2 a_1176_9169.t3 20.7699
Rpar3 a_3826_11585.t0 a_3826_11585.t5 180.3669
Rpar4 a_3826_11585.t0 a_3826_11585.t4 69.7009
Rpar5 a_3826_11585.t5 a_3826_11585.t4 68.0796
Rpar6 a_3992_13351.t0 a_3992_13351.t1 21.7325
Rpar7 a_3992_13351.t0 a_3992_13351.t4 96.4659
Rpar8 a_3992_13351.t1 a_3992_13351.t4 61.2411
Rpar9 a_4000_15158.t0 a_4000_15158.t8 83.4618
Rpar10 a_6734_11585.t0 a_6734_11585.t8 68.0796
Rpar11 a_6734_11585.t0 a_6734_11585.t3 69.7009
Rpar12 a_6734_11585.t8 a_6734_11585.t3 180.3669
Rpar13 ib ib.t0 31.7142
Rpar14 ib ib.t1 9.4797
Rpar15 ib ib.t4 129.1722
Rpar16 ib.t0 ib.t1 41.3201
Rpar17 ib.t0 ib.t4 145.3103
Rpar18 ib.t1 ib.t4 168.2971
Rpar19 inn inn.t0 3.5880
Rpar20 inp inp.t0 3.5880
Rpar21 out out.t0 3.7189
Rpar22 out out.t1 44.0092
Rpar23 vdd vdd.t0 184.3397
Rpar24 vdd vdd.t1 450.9838
Rpar25 vdd vdd.t11 57.5508
Rpar26 vdd.t0 vdd.t1 4.6919
Rpar27 vdd.t0 vdd.t11 88.0092
Rpar28 vdd.t1 vdd.t11 215.3130
Rpar29 vss vss.t0 231.1589
Rpar30 vss vss.t1 385.8496
Rpar31 vss vss.t2 53.2766
Rpar32 vss.t0 vss.t1 6.3145
Rpar33 vss.t0 vss.t2 120.0704
Rpar34 vss.t1 vss.t2 200.8335
Cpar0 a_1176_9169.t0 vss 5.22303e-15
Cpar1 a_1176_9169.t2 vss 6.90249e-14
Cpar2 a_1176_9169.t3 vss 4.43241e-15
Cpar3 a_3826_11585.t0 vss 8.04110e-15
Cpar4 a_3826_11585.t4 vss 1.71057e-14
Cpar5 a_3826_11585.t5 vss 6.64280e-15
Cpar6 a_3992_13351.t0 vss 5.70454e-15
Cpar7 a_3992_13351.t1 vss 1.25894e-15
Cpar8 a_3992_13351.t4 vss 1.19680e-15
Cpar9 a_4000_15158.t0 vss 1.55102e-14
Cpar10 a_4000_15158.t8 vss 8.83367e-15
Cpar11 a_6734_11585.t0 vss 1.40327e-14
Cpar12 a_6734_11585.t3 vss 6.59651e-15
Cpar13 a_6734_11585.t8 vss 5.44943e-15
Cpar14 ib out 6.96560e-16
Cpar15 ib vdd 1.12607e-14
Cpar16 ib vss 3.72943e-14
Cpar17 ib.t0 vss 1.31600e-14
Cpar18 ib.t1 vss 9.78265e-16
Cpar19 ib.t4 vss 7.35798e-15
Cpar20 inn inp 1.03940e-16
Cpar21 inn vss 7.67049e-15
Cpar22 inn.t0 vss 2.10080e-15
Cpar23 inp vss 7.54265e-15
Cpar24 inp.t0 vss 2.09864e-15
Cpar25 out vdd 2.23122e-15
Cpar26 out vss 8.18542e-15
Cpar27 out.t0 vss 1.19827e-15
Cpar28 out.t1 vss 3.40673e-15
Cpar29 vdd vss 2.47602e-13
Cpar30 vdd.t0 vss 5.58568e-14
Cpar31 vdd.t1 vss 2.37031e-14
Cpar32 vdd.t11 vss 1.31955e-14
.ends opamp_dut

Vdd vdd 0 1.800000
Vss vss 0 0
Ibias vdd ib 1.111000e-07
Vinp inp 0 DC 0.985000 AC 1 PWL(0 0.985000 5.904605e-08 0.985000 6.495065e-08 0.995000)
Rfb out inn 1m
Cload out 0 2.000000e-13
Xdut vdd vss inp inn out ib opamp_dut
.end
