* opa1000[0888]: 2p/telescopic_nmos_1v8_i10u_weak (telescopic_nmos, VDD=1.8V, CL=2.0pF, Iref=2.875uA)
.include "pdk_opa.inc"
.temp 27
.option gmin=1e-12 rshunt=1e12 reltol=1e-3 abstol=1e-12 vntol=1e-5 method=gear
* Post-PEX R+C extracted netlist for telescopic_nmos_1v8_i10u_weak
.subckt opamp_dut vdd vss inp inn out ib
XMpar0 a_1952_13493.t1 a_2072_13285.t6 a_2072_13285.t7 vdd.t0 pfet_03v3 w=1.91u l=1.13u ad=7.6988e-13 pd=3.4508e-06 as=5.8182e-13 ps=2.6662e-06 nf=1 m=26 par=26
XMpar1 a_2904_13493.t0 a_2072_13285.t6 out.t0 vdd.t0 pfet_03v3 w=1.91u l=1.13u ad=7.6988e-13 pd=3.4508e-06 as=5.8182e-13 ps=2.6662e-06 nf=1 m=26 par=26
XMpar2 a_2904_13493.t3 a_2072_13285.t58 vdd.t4 vdd.t3 pfet_03v3 w=2.01u l=1.8u ad=6.3427e-13 pd=2.8644e-06 as=6.3427e-13 ps=2.8644e-06 nf=1 m=18 par=18
XMpar3 a_2159_1204.t0 inp.t0 a_4556_5452.t0 vss.t0 nfet_03v3 w=1.86u l=1.63u ad=7.1920e-13 pd=3.2533e-06 as=5.2080e-13 ps=2.4200e-06 nf=1 m=12 par=12
XMpar4 a_1952_13493.t0 a_2072_13285.t58 vdd.t4 vdd.t3 pfet_03v3 w=2.01u l=1.8u ad=6.3427e-13 pd=2.8644e-06 as=6.3427e-13 ps=2.8644e-06 nf=1 m=18 par=18
XMpar5 a_2159_1204.t0 inn.t0 a_7054_8234.t0 vss.t0 nfet_03v3 w=1.86u l=1.63u ad=7.1920e-13 pd=3.2533e-06 as=5.2080e-13 ps=2.4200e-06 nf=1 m=12 par=12
XMpar6 a_2072_13285.t0 vdd.t80 a_4556_5452.t12 vss.t0 nfet_03v3 w=1.77u l=1.13u ad=4.9560e-13 pd=2.3300e-06 as=6.8440e-13 ps=3.1333e-06 nf=1 m=6 par=6
XMpar7 a_7054_8234.t12 vdd.t80 out.t11 vss.t0 nfet_03v3 w=1.77u l=1.13u ad=6.8440e-13 pd=3.1333e-06 as=4.9560e-13 ps=2.3300e-06 nf=1 m=6 par=6
XMpar8 ib.t1 ib.t0 vss.t13 vss.t12 nfet_03v3 w=3.01u l=2.25u ad=1.8060e-12 pd=7.2200e-06 as=8.4280e-13 ps=3.5700e-06 nf=1 m=2 par=2
XMpar9 a_2159_1204.t24 ib.t0 vss.t13 vss.t12 nfet_03v3 w=3.01u l=2.25u ad=8.4280e-13 pd=3.5700e-06 as=1.5652e-12 ps=6.3075e-06 nf=1 m=8 par=8
X130 out.t32 vss.t39 cap_mim_2f0fF c_width=12.99u c_length=12.99u
Rpar0 a_1952_13493.t0 a_1952_13493.t1 56.7026
Rpar1 a_2072_13285.t0 a_2072_13285.t6 590.4504
Rpar2 a_2072_13285.t0 a_2072_13285.t7 185.8588
Rpar3 a_2072_13285.t0 a_2072_13285.t58 62.8596
Rpar4 a_2072_13285.t6 a_2072_13285.t7 8.1390
Rpar5 a_2072_13285.t6 a_2072_13285.t58 178.0928
Rpar6 a_2072_13285.t7 a_2072_13285.t58 56.0591
Rpar7 a_2159_1204.t0 a_2159_1204.t24 48.5344
Rpar8 a_2904_13493.t0 a_2904_13493.t3 54.7623
Rpar9 a_4556_5452.t0 a_4556_5452.t12 36.4931
Rpar10 a_7054_8234.t0 a_7054_8234.t12 36.4931
Rpar11 ib ib.t0 12.6951
Rpar12 ib ib.t1 8.7995
Rpar13 ib.t0 ib.t1 22.0569
Rpar14 inn inn.t0 2.1647
Rpar15 inp inp.t0 2.1647
Rpar16 out out.t0 3.4464
Rpar17 out out.t11 3291.5732
Rpar18 out out.t32 5824.9372
Rpar19 out.t0 out.t11 105.0500
Rpar20 out.t0 out.t32 185.9019
Rpar21 out.t11 out.t32 114.1283
Rpar22 vdd vdd.t0 24.8575
Rpar23 vdd vdd.t3 130.1467
Rpar24 vdd vdd.t4 2366.3509
Rpar25 vdd vdd.t80 482.2662
Rpar26 vdd.t0 vdd.t3 58.2479
Rpar27 vdd.t0 vdd.t4 1059.0739
Rpar28 vdd.t0 vdd.t80 215.8410
Rpar29 vdd.t3 vdd.t4 10.8163
Rpar30 vdd.t3 vdd.t80 74.9805
Rpar31 vdd.t4 vdd.t80 1363.3099
Rpar32 vss vss.t0 83.5426
Rpar33 vss vss.t12 396.6385
Rpar34 vss vss.t13 57.7816
Rpar35 vss vss.t39 108.0610
Rpar36 vss.t0 vss.t12 2.4646
Rpar37 vss.t0 vss.t13 24.0046
Rpar38 vss.t0 vss.t39 261.6715
Rpar39 vss.t12 vss.t13 19.5471
Rpar40 vss.t12 vss.t39 983.8539
Rpar41 vss.t13 vss.t39 73.3590
Cpar0 a_1952_13493.t0 vss 2.55358e-14
Cpar1 a_1952_13493.t1 vss 3.32606e-14
Cpar2 a_2072_13285.t0 vss 3.68173e-15
Cpar3 a_2072_13285.t58 vss 5.72282e-14
Cpar4 a_2072_13285.t6 vss 5.15174e-14
Cpar5 a_2072_13285.t7 vss 2.49256e-14
Cpar6 a_2159_1204.t0 vss 1.38320e-14
Cpar7 a_2159_1204.t24 vss 7.56926e-15
Cpar8 a_2904_13493.t0 vss 3.78347e-14
Cpar9 a_2904_13493.t3 vss 2.86376e-14
Cpar10 a_4556_5452.t0 vss 9.53628e-15
Cpar11 a_4556_5452.t12 vss 3.19626e-15
Cpar12 a_7054_8234.t0 vss 9.34888e-15
Cpar13 a_7054_8234.t12 vss 3.13340e-15
Cpar14 ib out 6.77100e-17
Cpar15 ib vss 2.40753e-14
Cpar16 ib.t0 vss 4.09726e-15
Cpar17 ib.t1 vss 8.43681e-16
Cpar18 inn inp 1.03860e-16
Cpar19 inn out 8.70300e-17
Cpar20 inn vdd 1.54300e-17
Cpar21 inn vss 1.18045e-14
Cpar22 inn.t0 vss 4.07928e-15
Cpar23 inp out 2.08500e-17
Cpar24 inp vdd 1.98900e-17
Cpar25 inp vss 1.18319e-14
Cpar26 inp.t0 vss 4.07320e-15
Cpar27 out vdd 1.49908e-14
Cpar28 out vss 1.66622e-14
Cpar29 out.t0 vss 9.60472e-15
Cpar30 out.t11 vss 2.39471e-15
Cpar31 out.t32 vss 2.76166e-14
Cpar32 vdd vss 2.44928e-13
Cpar33 vdd.t0 vss 7.11358e-14
Cpar34 vdd.t3 vss 5.56035e-14
Cpar35 vdd.t4 vss 8.67858e-15
Cpar36 vdd.t80 vss 3.72067e-15
.ends opamp_dut

Vdd vdd 0 1.800000
Vss vss 0 0
Ibias vdd ib 2.875000e-06
Vinp inp 0 DC 0.931000 AC 1 PWL(0 0.931000 1.765940e-08 0.931000 1.942535e-08 0.941000)
Rfb out inn 1m
Cload out 0 2.000000e-12
Xdut vdd vss inp inn out ib opamp_dut
.end
