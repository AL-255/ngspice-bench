* opa1000[0652]: 2p/pmos_miller_3v3_0p1u_1u_weak (pmos_miller, VDD=3.3V, CL=2.0pF, Iref=0.0813uA)
.include "pdk_opa.inc"
.temp 27
.option gmin=1e-12 rshunt=1e12 reltol=1e-3 abstol=1e-12 vntol=1e-5 method=gear
* Post-PEX R+C extracted netlist for pmos_miller_3v3_0p1u_1u_weak
.subckt opamp_dut vdd vss inp inn out ib
XMpar0 a_7610_5650.t0 ib.t0 vss.t6 vss.t5 nfet_03v3 w=0.4u l=3.25u ad=2.4000e-13 pd=2.0000e-06 as=1.1200e-13 ps=9.6000e-07 nf=1 m=2 par=2
XMpar1 ib.t1 ib.t0 vss.t6 vss.t5 nfet_03v3 w=0.4u l=3.25u ad=2.4000e-13 pd=2.0000e-06 as=1.1200e-13 ps=9.6000e-07 nf=1 m=2 par=2
XMpar2 a_1251_8359.t3 a_8312_4079.t2 vss.t2 vss.t1 nfet_03v3 w=0.4u l=3.75u ad=2.4000e-13 pd=2.0000e-06 as=1.1200e-13 ps=9.6000e-07 nf=1 m=2 par=2
XMpar3 a_8312_4079.t3 a_8312_4079.t2 vss.t2 vss.t1 nfet_03v3 w=0.4u l=3.75u ad=1.1200e-13 pd=9.6000e-07 as=1.1200e-13 ps=9.6000e-07 nf=1 m=2 par=2
XMpar4 a_1251_8359.t0 inp.t0 a_8706_1249.t1 vdd.t15 pfet_03v3 w=2.39u l=4u ad=1.4340e-12 pd=5.9800e-06 as=1.4340e-12 ps=5.9800e-06 nf=1 m=2 par=2
XMpar5 out.t0 a_7610_5650.t2 vdd.t1 vdd.t0 pfet_03v3 w=0.52u l=3.25u ad=2.4544e-13 pd=1.7760e-06 as=2.1216e-13 ps=1.5440e-06 nf=1 m=10 par=10
XMpar6 a_7610_5650.t3 a_7610_5650.t2 vdd.t1 vdd.t0 pfet_03v3 w=0.52u l=3.25u ad=3.1200e-13 pd=2.2400e-06 as=1.4560e-13 ps=1.0800e-06 nf=1 m=2 par=2
XMpar7 out.t2 a_1251_8359.t5 vss.t2 vss.t1 nfet_03v3 w=0.4u l=3.75u ad=1.3760e-13 pd=1.1680e-06 as=1.6320e-13 ps=1.3760e-06 nf=1 m=10 par=10
XMpar8 a_8706_1249.t0 a_7610_5650.t2 vdd.t1 vdd.t0 pfet_03v3 w=0.52u l=3.25u ad=3.1200e-13 pd=2.2400e-06 as=1.4560e-13 ps=1.0800e-06 nf=1 m=4 par=4
XMpar9 a_8312_4079.t0 inn.t0 a_8706_1249.t1 vdd.t15 pfet_03v3 w=2.39u l=4u ad=1.4340e-12 pd=5.9800e-06 as=1.4340e-12 ps=5.9800e-06 nf=1 m=2 par=2
X1 a_1251_8879.t0 a_5229_9399.t0 vss.t0 ppolyf_u_1k r_width=1u r_length=19.23u
X4 a_1251_8879.t0 a_5229_8359.t0 vss.t0 ppolyf_u_1k r_width=1u r_length=19.23u
X5 a_1251_11999.t0 a_5229_11479.t0 vss.t0 ppolyf_u_1k r_width=1u r_length=19.23u
X10 a_1251_14079.t0 a_5229_14599.t0 vss.t0 ppolyf_u_1k r_width=1u r_length=19.23u
X11 a_1251_8359.t2 a_5229_8359.t0 vss.t0 ppolyf_u_1k r_width=1u r_length=19.23u
X15 a_1251_10959.t0 a_5229_11479.t0 vss.t0 ppolyf_u_1k r_width=1u r_length=19.23u
X24 a_1251_10959.t0 a_5229_10439.t0 vss.t0 ppolyf_u_1k r_width=1u r_length=19.23u
X29 a_1251_14079.t0 a_5229_13559.t0 vss.t0 ppolyf_u_1k r_width=1u r_length=19.23u
X32 a_1251_16159.t1 out.t16 cap_mim_2f0fF c_width=14.37u c_length=14.36u
X34 a_1251_16159.t1 out.t16 cap_mim_2f0fF c_width=14.37u c_length=14.36u
X35 a_1251_13039.t0 a_5229_13559.t0 vss.t0 ppolyf_u_1k r_width=1u r_length=19.23u
X36 a_1251_9919.t0 a_5229_10439.t0 vss.t0 ppolyf_u_1k r_width=1u r_length=19.23u
X41 a_1251_9919.t0 a_5229_9399.t0 vss.t0 ppolyf_u_1k r_width=1u r_length=19.23u
X42 a_1251_16159.t0 a_5229_15639.t0 vss.t0 ppolyf_u_1k r_width=1u r_length=19.23u
X43 a_1251_13039.t0 a_5229_12519.t0 vss.t0 ppolyf_u_1k r_width=1u r_length=19.23u
X47 a_1251_15119.t0 a_5229_15639.t0 vss.t0 ppolyf_u_1k r_width=1u r_length=19.23u
X49 a_1251_11999.t0 a_5229_12519.t0 vss.t0 ppolyf_u_1k r_width=1u r_length=19.23u
X55 a_1251_15119.t0 a_5229_14599.t0 vss.t0 ppolyf_u_1k r_width=1u r_length=19.23u
Rpar0 a_1251_16159.t0 a_1251_16159.t1 63.1476
Rpar1 a_1251_8359.t0 a_1251_8359.t5 73.5337
Rpar2 a_1251_8359.t0 a_1251_8359.t2 198.4129
Rpar3 a_1251_8359.t0 a_1251_8359.t3 150.5760
Rpar4 a_1251_8359.t5 a_1251_8359.t2 99.1185
Rpar5 a_1251_8359.t5 a_1251_8359.t3 81.7982
Rpar6 a_1251_8359.t2 a_1251_8359.t3 220.7125
Rpar7 a_7610_5650.t0 a_7610_5650.t2 97.1031
Rpar8 a_7610_5650.t0 a_7610_5650.t3 88.7676
Rpar9 a_7610_5650.t2 a_7610_5650.t3 16.0836
Rpar10 a_8312_4079.t0 a_8312_4079.t2 106.8187
Rpar11 a_8312_4079.t0 a_8312_4079.t3 107.6699
Rpar12 a_8312_4079.t2 a_8312_4079.t3 30.7660
Rpar13 a_8706_1249.t0 a_8706_1249.t1 51.5210
Rpar14 ib ib.t0 12.7234
Rpar15 ib ib.t1 15.3650
Rpar16 ib.t0 ib.t1 29.2500
Rpar17 inn inn.t0 5.7006
Rpar18 inp inp.t0 5.7002
Rpar19 out out.t0 30.1935
Rpar20 out out.t2 54.5719
Rpar21 out out.t16 20.7981
Rpar22 out.t0 out.t2 80.4158
Rpar23 vdd vdd.t0 92.3861
Rpar24 vdd vdd.t1 932.9125
Rpar25 vdd vdd.t15 462.0811
Rpar26 vdd.t0 vdd.t1 12.3716
Rpar27 vdd.t0 vdd.t15 127.6481
Rpar28 vdd.t1 vdd.t15 1288.9869
Rpar29 vss vss.t0 557.5398
Rpar30 vss vss.t1 66.5134
Rpar31 vss vss.t6 117.8719
Rpar32 vss vss.t5 210.6292
Rpar33 vss vss.t2 54.8723
Rpar34 vss.t0 vss.t1 3.3397
Rpar35 vss.t0 vss.t6 1291.3964
Rpar36 vss.t0 vss.t5 27.1383
Rpar37 vss.t0 vss.t2 66.6223
Rpar38 vss.t1 vss.t6 682.5099
Rpar39 vss.t1 vss.t5 27.3239
Rpar40 vss.t1 vss.t2 7.9293
Rpar41 vss.t6 vss.t5 19.9439
Rpar42 vss.t6 vss.t2 988.9791
Rpar43 vss.t5 vss.t2 328.6947
Cpar0 a_1251_10959.t0 vss 2.93600e-17
Cpar1 a_1251_11999.t0 vss 2.93600e-17
Cpar2 a_1251_13039.t0 vss 2.93600e-17
Cpar3 a_1251_14079.t0 vss 2.93600e-17
Cpar4 a_1251_15119.t0 vss 3.20200e-17
Cpar5 a_1251_16159.t0 vss 1.26786e-16
Cpar6 a_1251_16159.t1 vss 4.71584e-15
Cpar7 a_1251_8359.t0 vss 1.88485e-15
Cpar8 a_1251_8359.t2 vss 1.25165e-15
Cpar9 a_1251_8359.t3 vss 1.29088e-15
Cpar10 a_1251_8359.t5 vss 7.45825e-15
Cpar11 a_1251_8879.t0 vss 3.31600e-17
Cpar12 a_1251_9919.t0 vss 2.93600e-17
Cpar13 a_5229_10439.t0 vss 3.79600e-17
Cpar14 a_5229_11479.t0 vss 3.79600e-17
Cpar15 a_5229_12519.t0 vss 4.00200e-17
Cpar16 a_5229_13559.t0 vss 3.68600e-17
Cpar17 a_5229_14599.t0 vss 3.76000e-17
Cpar18 a_5229_15639.t0 vss 3.56800e-17
Cpar19 a_5229_8359.t0 vss 4.01400e-17
Cpar20 a_5229_9399.t0 vss 3.81400e-17
Cpar21 a_7610_5650.t0 vss 6.10148e-15
Cpar22 a_7610_5650.t2 vss 3.80081e-14
Cpar23 a_7610_5650.t3 vss 7.13384e-15
Cpar24 a_8312_4079.t0 vss 2.74647e-15
Cpar25 a_8312_4079.t2 vss 4.40726e-15
Cpar26 a_8312_4079.t3 vss 9.79633e-16
Cpar27 a_8706_1249.t0 vss 1.53084e-14
Cpar28 a_8706_1249.t1 vss 1.30598e-14
Cpar29 ib vss 1.33610e-14
Cpar30 ib.t0 vss 2.13542e-15
Cpar31 ib.t1 vss 3.91638e-16
Cpar32 inn inp 1.03070e-16
Cpar33 inn vdd 4.63941e-15
Cpar34 inn vss 2.45119e-15
Cpar35 inn.t0 vss 4.38169e-15
Cpar36 inp vdd 4.69645e-15
Cpar37 inp vss 2.45491e-15
Cpar38 inp.t0 vss 4.42199e-15
Cpar39 out vdd 1.38589e-14
Cpar40 out vss 2.53837e-14
Cpar41 out.t0 vss 6.01055e-15
Cpar42 out.t16 vss 1.41516e-14
Cpar43 out.t2 vss 5.07897e-15
Cpar44 vdd vss 1.50575e-13
Cpar45 vdd.t0 vss 3.96628e-14
Cpar46 vdd.t1 vss 6.02823e-15
Cpar47 vdd.t15 vss 1.83595e-14
.ends opamp_dut

Vdd vdd 0 3.300000
Vss vss 0 0
Ibias vdd ib 8.130000e-08
Vinp inp 0 DC 1.480000 AC 1 PWL(0 1.480000 3.782034e-07 1.480000 4.160238e-07 1.490000)
Rfb out inn 1m
Cload out 0 2.000000e-12
Xdut vdd vss inp inn out ib opamp_dut
.end
