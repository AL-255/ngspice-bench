* opa1000[0728]: 2p/rail_to_rail_1v8_i500u_subth (rail_to_rail, VDD=1.8V, CL=2.0pF, Iref=43.75uA)
.include "pdk_opa.inc"
.temp 27
.option gmin=1e-12 rshunt=1e12 reltol=1e-3 abstol=1e-12 vntol=1e-5 method=gear
* Post-PEX R+C extracted netlist for rail_to_rail_1v8_i500u_subth
.subckt opamp_dut vdd vss inp inn out ib
XMpar0 a_3175_1294.t0 inp.t0 a_7008_14868.t20 vss.t2 nfet_03v3 w=8u l=0.28u ad=3.6000e-12 pd=9.4000e-06 as=3.4400e-12 ps=8.8600e-06 nf=1 m=64 par=64
XMpar1 ib.t1 ib.t0 vss.t61 vss.t2 nfet_03v3 w=4.13u l=0.68u ad=1.1564e-12 pd=4.6900e-06 as=1.1564e-12 ps=4.6900e-06 nf=1 m=16 par=16
XMpar2 a_6802_20239.t0 a_1054_10655.t0 vdd.t1 vdd.t0 pfet_03v3 w=10u l=0.68u ad=2.8000e-12 pd=1.0560e-05 as=3.2000e-12 ps=1.1890e-05 nf=1 m=16 par=16
XMpar3 a_7008_20239.t1 a_7008_20239.t0 vss.t1 vss.t0 nfet_03v3 w=1.38u l=0.63u ad=3.8640e-13 pd=1.9400e-06 as=4.4160e-13 ps=2.1925e-06 nf=1 m=16 par=16
XMpar4 a_11444_10990.t0 inn.t0 a_3175_1294.t0 vss.t2 nfet_03v3 w=8u l=0.28u ad=3.4400e-12 pd=8.8600e-06 as=3.6000e-12 ps=9.4000e-06 nf=1 m=64 par=64
XMpar5 a_6802_20239.t16 inp.t64 a_7008_20239.t32 vdd.t38 pfet_03v3 w=8u l=0.28u ad=3.6000e-12 pd=9.4000e-06 as=3.4400e-12 ps=8.8600e-06 nf=1 m=64 par=64
XMpar6 a_11444_10990.t96 a_7008_20239.t0 vss.t1 vss.t0 nfet_03v3 w=1.38u l=0.63u ad=3.8640e-13 pd=1.9400e-06 as=4.4160e-13 ps=2.1925e-06 nf=1 m=16 par=16
XMpar7 a_10708_25357.t0 inn.t64 a_6802_20239.t16 vdd.t38 pfet_03v3 w=8u l=0.28u ad=3.4400e-12 pd=8.8600e-06 as=3.6000e-12 ps=9.4000e-06 nf=1 m=64 par=64
XMpar8 out.t0 a_7008_14868.t97 vdd.t9 vdd.t8 pfet_03v3 w=10u l=0.4u ad=2.8000e-12 pd=1.0560e-05 as=3.0000e-12 ps=1.1225e-05 nf=1 m=64 par=64
XMpar9 a_10708_25357.t65 a_10708_25357.t64 vss.t1 vss.t0 nfet_03v3 w=1.38u l=0.63u ad=3.8640e-13 pd=1.9400e-06 as=3.8640e-13 ps=1.9400e-06 nf=1 m=16 par=16
XMpar10 a_1054_10655.t32 ib.t0 vss.t61 vss.t2 nfet_03v3 w=4.13u l=0.68u ad=1.1564e-12 pd=4.6900e-06 as=1.3216e-12 ps=5.2863e-06 nf=1 m=16 par=16
XMpar11 out.t15 ib.t0 vss.t61 vss.t2 nfet_03v3 w=4.13u l=0.68u ad=1.1564e-12 pd=4.6900e-06 as=1.3216e-12 ps=5.2863e-06 nf=1 m=64 par=64
XMpar12 a_3175_1294.t64 ib.t0 vss.t61 vss.t2 nfet_03v3 w=4.13u l=0.68u ad=1.1564e-12 pd=4.6900e-06 as=1.1564e-12 ps=4.6900e-06 nf=1 m=16 par=16
XMpar13 a_7008_14868.t0 a_10708_25357.t64 vss.t1 vss.t0 nfet_03v3 w=1.38u l=0.63u ad=3.8640e-13 pd=1.9400e-06 as=4.4160e-13 ps=2.1925e-06 nf=1 m=16 par=16
XMpar14 a_11444_10990.t65 a_11444_10990.t64 vdd.t9 vdd.t8 pfet_03v3 w=10u l=0.4u ad=2.8000e-12 pd=1.0560e-05 as=2.8000e-12 ps=1.0560e-05 nf=1 m=16 par=16
XMpar15 a_1054_10655.t1 a_1054_10655.t0 vdd.t1 vdd.t0 pfet_03v3 w=10u l=0.68u ad=2.8000e-12 pd=1.0560e-05 as=2.8000e-12 ps=1.0560e-05 nf=1 m=16 par=16
XMpar16 a_7008_14868.t4 a_11444_10990.t64 vdd.t9 vdd.t8 pfet_03v3 w=10u l=0.4u ad=2.8000e-12 pd=1.0560e-05 as=3.2000e-12 ps=1.1890e-05 nf=1 m=16 par=16
X81 a_10144_7918.t1 out.t70 cap_mim_2f0fF c_width=18.91u c_length=18.91u
X100 a_7008_14868.t84 a_10144_7918.t0 vss.t288 ppolyf_u_1k r_width=1u r_length=1u
X114 a_10144_7918.t1 out.t70 cap_mim_2f0fF c_width=18.91u c_length=18.91u
X126 a_10144_7918.t1 out.t70 cap_mim_2f0fF c_width=18.91u c_length=18.91u
X158 a_10144_7918.t1 out.t70 cap_mim_2f0fF c_width=18.91u c_length=18.91u
Rpar0 a_10144_7918.t0 a_10144_7918.t1 75.7578
Rpar1 a_1054_10655.t0 a_1054_10655.t1 17.3273
Rpar2 a_1054_10655.t0 a_1054_10655.t32 464.6616
Rpar3 a_1054_10655.t1 a_1054_10655.t32 89.5749
Rpar4 a_10708_25357.t0 a_10708_25357.t64 897.2577
Rpar5 a_10708_25357.t0 a_10708_25357.t65 50.5617
Rpar6 a_10708_25357.t64 a_10708_25357.t65 15.0313
Rpar7 a_11444_10990.t0 a_11444_10990.t96 243.3811
Rpar8 a_11444_10990.t0 a_11444_10990.t64 4024.4663
Rpar9 a_11444_10990.t0 a_11444_10990.t65 78.1776
Rpar10 a_11444_10990.t96 a_11444_10990.t64 2903.9070
Rpar11 a_11444_10990.t96 a_11444_10990.t65 56.4101
Rpar12 a_11444_10990.t64 a_11444_10990.t65 17.7998
Rpar13 a_3175_1294.t0 a_3175_1294.t64 74.0778
Rpar14 a_6802_20239.t0 a_6802_20239.t16 84.2802
Rpar15 a_7008_14868.t0 a_7008_14868.t4 226.4341
Rpar16 a_7008_14868.t0 a_7008_14868.t97 899.7305
Rpar17 a_7008_14868.t0 a_7008_14868.t20 90.3124
Rpar18 a_7008_14868.t0 a_7008_14868.t84 766.8216
Rpar19 a_7008_14868.t4 a_7008_14868.t97 133.0905
Rpar20 a_7008_14868.t4 a_7008_14868.t20 114.6724
Rpar21 a_7008_14868.t4 a_7008_14868.t84 113.4303
Rpar22 a_7008_14868.t97 a_7008_14868.t20 455.6482
Rpar23 a_7008_14868.t97 a_7008_14868.t84 64.5065
Rpar24 a_7008_14868.t20 a_7008_14868.t84 388.3395
Rpar25 a_7008_20239.t0 a_7008_20239.t1 8.2763
Rpar26 a_7008_20239.t0 a_7008_20239.t32 300.5811
Rpar27 a_7008_20239.t1 a_7008_20239.t32 110.1164
Rpar28 ib ib.t0 15.6927
Rpar29 ib ib.t1 4.2576
Rpar30 ib.t0 ib.t1 5.4628
Rpar31 inn inn.t0 3.7544
Rpar32 inn inn.t64 55.9639
Rpar33 inp inp.t0 3.7544
Rpar34 inp inp.t64 54.8065
Rpar35 out out.t15 2.9708
Rpar36 out.t0 out.t15 47.8405
Rpar37 out.t0 out.t70 91.7549
Rpar38 out.t15 out.t70 243.7830
Rpar39 vdd vdd.t0 1038.9138
Rpar40 vdd vdd.t8 759.4951
Rpar41 vdd vdd.t9 789.4210
Rpar42 vdd vdd.t38 41.6069
Rpar43 vdd.t0 vdd.t1 4.3594
Rpar44 vdd.t0 vdd.t8 102.1813
Rpar45 vdd.t0 vdd.t9 85.8657
Rpar46 vdd.t0 vdd.t38 589.4665
Rpar47 vdd.t1 vdd.t9 860.9393
Rpar48 vdd.t1 vdd.t38 5910.3310
Rpar49 vdd.t8 vdd.t9 2.5132
Rpar50 vdd.t8 vdd.t38 430.9279
Rpar51 vdd.t9 vdd.t38 447.9074
Rpar52 vss vss.t0 3768.5553
Rpar53 vss vss.t1 297.0596
Rpar54 vss vss.t2 130.3778
Rpar55 vss vss.t61 99.2730
Rpar56 vss vss.t288 1927.7519
Rpar57 vss.t0 vss.t1 2.8653
Rpar58 vss.t0 vss.t2 107.6468
Rpar59 vss.t1 vss.t2 36.6673
Rpar60 vss.t1 vss.t61 157.1405
Rpar61 vss.t1 vss.t288 1051.9857
Rpar62 vss.t2 vss.t61 2.4909
Rpar63 vss.t2 vss.t288 8.4397
Rpar64 vss.t61 vss.t288 1054.0874
Cpar0 a_10144_7918.t0 vss 1.10243e-16
Cpar1 a_10144_7918.t1 vss 1.25953e-14
Cpar2 a_1054_10655.t0 vss 3.29146e-14
Cpar3 a_1054_10655.t1 vss 2.25247e-14
Cpar4 a_1054_10655.t32 vss 1.12534e-14
Cpar5 a_10708_25357.t0 vss 8.69859e-14
Cpar6 a_10708_25357.t64 vss 1.37581e-14
Cpar7 a_10708_25357.t65 vss 6.64701e-15
Cpar8 a_11444_10990.t0 vss 9.79362e-14
Cpar9 a_11444_10990.t64 vss 2.88979e-14
Cpar10 a_11444_10990.t65 vss 3.34647e-14
Cpar11 a_11444_10990.t96 vss 9.22571e-15
Cpar12 a_3175_1294.t0 vss 1.85318e-13
Cpar13 a_3175_1294.t64 vss 2.69416e-14
Cpar14 a_6802_20239.t0 vss 3.05818e-14
Cpar15 a_6802_20239.t16 vss 2.00733e-13
Cpar16 a_7008_14868.t0 vss 8.78752e-15
Cpar17 a_7008_14868.t20 vss 9.39377e-14
Cpar18 a_7008_14868.t4 vss 2.89625e-14
Cpar19 a_7008_14868.t84 vss 3.54276e-15
Cpar20 a_7008_14868.t97 vss 6.07791e-14
Cpar21 a_7008_20239.t0 vss 1.54751e-14
Cpar22 a_7008_20239.t1 vss 9.87627e-15
Cpar23 a_7008_20239.t32 vss 9.08185e-14
Cpar24 ib out 1.29668e-14
Cpar25 ib vss 1.11612e-13
Cpar26 ib.t0 vss 2.37158e-14
Cpar27 ib.t1 vss 5.76595e-15
Cpar28 inn inp 2.01660e-16
Cpar29 inn vdd 2.73313e-14
Cpar30 inn vss 4.13041e-14
Cpar31 inn.t0 vss 2.27480e-14
Cpar32 inn.t64 vss 3.32613e-14
Cpar33 inp vdd 2.68472e-14
Cpar34 inp vss 4.21796e-14
Cpar35 inp.t0 vss 2.26502e-14
Cpar36 inp.t64 vss 3.28763e-14
Cpar37 out vdd 1.34750e-13
Cpar38 out vss 7.05882e-14
Cpar39 out.t0 vss 8.72768e-14
Cpar40 out.t15 vss 4.52761e-14
Cpar41 out.t70 vss 4.75474e-14
Cpar42 vdd vss 5.93646e-13
Cpar43 vdd.t0 vss 5.38574e-14
Cpar44 vdd.t1 vss 2.12484e-14
Cpar45 vdd.t38 vss 1.54599e-13
Cpar46 vdd.t8 vss 1.25630e-13
Cpar47 vdd.t9 vss 6.12167e-14
.ends opamp_dut

Vdd vdd 0 1.800000
Vss vss 0 0
Ibias vdd ib 4.375000e-05
Vinp inp 0 DC 0.895000 AC 1 PWL(0 0.895000 3.000000e-09 0.895000 3.300000e-09 0.905000)
Rfb out inn 1m
Cload out 0 2.000000e-12
Xdut vdd vss inp inn out ib opamp_dut
.end
