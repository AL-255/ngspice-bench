* opa1000[0259]: 200f/folded_cascode_pmos_1v8_i2u_subth (folded_cascode_pmos, VDD=1.8V, CL=0.2pF, Iref=0.3778uA)
.include "pdk_opa.inc"
.temp 27
.option gmin=1e-12 rshunt=1e12 reltol=1e-3 abstol=1e-12 vntol=1e-5 method=gear
* Post-PEX R+C extracted netlist for folded_cascode_pmos_1v8_i2u_subth
.subckt opamp_dut vdd vss inp inn out ib
XMpar0 a_2086_6349.t1 a_2086_6349.t0 vdd.t1 vdd.t0 pfet_03v3 w=5.48u l=2.72u ad=1.5344e-12 pd=6.0400e-06 as=1.5344e-12 ps=6.0400e-06 nf=1 m=2 par=2
XMpar1 a_2086_6349.t4 ib.t0 vss.t4 vss.t3 nfet_03v3 w=0.79u l=1.56u ad=2.2120e-13 pd=1.3500e-06 as=2.2120e-13 ps=1.3500e-06 nf=1 m=2 par=2
XMpar2 a_1746_1249.t1 inp.t0 a_2170_1249.t1 vdd.t6 pfet_03v3 w=1.95u l=1.52u ad=6.2739e-13 pd=2.8478e-06 as=5.7313e-13 ps=2.6226e-06 nf=1 m=46 par=46
XMpar3 a_1746_1249.t1 inn.t0 a_7054_10514.t1 vdd.t6 pfet_03v3 w=1.95u l=1.52u ad=6.2739e-13 pd=2.8478e-06 as=5.7313e-13 ps=2.6226e-06 nf=1 m=46 par=46
XMpar4 a_2170_1249.t48 ib.t0 vss.t4 vss.t3 nfet_03v3 w=0.79u l=1.56u ad=2.2120e-13 pd=1.3500e-06 as=3.4760e-13 ps=2.0650e-06 nf=1 m=4 par=4
XMpar5 a_7054_10514.t47 ib.t0 vss.t4 vss.t3 nfet_03v3 w=0.79u l=1.56u ad=2.2120e-13 pd=1.3500e-06 as=3.4760e-13 ps=2.0650e-06 nf=1 m=4 par=4
XMpar6 a_2170_1249.t0 a_2086_6349.t10 a_5724_13353.t0 vss.t0 nfet_03v3 w=1.78u l=1.95u ad=1.0680e-12 pd=4.7600e-06 as=4.9840e-13 ps=2.3400e-06 nf=1 m=4 par=4
XMpar7 ib.t1 ib.t0 vss.t4 vss.t3 nfet_03v3 w=0.79u l=1.56u ad=4.7400e-13 pd=2.7800e-06 as=2.2120e-13 ps=1.3500e-06 nf=1 m=2 par=2
XMpar8 a_7054_10514.t0 a_2086_6349.t10 out.t1 vss.t0 nfet_03v3 w=1.78u l=1.95u ad=1.0680e-12 pd=4.7600e-06 as=4.9840e-13 ps=2.3400e-06 nf=1 m=4 par=4
XMpar9 a_1746_1249.t0 a_2086_6349.t0 vdd.t1 vdd.t0 pfet_03v3 w=5.48u l=2.72u ad=1.5344e-12 pd=6.0400e-06 as=2.4112e-12 ps=9.1000e-06 nf=1 m=4 par=4
XMpar10 out.t0 a_5724_13353.t4 vdd.t1 vdd.t0 pfet_03v3 w=5.48u l=2.72u ad=1.5344e-12 pd=6.0400e-06 as=1.5344e-12 ps=6.0400e-06 nf=1 m=2 par=2
XMpar11 a_5724_13353.t5 a_5724_13353.t4 vdd.t1 vdd.t0 pfet_03v3 w=5.48u l=2.72u ad=3.2880e-12 pd=1.2160e-05 as=1.5344e-12 ps=6.0400e-06 nf=1 m=2 par=2
X119 out.t6 vss.t2 cap_mim_2f0fF c_width=11.18u c_length=11.18u
Rpar0 a_1746_1249.t0 a_1746_1249.t1 69.7536
Rpar1 a_2086_6349.t0 a_2086_6349.t1 25.5282
Rpar2 a_2086_6349.t0 a_2086_6349.t10 164.2148
Rpar3 a_2086_6349.t0 a_2086_6349.t4 161.1143
Rpar4 a_2086_6349.t1 a_2086_6349.t10 103.6387
Rpar5 a_2086_6349.t1 a_2086_6349.t4 101.6819
Rpar6 a_2086_6349.t10 a_2086_6349.t4 141.9525
Rpar7 a_2170_1249.t0 a_2170_1249.t1 88.6481
Rpar8 a_2170_1249.t0 a_2170_1249.t48 74.9806
Rpar9 a_2170_1249.t1 a_2170_1249.t48 63.8725
Rpar10 a_5724_13353.t0 a_5724_13353.t4 195.0554
Rpar11 a_5724_13353.t0 a_5724_13353.t5 50.2993
Rpar12 a_5724_13353.t4 a_5724_13353.t5 18.9730
Rpar13 a_7054_10514.t0 a_7054_10514.t1 88.6481
Rpar14 a_7054_10514.t0 a_7054_10514.t47 74.9806
Rpar15 a_7054_10514.t1 a_7054_10514.t47 63.8725
Rpar16 ib ib.t0 1.6758
Rpar17 ib ib.t1 52.3498
Rpar18 ib.t0 ib.t1 22.3803
Rpar19 inn inn.t0 1.6209
Rpar20 inp inp.t0 1.6209
Rpar21 out out.t0 52.7407
Rpar22 out out.t1 6.7631
Rpar23 out out.t6 136.7090
Rpar24 out.t0 out.t6 91.9378
Rpar25 vdd vdd.t0 30.1419
Rpar26 vdd vdd.t1 81.9931
Rpar27 vdd vdd.t6 366.5599
Rpar28 vdd.t0 vdd.t1 3.6948
Rpar29 vdd.t0 vdd.t6 37.2847
Rpar30 vdd.t1 vdd.t6 99.7152
Rpar31 vss vss.t0 543.0914
Rpar32 vss vss.t4 113.2025
Rpar33 vss vss.t3 144.8425
Rpar34 vss vss.t2 583.2817
Rpar35 vss.t0 vss.t4 16.0096
Rpar36 vss.t0 vss.t3 5.5118
Rpar37 vss.t0 vss.t2 220.4861
Rpar38 vss.t4 vss.t3 7.0992
Rpar39 vss.t4 vss.t2 130.7760
Rpar40 vss.t3 vss.t2 149.4204
Cpar0 a_1746_1249.t0 vss 8.53123e-15
Cpar1 a_1746_1249.t1 vss 6.41681e-14
Cpar2 a_2086_6349.t0 vss 1.36113e-14
Cpar3 a_2086_6349.t1 vss 2.82751e-15
Cpar4 a_2086_6349.t10 vss 8.82208e-15
Cpar5 a_2086_6349.t4 vss 1.24456e-15
Cpar6 a_2170_1249.t0 vss 5.53593e-15
Cpar7 a_2170_1249.t1 vss 3.62444e-14
Cpar8 a_2170_1249.t48 vss 3.85279e-15
Cpar9 a_5724_13353.t0 vss 2.48367e-15
Cpar10 a_5724_13353.t4 vss 1.06194e-14
Cpar11 a_5724_13353.t5 vss 4.78927e-15
Cpar12 a_7054_10514.t0 vss 5.47377e-15
Cpar13 a_7054_10514.t1 vss 3.58374e-14
Cpar14 a_7054_10514.t47 vss 3.80952e-15
Cpar15 ib vdd 3.16030e-16
Cpar16 ib vss 1.73582e-14
Cpar17 ib.t0 vss 2.13915e-15
Cpar18 ib.t1 vss 4.68234e-16
Cpar19 inn inp 1.40270e-16
Cpar20 inn vdd 3.15733e-14
Cpar21 inn vss 5.16737e-15
Cpar22 inn.t0 vss 4.80440e-14
Cpar23 inp vdd 3.15315e-14
Cpar24 inp vss 5.30756e-15
Cpar25 inp.t0 vss 4.80230e-14
Cpar26 out vdd 4.67669e-15
Cpar27 out vss 1.01914e-14
Cpar28 out.t0 vss 9.28961e-16
Cpar29 out.t1 vss 1.70825e-16
Cpar30 out.t6 vss 9.19984e-15
Cpar31 vdd vss 2.64608e-13
Cpar32 vdd.t0 vss 2.33254e-14
Cpar33 vdd.t1 vss 1.12148e-14
Cpar34 vdd.t6 vss 8.13187e-14
.ends opamp_dut

Vdd vdd 0 1.800000
Vss vss 0 0
Ibias vdd ib 3.778000e-07
Vinp inp 0 DC 0.751000 AC 1 PWL(0 0.751000 3.747227e-08 0.751000 4.121950e-08 0.761000)
Rfb out inn 1m
Cload out 0 2.000000e-13
Xdut vdd vss inp inn out ib opamp_dut
.end
