* opa1000[0153]: 2p/current_reuse_3v3_i1u_weak (current_reuse, VDD=3.3V, CL=2.0pF, Iref=0.1857uA)
.include "pdk_opa.inc"
.temp 27
.option gmin=1e-12 rshunt=1e12 reltol=1e-3 abstol=1e-12 vntol=1e-5 method=gear
* Post-PEX R+C extracted netlist for current_reuse_3v3_i1u_weak
.subckt opamp_dut vdd vss inp inn out ib
XMpar0 a_1358_11639.t2 a_998_11431.t4 vdd.t3 vdd.t2 pfet_03v3 w=1.32u l=1.8u ad=3.6960e-13 pd=1.8800e-06 as=7.9200e-13 ps=3.8400e-06 nf=1 m=2 par=2
XMpar1 a_3534_9774.t2 ib.t0 vss.t3 vss.t2 nfet_03v3 w=0.4u l=2.1u ad=1.1200e-13 pd=9.6000e-07 as=1.1200e-13 ps=9.6000e-07 nf=1 m=4 par=4
XMpar2 a_1358_11639.t0 inn.t0 a_998_11431.t0 vdd.t0 pfet_03v3 w=1.61u l=3.2u ad=9.6600e-13 pd=4.4200e-06 as=4.5080e-13 ps=2.1700e-06 nf=1 m=2 par=2
XMpar3 out.t0 ib.t0 vss.t3 vss.t2 nfet_03v3 w=0.4u l=2.1u ad=1.3760e-13 pd=1.1680e-06 as=1.1200e-13 ps=9.6000e-07 nf=1 m=10 par=10
XMpar4 a_998_11431.t5 a_998_11431.t4 vdd.t3 vdd.t2 pfet_03v3 w=1.32u l=1.8u ad=7.9200e-13 pd=3.8400e-06 as=3.6960e-13 ps=1.8800e-06 nf=1 m=1
XMpar5 a_1132_5858.t2 inp.t2 a_3534_9774.t0 vss.t1 nfet_03v3 w=0.77u l=3.2u ad=4.6200e-13 pd=2.7400e-06 as=4.6200e-13 ps=2.7400e-06 nf=1 m=2 par=2
XMpar6 ib.t1 ib.t0 vss.t3 vss.t2 nfet_03v3 w=0.4u l=2.1u ad=1.1200e-13 pd=9.6000e-07 as=1.1200e-13 ps=9.6000e-07 nf=1 m=2 par=2
XMpar7 out.t2 a_1132_5858.t6 vdd.t3 vdd.t2 pfet_03v3 w=1.32u l=1.8u ad=3.6960e-13 pd=1.8800e-06 as=4.5408e-13 ps=2.2720e-06 nf=1 m=10 par=10
XMpar8 a_3534_9774.t0 inn.t2 a_998_11431.t2 vss.t1 nfet_03v3 w=0.77u l=3.2u ad=4.6200e-13 pd=2.7400e-06 as=4.6200e-13 ps=2.7400e-06 nf=1 m=2 par=2
XMpar9 a_1132_5858.t0 inp.t0 a_1358_11639.t0 vdd.t0 pfet_03v3 w=1.61u l=3.2u ad=4.5080e-13 pd=2.1700e-06 as=9.6600e-13 ps=4.4200e-06 nf=1 m=2 par=2
XMpar10 a_1132_5858.t4 a_998_11431.t4 vdd.t3 vdd.t2 pfet_03v3 w=1.32u l=1.8u ad=7.9200e-13 pd=3.8400e-06 as=3.6960e-13 ps=1.8800e-06 nf=1 m=1
X1 a_11638_9702.t1 out.t1 cap_mim_2f0fF c_width=15.62u c_length=15.61u
X3 a_11638_6582.t0 a_15288_7102.t0 vss.t0 ppolyf_u_1k r_width=1u r_length=17.59u
X8 a_11638_9702.t0 a_15288_9182.t0 vss.t0 ppolyf_u_1k r_width=1u r_length=17.59u
X16 a_11638_9702.t1 out.t1 cap_mim_2f0fF c_width=15.62u c_length=15.61u
X21 a_11638_6582.t0 a_15288_6062.t0 vss.t0 ppolyf_u_1k r_width=1u r_length=17.59u
X28 a_11638_8662.t0 a_15288_9182.t0 vss.t0 ppolyf_u_1k r_width=1u r_length=17.59u
X31 a_1132_5858.t5 a_15288_6062.t0 vss.t0 ppolyf_u_1k r_width=1u r_length=17.59u
X39 a_11638_8662.t0 a_15288_8142.t0 vss.t0 ppolyf_u_1k r_width=1u r_length=17.59u
X42 a_11638_7622.t0 a_15288_8142.t0 vss.t0 ppolyf_u_1k r_width=1u r_length=17.59u
X47 a_11638_7622.t0 a_15288_7102.t0 vss.t0 ppolyf_u_1k r_width=1u r_length=17.59u
Rpar0 a_1132_5858.t0 a_1132_5858.t6 153.1216
Rpar1 a_1132_5858.t0 a_1132_5858.t2 62.5992
Rpar2 a_1132_5858.t0 a_1132_5858.t4 293.1524
Rpar3 a_1132_5858.t0 a_1132_5858.t5 563.0859
Rpar4 a_1132_5858.t6 a_1132_5858.t2 234.9460
Rpar5 a_1132_5858.t6 a_1132_5858.t4 99.2533
Rpar6 a_1132_5858.t6 a_1132_5858.t5 190.6453
Rpar7 a_1132_5858.t2 a_1132_5858.t4 449.8060
Rpar8 a_1132_5858.t2 a_1132_5858.t5 863.9854
Rpar9 a_1132_5858.t4 a_1132_5858.t5 133.2108
Rpar10 a_11638_9702.t0 a_11638_9702.t1 90.6305
Rpar11 a_1358_11639.t0 a_1358_11639.t2 55.2360
Rpar12 a_3534_9774.t0 a_3534_9774.t2 74.5948
Rpar13 a_998_11431.t0 a_998_11431.t2 68.3046
Rpar14 a_998_11431.t0 a_998_11431.t4 206.6136
Rpar15 a_998_11431.t0 a_998_11431.t5 349.2798
Rpar16 a_998_11431.t2 a_998_11431.t4 444.2488
Rpar17 a_998_11431.t2 a_998_11431.t5 751.0016
Rpar18 a_998_11431.t4 a_998_11431.t5 27.0950
Rpar19 ib ib.t0 10.8795
Rpar20 ib ib.t1 17.5629
Rpar21 inn inn.t0 43.5321
Rpar22 inn inn.t2 4.9805
Rpar23 inp inp.t0 43.4835
Rpar24 inp inp.t2 4.9801
Rpar25 out out.t0 66.1173
Rpar26 out out.t1 101.3343
Rpar27 out out.t2 3.5829
Rpar28 out.t0 out.t1 191.7373
Rpar29 vdd vdd.t0 63.5780
Rpar30 vdd vdd.t2 144.7107
Rpar31 vdd vdd.t3 123.8743
Rpar32 vdd.t0 vdd.t2 412.3504
Rpar33 vdd.t0 vdd.t3 352.9774
Rpar34 vdd.t2 vdd.t3 3.6998
Rpar35 vss vss.t0 121.2866
Rpar36 vss vss.t1 207.9392
Rpar37 vss vss.t2 71.5386
Rpar38 vss vss.t3 386.5465
Rpar39 vss.t0 vss.t1 447.6457
Rpar40 vss.t0 vss.t2 17.8476
Rpar41 vss.t0 vss.t3 140.5917
Rpar42 vss.t1 vss.t2 123.9978
Rpar43 vss.t1 vss.t3 664.8932
Rpar44 vss.t2 vss.t3 5.5700
Cpar0 a_1132_5858.t0 vss 3.58279e-15
Cpar1 a_1132_5858.t2 vss 3.63133e-15
Cpar2 a_1132_5858.t4 vss 3.96832e-15
Cpar3 a_1132_5858.t5 vss 4.31713e-15
Cpar4 a_1132_5858.t6 vss 1.34496e-14
Cpar5 a_11638_6582.t0 vss 3.20200e-17
Cpar6 a_11638_7622.t0 vss 2.98200e-17
Cpar7 a_11638_8662.t0 vss 3.91200e-17
Cpar8 a_11638_9702.t0 vss 1.83877e-16
Cpar9 a_11638_9702.t1 vss 7.02478e-15
Cpar10 a_1358_11639.t0 vss 5.42017e-15
Cpar11 a_1358_11639.t2 vss 2.51876e-15
Cpar12 a_15288_6062.t0 vss 2.64400e-17
Cpar13 a_15288_7102.t0 vss 3.00800e-17
Cpar14 a_15288_8142.t0 vss 3.00800e-17
Cpar15 a_15288_9182.t0 vss 2.64400e-17
Cpar16 a_3534_9774.t0 vss 8.36017e-15
Cpar17 a_3534_9774.t2 vss 7.74439e-15
Cpar18 a_998_11431.t0 vss 5.11398e-15
Cpar19 a_998_11431.t2 vss 4.73112e-15
Cpar20 a_998_11431.t4 vss 1.13872e-14
Cpar21 a_998_11431.t5 vss 3.84541e-15
Cpar22 ib inp 1.07100e-17
Cpar23 ib out 1.00233e-15
Cpar24 ib vdd 2.00850e-16
Cpar25 ib vss 2.69407e-14
Cpar26 ib.t0 vss 3.97594e-15
Cpar27 ib.t1 vss 2.30755e-16
Cpar28 inn inp 1.55040e-16
Cpar29 inn vdd 3.33878e-15
Cpar30 inn vss 7.55349e-15
Cpar31 inn.t0 vss 3.34585e-15
Cpar32 inn.t2 vss 1.65749e-15
Cpar33 inp vdd 3.71379e-15
Cpar34 inp vss 7.24832e-15
Cpar35 inp.t0 vss 3.55024e-15
Cpar36 inp.t2 vss 1.75929e-15
Cpar37 out vdd 7.72488e-15
Cpar38 out vss 1.76661e-14
Cpar39 out.t0 vss 3.14058e-15
Cpar40 out.t1 vss 1.30438e-14
Cpar41 out.t2 vss 7.84461e-16
Cpar42 vdd vss 8.65406e-14
Cpar43 vdd.t0 vss 1.01122e-14
Cpar44 vdd.t2 vss 1.77358e-14
Cpar45 vdd.t3 vss 9.70065e-15
.ends opamp_dut

Vdd vdd 0 3.300000
Vss vss 0 0
Ibias vdd ib 1.857000e-07
Vinp inp 0 DC 1.645000 AC 1 PWL(0 1.645000 1.506624e-07 1.645000 1.657286e-07 1.655000)
Rfb out inn 1m
Cload out 0 2.000000e-12
Xdut vdd vss inp inn out ib opamp_dut
.end
