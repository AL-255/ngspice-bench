* opa1000[0069]: 2p/cherry_hooper_3v3_i2u_weak (cherry_hooper, VDD=3.3V, CL=2.0pF, Iref=0.0778uA)
.include "pdk_opa.inc"
.temp 27
.option gmin=1e-12 rshunt=1e12 reltol=1e-3 abstol=1e-12 vntol=1e-5 method=gear
* Post-PEX R+C extracted netlist for cherry_hooper_3v3_i2u_weak
.subckt opamp_dut vdd vss inp inn out ib
XMpar0 a_5628_12554.t2 a_5628_12554.t1 vdd.t1 vdd.t0 pfet_03v3 w=0.66u l=1.35u ad=1.8480e-13 pd=1.2200e-06 as=2.9040e-13 ps=1.8700e-06 nf=1 m=4 par=4
XMpar1 a_6146_10739.t0 ib.t0 vss.t2 vss.t1 nfet_03v3 w=0.4u l=2.6u ad=1.4400e-13 pd=1.2200e-06 as=1.7600e-13 ps=1.4800e-06 nf=1 m=8 par=8
XMpar2 a_5279_1041.t7 a_3805_7477.t3 a_6154_4462.t2 vdd.t11 pfet_03v3 w=0.4u l=2.92u ad=2.4000e-13 pd=2.0000e-06 as=2.4000e-13 ps=2.0000e-06 nf=1 m=1
XMpar3 a_5554_4462.t2 inn.t0 a_7054_7730.t1 vss.t37 nfet_03v3 w=0.4u l=2.4u ad=2.4000e-13 pd=2.0000e-06 as=1.1200e-13 ps=9.6000e-07 nf=1 m=1
XMpar4 a_5554_4462.t0 ib.t0 vss.t2 vss.t1 nfet_03v3 w=0.4u l=2.6u ad=1.1200e-13 pd=9.6000e-07 as=1.1200e-13 ps=9.6000e-07 nf=1 m=2 par=2
XMpar5 a_3879_11046.t2 a_3879_11046.t1 vdd.t20 vdd.t19 pfet_03v3 w=0.44u l=2.6u ad=2.6400e-13 pd=2.0800e-06 as=2.6400e-13 ps=2.0800e-06 nf=1 m=1
XMpar6 a_3601_2801.t0 a_6154_4462.t4 a_5279_1041.t6 vss.t0 nfet_03v3 w=1.73u l=2.4u ad=1.0380e-12 pd=4.6600e-06 as=1.0380e-12 ps=4.6600e-06 nf=1 m=1
XMpar7 a_5279_1041.t1 a_5279_1041.t0 vdd.t1 vdd.t0 pfet_03v3 w=0.66u l=1.35u ad=2.5520e-13 pd=1.6533e-06 as=2.5520e-13 ps=1.6533e-06 nf=1 m=3 par=3
XMpar8 a_7054_5963.t7 a_3805_7477.t3 a_7054_7730.t0 vdd.t11 pfet_03v3 w=0.4u l=2.92u ad=2.4000e-13 pd=2.0000e-06 as=2.4000e-13 ps=2.0000e-06 nf=1 m=1
XMpar9 a_3601_2801.t1 ib.t0 vss.t2 vss.t1 nfet_03v3 w=0.4u l=2.6u ad=1.5467e-13 pd=1.3067e-06 as=1.1200e-13 ps=9.6000e-07 nf=1 m=6 par=6
XMpar10 a_3879_11046.t0 ib.t0 vss.t2 vss.t1 nfet_03v3 w=0.4u l=2.6u ad=2.4000e-13 pd=2.0000e-06 as=1.1200e-13 ps=9.6000e-07 nf=1 m=1
XMpar11 out.t1 a_5628_12554.t1 vdd.t1 vdd.t0 pfet_03v3 w=0.66u l=1.35u ad=1.8480e-13 pd=1.2200e-06 as=1.8480e-13 ps=1.2200e-06 nf=1 m=4 par=4
XMpar12 a_3805_7477.t0 ib.t0 vss.t2 vss.t1 nfet_03v3 w=0.4u l=2.6u ad=2.4000e-13 pd=2.0000e-06 as=2.4000e-13 ps=2.0000e-06 nf=1 m=1
XMpar13 a_5554_4462.t2 inp.t0 a_6154_4462.t0 vss.t0 nfet_03v3 w=0.4u l=2.4u ad=2.4000e-13 pd=2.0000e-06 as=1.1200e-13 ps=9.6000e-07 nf=1 m=1
XMpar14 a_5628_12554.t0 a_5279_1041.t8 a_6146_10739.t8 vss.t36 nfet_03v3 w=2.31u l=2.4u ad=1.3860e-12 pd=5.8200e-06 as=1.3860e-12 ps=5.8200e-06 nf=1 m=1
XMpar15 a_3601_2801.t0 a_7054_7730.t4 a_7054_5963.t6 vss.t0 nfet_03v3 w=1.73u l=2.4u ad=1.0380e-12 pd=4.6600e-06 as=1.0380e-12 ps=4.6600e-06 nf=1 m=1
XMpar16 a_7054_5963.t1 a_7054_5963.t0 vdd.t1 vdd.t0 pfet_03v3 w=0.66u l=1.35u ad=2.5520e-13 pd=1.6533e-06 as=2.5520e-13 ps=1.6533e-06 nf=1 m=3 par=3
XMpar17 a_5554_4462.t2 inp.t0 a_6154_4462.t0 vss.t37 nfet_03v3 w=0.4u l=2.4u ad=2.4000e-13 pd=2.0000e-06 as=1.1200e-13 ps=9.6000e-07 nf=1 m=1
XMpar18 a_5554_4462.t2 inn.t0 a_7054_7730.t1 vss.t0 nfet_03v3 w=0.4u l=2.4u ad=2.4000e-13 pd=2.0000e-06 as=1.1200e-13 ps=9.6000e-07 nf=1 m=1
XMpar19 a_6154_4462.t3 a_3879_11046.t1 vdd.t20 vdd.t19 pfet_03v3 w=0.44u l=2.6u ad=2.6400e-13 pd=2.0800e-06 as=2.6400e-13 ps=2.0800e-06 nf=1 m=1
XMpar20 a_3685_7685.t1 a_3685_7685.t0 vdd.t1 vdd.t0 pfet_03v3 w=0.66u l=1.35u ad=3.9600e-13 pd=2.5200e-06 as=3.9600e-13 ps=2.5200e-06 nf=1 m=1
XMpar21 a_6146_10739.t8 a_7054_5963.t8 out.t0 vss.t36 nfet_03v3 w=2.31u l=2.4u ad=1.3860e-12 pd=5.8200e-06 as=1.3860e-12 ps=5.8200e-06 nf=1 m=1
XMpar22 a_3685_7685.t2 a_3805_7477.t1 a_3805_7477.t2 vdd.t2 pfet_03v3 w=3.21u l=1u ad=1.9260e-12 pd=7.6200e-06 as=1.9260e-12 ps=7.6200e-06 nf=1 m=1
XMpar23 a_7054_7730.t3 a_3879_11046.t1 vdd.t20 vdd.t19 pfet_03v3 w=0.44u l=2.6u ad=2.6400e-13 pd=2.0800e-06 as=2.6400e-13 ps=2.0800e-06 nf=1 m=1
XMpar24 ib.t1 ib.t0 vss.t2 vss.t1 nfet_03v3 w=0.4u l=2.6u ad=2.4000e-13 pd=2.0000e-06 as=1.1200e-13 ps=9.6000e-07 nf=1 m=1
X42 out.t5 vss.t39 cap_mim_2f0fF c_width=15u c_length=15u
Rpar0 a_3601_2801.t0 a_3601_2801.t1 41.2309
Rpar1 a_3685_7685.t0 a_3685_7685.t1 56.6167
Rpar2 a_3685_7685.t0 a_3685_7685.t2 112.8278
Rpar3 a_3685_7685.t1 a_3685_7685.t2 54.0374
Rpar4 a_3805_7477.t0 a_3805_7477.t1 1444.9625
Rpar5 a_3805_7477.t0 a_3805_7477.t2 237.9864
Rpar6 a_3805_7477.t0 a_3805_7477.t3 310.1999
Rpar7 a_3805_7477.t1 a_3805_7477.t2 57.4428
Rpar8 a_3805_7477.t1 a_3805_7477.t3 293.4812
Rpar9 a_3805_7477.t2 a_3805_7477.t3 48.3366
Rpar10 a_3879_11046.t0 a_3879_11046.t1 68.4716
Rpar11 a_3879_11046.t0 a_3879_11046.t2 482.6220
Rpar12 a_3879_11046.t1 a_3879_11046.t2 30.4081
Rpar13 a_5279_1041.t0 a_5279_1041.t1 22.2933
Rpar14 a_5279_1041.t0 a_5279_1041.t6 274.0292
Rpar15 a_5279_1041.t0 a_5279_1041.t7 1151.6208
Rpar16 a_5279_1041.t0 a_5279_1041.t8 1419.1158
Rpar17 a_5279_1041.t1 a_5279_1041.t6 137.8363
Rpar18 a_5279_1041.t1 a_5279_1041.t7 579.2636
Rpar19 a_5279_1041.t1 a_5279_1041.t8 713.8132
Rpar20 a_5279_1041.t6 a_5279_1041.t7 145.6078
Rpar21 a_5279_1041.t6 a_5279_1041.t8 179.4291
Rpar22 a_5279_1041.t7 a_5279_1041.t8 72.2800
Rpar23 a_5554_4462.t0 a_5554_4462.t2 49.9929
Rpar24 a_5628_12554.t0 a_5628_12554.t1 197.1845
Rpar25 a_5628_12554.t0 a_5628_12554.t2 121.9326
Rpar26 a_5628_12554.t1 a_5628_12554.t2 19.1458
Rpar27 a_6146_10739.t0 a_6146_10739.t8 63.1448
Rpar28 a_6154_4462.t0 a_6154_4462.t2 217.4958
Rpar29 a_6154_4462.t0 a_6154_4462.t3 206.2151
Rpar30 a_6154_4462.t0 a_6154_4462.t4 98.7663
Rpar31 a_6154_4462.t2 a_6154_4462.t3 94.5636
Rpar32 a_6154_4462.t2 a_6154_4462.t4 141.6807
Rpar33 a_6154_4462.t3 a_6154_4462.t4 134.3322
Rpar34 a_7054_5963.t0 a_7054_5963.t1 22.1389
Rpar35 a_7054_5963.t0 a_7054_5963.t6 439.3912
Rpar36 a_7054_5963.t0 a_7054_5963.t7 646.1373
Rpar37 a_7054_5963.t0 a_7054_5963.t8 1076.9384
Rpar38 a_7054_5963.t1 a_7054_5963.t6 221.0131
Rpar39 a_7054_5963.t1 a_7054_5963.t7 325.0061
Rpar40 a_7054_5963.t1 a_7054_5963.t8 541.6984
Rpar41 a_7054_5963.t6 a_7054_5963.t7 87.8563
Rpar42 a_7054_5963.t6 a_7054_5963.t8 146.4331
Rpar43 a_7054_5963.t7 a_7054_5963.t8 107.9645
Rpar44 a_7054_7730.t0 a_7054_7730.t1 198.3859
Rpar45 a_7054_7730.t0 a_7054_7730.t3 156.4850
Rpar46 a_7054_7730.t0 a_7054_7730.t4 172.5728
Rpar47 a_7054_7730.t1 a_7054_7730.t3 148.4270
Rpar48 a_7054_7730.t1 a_7054_7730.t4 81.4253
Rpar49 a_7054_7730.t3 a_7054_7730.t4 129.1144
Rpar50 ib ib.t0 12.8406
Rpar51 ib ib.t1 20.0339
Rpar52 ib.t0 ib.t1 126.5899
Rpar53 inn inn.t0 3.8284
Rpar54 inp inp.t0 3.8769
Rpar55 out out.t0 82.3579
Rpar56 out out.t1 55.8877
Rpar57 out out.t5 15.6895
Rpar58 out.t0 out.t1 98.1227
Rpar59 out.t0 out.t5 787.5072
Rpar60 out.t1 out.t5 534.3992
Rpar61 vdd vdd.t0 129.7746
Rpar62 vdd vdd.t1 161.2852
Rpar63 vdd vdd.t11 1098.3418
Rpar64 vdd vdd.t19 290.4136
Rpar65 vdd vdd.t2 357.2395
Rpar66 vdd vdd.t20 232.9998
Rpar67 vdd.t0 vdd.t1 3.0024
Rpar68 vdd.t0 vdd.t11 437.2408
Rpar69 vdd.t0 vdd.t19 143.8501
Rpar70 vdd.t0 vdd.t2 139.0170
Rpar71 vdd.t0 vdd.t20 144.5786
Rpar72 vdd.t1 vdd.t11 594.8820
Rpar73 vdd.t1 vdd.t19 189.7107
Rpar74 vdd.t1 vdd.t2 169.1990
Rpar75 vdd.t1 vdd.t20 183.4289
Rpar76 vdd.t11 vdd.t19 25.8172
Rpar77 vdd.t11 vdd.t2 2325.5732
Rpar78 vdd.t11 vdd.t20 53.6294
Rpar79 vdd.t19 vdd.t2 583.4427
Rpar80 vdd.t19 vdd.t20 15.9912
Rpar81 vdd.t2 vdd.t20 449.1173
Rpar82 vss vss.t0 284.9531
Rpar83 vss vss.t1 76.8665
Rpar84 vss vss.t2 133.9446
Rpar85 vss vss.t36 1432.7695
Rpar86 vss vss.t37 304.5744
Rpar87 vss vss.t39 706.2618
Rpar88 vss.t0 vss.t1 1.6096
Rpar89 vss.t0 vss.t2 31.8372
Rpar90 vss.t0 vss.t36 2211.2576
Rpar91 vss.t0 vss.t37 44.6950
Rpar92 vss.t0 vss.t39 1131.1932
Rpar93 vss.t1 vss.t2 3.9142
Rpar94 vss.t1 vss.t36 189.0309
Rpar95 vss.t1 vss.t37 9.4320
Rpar96 vss.t1 vss.t39 99.9162
Rpar97 vss.t2 vss.t36 462.6628
Rpar98 vss.t2 vss.t37 34.5654
Rpar99 vss.t2 vss.t39 232.6043
Rpar100 vss.t36 vss.t37 2439.8476
Rpar101 vss.t36 vss.t39 174.1574
Rpar102 vss.t37 vss.t39 1252.0748
Cpar0 a_3601_2801.t0 vss 2.23470e-15
Cpar1 a_3601_2801.t1 vss 3.89114e-15
Cpar2 a_3685_7685.t0 vss 1.19102e-15
Cpar3 a_3685_7685.t1 vss 1.35047e-15
Cpar4 a_3685_7685.t2 vss 2.50708e-15
Cpar5 a_3805_7477.t0 vss 5.33061e-15
Cpar6 a_3805_7477.t1 vss 1.19520e-15
Cpar7 a_3805_7477.t2 vss 4.40596e-15
Cpar8 a_3805_7477.t3 vss 4.36467e-15
Cpar9 a_3879_11046.t0 vss 3.29186e-15
Cpar10 a_3879_11046.t1 vss 9.79869e-15
Cpar11 a_3879_11046.t2 vss 2.33967e-15
Cpar12 a_5279_1041.t0 vss 3.45468e-15
Cpar13 a_5279_1041.t1 vss 3.37493e-15
Cpar14 a_5279_1041.t6 vss 3.48591e-15
Cpar15 a_5279_1041.t7 vss 1.99648e-15
Cpar16 a_5279_1041.t8 vss 3.07153e-15
Cpar17 a_5554_4462.t0 vss 2.58919e-15
Cpar18 a_5554_4462.t2 vss 3.41109e-15
Cpar19 a_5628_12554.t0 vss 4.11623e-15
Cpar20 a_5628_12554.t1 vss 8.61150e-15
Cpar21 a_5628_12554.t2 vss 3.95819e-15
Cpar22 a_6146_10739.t0 vss 2.85774e-15
Cpar23 a_6146_10739.t8 vss 1.62156e-15
Cpar24 a_6154_4462.t0 vss 1.88959e-15
Cpar25 a_6154_4462.t2 vss 1.76923e-15
Cpar26 a_6154_4462.t3 vss 1.68227e-15
Cpar27 a_6154_4462.t4 vss 2.88825e-15
Cpar28 a_7054_5963.t0 vss 3.19493e-15
Cpar29 a_7054_5963.t1 vss 3.27820e-15
Cpar30 a_7054_5963.t6 vss 3.02770e-15
Cpar31 a_7054_5963.t7 vss 2.44889e-15
Cpar32 a_7054_5963.t8 vss 3.12717e-15
Cpar33 a_7054_7730.t0 vss 1.88350e-15
Cpar34 a_7054_7730.t1 vss 2.04993e-15
Cpar35 a_7054_7730.t3 vss 1.89681e-15
Cpar36 a_7054_7730.t4 vss 3.08579e-15
Cpar37 ib vdd 1.12270e-15
Cpar38 ib vss 4.37071e-14
Cpar39 ib.t0 vss 6.31561e-15
Cpar40 ib.t1 vss 4.52951e-17
Cpar41 inn inp 5.19700e-17
Cpar42 inn vss 3.08652e-15
Cpar43 inn.t0 vss 2.87548e-16
Cpar44 inp vss 2.99985e-15
Cpar45 inp.t0 vss 2.81522e-16
Cpar46 out vdd 3.28447e-15
Cpar47 out vss 8.73527e-15
Cpar48 out.t0 vss 1.37729e-16
Cpar49 out.t1 vss 1.83691e-16
Cpar50 out.t5 vss 6.07237e-15
Cpar51 vdd vss 9.52754e-14
Cpar52 vdd.t0 vss 2.01059e-14
Cpar53 vdd.t1 vss 1.13182e-14
Cpar54 vdd.t11 vss 3.12971e-15
Cpar55 vdd.t19 vss 7.84581e-15
Cpar56 vdd.t2 vss 3.33365e-15
Cpar57 vdd.t20 vss 5.83780e-15
.ends opamp_dut

Vdd vdd 0 3.300000
Vss vss 0 0
Ibias vdd ib 7.780000e-08
Vinp inp 0 DC 2.095300 AC 1 PWL(0 2.095300 5.827369e-08 2.095300 6.410105e-08 2.105300)
Rfb out inn 1m
Cload out 0 2.000000e-12
Xdut vdd vss inp inn out ib opamp_dut
.end
