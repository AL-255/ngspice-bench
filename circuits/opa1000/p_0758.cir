* opa1000[0758]: 200f/symmetrical_ota_1v8_i1u_subth (symmetrical_ota, VDD=1.8V, CL=0.2pF, Iref=0.2167uA)
.include "pdk_opa.inc"
.temp 27
.option gmin=1e-12 rshunt=1e12 reltol=1e-3 abstol=1e-12 vntol=1e-5 method=gear
* Post-PEX R+C extracted netlist for symmetrical_ota_1v8_i1u_subth
.subckt opamp_dut vdd vss inp inn out ib
XMpar0 ib.t1 ib.t0 vss.t23 vss.t22 nfet_03v3 w=1.73u l=5.25u ad=4.8440e-13 pd=2.2900e-06 as=4.8440e-13 ps=2.2900e-06 nf=1 m=2 par=2
XMpar1 a_2298_12049.t6 ib.t0 vss.t23 vss.t22 nfet_03v3 w=1.73u l=5.25u ad=4.8440e-13 pd=2.2900e-06 as=7.6120e-13 ps=3.4750e-06 nf=1 m=4 par=4
XMpar2 a_3668_10170.t1 a_3668_10170.t0 vss.t3 vss.t2 nfet_03v3 w=0.9u l=3.6u ad=2.5200e-13 pd=1.4600e-06 as=2.5200e-13 ps=1.4600e-06 nf=1 m=4 par=4
XMpar3 a_1248_6228.t0 inp.t0 a_2298_12049.t0 vss.t8 nfet_03v3 w=2u l=1.56u ad=5.6000e-13 pd=2.5600e-06 as=7.7333e-13 ps=3.4400e-06 nf=1 m=6 par=6
XMpar4 a_7326_8647.t7 a_7326_8647.t6 vdd.t1 vdd.t0 pfet_03v3 w=3.6u l=3.6u ad=1.0080e-12 pd=4.1600e-06 as=1.0080e-12 ps=4.1600e-06 nf=1 m=2 par=2
XMpar5 a_2298_12049.t0 inn.t0 a_7326_8647.t0 vss.t8 nfet_03v3 w=2u l=1.56u ad=7.7333e-13 pd=3.4400e-06 as=5.6000e-13 ps=2.5600e-06 nf=1 m=6 par=6
XMpar6 out.t0 a_1248_6228.t6 vdd.t1 vdd.t0 pfet_03v3 w=3.6u l=3.6u ad=1.0080e-12 pd=4.1600e-06 as=1.5840e-12 ps=6.2800e-06 nf=1 m=4 par=4
XMpar7 out.t1 a_3668_10170.t0 vss.t3 vss.t2 nfet_03v3 w=0.9u l=3.6u ad=2.5200e-13 pd=1.4600e-06 as=3.9600e-13 ps=2.2300e-06 nf=1 m=4 par=4
XMpar8 a_3668_10170.t8 a_7326_8647.t6 vdd.t1 vdd.t0 pfet_03v3 w=3.6u l=3.6u ad=1.0080e-12 pd=4.1600e-06 as=1.5840e-12 ps=6.2800e-06 nf=1 m=4 par=4
XMpar9 a_1248_6228.t7 a_1248_6228.t6 vdd.t1 vdd.t0 pfet_03v3 w=3.6u l=3.6u ad=1.0080e-12 pd=4.1600e-06 as=1.0080e-12 ps=4.1600e-06 nf=1 m=2 par=2
X14 out.t8 vss.t0 cap_mim_2f0fF c_width=17.91u c_length=17.91u
X28 out.t8 vss.t0 cap_mim_2f0fF c_width=17.91u c_length=17.91u
Rpar0 a_1248_6228.t0 a_1248_6228.t6 97.3109
Rpar1 a_1248_6228.t0 a_1248_6228.t7 71.7771
Rpar2 a_1248_6228.t6 a_1248_6228.t7 24.1883
Rpar3 a_2298_12049.t0 a_2298_12049.t6 61.3986
Rpar4 a_3668_10170.t0 a_3668_10170.t1 21.4791
Rpar5 a_3668_10170.t0 a_3668_10170.t8 222.0144
Rpar6 a_3668_10170.t1 a_3668_10170.t8 90.3326
Rpar7 a_7326_8647.t0 a_7326_8647.t6 97.3109
Rpar8 a_7326_8647.t0 a_7326_8647.t7 71.7771
Rpar9 a_7326_8647.t6 a_7326_8647.t7 24.1883
Rpar10 ib ib.t0 11.7258
Rpar11 ib ib.t1 12.0388
Rpar12 inn inn.t0 2.4262
Rpar13 inp inp.t0 2.4748
Rpar14 out out.t0 28.7211
Rpar15 out out.t1 82.2948
Rpar16 out out.t8 17.0422
Rpar17 out.t0 out.t1 111.3085
Rpar18 vdd vdd.t0 98.2390
Rpar19 vdd vdd.t1 154.8517
Rpar20 vdd.t0 vdd.t1 3.2964
Rpar21 vss vss.t0 74.3123
Rpar22 vss vss.t8 129.1729
Rpar23 vss vss.t2 237.0225
Rpar24 vss vss.t3 1597.7381
Rpar25 vss vss.t22 463.7871
Rpar26 vss vss.t23 1714.4207
Rpar27 vss.t0 vss.t8 192.1676
Rpar28 vss.t0 vss.t2 352.6130
Rpar29 vss.t0 vss.t3 2376.9190
Rpar30 vss.t0 vss.t22 689.9656
Rpar31 vss.t0 vss.t23 2550.5051
Rpar32 vss.t8 vss.t2 2.3877
Rpar33 vss.t8 vss.t3 11.2687
Rpar34 vss.t8 vss.t22 1.5694
Rpar35 vss.t8 vss.t23 11.0579
Rpar36 vss.t2 vss.t3 18.4920
Rpar37 vss.t2 vss.t22 6.5463
Rpar38 vss.t2 vss.t23 20.9788
Rpar39 vss.t3 vss.t22 31.0445
Rpar40 vss.t3 vss.t23 106.7577
Rpar41 vss.t22 vss.t23 22.2148
Cpar0 a_1248_6228.t0 vss 3.84738e-15
Cpar1 a_1248_6228.t6 vss 1.70999e-14
Cpar2 a_1248_6228.t7 vss 3.22302e-15
Cpar3 a_2298_12049.t0 vss 8.36947e-15
Cpar4 a_2298_12049.t6 vss 4.58435e-15
Cpar5 a_3668_10170.t0 vss 8.63603e-15
Cpar6 a_3668_10170.t1 vss 2.37691e-15
Cpar7 a_3668_10170.t8 vss 3.69333e-15
Cpar8 a_7326_8647.t0 vss 3.91262e-15
Cpar9 a_7326_8647.t6 vss 1.73899e-14
Cpar10 a_7326_8647.t7 vss 3.27767e-15
Cpar11 ib vdd 1.19370e-16
Cpar12 ib vss 2.25586e-14
Cpar13 ib.t0 vss 3.20299e-15
Cpar14 ib.t1 vss 1.34145e-16
Cpar15 inn inp 5.12600e-17
Cpar16 inn vdd 1.90370e-16
Cpar17 inn vss 6.35434e-15
Cpar18 inn.t0 vss 1.28857e-15
Cpar19 inp vdd 4.79300e-17
Cpar20 inp vss 6.43404e-15
Cpar21 inp.t0 vss 1.21656e-15
Cpar22 out vdd 5.20518e-15
Cpar23 out vss 2.26702e-14
Cpar24 out.t0 vss 2.88174e-16
Cpar25 out.t1 vss 2.68760e-16
Cpar26 out.t8 vss 1.28869e-14
Cpar27 vdd vss 9.28008e-14
Cpar28 vdd.t0 vss 2.28712e-14
Cpar29 vdd.t1 vss 1.46818e-14
.ends opamp_dut

Vdd vdd 0 1.800000
Vss vss 0 0
Ibias vdd ib 2.167000e-07
Vinp inp 0 DC 0.895000 AC 1 PWL(0 0.895000 1.003848e-07 0.895000 1.104233e-07 0.905000)
Rfb out inn 1m
Cload out 0 2.000000e-13
Xdut vdd vss inp inn out ib opamp_dut
.end
