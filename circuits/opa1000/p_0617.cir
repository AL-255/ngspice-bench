* opa1000[0617]: 200f/pmos_miller_3v3_i10u_subth (pmos_miller, VDD=3.3V, CL=0.2pF, Iref=1.25uA)
.include "pdk_opa.inc"
.temp 27
.option gmin=1e-12 rshunt=1e12 reltol=1e-3 abstol=1e-12 vntol=1e-5 method=gear
* Post-PEX R+C extracted netlist for pmos_miller_3v3_i10u_subth
.subckt opamp_dut vdd vss inp inn out ib
XMpar0 a_1221_1086.t2 inp.t0 a_2468_9146.t0 vdd.t2 pfet_03v3 w=1.96u l=1.13u ad=5.7043e-13 pd=2.6097e-06 as=6.1368e-13 ps=2.7890e-06 nf=1 m=58 par=58
XMpar1 a_2468_9146.t0 inn.t0 a_7356_2984.t0 vdd.t2 pfet_03v3 w=1.96u l=1.13u ad=6.1368e-13 pd=2.7890e-06 as=5.7043e-13 ps=2.6097e-06 nf=1 m=58 par=58
XMpar2 out.t3 a_1607_5198.t0 vdd.t1 vdd.t0 pfet_03v3 w=10u l=1.88u ad=3.4400e-12 pd=1.2688e-05 as=2.8000e-12 ps=1.0560e-05 nf=1 m=10 par=10
XMpar3 out.t0 a_1221_1086.t61 vss.t1 vss.t0 nfet_03v3 w=2.39u l=0.94u ad=6.6920e-13 pd=2.9500e-06 as=8.2216e-13 ps=3.5560e-06 nf=1 m=10 par=10
XMpar4 a_1607_5198.t1 a_1607_5198.t0 vdd.t1 vdd.t0 pfet_03v3 w=10u l=1.88u ad=2.8000e-12 pd=1.0560e-05 as=2.8000e-12 ps=1.0560e-05 nf=1 m=2 par=2
XMpar5 a_1607_5198.t4 ib.t0 vss.t28 vss.t27 nfet_03v3 w=3.17u l=1.88u ad=8.8760e-13 pd=3.7300e-06 as=8.8760e-13 ps=3.7300e-06 nf=1 m=2 par=2
XMpar6 ib.t1 ib.t0 vss.t28 vss.t27 nfet_03v3 w=3.17u l=1.88u ad=1.9020e-12 pd=7.5400e-06 as=8.8760e-13 ps=3.7300e-06 nf=1 m=2 par=2
XMpar7 a_2468_9146.t116 a_1607_5198.t0 vdd.t1 vdd.t0 pfet_03v3 w=10u l=1.88u ad=2.8000e-12 pd=1.0560e-05 as=2.8000e-12 ps=1.0560e-05 nf=1 m=4 par=4
XMpar8 a_1221_1086.t0 a_7356_2984.t58 vss.t1 vss.t0 nfet_03v3 w=2.39u l=0.94u ad=1.4340e-12 pd=5.9800e-06 as=6.6920e-13 ps=2.9500e-06 nf=1 m=2 par=2
XMpar9 a_7356_2984.t59 a_7356_2984.t58 vss.t1 vss.t0 nfet_03v3 w=2.39u l=0.94u ad=6.6920e-13 pd=2.9500e-06 as=6.6920e-13 ps=2.9500e-06 nf=1 m=2 par=2
X17 a_9037_1290.t1 out.t18 cap_mim_2f0fF c_width=19.63u c_length=19.62u
X99 a_1221_1086.t60 a_9037_1290.t0 vss.t26 ppolyf_u_1k r_width=1u r_length=10.53u
Rpar0 a_1221_1086.t0 a_1221_1086.t2 503.0659
Rpar1 a_1221_1086.t0 a_1221_1086.t60 61.5122
Rpar2 a_1221_1086.t0 a_1221_1086.t61 149.0554
Rpar3 a_1221_1086.t2 a_1221_1086.t60 429.8288
Rpar4 a_1221_1086.t2 a_1221_1086.t61 94.8668
Rpar5 a_1221_1086.t60 a_1221_1086.t61 127.3557
Rpar6 a_1607_5198.t0 a_1607_5198.t1 25.8490
Rpar7 a_1607_5198.t0 a_1607_5198.t4 156.9007
Rpar8 a_1607_5198.t1 a_1607_5198.t4 115.1880
Rpar9 a_2468_9146.t0 a_2468_9146.t116 100.6164
Rpar10 a_7356_2984.t0 a_7356_2984.t58 268.4652
Rpar11 a_7356_2984.t0 a_7356_2984.t59 123.8254
Rpar12 a_7356_2984.t58 a_7356_2984.t59 25.8661
Rpar13 a_9037_1290.t0 a_9037_1290.t1 68.8756
Rpar14 ib ib.t0 13.8164
Rpar15 ib ib.t1 3.8491
Rpar16 inn inn.t0 1.5769
Rpar17 inp inp.t0 1.5769
Rpar18 out out.t0 147.2670
Rpar19 out out.t3 2.1584
Rpar20 out out.t18 120.9709
Rpar21 out.t0 out.t18 105.0697
Rpar22 vdd vdd.t0 60.8998
Rpar23 vdd vdd.t1 546.8952
Rpar24 vdd vdd.t2 20.9970
Rpar25 vdd.t0 vdd.t1 5.5880
Rpar26 vdd.t0 vdd.t2 189.2176
Rpar27 vdd.t1 vdd.t2 1699.2216
Rpar28 vss vss.t0 33.4606
Rpar29 vss vss.t1 92.9280
Rpar30 vss vss.t26 339.8676
Rpar31 vss vss.t27 145.5717
Rpar32 vss vss.t28 237.6653
Rpar33 vss.t0 vss.t1 4.2626
Rpar34 vss.t0 vss.t26 19.6651
Rpar35 vss.t0 vss.t27 7.2061
Rpar36 vss.t0 vss.t28 12.5590
Rpar37 vss.t1 vss.t26 43.3734
Rpar38 vss.t1 vss.t27 19.4536
Rpar39 vss.t1 vss.t28 79.7089
Rpar40 vss.t26 vss.t27 1290.2221
Rpar41 vss.t26 vss.t28 1417.7547
Rpar42 vss.t27 vss.t28 27.2000
Cpar0 a_1221_1086.t0 vss 4.54378e-15
Cpar1 a_1221_1086.t2 vss 3.42486e-14
Cpar2 a_1221_1086.t60 vss 3.43692e-15
Cpar3 a_1221_1086.t61 vss 1.26326e-14
Cpar4 a_1607_5198.t0 vss 3.95165e-14
Cpar5 a_1607_5198.t1 vss 5.05138e-15
Cpar6 a_1607_5198.t4 vss 2.71098e-15
Cpar7 a_2468_9146.t0 vss 7.96902e-14
Cpar8 a_2468_9146.t116 vss 1.72571e-14
Cpar9 a_7356_2984.t0 vss 4.01292e-14
Cpar10 a_7356_2984.t58 vss 5.19272e-15
Cpar11 a_7356_2984.t59 vss 4.50019e-15
Cpar12 a_9037_1290.t0 vss 9.73400e-17
Cpar13 a_9037_1290.t1 vss 4.06167e-15
Cpar14 ib out 5.74700e-17
Cpar15 ib vss 8.99284e-15
Cpar16 ib.t0 vss 1.06081e-15
Cpar17 ib.t1 vss 2.68150e-16
Cpar18 inn inp 1.43640e-16
Cpar19 inn out 1.03100e-17
Cpar20 inn vdd 3.21550e-14
Cpar21 inn vss 5.36554e-15
Cpar22 inn.t0 vss 4.98781e-14
Cpar23 inp vdd 3.24484e-14
Cpar24 inp vss 5.31504e-15
Cpar25 inp.t0 vss 5.01134e-14
Cpar26 out vdd 1.20311e-14
Cpar27 out vss 2.43479e-14
Cpar28 out.t0 vss 4.35986e-15
Cpar29 out.t18 vss 8.94436e-15
Cpar30 out.t3 vss 8.94590e-15
Cpar31 vdd vss 2.88706e-13
Cpar32 vdd.t0 vss 3.91487e-14
Cpar33 vdd.t1 vss 1.09674e-14
Cpar34 vdd.t2 vss 8.07346e-14
.ends opamp_dut

Vdd vdd 0 3.300000
Vss vss 0 0
Ibias vdd ib 1.250000e-06
Vinp inp 0 DC 1.480000 AC 1 PWL(0 1.480000 1.687175e-08 1.480000 1.855892e-08 1.490000)
Rfb out inn 1m
Cload out 0 2.000000e-13
Xdut vdd vss inp inn out ib opamp_dut
.end
