* opa1000[0782]: 200f/symmetrical_ota_3v3_1u_10u_weak (symmetrical_ota, VDD=3.3V, CL=0.2pF, Iref=0.875uA)
.include "pdk_opa.inc"
.temp 27
.option gmin=1e-12 rshunt=1e12 reltol=1e-3 abstol=1e-12 vntol=1e-5 method=gear
* Post-PEX R+C extracted netlist for symmetrical_ota_3v3_1u_10u_weak
.subckt opamp_dut vdd vss inp inn out ib
XMpar0 a_1423_1249.t1 a_1423_1249.t0 vss.t1 vss.t0 nfet_03v3 w=0.45u l=1.63u ad=1.2600e-13 pd=1.0100e-06 as=1.2600e-13 ps=1.0100e-06 nf=1 m=4 par=4
XMpar1 a_1777_6637.t0 inp.t0 a_4394_3206.t0 vss.t7 nfet_03v3 w=1.7u l=1.6u ad=1.0200e-12 pd=4.6000e-06 as=4.7600e-13 ps=2.2600e-06 nf=1 m=2 par=2
XMpar2 a_1097_1041.t0 inn.t0 a_1777_6637.t0 vss.t7 nfet_03v3 w=1.7u l=1.6u ad=4.7600e-13 pd=2.2600e-06 as=1.0200e-12 ps=4.6000e-06 nf=1 m=2 par=2
XMpar3 a_4394_3206.t3 a_4394_3206.t2 vdd.t1 vdd.t0 pfet_03v3 w=1.88u l=1.63u ad=5.2640e-13 pd=2.4400e-06 as=5.2640e-13 ps=2.4400e-06 nf=1 m=2 par=2
XMpar4 ib.t1 ib.t0 vss.t14 vss.t13 nfet_03v3 w=0.81u l=2u ad=2.2680e-13 pd=1.3700e-06 as=2.2680e-13 ps=1.3700e-06 nf=1 m=2 par=2
XMpar5 out.t2 a_1423_1249.t0 vss.t1 vss.t0 nfet_03v3 w=0.45u l=1.63u ad=1.2600e-13 pd=1.0100e-06 as=1.9800e-13 ps=1.5550e-06 nf=1 m=4 par=4
XMpar6 a_1097_1041.t3 a_1097_1041.t2 vdd.t1 vdd.t0 pfet_03v3 w=1.88u l=1.63u ad=5.2640e-13 pd=2.4400e-06 as=5.2640e-13 ps=2.4400e-06 nf=1 m=2 par=2
XMpar7 out.t0 a_4394_3206.t2 vdd.t1 vdd.t0 pfet_03v3 w=1.88u l=1.63u ad=5.2640e-13 pd=2.4400e-06 as=8.2720e-13 ps=3.7000e-06 nf=1 m=4 par=4
XMpar8 a_1777_6637.t4 ib.t0 vss.t14 vss.t13 nfet_03v3 w=0.81u l=2u ad=2.2680e-13 pd=1.3700e-06 as=3.5640e-13 ps=2.0950e-06 nf=1 m=4 par=4
XMpar9 a_1423_1249.t8 a_1097_1041.t2 vdd.t1 vdd.t0 pfet_03v3 w=1.88u l=1.63u ad=5.2640e-13 pd=2.4400e-06 as=8.2720e-13 ps=3.7000e-06 nf=1 m=4 par=4
X19 out.t8 vss.t2 cap_mim_2f0fF c_width=9.22u c_length=9.22u
Rpar0 a_1097_1041.t0 a_1097_1041.t2 165.3004
Rpar1 a_1097_1041.t0 a_1097_1041.t3 132.3289
Rpar2 a_1097_1041.t2 a_1097_1041.t3 23.6748
Rpar3 a_1423_1249.t0 a_1423_1249.t1 21.8826
Rpar4 a_1423_1249.t0 a_1423_1249.t8 99.3546
Rpar5 a_1423_1249.t1 a_1423_1249.t8 74.2837
Rpar6 a_1777_6637.t0 a_1777_6637.t4 57.8719
Rpar7 a_4394_3206.t0 a_4394_3206.t2 145.2765
Rpar8 a_4394_3206.t0 a_4394_3206.t3 116.2991
Rpar9 a_4394_3206.t2 a_4394_3206.t3 23.9372
Rpar10 ib ib.t0 11.6027
Rpar11 ib ib.t1 13.9228
Rpar12 inn inn.t0 6.1724
Rpar13 inp inp.t0 6.2210
Rpar14 out out.t0 57.6657
Rpar15 out out.t2 7.5532
Rpar16 out out.t8 74.7269
Rpar17 out.t0 out.t8 168.0286
Rpar18 vdd vdd.t0 96.1366
Rpar19 vdd vdd.t1 163.0872
Rpar20 vdd.t0 vdd.t1 3.1533
Rpar21 vss vss.t0 83.5647
Rpar22 vss vss.t1 445.4537
Rpar23 vss vss.t7 253.3958
Rpar24 vss vss.t13 311.1964
Rpar25 vss vss.t14 1095.4526
Rpar26 vss vss.t2 789.6701
Rpar27 vss.t0 vss.t1 9.0061
Rpar28 vss.t0 vss.t7 1.6592
Rpar29 vss.t0 vss.t13 3.1771
Rpar30 vss.t0 vss.t14 19.3500
Rpar31 vss.t0 vss.t2 77.0465
Rpar32 vss.t1 vss.t7 29.4656
Rpar33 vss.t1 vss.t13 34.5321
Rpar34 vss.t1 vss.t14 131.3126
Rpar35 vss.t1 vss.t2 383.1031
Rpar36 vss.t7 vss.t13 10.1178
Rpar37 vss.t7 vss.t14 26.7540
Rpar38 vss.t7 vss.t2 206.9549
Rpar39 vss.t13 vss.t14 14.4756
Rpar40 vss.t13 vss.t2 209.2310
Rpar41 vss.t14 vss.t2 575.6034
Cpar0 a_1097_1041.t0 vss 2.33031e-15
Cpar1 a_1097_1041.t2 vss 8.49110e-15
Cpar2 a_1097_1041.t3 vss 2.72783e-15
Cpar3 a_1423_1249.t0 vss 3.53110e-15
Cpar4 a_1423_1249.t1 vss 1.28615e-15
Cpar5 a_1423_1249.t8 vss 1.94190e-15
Cpar6 a_1777_6637.t0 vss 2.73925e-15
Cpar7 a_1777_6637.t4 vss 2.49232e-15
Cpar8 a_4394_3206.t0 vss 2.39074e-15
Cpar9 a_4394_3206.t2 vss 8.87253e-15
Cpar10 a_4394_3206.t3 vss 2.85090e-15
Cpar11 ib vss 1.08977e-14
Cpar12 ib.t0 vss 1.42504e-15
Cpar13 ib.t1 vss 5.79703e-17
Cpar14 inn inp 5.19900e-17
Cpar15 inn vss 2.34631e-15
Cpar16 inn.t0 vss 3.91721e-16
Cpar17 inp vss 2.36845e-15
Cpar18 inp.t0 vss 3.98335e-16
Cpar19 out vdd 6.51251e-15
Cpar20 out vss 9.92228e-15
Cpar21 out.t0 vss 1.07837e-15
Cpar22 out.t2 vss 9.48244e-17
Cpar23 out.t8 vss 8.21923e-15
Cpar24 vdd vss 5.54964e-14
Cpar25 vdd.t0 vss 1.43216e-14
Cpar26 vdd.t1 vss 7.72457e-15
.ends opamp_dut

Vdd vdd 0 3.300000
Vss vss 0 0
Ibias vdd ib 8.750000e-07
Vinp inp 0 DC 1.645000 AC 1 PWL(0 1.645000 9.460446e-09 1.645000 1.040649e-08 1.655000)
Rfb out inn 1m
Cload out 0 2.000000e-13
Xdut vdd vss inp inn out ib opamp_dut
.end
