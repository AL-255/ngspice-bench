* opa1000[0217]: 2p/folded_cascode_nmos_1v8_i2u_subth (folded_cascode_nmos, VDD=1.8V, CL=2.0pF, Iref=0.5778uA)
.include "pdk_opa.inc"
.temp 27
.option gmin=1e-12 rshunt=1e12 reltol=1e-3 abstol=1e-12 vntol=1e-5 method=gear
* Post-PEX R+C extracted netlist for folded_cascode_nmos_1v8_i2u_subth
.subckt opamp_dut vdd vss inp inn out ib
XMpar0 a_1522_10243.t4 inp.t0 a_1946_10243.t12 vss.t21 nfet_03v3 w=3.01u l=1.52u ad=9.6320e-13 pd=4.0262e-06 as=8.4280e-13 ps=3.5700e-06 nf=1 m=64 par=64
XMpar1 a_1522_10243.t4 inn.t0 a_8494_5951.t12 vss.t21 nfet_03v3 w=3.01u l=1.52u ad=9.6320e-13 pd=4.0262e-06 as=8.4280e-13 ps=3.5700e-06 nf=1 m=64 par=64
XMpar2 a_1946_10243.t76 a_4868_3408.t2 vdd.t25 vdd.t24 pfet_03v3 w=6.29u l=2.04u ad=1.7612e-12 pd=6.8500e-06 as=2.7676e-12 ps=1.0315e-05 nf=1 m=4 par=4
XMpar3 a_4868_3408.t3 a_4868_3408.t2 vdd.t25 vdd.t24 pfet_03v3 w=6.29u l=2.04u ad=1.7612e-12 pd=6.8500e-06 as=3.7740e-12 ps=1.3780e-05 nf=1 m=2 par=2
XMpar4 a_8494_5951.t76 a_4868_3408.t2 vdd.t25 vdd.t24 pfet_03v3 w=6.29u l=2.04u ad=1.7612e-12 pd=6.8500e-06 as=2.7676e-12 ps=1.0315e-05 nf=1 m=4 par=4
XMpar5 a_8494_5951.t0 ib.t10 out.t0 vdd.t0 pfet_03v3 w=1.86u l=0.78u ad=6.2000e-13 pd=2.8367e-06 as=5.2080e-13 ps=2.4200e-06 nf=1 m=12 par=12
XMpar6 a_1946_10243.t0 ib.t10 a_5238_5951.t0 vdd.t0 pfet_03v3 w=1.86u l=0.78u ad=6.2000e-13 pd=2.8367e-06 as=5.2080e-13 ps=2.4200e-06 nf=1 m=12 par=12
XMpar7 ib.t1 ib.t0 vss.t1 vss.t0 nfet_03v3 w=3.34u l=3.9u ad=2.0040e-12 pd=7.8800e-06 as=9.3520e-13 ps=3.9000e-06 nf=1 m=2 par=2
XMpar8 a_1522_10243.t0 ib.t0 vss.t1 vss.t0 nfet_03v3 w=3.34u l=3.9u ad=9.3520e-13 pd=3.9000e-06 as=9.3520e-13 ps=3.9000e-06 nf=1 m=4 par=4
XMpar9 out.t6 a_5238_5951.t12 vss.t1 vss.t0 nfet_03v3 w=3.34u l=3.9u ad=9.3520e-13 pd=3.9000e-06 as=9.3520e-13 ps=3.9000e-06 nf=1 m=2 par=2
XMpar10 a_5238_5951.t13 a_5238_5951.t12 vss.t1 vss.t0 nfet_03v3 w=3.34u l=3.9u ad=2.0040e-12 pd=7.8800e-06 as=9.3520e-13 ps=3.9000e-06 nf=1 m=2 par=2
XMpar11 a_4868_3408.t0 ib.t0 vss.t1 vss.t0 nfet_03v3 w=3.34u l=3.9u ad=9.3520e-13 pd=3.9000e-06 as=9.3520e-13 ps=3.9000e-06 nf=1 m=2 par=2
X10 out.t14 vss.t20 cap_mim_2f0fF c_width=6.71u c_length=6.71u
Rpar0 a_1522_10243.t0 a_1522_10243.t4 43.9602
Rpar1 a_1946_10243.t0 a_1946_10243.t12 95.8842
Rpar2 a_1946_10243.t0 a_1946_10243.t76 80.2196
Rpar3 a_1946_10243.t12 a_1946_10243.t76 95.9395
Rpar4 a_4868_3408.t0 a_4868_3408.t2 115.5765
Rpar5 a_4868_3408.t0 a_4868_3408.t3 65.2266
Rpar6 a_4868_3408.t2 a_4868_3408.t3 26.6190
Rpar7 a_5238_5951.t0 a_5238_5951.t12 263.6824
Rpar8 a_5238_5951.t0 a_5238_5951.t13 85.9424
Rpar9 a_5238_5951.t12 a_5238_5951.t13 17.5372
Rpar10 a_8494_5951.t0 a_8494_5951.t12 120.2232
Rpar11 a_8494_5951.t0 a_8494_5951.t76 95.7720
Rpar12 a_8494_5951.t12 a_8494_5951.t76 87.0520
Rpar13 ib ib.t0 11.5885
Rpar14 ib ib.t1 4.5496
Rpar15 ib ib.t10 53.4982
Rpar16 inn inn.t0 1.3911
Rpar17 inp inp.t0 1.3911
Rpar18 out out.t0 2.3990
Rpar19 out out.t6 135.0233
Rpar20 out out.t14 73.2797
Rpar21 out.t6 out.t14 99.1009
Rpar22 vdd vdd.t0 129.0373
Rpar23 vdd vdd.t24 227.0153
Rpar24 vdd vdd.t25 83.9116
Rpar25 vdd.t0 vdd.t24 44.1143
Rpar26 vdd.t0 vdd.t25 26.4796
Rpar27 vdd.t24 vdd.t25 4.9840
Rpar28 vss vss.t0 68.2292
Rpar29 vss vss.t1 140.2450
Rpar30 vss vss.t20 90.0539
Rpar31 vss vss.t21 306.9594
Rpar32 vss.t0 vss.t1 4.1095
Rpar33 vss.t0 vss.t20 221.2647
Rpar34 vss.t0 vss.t21 105.1315
Rpar35 vss.t1 vss.t20 454.8095
Rpar36 vss.t1 vss.t21 216.3329
Rpar37 vss.t20 vss.t21 995.4584
Cpar0 a_1522_10243.t0 vss 7.05816e-15
Cpar1 a_1522_10243.t4 vss 9.08417e-14
Cpar2 a_1946_10243.t0 vss 8.33121e-15
Cpar3 a_1946_10243.t12 vss 4.74074e-14
Cpar4 a_1946_10243.t76 vss 7.14092e-15
Cpar5 a_4868_3408.t0 vss 4.09137e-15
Cpar6 a_4868_3408.t2 vss 2.36997e-14
Cpar7 a_4868_3408.t3 vss 4.40715e-15
Cpar8 a_5238_5951.t0 vss 3.84011e-15
Cpar9 a_5238_5951.t12 vss 6.72647e-15
Cpar10 a_5238_5951.t13 vss 3.12784e-15
Cpar11 a_8494_5951.t0 vss 8.85437e-15
Cpar12 a_8494_5951.t12 vss 5.14151e-14
Cpar13 a_8494_5951.t76 vss 8.06708e-15
Cpar14 ib out 1.05457e-15
Cpar15 ib vdd 1.37889e-14
Cpar16 ib vss 3.07564e-14
Cpar17 ib.t0 vss 1.35059e-14
Cpar18 ib.t1 vss 1.19456e-15
Cpar19 ib.t10 vss 8.04795e-15
Cpar20 inn inp 2.06730e-16
Cpar21 inn vdd 2.73150e-16
Cpar22 inn vss 4.57466e-14
Cpar23 inn.t0 vss 3.16593e-14
Cpar24 inp vdd 1.35350e-16
Cpar25 inp vss 4.59726e-14
Cpar26 inp.t0 vss 3.15466e-14
Cpar27 out vdd 3.05929e-15
Cpar28 out vss 1.15755e-14
Cpar29 out.t0 vss 1.99815e-15
Cpar30 out.t14 vss 1.05523e-14
Cpar31 out.t6 vss 2.57465e-15
Cpar32 vdd vss 1.09475e-13
Cpar33 vdd.t0 vss 1.77745e-14
Cpar34 vdd.t24 vss 1.61548e-14
Cpar35 vdd.t25 vss 1.27673e-14
.ends opamp_dut

Vdd vdd 0 1.800000
Vss vss 0 0
Ibias vdd ib 5.778000e-07
Vinp inp 0 DC 0.985000 AC 1 PWL(0 0.985000 8.603567e-08 0.985000 9.463923e-08 0.995000)
Rfb out inn 1m
Cload out 0 2.000000e-12
Xdut vdd vss inp inn out ib opamp_dut
.end
