* opa1000[0678]: 200f/rail_to_rail_1v8_1u_10u_subth (rail_to_rail, VDD=1.8V, CL=0.2pF, Iref=0.8125uA)
.include "pdk_opa.inc"
.temp 27
.option gmin=1e-12 rshunt=1e12 reltol=1e-3 abstol=1e-12 vntol=1e-5 method=gear
* Post-PEX R+C extracted netlist for rail_to_rail_1v8_1u_10u_subth
.subckt opamp_dut vdd vss inp inn out ib
XMpar0 a_5459_9418.t6 ib.t0 vss.t9 vss.t2 nfet_03v3 w=3.8u l=3u ad=2.2800e-12 pd=8.8000e-06 as=1.0640e-12 ps=4.3600e-06 nf=1 m=2 par=2
XMpar1 a_3051_7442.t0 inp.t0 a_5459_9418.t0 vss.t2 nfet_03v3 w=2.12u l=1u ad=5.9360e-13 pd=2.6800e-06 as=8.1973e-13 ps=3.6000e-06 nf=1 m=6 par=6
XMpar2 a_3283_1204.t0 inn.t6 a_7832_6361.t0 vdd.t4 pfet_03v3 w=2.25u l=1u ad=6.9750e-13 pd=3.0809e-06 as=6.7500e-13 ps=2.9906e-06 nf=1 m=64 par=64
XMpar3 a_3051_7442.t6 a_9092_996.t8 vdd.t30 vdd.t29 pfet_03v3 w=6.65u l=0.6u ad=3.9900e-12 pd=1.4500e-05 as=1.8620e-12 ps=7.2100e-06 nf=1 m=2 par=2
XMpar4 a_3283_1204.t0 inp.t6 a_5402_13743.t4 vdd.t4 pfet_03v3 w=2.25u l=1u ad=6.9750e-13 pd=3.0809e-06 as=6.7500e-13 ps=2.9906e-06 nf=1 m=64 par=64
XMpar5 out.t0 a_3051_7442.t11 vdd.t30 vdd.t29 pfet_03v3 w=6.65u l=0.6u ad=1.8620e-12 pd=7.2100e-06 as=2.3940e-12 ps=9.0325e-06 nf=1 m=8 par=8
XMpar6 a_3283_1204.t128 a_3403_996.t2 vdd.t1 vdd.t0 pfet_03v3 w=10u l=3u ad=6.0000e-12 pd=2.1200e-05 as=2.8000e-12 ps=1.0560e-05 nf=1 m=2 par=2
XMpar7 a_9092_996.t6 a_5402_13743.t0 vss.t1 vss.t0 nfet_03v3 w=1.92u l=3.75u ad=5.3760e-13 pd=2.4800e-06 as=5.3760e-13 ps=2.4800e-06 nf=1 m=2 par=2
XMpar8 out.t5 ib.t0 vss.t9 vss.t2 nfet_03v3 w=3.8u l=3u ad=1.0640e-12 pd=4.3600e-06 as=1.3680e-12 ps=5.4700e-06 nf=1 m=8 par=8
XMpar9 a_5402_13743.t1 a_5402_13743.t0 vss.t1 vss.t0 nfet_03v3 w=1.92u l=3.75u ad=1.1520e-12 pd=5.0400e-06 as=5.3760e-13 ps=2.4800e-06 nf=1 m=2 par=2
XMpar10 a_3403_996.t3 a_3403_996.t2 vdd.t1 vdd.t0 pfet_03v3 w=10u l=3u ad=2.8000e-12 pd=1.0560e-05 as=2.8000e-12 ps=1.0560e-05 nf=1 m=2 par=2
XMpar11 a_3051_7442.t9 a_7832_6361.t64 vss.t1 vss.t0 nfet_03v3 w=1.92u l=3.75u ad=1.1520e-12 pd=5.0400e-06 as=5.3760e-13 ps=2.4800e-06 nf=1 m=2 par=2
XMpar12 ib.t1 ib.t0 vss.t9 vss.t2 nfet_03v3 w=3.8u l=3u ad=2.2800e-12 pd=8.8000e-06 as=1.0640e-12 ps=4.3600e-06 nf=1 m=2 par=2
XMpar13 a_5459_9418.t0 inn.t0 a_9092_996.t0 vss.t2 nfet_03v3 w=2.12u l=1u ad=8.1973e-13 pd=3.6000e-06 as=5.9360e-13 ps=2.6800e-06 nf=1 m=6 par=6
XMpar14 a_7832_6361.t65 a_7832_6361.t64 vss.t1 vss.t0 nfet_03v3 w=1.92u l=3.75u ad=5.3760e-13 pd=2.4800e-06 as=5.3760e-13 ps=2.4800e-06 nf=1 m=2 par=2
XMpar15 a_3403_996.t0 ib.t0 vss.t9 vss.t2 nfet_03v3 w=3.8u l=3u ad=1.0640e-12 pd=4.3600e-06 as=1.0640e-12 ps=4.3600e-06 nf=1 m=2 par=2
XMpar16 a_9092_996.t9 a_9092_996.t8 vdd.t30 vdd.t29 pfet_03v3 w=6.65u l=0.6u ad=1.8620e-12 pd=7.2100e-06 as=1.8620e-12 ps=7.2100e-06 nf=1 m=2 par=2
X28 a_3051_7962.t0 a_6299_7442.t0 vss.t45 ppolyf_u_1k r_width=1u r_length=15.58u
X54 a_3051_7442.t8 a_6299_7442.t0 vss.t45 ppolyf_u_1k r_width=1u r_length=15.58u
X128 a_3051_7962.t1 out.t12 cap_mim_2f0fF c_width=15u c_length=15u
Rpar0 a_3051_7442.t0 a_3051_7442.t9 1234.0818
Rpar1 a_3051_7442.t0 a_3051_7442.t11 187.7936
Rpar2 a_3051_7442.t0 a_3051_7442.t6 379.9362
Rpar3 a_3051_7442.t0 a_3051_7442.t8 124.1045
Rpar4 a_3051_7442.t9 a_3051_7442.t11 361.0511
Rpar5 a_3051_7442.t9 a_3051_7442.t6 121.3288
Rpar6 a_3051_7442.t9 a_3051_7442.t8 710.5290
Rpar7 a_3051_7442.t11 a_3051_7442.t6 111.1567
Rpar8 a_3051_7442.t11 a_3051_7442.t8 108.1231
Rpar9 a_3051_7442.t6 a_3051_7442.t8 218.7503
Rpar10 a_3051_7962.t0 a_3051_7962.t1 83.2138
Rpar11 a_3283_1204.t0 a_3283_1204.t128 66.8428
Rpar12 a_3403_996.t0 a_3403_996.t2 226.5260
Rpar13 a_3403_996.t0 a_3403_996.t3 106.0405
Rpar14 a_3403_996.t2 a_3403_996.t3 25.6943
Rpar15 a_5402_13743.t0 a_5402_13743.t1 17.7105
Rpar16 a_5402_13743.t0 a_5402_13743.t4 447.8654
Rpar17 a_5402_13743.t1 a_5402_13743.t4 193.0210
Rpar18 a_5459_9418.t0 a_5459_9418.t6 49.4448
Rpar19 a_7832_6361.t0 a_7832_6361.t64 207.1756
Rpar20 a_7832_6361.t0 a_7832_6361.t65 129.1309
Rpar21 a_7832_6361.t64 a_7832_6361.t65 24.4593
Rpar22 a_9092_996.t0 a_9092_996.t8 1354.6081
Rpar23 a_9092_996.t0 a_9092_996.t9 287.1990
Rpar24 a_9092_996.t0 a_9092_996.t6 152.0660
Rpar25 a_9092_996.t8 a_9092_996.t9 37.6499
Rpar26 a_9092_996.t8 a_9092_996.t6 378.7029
Rpar27 a_9092_996.t9 a_9092_996.t6 80.2912
Rpar28 ib ib.t0 12.2242
Rpar29 ib ib.t1 6.7097
Rpar30 inn inn.t0 3.3417
Rpar31 inn inn.t6 35.6179
Rpar32 inp inp.t0 3.3903
Rpar33 inp inp.t6 35.5693
Rpar34 out out.t0 95.1911
Rpar35 out out.t5 129.3162
Rpar36 out out.t12 20.0189
Rpar37 out.t0 out.t5 243.9622
Rpar38 out.t0 out.t12 1210.8981
Rpar39 out.t5 out.t12 1644.9938
Rpar40 vdd vdd.t0 213.9488
Rpar41 vdd vdd.t1 640.1170
Rpar42 vdd vdd.t4 26.1795
Rpar43 vdd vdd.t29 937.0246
Rpar44 vdd vdd.t30 1683.5715
Rpar45 vdd.t0 vdd.t1 9.7120
Rpar46 vdd.t0 vdd.t4 608.8764
Rpar47 vdd.t0 vdd.t29 73.7748
Rpar48 vdd.t0 vdd.t30 132.5527
Rpar49 vdd.t1 vdd.t4 1821.7075
Rpar50 vdd.t1 vdd.t29 220.7281
Rpar51 vdd.t1 vdd.t30 396.5868
Rpar52 vdd.t4 vdd.t29 2666.6762
Rpar53 vdd.t4 vdd.t30 4791.2722
Rpar54 vdd.t29 vdd.t30 3.7903
Rpar55 vss vss.t0 230.9893
Rpar56 vss vss.t1 366.3347
Rpar57 vss vss.t9 487.3285
Rpar58 vss vss.t2 36.9754
Rpar59 vss vss.t45 364.8471
Rpar60 vss.t0 vss.t1 20.6006
Rpar61 vss.t0 vss.t9 38.1413
Rpar62 vss.t0 vss.t2 1.7723
Rpar63 vss.t0 vss.t45 43.1482
Rpar64 vss.t1 vss.t9 110.8611
Rpar65 vss.t1 vss.t2 4.9837
Rpar66 vss.t1 vss.t45 126.0783
Rpar67 vss.t9 vss.t2 5.2585
Rpar68 vss.t9 vss.t45 53.8788
Rpar69 vss.t2 vss.t45 5.5458
Cpar0 a_3051_7442.t0 vss 4.94340e-15
Cpar1 a_3051_7442.t11 vss 8.45816e-15
Cpar2 a_3051_7442.t6 vss 8.07672e-15
Cpar3 a_3051_7442.t8 vss 3.85996e-15
Cpar4 a_3051_7442.t9 vss 6.17618e-15
Cpar5 a_3051_7962.t0 vss 1.60160e-16
Cpar6 a_3051_7962.t1 vss 3.04938e-15
Cpar7 a_3283_1204.t0 vss 8.75711e-14
Cpar8 a_3283_1204.t128 vss 1.41777e-14
Cpar9 a_3403_996.t0 vss 5.10762e-15
Cpar10 a_3403_996.t2 vss 1.58667e-14
Cpar11 a_3403_996.t3 vss 4.92978e-15
Cpar12 a_5402_13743.t0 vss 1.28929e-14
Cpar13 a_5402_13743.t1 vss 8.63669e-15
Cpar14 a_5402_13743.t4 vss 4.46666e-14
Cpar15 a_5459_9418.t0 vss 9.86173e-15
Cpar16 a_5459_9418.t6 vss 9.63189e-15
Cpar17 a_6299_7442.t0 vss 3.14400e-17
Cpar18 a_7832_6361.t0 vss 4.13787e-14
Cpar19 a_7832_6361.t64 vss 1.22730e-14
Cpar20 a_7832_6361.t65 vss 4.37552e-15
Cpar21 a_9092_996.t0 vss 7.35682e-15
Cpar22 a_9092_996.t6 vss 5.69517e-15
Cpar23 a_9092_996.t8 vss 3.62170e-15
Cpar24 a_9092_996.t9 vss 5.56325e-15
Cpar25 ib inn 1.78900e-17
Cpar26 ib inp 1.35300e-17
Cpar27 ib out 2.21077e-15
Cpar28 ib vss 3.02576e-14
Cpar29 ib.t0 vss 1.16389e-14
Cpar30 ib.t1 vss 1.23014e-15
Cpar31 inn inp 2.81010e-16
Cpar32 inn vdd 3.29810e-14
Cpar33 inn vss 1.01317e-14
Cpar34 inn.t0 vss 2.59110e-15
Cpar35 inn.t6 vss 5.49770e-14
Cpar36 inp vdd 3.30178e-14
Cpar37 inp vss 1.02024e-14
Cpar38 inp.t0 vss 2.58858e-15
Cpar39 inp.t6 vss 5.43270e-14
Cpar40 out vdd 1.14079e-14
Cpar41 out vss 2.22260e-14
Cpar42 out.t0 vss 8.32144e-15
Cpar43 out.t12 vss 7.29541e-15
Cpar44 out.t5 vss 9.21463e-15
Cpar45 vdd vss 2.98760e-13
Cpar46 vdd.t0 vss 1.54891e-14
Cpar47 vdd.t1 vss 6.79953e-15
Cpar48 vdd.t29 vss 1.43233e-14
Cpar49 vdd.t30 vss 9.80229e-15
Cpar50 vdd.t4 vss 9.04923e-14
.ends opamp_dut

Vdd vdd 0 1.800000
Vss vss 0 0
Ibias vdd ib 8.125000e-07
Vinp inp 0 DC 0.895000 AC 1 PWL(0 0.895000 2.060812e-08 0.895000 2.266893e-08 0.905000)
Rfb out inn 1m
Cload out 0 2.000000e-13
Xdut vdd vss inp inn out ib opamp_dut
.end
