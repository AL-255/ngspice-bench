* opa1000[0506]: 200f/pmos_5t_1v8_0p1u_1u_weak (pmos_5t, VDD=1.8V, CL=0.2pF, Iref=0.115uA)
.include "pdk_opa.inc"
.temp 27
.option gmin=1e-12 rshunt=1e12 reltol=1e-3 abstol=1e-12 vntol=1e-5 method=gear
* Post-PEX R+C extracted netlist for pmos_5t_1v8_0p1u_1u_weak
.subckt opamp_dut vdd vss inp inn out ib
XMpar0 a_1654_7923.t1 a_1654_7923.t0 vdd.t3 vdd.t2 pfet_03v3 w=1.89u l=7.5u ad=1.1340e-12 pd=4.9800e-06 as=5.2920e-13 ps=2.4500e-06 nf=1 m=2 par=2
XMpar1 a_2474_4386.t0 inn.t0 out.t0 vdd.t0 pfet_03v3 w=1.67u l=6.5u ad=1.0020e-12 pd=4.5400e-06 as=4.6760e-13 ps=2.2300e-06 nf=1 m=6 par=6
XMpar2 a_2772_2791.t7 a_2772_2791.t6 vss.t1 vss.t0 nfet_03v3 w=0.52u l=6.5u ad=3.1200e-13 pd=2.2400e-06 as=1.4560e-13 ps=1.0800e-06 nf=1 m=1
XMpar3 ib.t1 ib.t0 vss.t7 vss.t6 nfet_03v3 w=0.48u l=7.5u ad=2.8800e-13 pd=2.1600e-06 as=1.3440e-13 ps=1.0400e-06 nf=1 m=2 par=2
XMpar4 a_2474_4386.t0 inp.t0 a_2772_2791.t0 vdd.t0 pfet_03v3 w=1.67u l=6.5u ad=1.0020e-12 pd=4.5400e-06 as=4.6760e-13 ps=2.2300e-06 nf=1 m=6 par=6
XMpar5 a_2772_2791.t7 a_2772_2791.t6 vss.t1 vss.t8 nfet_03v3 w=0.52u l=6.5u ad=3.1200e-13 pd=2.2400e-06 as=1.4560e-13 ps=1.0800e-06 nf=1 m=1
XMpar6 a_2474_4386.t6 a_1654_7923.t0 vdd.t3 vdd.t2 pfet_03v3 w=1.89u l=7.5u ad=5.2920e-13 pd=2.4500e-06 as=9.8280e-13 ps=4.3475e-06 nf=1 m=8 par=8
XMpar7 out.t3 a_2772_2791.t6 vss.t1 vss.t0 nfet_03v3 w=0.52u l=6.5u ad=1.4560e-13 pd=1.0800e-06 as=1.4560e-13 ps=1.0800e-06 nf=1 m=2 par=2
XMpar8 a_1654_7923.t4 ib.t0 vss.t7 vss.t6 nfet_03v3 w=0.48u l=7.5u ad=1.3440e-13 pd=1.0400e-06 as=1.3440e-13 ps=1.0400e-06 nf=1 m=1
XMpar9 a_1654_7923.t4 ib.t0 vss.t7 vss.t8 nfet_03v3 w=0.48u l=7.5u ad=1.3440e-13 pd=1.0400e-06 as=1.3440e-13 ps=1.0400e-06 nf=1 m=1
Rpar0 a_1654_7923.t0 a_1654_7923.t1 13.2685
Rpar1 a_1654_7923.t0 a_1654_7923.t4 128.6898
Rpar2 a_1654_7923.t1 a_1654_7923.t4 145.6168
Rpar3 a_2474_4386.t0 a_2474_4386.t6 48.5261
Rpar4 a_2772_2791.t0 a_2772_2791.t6 142.4344
Rpar5 a_2772_2791.t0 a_2772_2791.t7 104.2436
Rpar6 a_2772_2791.t6 a_2772_2791.t7 21.4972
Rpar7 ib ib.t0 11.5637
Rpar8 ib ib.t1 8.6272
Rpar9 inn inn.t0 2.8202
Rpar10 inp inp.t0 2.8202
Rpar11 out out.t0 49.5596
Rpar12 out out.t3 16.4898
Rpar13 out.t0 out.t3 246.8967
Rpar14 vdd vdd.t0 151.5551
Rpar15 vdd vdd.t3 255.2197
Rpar16 vdd vdd.t2 23.9903
Rpar17 vdd.t0 vdd.t3 750.4869
Rpar18 vdd.t0 vdd.t2 70.5448
Rpar19 vdd.t3 vdd.t2 12.6925
Rpar20 vss vss.t0 86.5750
Rpar21 vss vss.t1 186.2612
Rpar22 vss vss.t6 49.5411
Rpar23 vss vss.t7 127.5176
Rpar24 vss vss.t8 211.6481
Rpar25 vss.t0 vss.t1 33.5063
Rpar26 vss.t0 vss.t6 13.0998
Rpar27 vss.t0 vss.t7 43.4536
Rpar28 vss.t0 vss.t8 48.2895
Rpar29 vss.t1 vss.t6 27.7448
Rpar30 vss.t1 vss.t7 97.0052
Rpar31 vss.t1 vss.t8 91.2676
Rpar32 vss.t6 vss.t7 23.9920
Rpar33 vss.t6 vss.t8 32.9971
Rpar34 vss.t7 vss.t8 104.9649
Cpar0 a_1654_7923.t0 vss 4.99842e-14
Cpar1 a_1654_7923.t1 vss 8.88078e-15
Cpar2 a_1654_7923.t4 vss 4.97421e-15
Cpar3 a_2474_4386.t0 vss 2.42269e-14
Cpar4 a_2474_4386.t6 vss 2.10394e-14
Cpar5 a_2772_2791.t0 vss 5.72600e-15
Cpar6 a_2772_2791.t6 vss 9.06680e-15
Cpar7 a_2772_2791.t7 vss 2.57807e-15
Cpar8 ib vss 2.10775e-14
Cpar9 ib.t0 vss 2.31943e-15
Cpar10 ib.t1 vss 1.30700e-16
Cpar11 inn inp 1.54840e-16
Cpar12 inn out 3.82675e-15
Cpar13 inn vdd 1.54835e-14
Cpar14 inn vss 4.16404e-15
Cpar15 inn.t0 vss 1.83117e-14
Cpar16 inp vdd 1.53064e-14
Cpar17 inp vss 4.13696e-15
Cpar18 inp.t0 vss 1.81872e-14
Cpar19 out vdd 4.97179e-15
Cpar20 out vss 9.51422e-15
Cpar21 out.t0 vss 1.12062e-14
Cpar22 out.t3 vss 1.05935e-15
Cpar23 vdd vss 1.95994e-13
Cpar24 vdd.t0 vss 4.19088e-14
Cpar25 vdd.t2 vss 4.77292e-14
Cpar26 vdd.t3 vss 8.05938e-15
.ends opamp_dut

Vdd vdd 0 1.800000
Vss vss 0 0
Ibias vdd ib 1.150000e-07
Vinp inp 0 DC 0.805000 AC 1 PWL(0 0.805000 4.675984e-08 0.805000 5.143582e-08 0.815000)
Rfb out inn 1m
Cload out 0 2.000000e-13
Xdut vdd vss inp inn out ib opamp_dut
.end
