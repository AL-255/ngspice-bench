* opa1000[0922]: 200f/telescopic_pmos_1v8_i200n_weak (telescopic_pmos, VDD=1.8V, CL=0.2pF, Iref=0.052uA)
.include "pdk_opa.inc"
.temp 27
.option gmin=1e-12 rshunt=1e12 reltol=1e-3 abstol=1e-12 vntol=1e-5 method=gear
* Post-PEX R+C extracted netlist for telescopic_pmos_1v8_i200n_weak
.subckt opamp_dut vdd vss inp inn out ib
XMpar0 a_1796_6025.t0 inn.t0 a_4654_1205.t0 vdd.t3 pfet_03v3 w=2.24u l=5.2u ad=1.3440e-12 pd=5.6800e-06 as=6.2720e-13 ps=2.8000e-06 nf=1 m=2 par=2
XMpar1 a_1196_5817.t3 a_1196_5817.t2 vdd.t1 vdd.t0 pfet_03v3 w=0.4u l=3u ad=1.1200e-13 pd=9.6000e-07 as=1.1200e-13 ps=9.6000e-07 nf=1 m=2 par=2
XMpar2 a_1796_6025.t4 a_1196_5817.t2 vdd.t1 vdd.t0 pfet_03v3 w=0.4u l=3u ad=1.1200e-13 pd=9.6000e-07 as=1.4400e-13 ps=1.2200e-06 nf=1 m=8 par=8
XMpar3 a_4654_1205.t2 vss.t20 out.t1 vdd.t2 pfet_03v3 w=0.94u l=2.24u ad=5.6400e-13 pd=3.0800e-06 as=2.6320e-13 ps=1.5000e-06 nf=1 m=2 par=2
XMpar4 ib.t1 ib.t0 vss.t4 vss.t3 nfet_03v3 w=0.4u l=3u ad=2.4000e-13 pd=2.0000e-06 as=1.1200e-13 ps=9.6000e-07 nf=1 m=2 par=2
XMpar5 a_1796_6025.t0 inp.t0 a_3194_9167.t0 vdd.t3 pfet_03v3 w=2.24u l=5.2u ad=1.3440e-12 pd=5.6800e-06 as=6.2720e-13 ps=2.8000e-06 nf=1 m=2 par=2
XMpar6 a_1672_2723.t2 a_1792_2515.t6 vss.t12 vss.t11 nfet_03v3 w=0.4u l=6.5u ad=2.4000e-13 pd=2.0000e-06 as=1.1200e-13 ps=9.6000e-07 nf=1 m=2 par=2
XMpar7 a_4076_4295.t0 a_1792_2515.t0 out.t0 vss.t0 nfet_03v3 w=0.4u l=2.24u ad=2.4000e-13 pd=2.0000e-06 as=1.1200e-13 ps=9.6000e-07 nf=1 m=2 par=2
XMpar8 a_1792_2515.t4 vss.t20 a_3194_9167.t2 vdd.t2 pfet_03v3 w=0.94u l=2.24u ad=2.6320e-13 pd=1.5000e-06 as=5.6400e-13 ps=3.0800e-06 nf=1 m=2 par=2
XMpar9 a_1196_5817.t0 ib.t0 vss.t4 vss.t3 nfet_03v3 w=0.4u l=3u ad=1.1200e-13 pd=9.6000e-07 as=1.1200e-13 ps=9.6000e-07 nf=1 m=2 par=2
XMpar10 a_1672_2723.t0 a_1792_2515.t0 a_1792_2515.t1 vss.t0 nfet_03v3 w=0.4u l=2.24u ad=2.4000e-13 pd=2.0000e-06 as=2.4000e-13 ps=2.0000e-06 nf=1 m=2 par=2
XMpar11 a_4076_4295.t1 a_1792_2515.t6 vss.t12 vss.t11 nfet_03v3 w=0.4u l=6.5u ad=1.1200e-13 pd=9.6000e-07 as=1.1200e-13 ps=9.6000e-07 nf=1 m=2 par=2
Rpar0 a_1196_5817.t0 a_1196_5817.t2 69.1571
Rpar1 a_1196_5817.t0 a_1196_5817.t3 104.7475
Rpar2 a_1196_5817.t2 a_1196_5817.t3 31.7272
Rpar3 a_1672_2723.t0 a_1672_2723.t2 77.2492
Rpar4 a_1792_2515.t0 a_1792_2515.t1 23.9063
Rpar5 a_1792_2515.t0 a_1792_2515.t4 413.3173
Rpar6 a_1792_2515.t0 a_1792_2515.t6 180.8040
Rpar7 a_1792_2515.t1 a_1792_2515.t4 304.3739
Rpar8 a_1792_2515.t1 a_1792_2515.t6 133.1471
Rpar9 a_1792_2515.t4 a_1792_2515.t6 66.0831
Rpar10 a_1796_6025.t0 a_1796_6025.t4 59.1091
Rpar11 a_3194_9167.t0 a_3194_9167.t2 63.1882
Rpar12 a_4076_4295.t0 a_4076_4295.t1 65.4139
Rpar13 a_4654_1205.t0 a_4654_1205.t2 63.1882
Rpar14 ib ib.t0 16.2559
Rpar15 ib ib.t1 9.0272
Rpar16 ib.t0 ib.t1 98.6297
Rpar17 inn inn.t0 3.9331
Rpar18 inp inp.t0 3.9817
Rpar19 out out.t0 15.2669
Rpar20 out out.t1 73.2331
Rpar21 out.t0 out.t1 753.9710
Rpar22 vdd vdd.t0 144.5387
Rpar23 vdd vdd.t1 434.7260
Rpar24 vdd vdd.t2 730.7925
Rpar25 vdd vdd.t3 27.1297
Rpar26 vdd.t0 vdd.t1 6.5919
Rpar27 vdd.t0 vdd.t2 94.7132
Rpar28 vdd.t0 vdd.t3 95.0462
Rpar29 vdd.t1 vdd.t2 284.8669
Rpar30 vdd.t1 vdd.t3 285.8683
Rpar31 vdd.t2 vdd.t3 480.5566
Rpar32 vss vss.t0 249.1260
Rpar33 vss vss.t4 418.4855
Rpar34 vss vss.t11 165.1420
Rpar35 vss vss.t12 325.3917
Rpar36 vss vss.t20 46.5846
Rpar37 vss vss.t3 402.9183
Rpar38 vss.t0 vss.t4 2482.2303
Rpar39 vss.t0 vss.t11 15.8530
Rpar40 vss.t0 vss.t12 32.7539
Rpar41 vss.t0 vss.t20 292.1081
Rpar42 vss.t0 vss.t3 2398.3891
Rpar43 vss.t4 vss.t11 1644.5315
Rpar44 vss.t4 vss.t12 3234.6961
Rpar45 vss.t4 vss.t20 406.4663
Rpar46 vss.t4 vss.t3 18.1934
Rpar47 vss.t11 vss.t12 21.4856
Rpar48 vss.t11 vss.t20 193.6341
Rpar49 vss.t11 vss.t3 1589.0390
Rpar50 vss.t12 vss.t20 381.5312
Rpar51 vss.t12 vss.t3 3125.8833
Rpar52 vss.t20 vss.t3 391.3398
Cpar0 a_1196_5817.t0 vss 3.25907e-15
Cpar1 a_1196_5817.t2 vss 2.13582e-14
Cpar2 a_1196_5817.t3 vss 3.50046e-15
Cpar3 a_1672_2723.t0 vss 3.51153e-15
Cpar4 a_1672_2723.t2 vss 4.84708e-15
Cpar5 a_1792_2515.t0 vss 1.81632e-15
Cpar6 a_1792_2515.t1 vss 8.94731e-16
Cpar7 a_1792_2515.t4 vss 6.68857e-16
Cpar8 a_1792_2515.t6 vss 4.13045e-15
Cpar9 a_1796_6025.t0 vss 9.48303e-15
Cpar10 a_1796_6025.t4 vss 7.88551e-15
Cpar11 a_3194_9167.t0 vss 4.62693e-15
Cpar12 a_3194_9167.t2 vss 4.15998e-15
Cpar13 a_4076_4295.t0 vss 4.16857e-15
Cpar14 a_4076_4295.t1 vss 4.24042e-15
Cpar15 a_4654_1205.t0 vss 3.62284e-15
Cpar16 a_4654_1205.t2 vss 3.25720e-15
Cpar17 ib inp 1.85500e-17
Cpar18 ib vdd 6.80500e-17
Cpar19 ib vss 1.01545e-14
Cpar20 ib.t0 vss 1.24918e-15
Cpar21 ib.t1 vss 8.54177e-17
Cpar22 inn inp 5.19700e-17
Cpar23 inn vdd 5.11840e-15
Cpar24 inn vss 2.48457e-15
Cpar25 inn.t0 vss 4.11623e-15
Cpar26 inp vdd 4.97303e-15
Cpar27 inp vss 2.45534e-15
Cpar28 inp.t0 vss 4.07592e-15
Cpar29 out vdd 3.25296e-15
Cpar30 out vss 7.64751e-15
Cpar31 out.t0 vss 5.51443e-16
Cpar32 out.t1 vss 3.24660e-15
Cpar33 vdd vss 1.01070e-13
Cpar34 vdd.t0 vss 1.62857e-14
Cpar35 vdd.t1 vss 5.81451e-15
Cpar36 vdd.t2 vss 7.99316e-15
Cpar37 vdd.t3 vss 1.26816e-14
.ends opamp_dut

Vdd vdd 0 1.800000
Vss vss 0 0
Ibias vdd ib 5.200000e-08
Vinp inp 0 DC 0.805000 AC 1 PWL(0 0.805000 8.707707e-08 0.805000 9.578478e-08 0.815000)
Rfb out inn 1m
Cload out 0 2.000000e-13
Xdut vdd vss inp inn out ib opamp_dut
.end
