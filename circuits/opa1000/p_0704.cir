* opa1000[0704]: 200f/rail_to_rail_3v3_10u_100u_subth (rail_to_rail, VDD=3.3V, CL=0.2pF, Iref=8.125uA)
.include "pdk_opa.inc"
.temp 27
.option gmin=1e-12 rshunt=1e12 reltol=1e-3 abstol=1e-12 vntol=1e-5 method=gear
* Post-PEX R+C extracted netlist for rail_to_rail_3v3_10u_100u_subth
.subckt opamp_dut vdd vss inp inn out ib
XMpar0 a_4739_14387.t2 inn.t64 a_8712_17175.t2 vss.t2 nfet_03v3 w=2.06u l=0.6u ad=6.8667e-13 pd=3.0700e-06 as=5.7680e-13 ps=2.6200e-06 nf=1 m=12 par=12
XMpar1 a_1287_17428.t2 inn.t0 a_8252_4456.t0 vdd.t18 pfet_03v3 w=2.19u l=0.6u ad=6.5700e-13 pd=2.9269e-06 as=6.3510e-13 ps=2.8384e-06 nf=1 m=64 par=64
XMpar2 out.t0 a_992_12346.t17 vdd.t1 vdd.t0 pfet_03v3 w=10u l=0.35u ad=2.8000e-12 pd=1.0560e-05 as=3.6000e-12 ps=1.3220e-05 nf=1 m=8 par=8
XMpar3 a_1287_17428.t2 inp.t0 a_3794_8407.t4 vdd.t18 pfet_03v3 w=2.19u l=0.6u ad=6.5700e-13 pd=2.9269e-06 as=6.3510e-13 ps=2.8384e-06 nf=1 m=64 par=64
XMpar4 out.t3 ib.t0 vss.t3 vss.t2 nfet_03v3 w=5.48u l=0.6u ad=1.5344e-12 pd=6.0400e-06 as=1.9728e-12 ps=7.5700e-06 nf=1 m=8 par=8
XMpar5 a_8712_17175.t0 a_3794_8407.t0 vss.t1 vss.t0 nfet_03v3 w=8.72u l=1.5u ad=2.4416e-12 pd=9.2800e-06 as=2.4416e-12 ps=9.2800e-06 nf=1 m=2 par=2
XMpar6 a_4739_14387.t2 inp.t64 a_992_12346.t0 vss.t2 nfet_03v3 w=2.06u l=0.6u ad=6.8667e-13 pd=3.0700e-06 as=5.7680e-13 ps=2.6200e-06 nf=1 m=12 par=12
XMpar7 a_4739_14387.t0 ib.t0 vss.t3 vss.t2 nfet_03v3 w=5.48u l=0.6u ad=3.2880e-12 pd=1.2160e-05 as=1.5344e-12 ps=6.0400e-06 nf=1 m=2 par=2
XMpar8 a_8712_17175.t15 a_8712_17175.t14 vdd.t1 vdd.t0 pfet_03v3 w=10u l=0.35u ad=2.8000e-12 pd=1.0560e-05 as=2.8000e-12 ps=1.0560e-05 nf=1 m=2 par=2
XMpar9 a_1287_17428.t0 a_1407_17220.t2 vdd.t7 vdd.t6 pfet_03v3 w=10u l=0.6u ad=6.0000e-12 pd=2.1200e-05 as=2.8000e-12 ps=1.0560e-05 nf=1 m=2 par=2
XMpar10 a_8252_4456.t65 a_8252_4456.t64 vss.t1 vss.t0 nfet_03v3 w=8.72u l=1.5u ad=2.4416e-12 pd=9.2800e-06 as=2.4416e-12 ps=9.2800e-06 nf=1 m=2 par=2
XMpar11 ib.t1 ib.t0 vss.t3 vss.t2 nfet_03v3 w=5.48u l=0.6u ad=3.2880e-12 pd=1.2160e-05 as=1.5344e-12 ps=6.0400e-06 nf=1 m=2 par=2
XMpar12 a_1407_17220.t0 ib.t0 vss.t3 vss.t2 nfet_03v3 w=5.48u l=0.6u ad=1.5344e-12 pd=6.0400e-06 as=1.5344e-12 ps=6.0400e-06 nf=1 m=2 par=2
XMpar13 a_992_12346.t14 a_8712_17175.t14 vdd.t1 vdd.t0 pfet_03v3 w=10u l=0.35u ad=6.0000e-12 pd=2.1200e-05 as=2.8000e-12 ps=1.0560e-05 nf=1 m=2 par=2
XMpar14 a_992_12346.t12 a_8252_4456.t64 vss.t1 vss.t0 nfet_03v3 w=8.72u l=1.5u ad=5.2320e-12 pd=1.8640e-05 as=2.4416e-12 ps=9.2800e-06 nf=1 m=2 par=2
XMpar15 a_1407_17220.t3 a_1407_17220.t2 vdd.t7 vdd.t6 pfet_03v3 w=10u l=0.6u ad=2.8000e-12 pd=1.0560e-05 as=2.8000e-12 ps=1.0560e-05 nf=1 m=2 par=2
XMpar16 a_3794_8407.t1 a_3794_8407.t0 vss.t1 vss.t0 nfet_03v3 w=8.72u l=1.5u ad=5.2320e-12 pd=1.8640e-05 as=2.4416e-12 ps=9.2800e-06 nf=1 m=2 par=2
X3 a_1625_6908.t1 out.t15 cap_mim_2f0fF c_width=19.85u c_length=19.84u
X40 a_992_12346.t16 a_1625_6908.t0 vss.t63 ppolyf_u_1k r_width=1u r_length=2.19u
Rpar0 a_1287_17428.t0 a_1287_17428.t2 95.2554
Rpar1 a_1407_17220.t0 a_1407_17220.t2 303.8905
Rpar2 a_1407_17220.t0 a_1407_17220.t3 54.0792
Rpar3 a_1407_17220.t2 a_1407_17220.t3 44.8197
Rpar4 a_1625_6908.t0 a_1625_6908.t1 56.9989
Rpar5 a_3794_8407.t0 a_3794_8407.t1 22.8272
Rpar6 a_3794_8407.t0 a_3794_8407.t4 479.4920
Rpar7 a_3794_8407.t1 a_3794_8407.t4 87.7137
Rpar8 a_4739_14387.t0 a_4739_14387.t2 59.0385
Rpar9 a_8252_4456.t0 a_8252_4456.t64 266.0819
Rpar10 a_8252_4456.t0 a_8252_4456.t65 81.9474
Rpar11 a_8252_4456.t64 a_8252_4456.t65 27.8940
Rpar12 a_8712_17175.t0 a_8712_17175.t2 90.7854
Rpar13 a_8712_17175.t0 a_8712_17175.t14 2891.1049
Rpar14 a_8712_17175.t0 a_8712_17175.t15 370.1579
Rpar15 a_8712_17175.t2 a_8712_17175.t14 537.1310
Rpar16 a_8712_17175.t2 a_8712_17175.t15 68.7707
Rpar17 a_8712_17175.t14 a_8712_17175.t15 59.1555
Rpar18 a_992_12346.t0 a_992_12346.t12 564.0558
Rpar19 a_992_12346.t0 a_992_12346.t14 208.5230
Rpar20 a_992_12346.t0 a_992_12346.t16 489.9072
Rpar21 a_992_12346.t0 a_992_12346.t17 152.9476
Rpar22 a_992_12346.t12 a_992_12346.t14 625.5905
Rpar23 a_992_12346.t12 a_992_12346.t16 77.7646
Rpar24 a_992_12346.t12 a_992_12346.t17 224.3904
Rpar25 a_992_12346.t14 a_992_12346.t16 543.3528
Rpar26 a_992_12346.t14 a_992_12346.t17 169.6331
Rpar27 a_992_12346.t16 a_992_12346.t17 194.8929
Rpar28 ib ib.t0 29.0262
Rpar29 ib ib.t1 4.9049
Rpar30 ib.t0 ib.t1 50.8933
Rpar31 inn inn.t0 53.7916
Rpar32 inn inn.t64 3.0333
Rpar33 inp inp.t0 63.6754
Rpar34 inp inp.t64 3.0819
Rpar35 out out.t0 197.9057
Rpar36 out out.t3 362.3745
Rpar37 out out.t15 20.2148
Rpar38 out.t0 out.t3 35.8006
Rpar39 out.t0 out.t15 1939.5551
Rpar40 out.t3 out.t15 3551.4155
Rpar41 vdd vdd.t0 57.7328
Rpar42 vdd vdd.t1 119.6082
Rpar43 vdd vdd.t18 238.4045
Rpar44 vdd vdd.t6 105.7669
Rpar45 vdd vdd.t7 195.0499
Rpar46 vdd.t0 vdd.t1 3.9148
Rpar47 vdd.t0 vdd.t18 237.0649
Rpar48 vdd.t0 vdd.t6 181.8134
Rpar49 vdd.t0 vdd.t7 335.2909
Rpar50 vdd.t1 vdd.t18 483.5231
Rpar51 vdd.t1 vdd.t6 384.3828
Rpar52 vdd.t1 vdd.t7 708.8590
Rpar53 vdd.t18 vdd.t6 1160.7826
Rpar54 vdd.t18 vdd.t7 2140.6553
Rpar55 vdd.t6 vdd.t7 10.2007
Rpar56 vss vss.t0 45.1384
Rpar57 vss vss.t1 86.7763
Rpar58 vss vss.t2 240.1676
Rpar59 vss vss.t3 4500.2511
Rpar60 vss vss.t63 252.0998
Rpar61 vss.t0 vss.t1 5.1693
Rpar62 vss.t0 vss.t2 99.0984
Rpar63 vss.t0 vss.t63 92.1047
Rpar64 vss.t1 vss.t2 192.5955
Rpar65 vss.t1 vss.t63 166.7008
Rpar66 vss.t2 vss.t3 3.8895
Rpar67 vss.t2 vss.t63 648.2970
Cpar0 a_1287_17428.t0 vss 1.48241e-14
Cpar1 a_1287_17428.t2 vss 8.45919e-14
Cpar2 a_1407_17220.t0 vss 4.22163e-15
Cpar3 a_1407_17220.t2 vss 4.27750e-15
Cpar4 a_1407_17220.t3 vss 5.28876e-15
Cpar5 a_1625_6908.t0 vss 3.33000e-17
Cpar6 a_1625_6908.t1 vss 2.43534e-15
Cpar7 a_3794_8407.t0 vss 1.12343e-14
Cpar8 a_3794_8407.t1 vss 1.07839e-14
Cpar9 a_3794_8407.t4 vss 3.42008e-14
Cpar10 a_4739_14387.t0 vss 7.23236e-15
Cpar11 a_4739_14387.t2 vss 1.35801e-14
Cpar12 a_8252_4456.t0 vss 3.55596e-14
Cpar13 a_8252_4456.t64 vss 1.24444e-14
Cpar14 a_8252_4456.t65 vss 7.05700e-15
Cpar15 a_8712_17175.t0 vss 5.41088e-15
Cpar16 a_8712_17175.t14 vss 2.20275e-15
Cpar17 a_8712_17175.t15 vss 5.42770e-15
Cpar18 a_8712_17175.t2 vss 8.32127e-15
Cpar19 a_992_12346.t0 vss 7.22411e-15
Cpar20 a_992_12346.t12 vss 7.47895e-15
Cpar21 a_992_12346.t14 vss 8.76066e-15
Cpar22 a_992_12346.t16 vss 3.13238e-15
Cpar23 a_992_12346.t17 vss 7.89823e-15
Cpar24 ib out 1.56975e-15
Cpar25 ib vdd 4.46400e-17
Cpar26 ib vss 1.39606e-14
Cpar27 ib.t0 vss 4.82367e-15
Cpar28 ib.t1 vss 1.68260e-15
Cpar29 inn inp 1.53010e-16
Cpar30 inn vdd 2.55992e-14
Cpar31 inn vss 1.58857e-14
Cpar32 inn.t0 vss 3.78745e-14
Cpar33 inn.t64 vss 3.27320e-15
Cpar34 inp out 4.40610e-16
Cpar35 inp vdd 2.56385e-14
Cpar36 inp vss 1.39950e-14
Cpar37 inp.t0 vss 3.86603e-14
Cpar38 inp.t64 vss 3.33871e-15
Cpar39 out vdd 1.91618e-14
Cpar40 out vss 2.61811e-14
Cpar41 out.t0 vss 1.19012e-14
Cpar42 out.t15 vss 1.05086e-14
Cpar43 out.t3 vss 7.69938e-15
Cpar44 vdd vss 2.41133e-13
Cpar45 vdd.t0 vss 1.87080e-14
Cpar46 vdd.t1 vss 1.28309e-14
Cpar47 vdd.t18 vss 8.01293e-14
Cpar48 vdd.t6 vss 8.78550e-15
Cpar49 vdd.t7 vss 5.17313e-15
.ends opamp_dut

Vdd vdd 0 3.300000
Vss vss 0 0
Ibias vdd ib 8.125000e-06
Vinp inp 0 DC 1.645000 AC 1 PWL(0 1.645000 3.122321e-09 1.645000 3.434553e-09 1.655000)
Rfb out inn 1m
Cload out 0 2.000000e-13
Xdut vdd vss inp inn out ib opamp_dut
.end
