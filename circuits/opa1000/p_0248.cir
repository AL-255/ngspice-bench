* opa1000[0248]: 2p/folded_cascode_nmos_3v3_i500u_weak (folded_cascode_nmos, VDD=3.3V, CL=2.0pF, Iref=94.4444uA)
.include "pdk_opa.inc"
.temp 27
.option gmin=1e-12 rshunt=1e12 reltol=1e-3 abstol=1e-12 vntol=1e-5 method=gear
* Post-PEX R+C extracted netlist for folded_cascode_nmos_3v3_i500u_weak
.subckt opamp_dut vdd vss inp inn out ib
XMpar0 out.t14 a_7338_9044.t122 vss.t1 vss.t0 nfet_03v3 w=2.65u l=0.56u ad=8.4800e-13 pd=3.6212e-06 as=7.4200e-13 ps=3.2100e-06 nf=1 m=16 par=16
XMpar1 a_12494_17614.t0 ib out.t0 vdd.t0 pfet_03v3 w=1.99u l=0.45u ad=5.9896e-13 pd=2.7225e-06 as=5.6764e-13 ps=2.5931e-06 nf=1 m=122 par=122
XMpar2 a_5614_15235.t0 ib a_7338_9044.t0 vdd.t0 pfet_03v3 w=1.99u l=0.45u ad=5.9896e-13 pd=2.7225e-06 as=5.6764e-13 ps=2.5931e-06 nf=1 m=122 par=122
XMpar3 a_1500_6978.t32 inp.t0 a_5614_15235.t154 vss.t120 nfet_03v3 w=2.02u l=0.36u ad=5.9370e-13 pd=2.6957e-06 as=5.9370e-13 ps=2.6957e-06 nf=1 m=46 par=46
XMpar4 a_1500_6978.t0 ib.t0 vss.t1 vss.t0 nfet_03v3 w=2.65u l=0.56u ad=7.4200e-13 pd=3.2100e-06 as=7.9500e-13 ps=3.4156e-06 nf=1 m=32 par=32
XMpar5 a_5614_15235.t122 a_1694_9089.t16 vdd.t99 vdd.t98 pfet_03v3 w=4.79u l=0.5u ad=1.3412e-12 pd=5.3500e-06 as=1.4370e-12 ps=5.6894e-06 nf=1 m=32 par=32
XMpar6 a_1694_9089.t0 ib.t0 vss.t1 vss.t0 nfet_03v3 w=2.65u l=0.56u ad=7.4200e-13 pd=3.2100e-06 as=9.5400e-13 ps=4.0325e-06 nf=1 m=16 par=16
XMpar7 a_12494_17614.t122 a_1694_9089.t16 vdd.t99 vdd.t98 pfet_03v3 w=4.79u l=0.5u ad=1.3412e-12 pd=5.3500e-06 as=1.4370e-12 ps=5.6894e-06 nf=1 m=32 par=32
XMpar8 a_12494_17614.t154 inn.t0 a_1500_6978.t32 vss.t120 nfet_03v3 w=2.02u l=0.36u ad=5.9370e-13 pd=2.6957e-06 as=5.9370e-13 ps=2.6957e-06 nf=1 m=46 par=46
XMpar9 a_1694_9089.t17 a_1694_9089.t16 vdd.t99 vdd.t98 pfet_03v3 w=4.79u l=0.5u ad=1.3412e-12 pd=5.3500e-06 as=1.5328e-12 ps=6.0287e-06 nf=1 m=16 par=16
XMpar10 a_7338_9044.t123 a_7338_9044.t122 vss.t1 vss.t0 nfet_03v3 w=2.65u l=0.56u ad=9.5400e-13 pd=4.0325e-06 as=7.4200e-13 ps=3.2100e-06 nf=1 m=16 par=16
XMpar11 ib.t1 ib.t0 vss.t1 vss.t0 nfet_03v3 w=2.65u l=0.56u ad=7.4200e-13 pd=3.2100e-06 as=7.4200e-13 ps=3.2100e-06 nf=1 m=16 par=16
X241 out.t138 vss.t199 cap_mim_2f0fF c_width=16.58u c_length=16.59u
Rpar0 a_12494_17614.t0 a_12494_17614.t122 62.8672
Rpar1 a_12494_17614.t0 a_12494_17614.t154 136.9881
Rpar2 a_12494_17614.t122 a_12494_17614.t154 43.5375
Rpar3 a_1500_6978.t0 a_1500_6978.t32 77.5280
Rpar4 a_1694_9089.t0 a_1694_9089.t16 37.8606
Rpar5 a_1694_9089.t0 a_1694_9089.t17 346.8571
Rpar6 a_1694_9089.t16 a_1694_9089.t17 14.8383
Rpar7 a_5614_15235.t0 a_5614_15235.t122 62.8672
Rpar8 a_5614_15235.t0 a_5614_15235.t154 136.9881
Rpar9 a_5614_15235.t122 a_5614_15235.t154 43.5375
Rpar10 a_7338_9044.t0 a_7338_9044.t122 433.6373
Rpar11 a_7338_9044.t0 a_7338_9044.t123 84.1595
Rpar12 a_7338_9044.t122 a_7338_9044.t123 5.5939
Rpar13 ib ib.t0 50.8352
Rpar14 ib ib.t1 168.7350
Rpar15 ib.t0 ib.t1 13.4887
Rpar16 inn inn.t0 2.3067
Rpar17 inp inp.t0 2.3067
Rpar18 out out.t0 270.8064
Rpar19 out out.t14 75.5327
Rpar20 out out.t138 15.5936
Rpar21 out.t0 out.t14 155.6607
Rpar22 out.t0 out.t138 2327.1154
Rpar23 out.t14 out.t138 649.0735
Rpar24 vdd vdd.t0 104.5310
Rpar25 vdd vdd.t98 360.3461
Rpar26 vdd vdd.t99 83.0001
Rpar27 vdd.t0 vdd.t98 72.8729
Rpar28 vdd.t0 vdd.t99 65.3422
Rpar29 vdd.t98 vdd.t99 2.1645
Rpar30 vss vss.t0 63.9538
Rpar31 vss vss.t1 48.4484
Rpar32 vss vss.t120 651.1338
Rpar33 vss vss.t199 68.1131
Rpar34 vss.t0 vss.t1 1.8648
Rpar35 vss.t0 vss.t120 74.9926
Rpar36 vss.t0 vss.t199 506.6757
Rpar37 vss.t1 vss.t120 349.4633
Rpar38 vss.t1 vss.t199 383.8335
Rpar39 vss.t120 vss.t199 5158.6255
Cpar0 a_12494_17614.t0 vss 8.25477e-14
Cpar1 a_12494_17614.t122 vss 4.25749e-14
Cpar2 a_12494_17614.t154 vss 3.41947e-14
Cpar3 a_1500_6978.t0 vss 2.74104e-14
Cpar4 a_1500_6978.t32 vss 5.15000e-14
Cpar5 a_1694_9089.t0 vss 1.36059e-14
Cpar6 a_1694_9089.t16 vss 6.09489e-14
Cpar7 a_1694_9089.t17 vss 2.03825e-14
Cpar8 a_5614_15235.t0 vss 8.26061e-14
Cpar9 a_5614_15235.t122 vss 4.26051e-14
Cpar10 a_5614_15235.t154 vss 3.42187e-14
Cpar11 a_7338_9044.t0 vss 6.59691e-14
Cpar12 a_7338_9044.t122 vss 2.04290e-14
Cpar13 a_7338_9044.t123 vss 2.34354e-14
Cpar14 ib out 1.81751e-14
Cpar15 ib vdd 7.90287e-14
Cpar16 ib vss 1.61675e-13
Cpar17 ib.t0 vss 3.59257e-14
Cpar18 ib.t1 vss 1.40631e-14
Cpar19 inn inp 1.03790e-16
Cpar20 inn vdd 7.38100e-17
Cpar21 inn vss 1.82826e-14
Cpar22 inn.t0 vss 6.44169e-15
Cpar23 inp vdd 7.55700e-17
Cpar24 inp vss 1.84482e-14
Cpar25 inp.t0 vss 6.41587e-15
Cpar26 out vdd 1.30014e-14
Cpar27 out vss 3.82323e-14
Cpar28 out.t0 vss 3.57382e-14
Cpar29 out.t138 vss 5.87352e-14
Cpar30 out.t14 vss 1.26108e-14
Cpar31 vdd vss 3.79143e-13
Cpar32 vdd.t0 vss 1.35903e-13
Cpar33 vdd.t98 vss 7.65496e-14
Cpar34 vdd.t99 vss 2.94226e-14
.ends opamp_dut

Vdd vdd 0 3.300000
Vss vss 0 0
Ibias vdd ib 9.444440e-05
Vinp inp 0 DC 1.810000 AC 1 PWL(0 1.810000 3.000000e-09 1.810000 3.300000e-09 1.820000)
Rfb out inn 1m
Cload out 0 2.000000e-12
Xdut vdd vss inp inn out ib opamp_dut
.end
