* opa1000[0221]: 2p/folded_cascode_nmos_1v8_i10u_weak (folded_cascode_nmos, VDD=1.8V, CL=2.0pF, Iref=2.5556uA)
.include "pdk_opa.inc"
.temp 27
.option gmin=1e-12 rshunt=1e12 reltol=1e-3 abstol=1e-12 vntol=1e-5 method=gear
* Post-PEX R+C extracted netlist for folded_cascode_nmos_1v8_i10u_weak
.subckt opamp_dut vdd vss inp inn out ib
XMpar0 a_4416_4069.t1 a_4416_4069.t0 vss.t6 vss.t5 nfet_03v3 w=2.66u l=2.25u ad=1.5960e-12 pd=6.5200e-06 as=7.4480e-13 ps=3.2200e-06 nf=1 m=2 par=2
XMpar1 a_5026_9108.t0 inn.t0 a_6414_4069.t0 vss.t0 nfet_03v3 w=1.76u l=0.78u ad=7.7440e-13 pd=3.5200e-06 as=4.9280e-13 ps=2.3200e-06 nf=1 m=4 par=4
XMpar2 a_6414_4069.t4 ib.t4 out.t2 vdd.t20 pfet_03v3 w=1.82u l=1.13u ad=7.0373e-13 pd=3.2000e-06 as=5.0960e-13 ps=2.3800e-06 nf=1 m=12 par=12
XMpar3 a_4070_4069.t4 ib.t4 a_4416_4069.t4 vdd.t20 pfet_03v3 w=1.82u l=1.13u ad=7.0373e-13 pd=3.2000e-06 as=5.0960e-13 ps=2.3800e-06 nf=1 m=12 par=12
XMpar4 ib.t1 ib.t0 vss.t6 vss.t5 nfet_03v3 w=2.66u l=2.25u ad=1.5960e-12 pd=6.5200e-06 as=7.4480e-13 ps=3.2200e-06 nf=1 m=2 par=2
XMpar5 a_6414_4069.t16 a_4330_1041.t2 vdd.t1 vdd.t0 pfet_03v3 w=7.22u l=1.8u ad=2.0216e-12 pd=7.7800e-06 as=3.1768e-12 ps=1.1710e-05 nf=1 m=4 par=4
XMpar6 a_5026_9108.t8 ib.t0 vss.t6 vss.t5 nfet_03v3 w=2.66u l=2.25u ad=7.4480e-13 pd=3.2200e-06 as=7.4480e-13 ps=3.2200e-06 nf=1 m=4 par=4
XMpar7 a_4070_4069.t0 inp.t0 a_5026_9108.t0 vss.t0 nfet_03v3 w=1.76u l=0.78u ad=4.9280e-13 pd=2.3200e-06 as=7.7440e-13 ps=3.5200e-06 nf=1 m=4 par=4
XMpar8 a_4330_1041.t0 ib.t0 vss.t6 vss.t5 nfet_03v3 w=2.66u l=2.25u ad=7.4480e-13 pd=3.2200e-06 as=7.4480e-13 ps=3.2200e-06 nf=1 m=2 par=2
XMpar9 a_4330_1041.t3 a_4330_1041.t2 vdd.t1 vdd.t0 pfet_03v3 w=7.22u l=1.8u ad=2.0216e-12 pd=7.7800e-06 as=4.3320e-12 ps=1.5640e-05 nf=1 m=2 par=2
XMpar10 a_4070_4069.t16 a_4330_1041.t2 vdd.t1 vdd.t0 pfet_03v3 w=7.22u l=1.8u ad=2.0216e-12 pd=7.7800e-06 as=3.1768e-12 ps=1.1710e-05 nf=1 m=4 par=4
XMpar11 out.t0 a_4416_4069.t0 vss.t6 vss.t5 nfet_03v3 w=2.66u l=2.25u ad=7.4480e-13 pd=3.2200e-06 as=7.4480e-13 ps=3.2200e-06 nf=1 m=2 par=2
X5 out.t14 vss.t4 cap_mim_2f0fF c_width=11.49u c_length=11.49u
Rpar0 a_4070_4069.t0 a_4070_4069.t4 70.6993
Rpar1 a_4070_4069.t0 a_4070_4069.t16 198.2820
Rpar2 a_4070_4069.t4 a_4070_4069.t16 55.9047
Rpar3 a_4330_1041.t0 a_4330_1041.t2 91.2778
Rpar4 a_4330_1041.t0 a_4330_1041.t3 86.5319
Rpar5 a_4330_1041.t2 a_4330_1041.t3 26.9857
Rpar6 a_4416_4069.t0 a_4416_4069.t1 17.8170
Rpar7 a_4416_4069.t0 a_4416_4069.t4 268.7231
Rpar8 a_4416_4069.t1 a_4416_4069.t4 85.3617
Rpar9 a_5026_9108.t0 a_5026_9108.t8 37.3700
Rpar10 a_6414_4069.t0 a_6414_4069.t4 70.6993
Rpar11 a_6414_4069.t0 a_6414_4069.t16 198.2820
Rpar12 a_6414_4069.t4 a_6414_4069.t16 55.9047
Rpar13 ib ib.t0 607.8319
Rpar14 ib ib.t1 128.6183
Rpar15 ib ib.t4 1.8658
Rpar16 ib.t0 ib.t1 17.2129
Rpar17 ib.t0 ib.t4 470.8779
Rpar18 ib.t1 ib.t4 99.6386
Rpar19 inn inn.t0 6.9366
Rpar20 inp inp.t0 6.9852
Rpar21 out out.t0 194.6618
Rpar22 out out.t2 3.3305
Rpar23 out out.t14 304.5603
Rpar24 out.t0 out.t14 84.1662
Rpar25 vdd vdd.t0 162.9442
Rpar26 vdd vdd.t1 316.1764
Rpar27 vdd vdd.t20 158.3680
Rpar28 vdd.t0 vdd.t1 4.1293
Rpar29 vdd.t0 vdd.t20 50.1529
Rpar30 vdd.t1 vdd.t20 74.7602
Rpar31 vss vss.t0 273.7923
Rpar32 vss vss.t5 223.1845
Rpar33 vss vss.t6 976.5043
Rpar34 vss vss.t4 3425.5262
Rpar35 vss.t0 vss.t5 1.6205
Rpar36 vss.t0 vss.t6 6.4267
Rpar37 vss.t0 vss.t4 90.1484
Rpar38 vss.t5 vss.t6 5.3466
Rpar39 vss.t5 vss.t4 95.7758
Rpar40 vss.t6 vss.t4 330.5613
Cpar0 a_4070_4069.t0 vss 4.94465e-15
Cpar1 a_4070_4069.t16 vss 8.32431e-15
Cpar2 a_4070_4069.t4 vss 8.90391e-15
Cpar3 a_4330_1041.t0 vss 3.16958e-15
Cpar4 a_4330_1041.t2 vss 2.16611e-14
Cpar5 a_4330_1041.t3 vss 3.70853e-15
Cpar6 a_4416_4069.t0 vss 7.34681e-15
Cpar7 a_4416_4069.t1 vss 5.35552e-15
Cpar8 a_4416_4069.t4 vss 6.41980e-15
Cpar9 a_5026_9108.t0 vss 4.08203e-15
Cpar10 a_5026_9108.t8 vss 5.57898e-15
Cpar11 a_6414_4069.t0 vss 4.82075e-15
Cpar12 a_6414_4069.t16 vss 8.11569e-15
Cpar13 a_6414_4069.t4 vss 8.68074e-15
Cpar14 ib out 2.90430e-15
Cpar15 ib vdd 1.76029e-14
Cpar16 ib vss 2.08414e-14
Cpar17 ib.t0 vss 1.11808e-14
Cpar18 ib.t1 vss 3.67302e-15
Cpar19 ib.t4 vss 1.33970e-14
Cpar20 inn inp 5.15300e-17
Cpar21 inn vss 2.86875e-15
Cpar22 inn.t0 vss 4.37531e-16
Cpar23 inp vss 2.93282e-15
Cpar24 inp.t0 vss 4.52577e-16
Cpar25 out vdd 5.32925e-15
Cpar26 out vss 2.04131e-14
Cpar27 out.t0 vss 2.99814e-15
Cpar28 out.t14 vss 1.94218e-14
Cpar29 out.t2 vss 1.03942e-15
Cpar30 vdd vss 1.28090e-13
Cpar31 vdd.t0 vss 1.88768e-14
Cpar32 vdd.t1 vss 1.09398e-14
Cpar33 vdd.t20 vss 2.29879e-14
.ends opamp_dut

Vdd vdd 0 1.800000
Vss vss 0 0
Ibias vdd ib 2.555600e-06
Vinp inp 0 DC 0.985000 AC 1 PWL(0 0.985000 3.355818e-08 0.985000 3.691400e-08 0.995000)
Rfb out inn 1m
Cload out 0 2.000000e-12
Xdut vdd vss inp inn out ib opamp_dut
.end
