* opa1000[0375]: 2p/nmos_5t_1v8_ulp_lt0p1uw_subth (nmos_5t, VDD=1.8V, CL=2.0pF, Iref=0.0007uA)
.include "pdk_opa.inc"
.temp 27
.option gmin=1e-12 rshunt=1e12 reltol=1e-3 abstol=1e-12 vntol=1e-5 method=gear
* Post-PEX R+C extracted netlist for nmos_5t_1v8_ulp_lt0p1uw_subth
.subckt opamp_dut vdd vss inp inn out ib
XMpar0 a_2034_4134.t0 inn.t0 out.t0 vss.t0 nfet_03v3 w=2.54u l=10u ad=1.5240e-12 pd=6.2800e-06 as=7.1120e-13 ps=3.1000e-06 nf=1 m=8 par=8
XMpar1 a_2034_4134.t8 ib.t0 vss.t3 vss.t2 nfet_03v3 w=0.4u l=9.5u ad=1.1200e-13 pd=9.6000e-07 as=2.0800e-13 ps=1.7400e-06 nf=1 m=8 par=8
XMpar2 a_2034_4134.t0 inp.t0 a_2532_9615.t0 vss.t0 nfet_03v3 w=2.54u l=10u ad=1.5240e-12 pd=6.2800e-06 as=7.1120e-13 ps=3.1000e-06 nf=1 m=8 par=8
XMpar3 ib.t1 ib.t0 vss.t3 vss.t2 nfet_03v3 w=0.4u l=9.5u ad=2.4000e-13 pd=2.0000e-06 as=1.1200e-13 ps=9.6000e-07 nf=1 m=2 par=2
XMpar4 a_2532_9615.t9 a_2532_9615.t8 vdd.t1 vdd.t0 pfet_03v3 w=0.4u l=9.5u ad=2.4000e-13 pd=2.0000e-06 as=1.1200e-13 ps=9.6000e-07 nf=1 m=2 par=2
XMpar5 out.t8 a_2532_9615.t8 vdd.t1 vdd.t0 pfet_03v3 w=0.4u l=9.5u ad=1.1200e-13 pd=9.6000e-07 as=1.1200e-13 ps=9.6000e-07 nf=1 m=2 par=2
X13 out.t10 vss.t19 cap_mim_2f0fF c_width=16.86u c_length=16.87u
X19 out.t10 vss.t19 cap_mim_2f0fF c_width=16.86u c_length=16.87u
Rpar0 a_2034_4134.t0 a_2034_4134.t8 41.9423
Rpar1 a_2532_9615.t0 a_2532_9615.t8 94.8137
Rpar2 a_2532_9615.t0 a_2532_9615.t9 72.4721
Rpar3 a_2532_9615.t8 a_2532_9615.t9 23.5097
Rpar4 ib ib.t0 17.1070
Rpar5 ib ib.t1 15.4680
Rpar6 ib.t0 ib.t1 33.6185
Rpar7 inn inn.t0 2.9460
Rpar8 inp inp.t0 2.9460
Rpar9 out out.t0 81.6327
Rpar10 out out.t10 115.7994
Rpar11 out out.t8 17.7083
Rpar12 out.t0 out.t10 203.2680
Rpar13 out.t0 out.t8 279.7822
Rpar14 out.t10 out.t8 396.8829
Rpar15 vdd vdd.t0 78.4277
Rpar16 vdd vdd.t1 203.8434
Rpar17 vdd.t0 vdd.t1 13.8895
Rpar18 vss vss.t0 57.1319
Rpar19 vss vss.t3 311.3224
Rpar20 vss vss.t2 32.1222
Rpar21 vss vss.t19 835.3571
Rpar22 vss.t0 vss.t3 35.5225
Rpar23 vss.t0 vss.t2 2.6897
Rpar24 vss.t0 vss.t19 204.1654
Rpar25 vss.t3 vss.t2 19.9428
Rpar26 vss.t3 vss.t19 1563.3917
Rpar27 vss.t2 vss.t19 116.1425
Cpar0 a_2034_4134.t0 vss 3.09868e-14
Cpar1 a_2034_4134.t8 vss 1.08870e-14
Cpar2 a_2532_9615.t0 vss 1.96918e-14
Cpar3 a_2532_9615.t8 vss 2.12280e-14
Cpar4 a_2532_9615.t9 vss 5.39116e-15
Cpar5 ib inn 3.82700e-17
Cpar6 ib inp 4.39400e-17
Cpar7 ib vss 6.34900e-14
Cpar8 ib.t0 vss 8.65434e-15
Cpar9 ib.t1 vss 6.54730e-16
Cpar10 inn inp 2.07870e-16
Cpar11 inn out 7.62575e-15
Cpar12 inn vdd 1.97200e-17
Cpar13 inn vss 3.02870e-14
Cpar14 inn.t0 vss 1.15191e-14
Cpar15 inp vdd 2.09300e-17
Cpar16 inp vss 3.00850e-14
Cpar17 inp.t0 vss 1.15981e-14
Cpar18 out vdd 8.19607e-15
Cpar19 out vss 2.54814e-14
Cpar20 out.t0 vss 1.94199e-15
Cpar21 out.t10 vss 2.72784e-14
Cpar22 out.t8 vss 1.84751e-16
Cpar23 vdd vss 6.23087e-14
Cpar24 vdd.t0 vss 1.69362e-14
Cpar25 vdd.t1 vss 6.50839e-15
.ends opamp_dut

Vdd vdd 0 1.800000
Vss vss 0 0
Ibias vdd ib 7.000000e-10
Vinp inp 0 DC 0.895000 AC 1 PWL(0 0.895000 5.238232e-05 0.895000 5.762055e-05 0.905000)
Rfb out inn 1m
Cload out 0 2.000000e-12
Xdut vdd vss inp inn out ib opamp_dut
.end
