* opa1000[0899]: 2p/telescopic_nmos_3v3_i200n_weak (telescopic_nmos, VDD=3.3V, CL=2.0pF, Iref=0.0575uA)
.include "pdk_opa.inc"
.temp 27
.option gmin=1e-12 rshunt=1e12 reltol=1e-3 abstol=1e-12 vntol=1e-5 method=gear
* Post-PEX R+C extracted netlist for telescopic_nmos_3v3_i200n_weak
.subckt opamp_dut vdd vss inp inn out ib
XMpar0 a_2794_7612.t0 a_1237_5562.t4 out.t1 vdd.t2 pfet_03v3 w=1.98u l=4.2u ad=1.1880e-12 pd=5.1600e-06 as=5.5440e-13 ps=2.5400e-06 nf=1 m=2 par=2
XMpar1 a_2794_7612.t2 a_1237_5562.t12 vdd.t1 vdd.t0 pfet_03v3 w=1.2u l=8.13u ad=3.3600e-13 pd=1.7600e-06 as=3.3600e-13 ps=1.7600e-06 nf=1 m=2 par=2
XMpar2 a_1180_9838.t1 a_1237_5562.t4 a_1237_5562.t5 vdd.t2 pfet_03v3 w=1.98u l=4.2u ad=1.1880e-12 pd=5.1600e-06 as=1.1880e-12 ps=5.1600e-06 nf=1 m=2 par=2
XMpar3 a_1117_5770.t0 inp.t0 a_2194_1205.t8 vss.t16 nfet_03v3 w=1.07u l=5.2u ad=2.9960e-13 pd=1.6300e-06 as=6.4200e-13 ps=3.3400e-06 nf=1 m=2 par=2
XMpar4 a_2346_5770.t0 a_1237_5562.t0 out.t0 vss.t0 nfet_03v3 w=0.51u l=4.2u ad=3.0600e-13 pd=2.2200e-06 as=1.4280e-13 ps=1.0700e-06 nf=1 m=2 par=2
XMpar5 a_1180_9838.t0 a_1237_5562.t12 vdd.t1 vdd.t0 pfet_03v3 w=1.2u l=8.13u ad=7.2000e-13 pd=3.6000e-06 as=3.3600e-13 ps=1.7600e-06 nf=1 m=2 par=2
XMpar6 a_1117_5770.t2 a_1237_5562.t0 a_1237_5562.t1 vss.t0 nfet_03v3 w=0.51u l=4.2u ad=3.0600e-13 pd=2.2200e-06 as=3.0600e-13 ps=2.2200e-06 nf=1 m=2 par=2
XMpar7 a_2194_1205.t0 ib.t0 vss.t2 vss.t1 nfet_03v3 w=0.4u l=5u ad=1.1200e-13 pd=9.6000e-07 as=2.0800e-13 ps=1.7400e-06 nf=1 m=8 par=8
XMpar8 ib.t1 ib.t0 vss.t2 vss.t1 nfet_03v3 w=0.4u l=5u ad=2.4000e-13 pd=2.0000e-06 as=1.1200e-13 ps=9.6000e-07 nf=1 m=2 par=2
XMpar9 a_2194_1205.t8 inn.t0 a_2346_5770.t1 vss.t16 nfet_03v3 w=1.07u l=5.2u ad=6.4200e-13 pd=3.3400e-06 as=2.9960e-13 ps=1.6300e-06 nf=1 m=2 par=2
Rpar0 a_1117_5770.t0 a_1117_5770.t2 63.5209
Rpar1 a_1180_9838.t0 a_1180_9838.t1 61.5845
Rpar2 a_1237_5562.t0 a_1237_5562.t1 25.6946
Rpar3 a_1237_5562.t0 a_1237_5562.t4 488.5577
Rpar4 a_1237_5562.t0 a_1237_5562.t12 143.5831
Rpar5 a_1237_5562.t0 a_1237_5562.t5 234.9091
Rpar6 a_1237_5562.t1 a_1237_5562.t4 368.1069
Rpar7 a_1237_5562.t1 a_1237_5562.t12 108.1836
Rpar8 a_1237_5562.t1 a_1237_5562.t5 176.9938
Rpar9 a_1237_5562.t4 a_1237_5562.t12 100.5202
Rpar10 a_1237_5562.t4 a_1237_5562.t5 23.5007
Rpar11 a_1237_5562.t12 a_1237_5562.t5 48.3323
Rpar12 a_2194_1205.t0 a_2194_1205.t8 50.2318
Rpar13 a_2346_5770.t0 a_2346_5770.t1 74.8529
Rpar14 a_2794_7612.t0 a_2794_7612.t2 60.3206
Rpar15 ib ib.t0 13.2769
Rpar16 ib ib.t1 14.2350
Rpar17 ib.t0 ib.t1 33.8812
Rpar18 inn inn.t0 3.5198
Rpar19 inp inp.t0 3.5684
Rpar20 out out.t0 15.9007
Rpar21 out out.t1 51.2421
Rpar22 out.t0 out.t1 327.9249
Rpar23 vdd vdd.t0 36.2689
Rpar24 vdd vdd.t1 87.6931
Rpar25 vdd vdd.t2 88.0924
Rpar26 vdd.t0 vdd.t1 14.6500
Rpar27 vdd.t0 vdd.t2 67.1821
Rpar28 vdd.t1 vdd.t2 162.4369
Rpar29 vss vss.t0 85.8279
Rpar30 vss vss.t1 79.1544
Rpar31 vss vss.t2 814.9865
Rpar32 vss vss.t16 152.0002
Rpar33 vss.t0 vss.t1 2.3651
Rpar34 vss.t0 vss.t2 32.0053
Rpar35 vss.t0 vss.t16 3.9563
Rpar36 vss.t1 vss.t2 27.7693
Rpar37 vss.t1 vss.t16 4.2281
Rpar38 vss.t2 vss.t16 59.4786
Cpar0 a_1117_5770.t0 vss 2.37081e-15
Cpar1 a_1117_5770.t2 vss 3.39580e-15
Cpar2 a_1180_9838.t0 vss 7.47590e-15
Cpar3 a_1180_9838.t1 vss 7.37230e-15
Cpar4 a_1237_5562.t0 vss 7.38724e-15
Cpar5 a_1237_5562.t1 vss 2.38328e-15
Cpar6 a_1237_5562.t12 vss 1.63342e-14
Cpar7 a_1237_5562.t4 vss 1.10858e-14
Cpar8 a_1237_5562.t5 vss 3.85993e-15
Cpar9 a_2194_1205.t0 vss 7.34386e-15
Cpar10 a_2194_1205.t8 vss 3.78854e-15
Cpar11 a_2346_5770.t0 vss 3.67845e-15
Cpar12 a_2346_5770.t1 vss 2.86623e-15
Cpar13 a_2794_7612.t0 vss 9.55357e-15
Cpar14 a_2794_7612.t2 vss 7.18442e-15
Cpar15 ib inn 1.80000e-17
Cpar16 ib inp 1.21300e-17
Cpar17 ib vss 3.75541e-14
Cpar18 ib.t0 vss 5.33785e-15
Cpar19 ib.t1 vss 4.32868e-16
Cpar20 inn inp 5.19700e-17
Cpar21 inn vss 5.57892e-15
Cpar22 inn.t0 vss 5.32468e-16
Cpar23 inp vss 5.67738e-15
Cpar24 inp.t0 vss 5.41436e-16
Cpar25 out vdd 2.80672e-15
Cpar26 out vss 7.18561e-15
Cpar27 out.t0 vss 6.43767e-16
Cpar28 out.t1 vss 3.78200e-15
Cpar29 vdd vss 7.94254e-14
Cpar30 vdd.t0 vss 1.30577e-14
Cpar31 vdd.t1 vss 5.65503e-15
Cpar32 vdd.t2 vss 1.54151e-14
.ends opamp_dut

Vdd vdd 0 3.300000
Vss vss 0 0
Ibias vdd ib 5.750000e-08
Vinp inp 0 DC 1.711000 AC 1 PWL(0 1.711000 6.224718e-07 1.711000 6.847190e-07 1.721000)
Rfb out inn 1m
Cload out 0 2.000000e-12
Xdut vdd vss inp inn out ib opamp_dut
.end
