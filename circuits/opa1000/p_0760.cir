* opa1000[0760]: 200f/symmetrical_ota_1v8_i2u_weak (symmetrical_ota, VDD=1.8V, CL=0.2pF, Iref=0.3833uA)
.include "pdk_opa.inc"
.temp 27
.option gmin=1e-12 rshunt=1e12 reltol=1e-3 abstol=1e-12 vntol=1e-5 method=gear
* Post-PEX R+C extracted netlist for symmetrical_ota_1v8_i2u_weak
.subckt opamp_dut vdd vss inp inn out ib
XMpar0 out.t3 a_1292_7669.t2 vdd.t1 vdd.t0 pfet_03v3 w=1.62u l=3.4u ad=4.5360e-13 pd=2.1800e-06 as=7.1280e-13 ps=3.3100e-06 nf=1 m=4 par=4
XMpar1 a_1292_7669.t3 a_1292_7669.t2 vdd.t1 vdd.t0 pfet_03v3 w=1.62u l=3.4u ad=4.5360e-13 pd=2.1800e-06 as=4.5360e-13 ps=2.1800e-06 nf=1 m=2 par=2
XMpar2 a_3668_6009.t0 a_7334_9737.t2 vdd.t1 vdd.t0 pfet_03v3 w=1.62u l=3.4u ad=4.5360e-13 pd=2.1800e-06 as=7.1280e-13 ps=3.3100e-06 nf=1 m=4 par=4
XMpar3 out.t0 a_3668_6009.t4 vss.t3 vss.t2 nfet_03v3 w=0.4u l=3.4u ad=1.1200e-13 pd=9.6000e-07 as=1.7600e-13 ps=1.4800e-06 nf=1 m=4 par=4
XMpar4 ib.t1 ib.t0 vss.t22 vss.t21 nfet_03v3 w=0.4u l=2.08u ad=2.4000e-13 pd=2.0000e-06 as=1.1200e-13 ps=9.6000e-07 nf=1 m=2 par=2
XMpar5 a_5234_9737.t0 inn.t0 a_7334_9737.t0 vss.t0 nfet_03v3 w=1.99u l=2.4u ad=1.1940e-12 pd=5.1800e-06 as=5.5720e-13 ps=2.5500e-06 nf=1 m=2 par=2
XMpar6 a_5234_9737.t4 ib.t0 vss.t22 vss.t21 nfet_03v3 w=0.4u l=2.08u ad=2.4000e-13 pd=2.0000e-06 as=1.7600e-13 ps=1.4800e-06 nf=1 m=4 par=4
XMpar7 a_7334_9737.t3 a_7334_9737.t2 vdd.t1 vdd.t0 pfet_03v3 w=1.62u l=3.4u ad=4.5360e-13 pd=2.1800e-06 as=4.5360e-13 ps=2.1800e-06 nf=1 m=2 par=2
XMpar8 a_1292_7669.t0 inp.t0 a_5234_9737.t0 vss.t0 nfet_03v3 w=1.99u l=2.4u ad=5.5720e-13 pd=2.5500e-06 as=1.1940e-12 ps=5.1800e-06 nf=1 m=2 par=2
XMpar9 a_3668_6009.t5 a_3668_6009.t4 vss.t3 vss.t2 nfet_03v3 w=0.4u l=3.4u ad=1.1200e-13 pd=9.6000e-07 as=1.1200e-13 ps=9.6000e-07 nf=1 m=4 par=4
X24 out.t8 vss.t10 cap_mim_2f0fF c_width=16.58u c_length=16.59u
Rpar0 a_1292_7669.t0 a_1292_7669.t2 100.3123
Rpar1 a_1292_7669.t0 a_1292_7669.t3 93.7900
Rpar2 a_1292_7669.t2 a_1292_7669.t3 25.1839
Rpar3 a_3668_6009.t0 a_3668_6009.t4 172.1629
Rpar4 a_3668_6009.t0 a_3668_6009.t5 79.0058
Rpar5 a_3668_6009.t4 a_3668_6009.t5 22.1951
Rpar6 a_5234_9737.t0 a_5234_9737.t4 89.1852
Rpar7 a_7334_9737.t0 a_7334_9737.t2 100.3123
Rpar8 a_7334_9737.t0 a_7334_9737.t3 93.7900
Rpar9 a_7334_9737.t2 a_7334_9737.t3 25.1839
Rpar10 ib ib.t0 11.2022
Rpar11 ib ib.t1 12.5411
Rpar12 ib.t0 ib.t1 39.8117
Rpar13 inn inn.t0 5.0383
Rpar14 inp inp.t0 5.0869
Rpar15 out out.t0 55.4623
Rpar16 out out.t3 32.7010
Rpar17 out out.t8 15.1754
Rpar18 out.t0 out.t3 104.2076
Rpar19 vdd vdd.t0 78.2764
Rpar20 vdd vdd.t1 171.6750
Rpar21 vdd.t0 vdd.t1 3.0801
Rpar22 vss vss.t0 552.6147
Rpar23 vss vss.t10 63.6458
Rpar24 vss vss.t2 69.0590
Rpar25 vss vss.t3 380.3063
Rpar26 vss vss.t21 308.3607
Rpar27 vss vss.t22 47.7320
Rpar28 vss.t0 vss.t10 4035.8899
Rpar29 vss.t0 vss.t2 77.7313
Rpar30 vss.t0 vss.t3 418.8689
Rpar31 vss.t0 vss.t21 452.8176
Rpar32 vss.t0 vss.t22 1045.6278
Rpar33 vss.t10 vss.t2 310.9405
Rpar34 vss.t10 vss.t3 1739.3032
Rpar35 vss.t10 vss.t21 1178.8753
Rpar36 vss.t10 vss.t22 125.3005
Rpar37 vss.t2 vss.t3 7.5717
Rpar38 vss.t2 vss.t21 6.8800
Rpar39 vss.t2 vss.t22 24.2233
Rpar40 vss.t3 vss.t21 44.4360
Rpar41 vss.t3 vss.t22 137.9390
Rpar42 vss.t21 vss.t22 78.5169
Cpar0 a_1292_7669.t0 vss 3.13615e-15
Cpar1 a_1292_7669.t2 vss 1.49947e-14
Cpar2 a_1292_7669.t3 vss 3.11541e-15
Cpar3 a_3668_6009.t0 vss 2.51217e-15
Cpar4 a_3668_6009.t4 vss 6.89123e-15
Cpar5 a_3668_6009.t5 vss 1.87224e-15
Cpar6 a_5234_9737.t0 vss 6.06706e-15
Cpar7 a_5234_9737.t4 vss 6.29134e-15
Cpar8 a_7334_9737.t0 vss 3.14491e-15
Cpar9 a_7334_9737.t2 vss 1.50365e-14
Cpar10 a_7334_9737.t3 vss 3.12411e-15
Cpar11 ib out 1.07700e-17
Cpar12 ib vss 1.48577e-14
Cpar13 ib.t0 vss 1.90757e-15
Cpar14 ib.t1 vss 2.96319e-16
Cpar15 inn inp 5.19700e-17
Cpar16 inn vdd 2.13700e-17
Cpar17 inn vss 3.06812e-15
Cpar18 inn.t0 vss 5.13795e-16
Cpar19 inp vdd 3.96900e-17
Cpar20 inp vss 3.07072e-15
Cpar21 inp.t0 vss 5.37839e-16
Cpar22 out vdd 4.00987e-15
Cpar23 out vss 1.40207e-14
Cpar24 out.t0 vss 3.74539e-16
Cpar25 out.t3 vss 3.39994e-16
Cpar26 out.t8 vss 9.69737e-15
Cpar27 vdd vss 7.79575e-14
Cpar28 vdd.t0 vss 2.38675e-14
Cpar29 vdd.t1 vss 9.93035e-15
.ends opamp_dut

Vdd vdd 0 1.800000
Vss vss 0 0
Ibias vdd ib 3.833000e-07
Vinp inp 0 DC 0.895000 AC 1 PWL(0 0.895000 3.877126e-08 0.895000 4.264839e-08 0.905000)
Rfb out inn 1m
Cload out 0 2.000000e-13
Xdut vdd vss inp inn out ib opamp_dut
.end
