* opa1000[0587]: 200f/pmos_miller_1v8_i50n_subth (pmos_miller, VDD=1.8V, CL=0.2pF, Iref=0.0081uA)
.include "pdk_opa.inc"
.temp 27
.option gmin=1e-12 rshunt=1e12 reltol=1e-3 abstol=1e-12 vntol=1e-5 method=gear
* Post-PEX R+C extracted netlist for pmos_miller_1v8_i50n_subth
.subckt opamp_dut vdd vss inp inn out ib
XMpar0 a_5379_9689.t1 a_5379_9689.t0 vdd.t1 vdd.t0 pfet_03v3 w=0.4u l=5u ad=2.4000e-13 pd=2.0000e-06 as=1.1200e-13 ps=9.6000e-07 nf=1 m=2 par=2
XMpar1 a_881_1290.t8 a_7630_1041.t8 vss.t1 vss.t0 nfet_03v3 w=0.4u l=4u ad=2.4000e-13 pd=2.0000e-06 as=1.1200e-13 ps=9.6000e-07 nf=1 m=2 par=2
XMpar2 a_4930_13325.t0 inp.t0 a_881_1290.t0 vdd.t2 pfet_03v3 w=3.33u l=3.3u ad=1.4652e-12 pd=5.8750e-06 as=9.3240e-13 ps=3.8900e-06 nf=1 m=8 par=8
XMpar3 out.t0 a_5379_9689.t0 vdd.t1 vdd.t0 pfet_03v3 w=0.4u l=5u ad=1.8880e-13 pd=1.5840e-06 as=1.6320e-13 ps=1.3760e-06 nf=1 m=10 par=10
XMpar4 out.t1 a_881_1290.t11 vss.t1 vss.t0 nfet_03v3 w=0.4u l=4u ad=1.3760e-13 pd=1.1680e-06 as=1.3760e-13 ps=1.1680e-06 nf=1 m=10 par=10
XMpar5 a_4930_13325.t0 inn.t0 a_7630_1041.t0 vdd.t2 pfet_03v3 w=3.33u l=3.3u ad=1.4652e-12 pd=5.8750e-06 as=9.3240e-13 ps=3.8900e-06 nf=1 m=8 par=8
XMpar6 a_4930_13325.t16 a_5379_9689.t0 vdd.t1 vdd.t0 pfet_03v3 w=0.4u l=5u ad=2.4000e-13 pd=2.0000e-06 as=1.1200e-13 ps=9.6000e-07 nf=1 m=4 par=4
XMpar7 a_7630_1041.t9 a_7630_1041.t8 vss.t1 vss.t0 nfet_03v3 w=0.4u l=4u ad=2.4000e-13 pd=2.0000e-06 as=1.1200e-13 ps=9.6000e-07 nf=1 m=2 par=2
XMpar8 ib.t1 ib.t0 vss.t22 vss.t21 nfet_03v3 w=0.4u l=5u ad=2.4000e-13 pd=2.0000e-06 as=1.1200e-13 ps=9.6000e-07 nf=1 m=2 par=2
XMpar9 a_5379_9689.t4 ib.t0 vss.t22 vss.t21 nfet_03v3 w=0.4u l=5u ad=2.4000e-13 pd=2.0000e-06 as=1.1200e-13 ps=9.6000e-07 nf=1 m=2 par=2
X1 a_881_4930.t0 a_4859_4410.t0 vss.t2 ppolyf_u_1k r_width=1u r_length=19.23u
X2 a_881_1810.t0 a_4859_1290.t0 vss.t2 ppolyf_u_1k r_width=1u r_length=19.23u
X9 a_881_7010.t0 a_4859_7530.t0 vss.t2 ppolyf_u_1k r_width=1u r_length=19.23u
X11 a_881_3890.t0 a_4859_4410.t0 vss.t2 ppolyf_u_1k r_width=1u r_length=19.23u
X19 a_881_7010.t0 a_4859_6490.t0 vss.t2 ppolyf_u_1k r_width=1u r_length=19.23u
X26 a_881_1290.t10 a_4859_1290.t0 vss.t2 ppolyf_u_1k r_width=1u r_length=19.23u
X33 a_881_3890.t0 a_4859_3370.t0 vss.t2 ppolyf_u_1k r_width=1u r_length=19.23u
X42 a_881_5970.t0 a_4859_6490.t0 vss.t2 ppolyf_u_1k r_width=1u r_length=19.23u
X43 a_881_2850.t0 a_4859_3370.t0 vss.t2 ppolyf_u_1k r_width=1u r_length=19.23u
X47 a_881_5970.t0 a_4859_5450.t0 vss.t2 ppolyf_u_1k r_width=1u r_length=19.23u
X50 a_881_2850.t0 a_4859_2330.t0 vss.t2 ppolyf_u_1k r_width=1u r_length=19.23u
X58 a_881_4930.t0 a_4859_5450.t0 vss.t2 ppolyf_u_1k r_width=1u r_length=19.23u
X59 a_881_1810.t0 a_4859_2330.t0 vss.t2 ppolyf_u_1k r_width=1u r_length=19.23u
X63 a_4859_7530.t1 out.t2 cap_mim_2f0fF c_width=13.23u c_length=13.23u
Rpar0 a_4859_7530.t0 a_4859_7530.t1 62.0906
Rpar1 a_4930_13325.t0 a_4930_13325.t16 59.4428
Rpar2 a_5379_9689.t0 a_5379_9689.t1 17.4695
Rpar3 a_5379_9689.t0 a_5379_9689.t4 113.6296
Rpar4 a_5379_9689.t1 a_5379_9689.t4 101.6358
Rpar5 a_7630_1041.t0 a_7630_1041.t8 147.7751
Rpar6 a_7630_1041.t0 a_7630_1041.t9 154.5865
Rpar7 a_7630_1041.t8 a_7630_1041.t9 16.1879
Rpar8 a_881_1290.t0 a_881_1290.t10 283.7743
Rpar9 a_881_1290.t0 a_881_1290.t11 276.0179
Rpar10 a_881_1290.t0 a_881_1290.t8 359.7521
Rpar11 a_881_1290.t10 a_881_1290.t11 76.0270
Rpar12 a_881_1290.t10 a_881_1290.t8 99.0909
Rpar13 a_881_1290.t11 a_881_1290.t8 83.5396
Rpar14 ib ib.t0 13.6988
Rpar15 ib ib.t1 16.8228
Rpar16 ib.t0 ib.t1 26.6273
Rpar17 inn inn.t0 2.4963
Rpar18 inp inp.t0 2.4963
Rpar19 out out.t0 78.3659
Rpar20 out out.t1 54.4280
Rpar21 out out.t2 20.2178
Rpar22 out.t0 out.t1 97.5867
Rpar23 out.t0 out.t2 1079.2488
Rpar24 out.t1 out.t2 749.5780
Rpar25 vdd vdd.t0 163.9201
Rpar26 vdd vdd.t1 1806.6644
Rpar27 vdd vdd.t2 22.4597
Rpar28 vdd.t0 vdd.t1 12.6011
Rpar29 vdd.t0 vdd.t2 74.9393
Rpar30 vdd.t1 vdd.t2 825.9525
Rpar31 vss vss.t0 77.6832
Rpar32 vss vss.t1 518.3746
Rpar33 vss vss.t2 50.8768
Rpar34 vss vss.t21 152.4843
Rpar35 vss vss.t22 1230.6884
Rpar36 vss.t0 vss.t1 11.5342
Rpar37 vss.t0 vss.t2 96.5172
Rpar38 vss.t0 vss.t21 2.9381
Rpar39 vss.t0 vss.t22 27.7624
Rpar40 vss.t1 vss.t2 661.9579
Rpar41 vss.t1 vss.t21 22.9538
Rpar42 vss.t1 vss.t22 244.4908
Rpar43 vss.t2 vss.t21 189.0706
Rpar44 vss.t2 vss.t22 1463.9459
Rpar45 vss.t21 vss.t22 53.1386
Cpar0 a_4859_1290.t0 vss 3.81400e-17
Cpar1 a_4859_2330.t0 vss 3.90800e-17
Cpar2 a_4859_3370.t0 vss 3.65200e-17
Cpar3 a_4859_4410.t0 vss 3.74200e-17
Cpar4 a_4859_5450.t0 vss 3.35800e-17
Cpar5 a_4859_6490.t0 vss 4.05600e-17
Cpar6 a_4859_7530.t0 vss 2.31840e-16
Cpar7 a_4859_7530.t1 vss 4.26277e-15
Cpar8 a_4930_13325.t0 vss 2.83116e-14
Cpar9 a_4930_13325.t16 vss 1.57914e-14
Cpar10 a_5379_9689.t0 vss 5.21334e-14
Cpar11 a_5379_9689.t1 vss 9.66596e-15
Cpar12 a_5379_9689.t4 vss 9.04568e-15
Cpar13 a_7630_1041.t0 vss 8.45964e-15
Cpar14 a_7630_1041.t8 vss 6.60721e-15
Cpar15 a_7630_1041.t9 vss 2.87278e-15
Cpar16 a_881_1290.t0 vss 5.87097e-15
Cpar17 a_881_1290.t10 vss 2.12052e-15
Cpar18 a_881_1290.t11 vss 8.49276e-15
Cpar19 a_881_1290.t8 vss 2.53211e-15
Cpar20 a_881_1810.t0 vss 4.03000e-17
Cpar21 a_881_2850.t0 vss 3.68600e-17
Cpar22 a_881_3890.t0 vss 3.68600e-17
Cpar23 a_881_4930.t0 vss 3.68600e-17
Cpar24 a_881_5970.t0 vss 3.75800e-17
Cpar25 a_881_7010.t0 vss 3.61000e-17
Cpar26 ib out 7.66500e-17
Cpar27 ib vdd 1.77800e-17
Cpar28 ib vss 1.72657e-14
Cpar29 ib.t0 vss 2.79719e-15
Cpar30 ib.t1 vss 4.46330e-16
Cpar31 inn inp 1.04240e-16
Cpar32 inn vdd 1.23108e-14
Cpar33 inn vss 3.76081e-15
Cpar34 inn.t0 vss 1.51762e-14
Cpar35 inp vdd 1.21108e-14
Cpar36 inp vss 3.72518e-15
Cpar37 inp.t0 vss 1.50007e-14
Cpar38 out vdd 1.34426e-14
Cpar39 out vss 2.26329e-14
Cpar40 out.t0 vss 1.08224e-14
Cpar41 out.t1 vss 6.45612e-15
Cpar42 out.t2 vss 8.10917e-15
Cpar43 vdd vss 2.03792e-13
Cpar44 vdd.t0 vss 5.29139e-14
Cpar45 vdd.t1 vss 7.63687e-15
Cpar46 vdd.t2 vss 3.91159e-14
.ends opamp_dut

Vdd vdd 0 1.800000
Vss vss 0 0
Ibias vdd ib 8.100000e-09
Vinp inp 0 DC 0.805000 AC 1 PWL(0 0.805000 1.082463e-06 0.805000 1.190710e-06 0.815000)
Rfb out inn 1m
Cload out 0 2.000000e-13
Xdut vdd vss inp inn out ib opamp_dut
.end
