* opa1000[0621]: 200f/pmos_miller_3v3_10u_100u_subth (pmos_miller, VDD=3.3V, CL=0.2pF, Iref=8.125uA)
.include "pdk_opa.inc"
.temp 27
.option gmin=1e-12 rshunt=1e12 reltol=1e-3 abstol=1e-12 vntol=1e-5 method=gear
* Post-PEX R+C extracted netlist for pmos_miller_3v3_10u_100u_subth
.subckt opamp_dut vdd vss inp inn out ib
XMpar0 a_4210_9733.t0 inn.t0 a_7852_5810.t0 vdd.t6 pfet_03v3 w=3.19u l=0.28u ad=1.4993e-12 pd=4.5287e-06 as=1.3717e-12 ps=4.0500e-06 nf=1 m=64 par=64
XMpar1 a_4004_6014.t2 inp.t0 a_4210_9733.t0 vdd.t6 pfet_03v3 w=3.19u l=0.28u ad=1.3717e-12 pd=4.0500e-06 as=1.4993e-12 ps=4.5287e-06 nf=1 m=64 par=64
XMpar2 out.t0 a_4004_6014.t67 vss.t1 vss.t0 nfet_03v3 w=10u l=0.5u ad=2.8000e-12 pd=1.0560e-05 as=3.4400e-12 ps=1.2688e-05 nf=1 m=10 par=10
XMpar3 out.t2 a_5841_996.t2 vdd.t1 vdd.t0 pfet_03v3 w=10u l=1.25u ad=3.4400e-12 pd=1.2688e-05 as=2.8000e-12 ps=1.0560e-05 nf=1 m=10 par=10
XMpar4 a_5841_996.t3 a_5841_996.t2 vdd.t1 vdd.t0 pfet_03v3 w=10u l=1.25u ad=2.8000e-12 pd=1.0560e-05 as=2.8000e-12 ps=1.0560e-05 nf=1 m=2 par=2
XMpar5 a_4210_9733.t128 a_5841_996.t2 vdd.t1 vdd.t0 pfet_03v3 w=10u l=1.25u ad=2.8000e-12 pd=1.0560e-05 as=2.8000e-12 ps=1.0560e-05 nf=1 m=4 par=4
XMpar6 a_4004_6014.t0 a_7852_5810.t64 vss.t1 vss.t0 nfet_03v3 w=10u l=0.5u ad=6.0000e-12 pd=2.1200e-05 as=2.8000e-12 ps=1.0560e-05 nf=1 m=2 par=2
XMpar7 a_5841_996.t0 ib.t0 vss.t23 vss.t22 nfet_03v3 w=10u l=1.25u ad=2.8000e-12 pd=1.0560e-05 as=2.8000e-12 ps=1.0560e-05 nf=1 m=2 par=2
XMpar8 a_7852_5810.t65 a_7852_5810.t64 vss.t1 vss.t0 nfet_03v3 w=10u l=0.5u ad=2.8000e-12 pd=1.0560e-05 as=2.8000e-12 ps=1.0560e-05 nf=1 m=2 par=2
XMpar9 ib.t1 ib.t0 vss.t23 vss.t22 nfet_03v3 w=10u l=1.25u ad=6.0000e-12 pd=2.1200e-05 as=2.8000e-12 ps=1.0560e-05 nf=1 m=2 par=2
X128 a_4506_6014.t1 out.t13 cap_mim_2f0fF c_width=15.37u c_length=15.37u
X129 a_4004_6014.t66 a_4506_6014.t0 vss.t36 ppolyf_u_1k r_width=1u r_length=1.85u
Rpar0 a_4004_6014.t0 a_4004_6014.t2 103.3904
Rpar1 a_4004_6014.t0 a_4004_6014.t66 130.4560
Rpar2 a_4004_6014.t0 a_4004_6014.t67 98.0083
Rpar3 a_4004_6014.t2 a_4004_6014.t66 113.3680
Rpar4 a_4004_6014.t2 a_4004_6014.t67 288.4532
Rpar5 a_4004_6014.t66 a_4004_6014.t67 363.9646
Rpar6 a_4210_9733.t0 a_4210_9733.t128 53.5765
Rpar7 a_4506_6014.t0 a_4506_6014.t1 75.1115
Rpar8 a_5841_996.t0 a_5841_996.t2 194.1940
Rpar9 a_5841_996.t0 a_5841_996.t3 123.5948
Rpar10 a_5841_996.t2 a_5841_996.t3 25.2173
Rpar11 a_7852_5810.t0 a_7852_5810.t64 442.1432
Rpar12 a_7852_5810.t0 a_7852_5810.t65 72.9458
Rpar13 a_7852_5810.t64 a_7852_5810.t65 46.7738
Rpar14 ib ib.t0 21.5356
Rpar15 ib ib.t1 3.3405
Rpar16 inn inn.t0 3.1915
Rpar17 inp inp.t0 3.1915
Rpar18 out out.t0 1.5962
Rpar19 out out.t13 433.9162
Rpar20 out out.t2 127.8461
Rpar21 out.t0 out.t13 610.8522
Rpar22 out.t0 out.t2 179.9773
Rpar23 out.t13 out.t2 61.8601
Rpar24 vdd vdd.t0 227.3170
Rpar25 vdd vdd.t1 2199.9196
Rpar26 vdd vdd.t6 20.5601
Rpar27 vdd.t0 vdd.t1 5.2640
Rpar28 vdd.t0 vdd.t6 82.3978
Rpar29 vdd.t1 vdd.t6 797.4258
Rpar30 vss vss.t0 150.4908
Rpar31 vss vss.t1 182.5749
Rpar32 vss vss.t22 2047.0999
Rpar33 vss vss.t23 3220.1377
Rpar34 vss vss.t36 87.4705
Rpar35 vss.t0 vss.t1 4.3733
Rpar36 vss.t0 vss.t22 33.4393
Rpar37 vss.t0 vss.t23 62.0897
Rpar38 vss.t0 vss.t36 63.3327
Rpar39 vss.t1 vss.t22 92.3595
Rpar40 vss.t1 vss.t23 166.4608
Rpar41 vss.t1 vss.t36 77.1266
Rpar42 vss.t22 vss.t23 11.9291
Rpar43 vss.t22 vss.t36 865.0837
Rpar44 vss.t23 vss.t36 1360.4712
Cpar0 a_4004_6014.t0 vss 9.30250e-15
Cpar1 a_4004_6014.t2 vss 4.24603e-14
Cpar2 a_4004_6014.t66 vss 2.78272e-15
Cpar3 a_4004_6014.t67 vss 1.19483e-14
Cpar4 a_4210_9733.t0 vss 1.08376e-13
Cpar5 a_4210_9733.t128 vss 1.30015e-14
Cpar6 a_4506_6014.t0 vss 5.05400e-17
Cpar7 a_4506_6014.t1 vss 2.11079e-15
Cpar8 a_5841_996.t0 vss 4.16900e-15
Cpar9 a_5841_996.t2 vss 2.98086e-14
Cpar10 a_5841_996.t3 vss 5.57532e-15
Cpar11 a_7852_5810.t0 vss 5.44420e-14
Cpar12 a_7852_5810.t64 vss 5.07469e-15
Cpar13 a_7852_5810.t65 vss 8.28302e-15
Cpar14 ib out 1.04300e-17
Cpar15 ib vdd 1.34550e-16
Cpar16 ib vss 1.12876e-14
Cpar17 ib.t0 vss 9.70527e-16
Cpar18 ib.t1 vss 5.54850e-16
Cpar19 inn inp 2.00660e-16
Cpar20 inn vdd 2.41708e-14
Cpar21 inn vss 1.02326e-14
Cpar22 inn.t0 vss 3.13599e-14
Cpar23 inp vdd 2.40017e-14
Cpar24 inp vss 1.02083e-14
Cpar25 inp.t0 vss 3.12789e-14
Cpar26 out vdd 1.38916e-14
Cpar27 out vss 2.85528e-14
Cpar28 out.t0 vss 7.86390e-15
Cpar29 out.t13 vss 7.03324e-15
Cpar30 out.t2 vss 1.21195e-14
Cpar31 vdd vss 2.61750e-13
Cpar32 vdd.t0 vss 2.98927e-14
Cpar33 vdd.t1 vss 9.26486e-15
Cpar34 vdd.t6 vss 7.22872e-14
.ends opamp_dut

Vdd vdd 0 3.300000
Vss vss 0 0
Ibias vdd ib 8.125000e-06
Vinp inp 0 DC 1.480000 AC 1 PWL(0 1.480000 3.000000e-09 1.480000 3.300000e-09 1.490000)
Rfb out inn 1m
Cload out 0 2.000000e-13
Xdut vdd vss inp inn out ib opamp_dut
.end
