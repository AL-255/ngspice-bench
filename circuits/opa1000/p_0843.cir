* opa1000[0843]: 200f/telescopic_nmos_1v8_i2u_subth (telescopic_nmos, VDD=1.8V, CL=0.2pF, Iref=0.575uA)
.include "pdk_opa.inc"
.temp 27
.option gmin=1e-12 rshunt=1e12 reltol=1e-3 abstol=1e-12 vntol=1e-5 method=gear
* Post-PEX R+C extracted netlist for telescopic_nmos_1v8_i2u_subth
.subckt opamp_dut vdd vss inp inn out ib
XMpar0 a_4198_17576.t3 a_1424_17368.t0 out.t4 vdd.t0 pfet_03v3 w=1.95u l=1.63u ad=6.3514e-13 pd=2.8800e-06 as=5.4600e-13 ps=2.5100e-06 nf=1 m=56 par=56
XMpar1 a_1864_15539.t0 inp.t0 a_3106_1205.t0 vss.t0 nfet_03v3 w=1.99u l=1.9u ad=6.4817e-13 pd=2.9257e-06 as=5.8752e-13 ps=2.6752e-06 nf=1 m=42 par=42
XMpar2 a_1864_15539.t0 inn.t0 a_8334_1205.t0 vss.t0 nfet_03v3 w=1.99u l=1.9u ad=6.4817e-13 pd=2.9257e-06 as=5.8752e-13 ps=2.6752e-06 nf=1 m=42 par=42
XMpar3 a_1864_15539.t84 ib.t0 vss.t63 vss.t62 nfet_03v3 w=2.73u l=3.25u ad=7.6440e-13 pd=3.2900e-06 as=9.8280e-13 ps=4.1325e-06 nf=1 m=8 par=8
XMpar4 a_1424_17368.t1 a_1424_17368.t0 a_1908_7967.t0 vdd.t0 pfet_03v3 w=1.95u l=1.63u ad=6.3514e-13 pd=2.8800e-06 as=6.3514e-13 ps=2.8800e-06 nf=1 m=56 par=56
XMpar5 a_1424_17368.t112 vdd.t94 a_3106_1205.t42 vss.t0 nfet_03v3 w=1.72u l=1.63u ad=4.8160e-13 pd=2.2800e-06 as=5.9168e-13 ps=2.7520e-06 nf=1 m=10 par=10
XMpar6 a_8334_1205.t42 vdd.t94 out.t0 vss.t0 nfet_03v3 w=1.72u l=1.63u ad=5.9168e-13 pd=2.7520e-06 as=4.8160e-13 ps=2.2800e-06 nf=1 m=10 par=10
XMpar7 a_4198_17576.t0 a_1424_17368.t178 vdd.t12 vdd.t11 pfet_03v3 w=2.01u l=4.25u ad=6.2712e-13 pd=2.8350e-06 as=6.2712e-13 ps=2.8350e-06 nf=1 m=20 par=20
XMpar8 a_1908_7967.t13 a_1424_17368.t178 vdd.t12 vdd.t11 pfet_03v3 w=2.01u l=4.25u ad=6.9144e-13 pd=3.1000e-06 as=6.2712e-13 ps=2.8350e-06 nf=1 m=20 par=20
XMpar9 ib.t1 ib.t0 vss.t63 vss.t62 nfet_03v3 w=2.73u l=3.25u ad=7.6440e-13 pd=3.2900e-06 as=7.6440e-13 ps=3.2900e-06 nf=1 m=2 par=2
Rpar0 a_1424_17368.t0 a_1424_17368.t1 3.6223
Rpar1 a_1424_17368.t0 a_1424_17368.t112 214.1029
Rpar2 a_1424_17368.t0 a_1424_17368.t178 332.5040
Rpar3 a_1424_17368.t1 a_1424_17368.t112 61.1071
Rpar4 a_1424_17368.t1 a_1424_17368.t178 94.9000
Rpar5 a_1424_17368.t112 a_1424_17368.t178 183.6359
Rpar6 a_1864_15539.t0 a_1864_15539.t84 64.8815
Rpar7 a_1908_7967.t0 a_1908_7967.t13 70.3840
Rpar8 a_3106_1205.t0 a_3106_1205.t42 36.8139
Rpar9 a_4198_17576.t0 a_4198_17576.t3 66.6459
Rpar10 a_8334_1205.t0 a_8334_1205.t42 36.8139
Rpar11 ib ib.t0 11.6281
Rpar12 ib ib.t1 10.6530
Rpar13 inn inn.t0 1.6109
Rpar14 inp inp.t0 1.6109
Rpar15 out out.t0 37.9543
Rpar16 out out.t4 6.3492
Rpar17 vdd vdd.t0 151.1233
Rpar18 vdd vdd.t94 793.6108
Rpar19 vdd vdd.t11 27.7084
Rpar20 vdd vdd.t12 2440.3563
Rpar21 vdd.t0 vdd.t94 95.0616
Rpar22 vdd.t0 vdd.t11 81.9765
Rpar23 vdd.t94 vdd.t11 430.4922
Rpar24 vdd.t11 vdd.t12 9.6170
Rpar25 vss vss.t0 51.1558
Rpar26 vss vss.t62 414.4322
Rpar27 vss vss.t63 720.9571
Rpar28 vss.t0 vss.t62 133.8648
Rpar29 vss.t0 vss.t63 232.8826
Rpar30 vss.t62 vss.t63 5.9812
Cpar0 a_1424_17368.t0 vss 1.39581e-13
Cpar1 a_1424_17368.t1 vss 5.44495e-14
Cpar2 a_1424_17368.t112 vss 5.76206e-15
Cpar3 a_1424_17368.t178 vss 1.25713e-13
Cpar4 a_1864_15539.t0 vss 5.37584e-14
Cpar5 a_1864_15539.t84 vss 1.04272e-14
Cpar6 a_1908_7967.t0 vss 7.11628e-14
Cpar7 a_1908_7967.t13 vss 4.53772e-14
Cpar8 a_3106_1205.t0 vss 3.31434e-14
Cpar9 a_3106_1205.t42 vss 5.17564e-15
Cpar10 a_4198_17576.t0 vss 4.95657e-14
Cpar11 a_4198_17576.t3 vss 8.07248e-14
Cpar12 a_8334_1205.t0 vss 3.19908e-14
Cpar13 a_8334_1205.t42 vss 4.99570e-15
Cpar14 ib out 1.28000e-17
Cpar15 ib vdd 6.23650e-16
Cpar16 ib vss 2.48898e-14
Cpar17 ib.t0 vss 5.00612e-15
Cpar18 ib.t1 vss 3.19043e-16
Cpar19 inn inp 1.34710e-16
Cpar20 inn vdd 3.24400e-17
Cpar21 inn vss 3.65410e-14
Cpar22 inn.t0 vss 2.01172e-14
Cpar23 inp vdd 4.20700e-17
Cpar24 inp vss 3.62149e-14
Cpar25 inp.t0 vss 2.01302e-14
Cpar26 out vdd 3.46379e-14
Cpar27 out vss 1.68544e-14
Cpar28 out.t0 vss 7.24499e-15
Cpar29 out.t4 vss 7.15202e-14
Cpar30 vdd vss 5.62525e-13
Cpar31 vdd.t0 vss 1.77270e-13
Cpar32 vdd.t11 vss 1.27615e-13
Cpar33 vdd.t12 vss 1.03723e-14
Cpar34 vdd.t94 vss 7.85407e-15
.ends opamp_dut

Vdd vdd 0 1.800000
Vss vss 0 0
Ibias vdd ib 5.750000e-07
Vinp inp 0 DC 0.931000 AC 1 PWL(0 0.931000 2.077058e-08 0.931000 2.284763e-08 0.941000)
Rfb out inn 1m
Cload out 0 2.000000e-13
Xdut vdd vss inp inn out ib opamp_dut
.end
