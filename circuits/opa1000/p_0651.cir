* opa1000[0651]: 2p/pmos_miller_3v3_0p1u_1u_subth (pmos_miller, VDD=3.3V, CL=2.0pF, Iref=0.0656uA)
.include "pdk_opa.inc"
.temp 27
.option gmin=1e-12 rshunt=1e12 reltol=1e-3 abstol=1e-12 vntol=1e-5 method=gear
* Post-PEX R+C extracted netlist for pmos_miller_3v3_0p1u_1u_subth
.subckt opamp_dut vdd vss inp inn out ib
XMpar0 a_3282_1205.t1 inn.t0 a_8492_7122.t0 vdd.t6 pfet_03v3 w=1.97u l=3.2u ad=6.8432e-13 pd=3.0795e-06 as=5.8478e-13 ps=2.6674e-06 nf=1 m=38 par=38
XMpar1 out.t0 a_1021_12807.t41 vss.t10 vss.t9 nfet_03v3 w=0.59u l=2.5u ad=1.6520e-13 pd=1.1500e-06 as=2.0296e-13 ps=1.3960e-06 nf=1 m=10 par=10
XMpar2 a_1837_8776.t3 a_1837_8776.t2 vdd.t1 vdd.t0 pfet_03v3 w=2.13u l=5u ad=1.2780e-12 pd=5.4600e-06 as=5.9640e-13 ps=2.6900e-06 nf=1 m=2 par=2
XMpar3 a_8492_7122.t39 a_8492_7122.t38 vss.t10 vss.t9 nfet_03v3 w=0.59u l=2.5u ad=1.6520e-13 pd=1.1500e-06 as=1.6520e-13 ps=1.1500e-06 nf=1 m=2 par=2
XMpar4 out.t1 a_1837_8776.t2 vdd.t1 vdd.t0 pfet_03v3 w=2.13u l=5u ad=1.0054e-12 pd=4.3520e-06 as=8.6904e-13 ps=3.7980e-06 nf=1 m=10 par=10
XMpar5 a_1021_12807.t0 inp.t0 a_3282_1205.t1 vdd.t6 pfet_03v3 w=1.97u l=3.2u ad=5.8478e-13 pd=2.6674e-06 as=6.8432e-13 ps=3.0795e-06 nf=1 m=38 par=38
XMpar6 a_3282_1205.t0 a_1837_8776.t2 vdd.t1 vdd.t0 pfet_03v3 w=2.13u l=5u ad=1.2780e-12 pd=5.4600e-06 as=5.9640e-13 ps=2.6900e-06 nf=1 m=4 par=4
XMpar7 a_1021_12807.t39 a_8492_7122.t38 vss.t10 vss.t9 nfet_03v3 w=0.59u l=2.5u ad=3.5400e-13 pd=2.3800e-06 as=1.6520e-13 ps=1.1500e-06 nf=1 m=2 par=2
XMpar8 a_1837_8776.t0 ib.t0 vss.t2 vss.t1 nfet_03v3 w=0.51u l=5u ad=1.4280e-13 pd=1.0700e-06 as=1.4280e-13 ps=1.0700e-06 nf=1 m=2 par=2
XMpar9 ib.t1 ib.t0 vss.t2 vss.t1 nfet_03v3 w=0.51u l=5u ad=3.0600e-13 pd=2.2200e-06 as=1.4280e-13 ps=1.0700e-06 nf=1 m=2 par=2
X4 a_1021_12807.t38 a_17273_9099.t0 vss.t0 ppolyf_u_1k r_width=1u r_length=19.05u
X6 a_13331_11699.t0 a_17273_12219.t0 vss.t0 ppolyf_u_1k r_width=1u r_length=19.05u
X37 a_13331_13779.t1 out.t14 cap_mim_2f0fF c_width=15.29u c_length=15.29u
X44 a_13331_11699.t0 a_17273_11179.t0 vss.t0 ppolyf_u_1k r_width=1u r_length=19.05u
X64 a_13331_10659.t0 a_17273_11179.t0 vss.t0 ppolyf_u_1k r_width=1u r_length=19.05u
X75 a_13331_13779.t0 a_17273_13259.t0 vss.t0 ppolyf_u_1k r_width=1u r_length=19.05u
X77 a_13331_9619.t0 a_17273_9099.t0 vss.t0 ppolyf_u_1k r_width=1u r_length=19.05u
X80 a_13331_10659.t0 a_17273_10139.t0 vss.t0 ppolyf_u_1k r_width=1u r_length=19.05u
X93 a_13331_12739.t0 a_17273_13259.t0 vss.t0 ppolyf_u_1k r_width=1u r_length=19.05u
X99 a_13331_9619.t0 a_17273_10139.t0 vss.t0 ppolyf_u_1k r_width=1u r_length=19.05u
X101 a_13331_13779.t1 out.t14 cap_mim_2f0fF c_width=15.29u c_length=15.29u
X110 a_13331_12739.t0 a_17273_12219.t0 vss.t0 ppolyf_u_1k r_width=1u r_length=19.05u
Rpar0 a_1021_12807.t0 a_1021_12807.t38 227.4680
Rpar1 a_1021_12807.t0 a_1021_12807.t39 83.4371
Rpar2 a_1021_12807.t0 a_1021_12807.t41 79.1949
Rpar3 a_1021_12807.t38 a_1021_12807.t39 433.4117
Rpar4 a_1021_12807.t38 a_1021_12807.t41 122.8146
Rpar5 a_1021_12807.t39 a_1021_12807.t41 150.8959
Rpar6 a_13331_13779.t0 a_13331_13779.t1 74.5211
Rpar7 a_1837_8776.t0 a_1837_8776.t2 167.3367
Rpar8 a_1837_8776.t0 a_1837_8776.t3 75.7600
Rpar9 a_1837_8776.t2 a_1837_8776.t3 13.5055
Rpar10 a_3282_1205.t0 a_3282_1205.t1 61.2127
Rpar11 a_8492_7122.t0 a_8492_7122.t38 176.9049
Rpar12 a_8492_7122.t0 a_8492_7122.t39 172.2022
Rpar13 a_8492_7122.t38 a_8492_7122.t39 28.0713
Rpar14 ib ib.t0 11.5736
Rpar15 ib ib.t1 8.1874
Rpar16 inn inn.t0 1.4328
Rpar17 inp inp.t0 1.4328
Rpar18 out out.t0 54.6003
Rpar19 out out.t1 4.5326
Rpar20 out out.t14 95.8290
Rpar21 out.t0 out.t14 111.3227
Rpar22 vdd vdd.t0 74.9170
Rpar23 vdd vdd.t1 925.5935
Rpar24 vdd vdd.t6 1013.6359
Rpar25 vdd.t0 vdd.t1 12.1294
Rpar26 vdd.t0 vdd.t6 107.0035
Rpar27 vdd.t1 vdd.t6 1322.0185
Rpar28 vss vss.t0 1395.4893
Rpar29 vss vss.t1 93.4349
Rpar30 vss vss.t10 672.8053
Rpar31 vss vss.t9 651.1521
Rpar32 vss vss.t2 777.8051
Rpar33 vss.t0 vss.t1 11.1982
Rpar34 vss.t0 vss.t10 1030.5235
Rpar35 vss.t0 vss.t9 983.3349
Rpar36 vss.t0 vss.t2 159.1255
Rpar37 vss.t1 vss.t10 66.9796
Rpar38 vss.t1 vss.t9 63.9015
Rpar39 vss.t1 vss.t2 10.9163
Rpar40 vss.t10 vss.t9 4.7873
Rpar41 vss.t10 vss.t2 676.9983
Rpar42 vss.t9 vss.t2 646.6809
Cpar0 a_1021_12807.t0 vss 3.10944e-14
Cpar1 a_1021_12807.t38 vss 6.17962e-15
Cpar2 a_1021_12807.t39 vss 4.54056e-15
Cpar3 a_1021_12807.t41 vss 1.51693e-14
Cpar4 a_13331_10659.t0 vss 3.80600e-17
Cpar5 a_13331_11699.t0 vss 3.94800e-17
Cpar6 a_13331_12739.t0 vss 3.20200e-17
Cpar7 a_13331_13779.t0 vss 1.87803e-16
Cpar8 a_13331_13779.t1 vss 5.58334e-15
Cpar9 a_13331_9619.t0 vss 4.38200e-17
Cpar10 a_17273_10139.t0 vss 3.00800e-17
Cpar11 a_17273_11179.t0 vss 2.93600e-17
Cpar12 a_17273_12219.t0 vss 3.00800e-17
Cpar13 a_17273_13259.t0 vss 2.64400e-17
Cpar14 a_17273_9099.t0 vss 3.12200e-17
Cpar15 a_1837_8776.t0 vss 3.18796e-15
Cpar16 a_1837_8776.t2 vss 5.86421e-14
Cpar17 a_1837_8776.t3 vss 9.65971e-15
Cpar18 a_3282_1205.t0 vss 1.99261e-14
Cpar19 a_3282_1205.t1 vss 8.18184e-14
Cpar20 a_8492_7122.t0 vss 3.62609e-14
Cpar21 a_8492_7122.t38 vss 7.79581e-15
Cpar22 a_8492_7122.t39 vss 3.15304e-15
Cpar23 ib inn 1.43100e-17
Cpar24 ib vdd 5.21000e-17
Cpar25 ib vss 1.51659e-14
Cpar26 ib.t0 vss 1.84365e-15
Cpar27 ib.t1 vss 1.03030e-16
Cpar28 inn inp 1.78650e-16
Cpar29 inn vdd 4.52072e-14
Cpar30 inn vss 5.92333e-15
Cpar31 inn.t0 vss 6.72150e-14
Cpar32 inp vdd 4.54520e-14
Cpar33 inp vss 5.54833e-15
Cpar34 inp.t0 vss 6.75561e-14
Cpar35 out vdd 1.52611e-14
Cpar36 out vss 1.95032e-14
Cpar37 out.t0 vss 3.64674e-15
Cpar38 out.t1 vss 9.34793e-15
Cpar39 out.t14 vss 1.86376e-14
Cpar40 vdd vss 4.14878e-13
Cpar41 vdd.t0 vss 6.35527e-14
Cpar42 vdd.t1 vss 9.68958e-15
Cpar43 vdd.t6 vss 1.22655e-13
.ends opamp_dut

Vdd vdd 0 3.300000
Vss vss 0 0
Ibias vdd ib 6.560000e-08
Vinp inp 0 DC 1.480000 AC 1 PWL(0 1.480000 3.961532e-07 1.480000 4.357685e-07 1.490000)
Rfb out inn 1m
Cload out 0 2.000000e-12
Xdut vdd vss inp inn out ib opamp_dut
.end
