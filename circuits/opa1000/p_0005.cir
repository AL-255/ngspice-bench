* opa1000[0005]: 200f/cherry_hooper_1v8_0p1u_1u_weak (cherry_hooper, VDD=1.8V, CL=0.2pF, Iref=0.0464uA)
.include "pdk_opa.inc"
.temp 27
.option gmin=1e-12 rshunt=1e12 reltol=1e-3 abstol=1e-12 vntol=1e-5 method=gear
* Post-PEX R+C extracted netlist for cherry_hooper_1v8_0p1u_1u_weak
.subckt opamp_dut vdd vss inp inn out ib
XMpar0 a_11360_20875.t1 a_11360_20875.t0 vdd.t1 vdd.t0 pfet_03v3 w=0.8u l=1.3u ad=3.0933e-13 pd=1.8400e-06 as=2.2400e-13 ps=1.3600e-06 nf=1 m=3 par=3
XMpar1 a_12494_14614.t2 a_12494_14614.t1 vdd.t1 vdd.t0 pfet_03v3 w=0.8u l=1.3u ad=2.2400e-13 pd=1.3600e-06 as=4.8000e-13 ps=2.8000e-06 nf=1 m=2 par=2
XMpar2 out.t0 a_11360_20875.t0 vdd.t1 vdd.t0 pfet_03v3 w=0.8u l=1.3u ad=3.0933e-13 pd=1.8400e-06 as=2.2400e-13 ps=1.3600e-06 nf=1 m=3 par=3
XMpar3 a_11286_14614.t4 a_12494_3338.t6 a_12494_14614.t0 vss.t0 nfet_03v3 w=6.25u l=3.9u ad=3.7500e-12 pd=1.3700e-05 as=3.7500e-12 ps=1.3700e-05 nf=1 m=1
XMpar4 a_10394_11265.t2 inp.t0 a_11294_11265.t0 vss.t25 nfet_03v3 w=0.4u l=3.9u ad=2.4000e-13 pd=2.0000e-06 as=1.1200e-13 ps=9.6000e-07 nf=1 m=2 par=2
XMpar5 ib.t1 ib.t0 vss.t2 vss.t1 nfet_03v3 w=0.4u l=4u ad=2.4000e-13 pd=2.0000e-06 as=1.1200e-13 ps=9.6000e-07 nf=1 m=1
XMpar6 a_11362_7878.t2 a_11362_7878.t1 a_16463_1294.t0 vdd.t2 pfet_03v3 w=10u l=1u ad=2.8000e-12 pd=1.0560e-05 as=3.2000e-12 ps=1.1890e-05 nf=1 m=16 par=16
XMpar7 a_6651_14658.t0 a_12494_14614.t8 out.t3 vss.t0 nfet_03v3 w=9.37u l=3.9u ad=5.6220e-12 pd=1.9940e-05 as=5.6220e-12 ps=1.9940e-05 nf=1 m=1
XMpar8 a_6651_14658.t1 ib.t0 vss.t2 vss.t1 nfet_03v3 w=0.4u l=4u ad=1.5467e-13 pd=1.3067e-06 as=1.5467e-13 ps=1.3067e-06 nf=1 m=6 par=6
XMpar9 a_10394_11265.t0 ib.t0 vss.t2 vss.t1 nfet_03v3 w=0.4u l=4u ad=2.4000e-13 pd=2.0000e-06 as=1.1200e-13 ps=9.6000e-07 nf=1 m=2 par=2
XMpar10 a_11286_14614.t0 ib.t0 vss.t2 vss.t1 nfet_03v3 w=0.4u l=4u ad=2.4000e-13 pd=2.0000e-06 as=1.7600e-13 ps=1.4800e-06 nf=1 m=4 par=4
XMpar11 a_11294_11265.t2 a_11130_4814.t1 vdd.t20 vdd.t19 pfet_03v3 w=0.42u l=4u ad=2.5200e-13 pd=2.0400e-06 as=2.5200e-13 ps=2.0400e-06 nf=1 m=1
XMpar12 a_10394_11265.t2 inn.t0 a_12494_3338.t0 vss.t25 nfet_03v3 w=0.4u l=3.9u ad=2.4000e-13 pd=2.0000e-06 as=1.1200e-13 ps=9.6000e-07 nf=1 m=2 par=2
XMpar13 a_10941_12691.t5 a_11362_7878.t33 a_11294_11265.t3 vdd.t10 pfet_03v3 w=5.34u l=1u ad=2.0648e-12 pd=7.8933e-06 as=2.0648e-12 ps=7.8933e-06 nf=1 m=3 par=3
XMpar14 a_16463_1294.t16 a_16463_1294.t15 vdd.t1 vdd.t0 pfet_03v3 w=0.8u l=1.3u ad=4.8000e-13 pd=2.8000e-06 as=4.8000e-13 ps=2.8000e-06 nf=1 m=1
XMpar15 a_10941_12691.t2 a_10941_12691.t1 vdd.t1 vdd.t0 pfet_03v3 w=0.8u l=1.3u ad=2.2400e-13 pd=1.3600e-06 as=4.8000e-13 ps=2.8000e-06 nf=1 m=2 par=2
XMpar16 a_11362_7878.t0 ib.t0 vss.t2 vss.t1 nfet_03v3 w=0.4u l=4u ad=2.4000e-13 pd=2.0000e-06 as=2.4000e-13 ps=2.0000e-06 nf=1 m=1
XMpar17 a_11130_4814.t0 ib.t0 vss.t2 vss.t1 nfet_03v3 w=0.4u l=4u ad=2.4000e-13 pd=2.0000e-06 as=1.1200e-13 ps=9.6000e-07 nf=1 m=1
XMpar18 a_12494_14614.t5 a_11362_7878.t33 a_12494_3338.t3 vdd.t10 pfet_03v3 w=5.34u l=1u ad=2.0648e-12 pd=7.8933e-06 as=2.0648e-12 ps=7.8933e-06 nf=1 m=3 par=3
XMpar19 a_11130_4814.t2 a_11130_4814.t1 vdd.t20 vdd.t19 pfet_03v3 w=0.42u l=4u ad=2.5200e-13 pd=2.0400e-06 as=2.5200e-13 ps=2.0400e-06 nf=1 m=1
XMpar20 a_10941_12691.t0 a_11294_11265.t6 a_11286_14614.t4 vss.t0 nfet_03v3 w=6.25u l=3.9u ad=3.7500e-12 pd=1.3700e-05 as=3.7500e-12 ps=1.3700e-05 nf=1 m=1
XMpar21 a_11360_20875.t6 a_10941_12691.t8 a_6651_14658.t0 vss.t0 nfet_03v3 w=9.37u l=3.9u ad=5.6220e-12 pd=1.9940e-05 as=5.6220e-12 ps=1.9940e-05 nf=1 m=1
XMpar22 a_12494_3338.t2 a_11130_4814.t1 vdd.t20 vdd.t19 pfet_03v3 w=0.42u l=4u ad=2.5200e-13 pd=2.0400e-06 as=2.5200e-13 ps=2.0400e-06 nf=1 m=1
X18 out.t4 vss.t29 cap_mim_2f0fF c_width=20u c_length=20u
X19 out.t4 vss.t29 cap_mim_2f0fF c_width=20u c_length=20u
X51 out.t4 vss.t29 cap_mim_2f0fF c_width=20u c_length=20u
X52 out.t4 vss.t29 cap_mim_2f0fF c_width=20u c_length=20u
Rpar0 a_10394_11265.t0 a_10394_11265.t2 49.3063
Rpar1 a_10941_12691.t0 a_10941_12691.t1 231.0369
Rpar2 a_10941_12691.t0 a_10941_12691.t2 154.5572
Rpar3 a_10941_12691.t0 a_10941_12691.t5 357.6368
Rpar4 a_10941_12691.t0 a_10941_12691.t8 53.1473
Rpar5 a_10941_12691.t1 a_10941_12691.t2 36.8810
Rpar6 a_10941_12691.t1 a_10941_12691.t5 284.9208
Rpar7 a_10941_12691.t1 a_10941_12691.t8 346.0457
Rpar8 a_10941_12691.t2 a_10941_12691.t5 190.6041
Rpar9 a_10941_12691.t2 a_10941_12691.t8 231.4950
Rpar10 a_10941_12691.t5 a_10941_12691.t8 535.6664
Rpar11 a_11130_4814.t0 a_11130_4814.t1 53.1584
Rpar12 a_11130_4814.t0 a_11130_4814.t2 312.7650
Rpar13 a_11130_4814.t1 a_11130_4814.t2 30.1941
Rpar14 a_11286_14614.t0 a_11286_14614.t4 112.2675
Rpar15 a_11294_11265.t0 a_11294_11265.t2 273.0249
Rpar16 a_11294_11265.t0 a_11294_11265.t3 69.6693
Rpar17 a_11294_11265.t0 a_11294_11265.t6 118.4368
Rpar18 a_11294_11265.t2 a_11294_11265.t3 150.9186
Rpar19 a_11294_11265.t2 a_11294_11265.t6 516.6098
Rpar20 a_11294_11265.t3 a_11294_11265.t6 131.8262
Rpar21 a_11360_20875.t0 a_11360_20875.t1 20.1825
Rpar22 a_11360_20875.t0 a_11360_20875.t6 116.8519
Rpar23 a_11360_20875.t1 a_11360_20875.t6 62.1225
Rpar24 a_11362_7878.t0 a_11362_7878.t1 530.7468
Rpar25 a_11362_7878.t0 a_11362_7878.t2 79.3438
Rpar26 a_11362_7878.t0 a_11362_7878.t33 264.2144
Rpar27 a_11362_7878.t1 a_11362_7878.t2 17.6791
Rpar28 a_11362_7878.t1 a_11362_7878.t33 500.1220
Rpar29 a_11362_7878.t2 a_11362_7878.t33 74.7656
Rpar30 a_12494_14614.t0 a_12494_14614.t1 247.4334
Rpar31 a_12494_14614.t0 a_12494_14614.t2 165.5260
Rpar32 a_12494_14614.t0 a_12494_14614.t5 274.8700
Rpar33 a_12494_14614.t0 a_12494_14614.t8 53.4763
Rpar34 a_12494_14614.t1 a_12494_14614.t2 37.4626
Rpar35 a_12494_14614.t1 a_12494_14614.t5 215.6472
Rpar36 a_12494_14614.t1 a_12494_14614.t8 363.4240
Rpar37 a_12494_14614.t2 a_12494_14614.t5 144.2620
Rpar38 a_12494_14614.t2 a_12494_14614.t8 243.1205
Rpar39 a_12494_14614.t5 a_12494_14614.t8 403.7222
Rpar40 a_12494_3338.t0 a_12494_3338.t2 356.7246
Rpar41 a_12494_3338.t0 a_12494_3338.t3 95.8725
Rpar42 a_12494_3338.t0 a_12494_3338.t6 83.4648
Rpar43 a_12494_3338.t2 a_12494_3338.t3 130.2539
Rpar44 a_12494_3338.t2 a_12494_3338.t6 500.5453
Rpar45 a_12494_3338.t3 a_12494_3338.t6 134.5255
Rpar46 a_16463_1294.t0 a_16463_1294.t15 160.1212
Rpar47 a_16463_1294.t0 a_16463_1294.t16 72.1702
Rpar48 a_16463_1294.t15 a_16463_1294.t16 51.8751
Rpar49 a_6651_14658.t0 a_6651_14658.t1 51.1163
Rpar50 ib ib.t0 2.5262
Rpar51 ib ib.t1 2224.2016
Rpar52 ib.t0 ib.t1 25.9481
Rpar53 inn inn.t0 3.2588
Rpar54 inp inp.t0 3.3074
Rpar55 out out.t0 102.2489
Rpar56 out out.t3 174.5576
Rpar57 out out.t4 18.4347
Rpar58 out.t0 out.t3 115.8463
Rpar59 out.t0 out.t4 388.5532
Rpar60 out.t3 out.t4 663.3314
Rpar61 vdd vdd.t0 83.8786
Rpar62 vdd vdd.t1 101.6448
Rpar63 vdd vdd.t10 157.5118
Rpar64 vdd vdd.t19 3915.7789
Rpar65 vdd vdd.t2 3345.1507
Rpar66 vdd vdd.t20 1623.4583
Rpar67 vdd.t0 vdd.t1 3.9008
Rpar68 vdd.t0 vdd.t10 156.3446
Rpar69 vdd.t0 vdd.t19 1156.9349
Rpar70 vdd.t0 vdd.t2 342.0444
Rpar71 vdd.t0 vdd.t20 453.5533
Rpar72 vdd.t1 vdd.t10 169.6178
Rpar73 vdd.t1 vdd.t19 949.4914
Rpar74 vdd.t1 vdd.t2 262.9666
Rpar75 vdd.t1 vdd.t20 370.1500
Rpar76 vdd.t10 vdd.t19 315.8373
Rpar77 vdd.t10 vdd.t2 269.8118
Rpar78 vdd.t10 vdd.t20 130.9442
Rpar79 vdd.t19 vdd.t2 239.3851
Rpar80 vdd.t19 vdd.t20 21.3400
Rpar81 vdd.t2 vdd.t20 91.9790
Rpar82 vss vss.t0 2651.4999
Rpar83 vss vss.t1 89.7577
Rpar84 vss vss.t2 178.2365
Rpar85 vss vss.t25 3318.5552
Rpar86 vss vss.t29 71.3356
Rpar87 vss.t0 vss.t1 81.8412
Rpar88 vss.t0 vss.t2 68.0165
Rpar89 vss.t0 vss.t25 314.7261
Rpar90 vss.t0 vss.t29 6076.2163
Rpar91 vss.t1 vss.t2 5.5313
Rpar92 vss.t1 vss.t25 5.5755
Rpar93 vss.t1 vss.t29 205.6900
Rpar94 vss.t2 vss.t25 46.0444
Rpar95 vss.t2 vss.t29 408.4494
Rpar96 vss.t25 vss.t29 7604.8501
Cpar0 a_10394_11265.t0 vss 4.70541e-15
Cpar1 a_10394_11265.t2 vss 4.27645e-15
Cpar2 a_10941_12691.t0 vss 2.86672e-15
Cpar3 a_10941_12691.t1 vss 1.71792e-15
Cpar4 a_10941_12691.t2 vss 1.50001e-15
Cpar5 a_10941_12691.t5 vss 3.67592e-15
Cpar6 a_10941_12691.t8 vss 5.26739e-15
Cpar7 a_11130_4814.t0 vss 2.85234e-15
Cpar8 a_11130_4814.t1 vss 9.94540e-15
Cpar9 a_11130_4814.t2 vss 1.77850e-15
Cpar10 a_11286_14614.t0 vss 6.91106e-15
Cpar11 a_11286_14614.t4 vss 7.66716e-15
Cpar12 a_11294_11265.t0 vss 2.47187e-15
Cpar13 a_11294_11265.t2 vss 2.12774e-15
Cpar14 a_11294_11265.t3 vss 5.52145e-15
Cpar15 a_11294_11265.t6 vss 5.99921e-15
Cpar16 a_11360_20875.t0 vss 5.84423e-15
Cpar17 a_11360_20875.t1 vss 2.39338e-15
Cpar18 a_11360_20875.t6 vss 4.72353e-15
Cpar19 a_11362_7878.t0 vss 1.79468e-15
Cpar20 a_11362_7878.t1 vss 2.17160e-14
Cpar21 a_11362_7878.t2 vss 1.96505e-14
Cpar22 a_11362_7878.t33 vss 6.83404e-15
Cpar23 a_12494_14614.t0 vss 2.97167e-15
Cpar24 a_12494_14614.t1 vss 1.87031e-15
Cpar25 a_12494_14614.t2 vss 1.64282e-15
Cpar26 a_12494_14614.t5 vss 4.07153e-15
Cpar27 a_12494_14614.t8 vss 5.60974e-15
Cpar28 a_12494_3338.t0 vss 2.46304e-15
Cpar29 a_12494_3338.t2 vss 2.92620e-15
Cpar30 a_12494_3338.t3 vss 6.05124e-15
Cpar31 a_12494_3338.t6 vss 5.56214e-15
Cpar32 a_16463_1294.t0 vss 2.58169e-14
Cpar33 a_16463_1294.t15 vss 9.15493e-16
Cpar34 a_16463_1294.t16 vss 1.09826e-15
Cpar35 a_6651_14658.t0 vss 2.83443e-15
Cpar36 a_6651_14658.t1 vss 2.17833e-15
Cpar37 ib out 3.92160e-16
Cpar38 ib vdd 1.11650e-15
Cpar39 ib vss 5.81917e-14
Cpar40 ib.t0 vss 6.04474e-15
Cpar41 ib.t1 vss 6.66934e-16
Cpar42 inn inp 5.23500e-17
Cpar43 inn vdd 8.50800e-17
Cpar44 inn vss 4.46282e-15
Cpar45 inn.t0 vss 3.92684e-16
Cpar46 inp vdd 1.26100e-17
Cpar47 inp vss 4.44156e-15
Cpar48 inp.t0 vss 3.90962e-16
Cpar49 out vdd 3.01866e-15
Cpar50 out vss 3.50643e-14
Cpar51 out.t0 vss 8.49217e-17
Cpar52 out.t3 vss 1.22601e-16
Cpar53 out.t4 vss 1.15909e-14
Cpar54 vdd vss 1.73353e-13
Cpar55 vdd.t0 vss 1.05299e-14
Cpar56 vdd.t1 vss 8.14093e-15
Cpar57 vdd.t10 vss 9.54654e-15
Cpar58 vdd.t19 vss 3.42732e-15
Cpar59 vdd.t2 vss 2.39817e-14
Cpar60 vdd.t20 vss 6.11869e-15
.ends opamp_dut

Vdd vdd 0 1.800000
Vss vss 0 0
Ibias vdd ib 4.640000e-08
Vinp inp 0 DC 1.183000 AC 1 PWL(0 1.183000 3.091024e-07 1.183000 3.400127e-07 1.193000)
Rfb out inn 1m
Cload out 0 2.000000e-13
Xdut vdd vss inp inn out ib opamp_dut
.end
