* opa1000[0216]: 2p/folded_cascode_nmos_1v8_i1u_subth (folded_cascode_nmos, VDD=1.8V, CL=2.0pF, Iref=0.2889uA)
.include "pdk_opa.inc"
.temp 27
.option gmin=1e-12 rshunt=1e12 reltol=1e-3 abstol=1e-12 vntol=1e-5 method=gear
* Post-PEX R+C extracted netlist for folded_cascode_nmos_1v8_i1u_subth
.subckt opamp_dut vdd vss inp inn out ib
XMpar0 a_1978_9609.t3 ib.t10 a_2712_3863.t0 vdd.t12 pfet_03v3 w=1.89u l=2.55u ad=6.3916e-13 pd=2.9100e-06 as=5.8418e-13 ps=2.6800e-06 nf=1 m=22 par=22
XMpar1 a_1546_9609.t4 inp.t0 a_1978_9609.t25 vss.t18 nfet_03v3 w=1.98u l=1.56u ad=6.3043e-13 pd=2.8544e-06 as=5.7974e-13 ps=2.6448e-06 nf=1 m=50 par=50
XMpar2 a_3850_14434.t3 a_3850_14434.t2 vdd.t1 vdd.t0 pfet_03v3 w=6.64u l=3.6u ad=1.8592e-12 pd=7.2000e-06 as=3.9840e-12 ps=1.4480e-05 nf=1 m=2 par=2
XMpar3 a_1546_9609.t4 inn.t0 a_7374_3863.t24 vss.t18 nfet_03v3 w=1.98u l=1.56u ad=6.3043e-13 pd=2.8544e-06 as=5.7974e-13 ps=2.6448e-06 nf=1 m=50 par=50
XMpar4 a_1546_9609.t0 ib.t0 vss.t1 vss.t0 nfet_03v3 w=1.89u l=4.38u ad=5.2920e-13 pd=2.4500e-06 as=5.2920e-13 ps=2.4500e-06 nf=1 m=4 par=4
XMpar5 a_7374_3863.t2 ib.t10 out.t1 vdd.t12 pfet_03v3 w=1.89u l=2.55u ad=6.3916e-13 pd=2.9100e-06 as=5.8418e-13 ps=2.6800e-06 nf=1 m=22 par=22
XMpar6 a_2712_3863.t23 a_2712_3863.t22 vss.t1 vss.t0 nfet_03v3 w=1.89u l=4.38u ad=1.1340e-12 pd=4.9800e-06 as=5.2920e-13 ps=2.4500e-06 nf=1 m=2 par=2
XMpar7 ib.t1 ib.t0 vss.t1 vss.t0 nfet_03v3 w=1.89u l=4.38u ad=1.1340e-12 pd=4.9800e-06 as=5.2920e-13 ps=2.4500e-06 nf=1 m=2 par=2
XMpar8 a_7374_3863.t0 a_3850_14434.t2 vdd.t1 vdd.t0 pfet_03v3 w=6.64u l=3.6u ad=1.8592e-12 pd=7.2000e-06 as=2.9216e-12 ps=1.0840e-05 nf=1 m=4 par=4
XMpar9 out.t0 a_2712_3863.t22 vss.t1 vss.t0 nfet_03v3 w=1.89u l=4.38u ad=5.2920e-13 pd=2.4500e-06 as=5.2920e-13 ps=2.4500e-06 nf=1 m=2 par=2
XMpar10 a_1978_9609.t0 a_3850_14434.t2 vdd.t1 vdd.t0 pfet_03v3 w=6.64u l=3.6u ad=1.8592e-12 pd=7.2000e-06 as=2.9216e-12 ps=1.0840e-05 nf=1 m=4 par=4
XMpar11 a_3850_14434.t0 ib.t0 vss.t1 vss.t0 nfet_03v3 w=1.89u l=4.38u ad=5.2920e-13 pd=2.4500e-06 as=5.2920e-13 ps=2.4500e-06 nf=1 m=2 par=2
Rpar0 a_1546_9609.t0 a_1546_9609.t4 37.6761
Rpar1 a_1978_9609.t0 a_1978_9609.t3 154.8621
Rpar2 a_1978_9609.t0 a_1978_9609.t25 49.4312
Rpar3 a_1978_9609.t3 a_1978_9609.t25 66.5859
Rpar4 a_2712_3863.t0 a_2712_3863.t22 192.4817
Rpar5 a_2712_3863.t0 a_2712_3863.t23 85.2644
Rpar6 a_2712_3863.t22 a_2712_3863.t23 18.3254
Rpar7 a_3850_14434.t0 a_3850_14434.t2 83.4699
Rpar8 a_3850_14434.t0 a_3850_14434.t3 58.2639
Rpar9 a_3850_14434.t2 a_3850_14434.t3 24.5918
Rpar10 a_7374_3863.t0 a_7374_3863.t2 154.8621
Rpar11 a_7374_3863.t0 a_7374_3863.t24 49.4312
Rpar12 a_7374_3863.t2 a_7374_3863.t24 66.5859
Rpar13 ib ib.t0 157.0177
Rpar14 ib ib.t1 82.1970
Rpar15 ib ib.t10 1.5016
Rpar16 ib.t0 ib.t1 18.1995
Rpar17 inn inn.t0 1.5704
Rpar18 inp inp.t0 1.5704
Rpar19 out out.t0 63.7770
Rpar20 out out.t1 2.8742
Rpar21 vdd vdd.t0 45.4424
Rpar22 vdd vdd.t1 117.3813
Rpar23 vdd vdd.t12 140.2484
Rpar24 vdd.t0 vdd.t1 4.9185
Rpar25 vdd.t0 vdd.t12 118.3878
Rpar26 vdd.t1 vdd.t12 124.6738
Rpar27 vss vss.t0 101.4136
Rpar28 vss vss.t1 261.0590
Rpar29 vss vss.t18 141.1212
Rpar30 vss.t0 vss.t1 6.7835
Rpar31 vss.t0 vss.t18 1.5671
Rpar32 vss.t1 vss.t18 8.1343
Cpar0 a_1546_9609.t0 vss 7.74162e-15
Cpar1 a_1546_9609.t4 vss 6.58576e-14
Cpar2 a_1978_9609.t0 vss 8.85664e-15
Cpar3 a_1978_9609.t25 vss 3.73509e-14
Cpar4 a_1978_9609.t3 vss 2.10553e-14
Cpar5 a_2712_3863.t0 vss 1.45295e-14
Cpar6 a_2712_3863.t22 vss 1.01887e-14
Cpar7 a_2712_3863.t23 vss 3.75412e-15
Cpar8 a_3850_14434.t0 vss 3.38044e-15
Cpar9 a_3850_14434.t2 vss 3.35950e-14
Cpar10 a_3850_14434.t3 vss 3.86386e-15
Cpar11 a_7374_3863.t0 vss 8.79480e-15
Cpar12 a_7374_3863.t2 vss 2.09083e-14
Cpar13 a_7374_3863.t24 vss 3.70901e-14
Cpar14 ib out 7.24069e-15
Cpar15 ib vdd 4.81308e-14
Cpar16 ib vss 3.37655e-14
Cpar17 ib.t0 vss 1.73064e-14
Cpar18 ib.t1 vss 3.78053e-15
Cpar19 ib.t10 vss 5.36951e-14
Cpar20 inn inp 1.38990e-16
Cpar21 inn out 9.88000e-17
Cpar22 inn vdd 1.48500e-17
Cpar23 inn vss 3.70599e-14
Cpar24 inn.t0 vss 2.13833e-14
Cpar25 inp vdd 1.77180e-16
Cpar26 inp vss 3.69471e-14
Cpar27 inp.t0 vss 2.14439e-14
Cpar28 out vdd 6.68198e-15
Cpar29 out vss 1.29941e-14
Cpar30 out.t0 vss 5.09520e-15
Cpar31 out.t1 vss 1.59892e-14
Cpar32 vdd vss 2.45566e-13
Cpar33 vdd.t0 vss 2.37524e-14
Cpar34 vdd.t1 vss 1.69822e-14
Cpar35 vdd.t12 vss 6.07661e-14
.ends opamp_dut

Vdd vdd 0 1.800000
Vss vss 0 0
Ibias vdd ib 2.889000e-07
Vinp inp 0 DC 0.985000 AC 1 PWL(0 0.985000 1.674107e-07 0.985000 1.841518e-07 0.995000)
Rfb out inn 1m
Cload out 0 2.000000e-12
Xdut vdd vss inp inn out ib opamp_dut
.end
