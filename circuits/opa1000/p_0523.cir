* opa1000[0523]: 200f/pmos_5t_3v3_i50n_subth (pmos_5t, VDD=3.3V, CL=0.2pF, Iref=0.013uA)
.include "pdk_opa.inc"
.temp 27
.option gmin=1e-12 rshunt=1e12 reltol=1e-3 abstol=1e-12 vntol=1e-5 method=gear
* Post-PEX R+C extracted netlist for pmos_5t_3v3_i50n_subth
.subckt opamp_dut vdd vss inp inn out ib
XMpar0 a_1426_1204.t8 a_1728_9420.t2 vdd.t5 vdd.t4 pfet_03v3 w=0.63u l=7.5u ad=1.7640e-13 pd=1.1900e-06 as=3.2760e-13 ps=2.1425e-06 nf=1 m=8 par=8
XMpar1 a_1728_9420.t0 ib.t0 vss.t7 vss.t6 nfet_03v3 w=0.4u l=7.5u ad=1.1200e-13 pd=9.6000e-07 as=1.1200e-13 ps=9.6000e-07 nf=1 m=2 par=2
XMpar2 a_1426_1204.t0 inn.t0 out.t2 vdd.t0 pfet_03v3 w=8u l=6.88u ad=3.5200e-12 pd=1.2880e-05 as=2.2400e-12 ps=8.5600e-06 nf=1 m=8 par=8
XMpar3 a_1426_1204.t0 inp.t0 a_2922_1204.t0 vdd.t0 pfet_03v3 w=8u l=6.88u ad=3.5200e-12 pd=1.2880e-05 as=2.2400e-12 ps=8.5600e-06 nf=1 m=8 par=8
XMpar4 out.t0 a_2922_1204.t8 vss.t1 vss.t0 nfet_03v3 w=0.4u l=9.75u ad=1.1200e-13 pd=9.6000e-07 as=1.1200e-13 ps=9.6000e-07 nf=1 m=2 par=2
XMpar5 ib.t1 ib.t0 vss.t7 vss.t6 nfet_03v3 w=0.4u l=7.5u ad=2.4000e-13 pd=2.0000e-06 as=1.1200e-13 ps=9.6000e-07 nf=1 m=2 par=2
XMpar6 a_2922_1204.t9 a_2922_1204.t8 vss.t1 vss.t0 nfet_03v3 w=0.4u l=9.75u ad=2.4000e-13 pd=2.0000e-06 as=1.1200e-13 ps=9.6000e-07 nf=1 m=2 par=2
XMpar7 a_1728_9420.t3 a_1728_9420.t2 vdd.t5 vdd.t4 pfet_03v3 w=0.63u l=7.5u ad=3.7800e-13 pd=2.4600e-06 as=1.7640e-13 ps=1.1900e-06 nf=1 m=2 par=2
Rpar0 a_1426_1204.t0 a_1426_1204.t8 50.8487
Rpar1 a_1728_9420.t0 a_1728_9420.t2 88.4919
Rpar2 a_1728_9420.t0 a_1728_9420.t3 138.9231
Rpar3 a_1728_9420.t2 a_1728_9420.t3 15.7479
Rpar4 a_2922_1204.t0 a_2922_1204.t8 113.5456
Rpar5 a_2922_1204.t0 a_2922_1204.t9 90.3314
Rpar6 a_2922_1204.t8 a_2922_1204.t9 23.3308
Rpar7 ib ib.t0 21.8108
Rpar8 ib ib.t1 10.1368
Rpar9 ib.t0 ib.t1 58.4563
Rpar10 inn inn.t0 2.6952
Rpar11 inp inp.t0 2.6952
Rpar12 out out.t0 18.5804
Rpar13 out out.t2 54.4043
Rpar14 out.t0 out.t2 194.3379
Rpar15 vdd vdd.t0 90.9448
Rpar16 vdd vdd.t4 37.8852
Rpar17 vdd vdd.t5 390.1690
Rpar18 vdd.t0 vdd.t4 227.3298
Rpar19 vdd.t0 vdd.t5 2341.2042
Rpar20 vdd.t4 vdd.t5 12.8134
Rpar21 vss vss.t0 144.5630
Rpar22 vss vss.t1 600.1819
Rpar23 vss vss.t6 279.4001
Rpar24 vss vss.t7 595.4176
Rpar25 vss.t0 vss.t1 20.0471
Rpar26 vss.t0 vss.t6 2.3879
Rpar27 vss.t0 vss.t7 20.5011
Rpar28 vss.t1 vss.t6 42.1119
Rpar29 vss.t1 vss.t7 95.4736
Rpar30 vss.t6 vss.t7 34.1532
Cpar0 a_1426_1204.t0 vss 4.63229e-14
Cpar1 a_1426_1204.t8 vss 1.19642e-14
Cpar2 a_1728_9420.t0 vss 5.25055e-15
Cpar3 a_1728_9420.t2 vss 4.88136e-14
Cpar4 a_1728_9420.t3 vss 8.40087e-15
Cpar5 a_2922_1204.t0 vss 1.20699e-14
Cpar6 a_2922_1204.t8 vss 1.09101e-14
Cpar7 a_2922_1204.t9 vss 2.68790e-15
Cpar8 ib vdd 3.01300e-17
Cpar9 ib vss 2.07208e-14
Cpar10 ib.t0 vss 2.55711e-15
Cpar11 ib.t1 vss 1.53191e-16
Cpar12 inn inp 1.04540e-16
Cpar13 inn out 6.96833e-15
Cpar14 inn vdd 2.23343e-14
Cpar15 inn vss 6.20179e-15
Cpar16 inn.t0 vss 3.16254e-14
Cpar17 inp vdd 2.21227e-14
Cpar18 inp vss 5.90467e-15
Cpar19 inp.t0 vss 3.14391e-14
Cpar20 out vdd 6.19859e-15
Cpar21 out vss 1.19403e-14
Cpar22 out.t0 vss 1.13524e-15
Cpar23 out.t2 vss 1.93003e-14
Cpar24 vdd vss 3.26600e-13
Cpar25 vdd.t0 vss 7.84310e-14
Cpar26 vdd.t4 vss 3.20958e-14
Cpar27 vdd.t5 vss 5.06388e-15
.ends opamp_dut

Vdd vdd 0 3.300000
Vss vss 0 0
Ibias vdd ib 1.300000e-08
Vinp inp 0 DC 1.480000 AC 1 PWL(0 1.480000 2.658314e-07 1.480000 2.924145e-07 1.490000)
Rfb out inn 1m
Cload out 0 2.000000e-13
Xdut vdd vss inp inn out ib opamp_dut
.end
