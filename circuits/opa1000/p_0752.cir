* opa1000[0752]: 200f/symmetrical_ota_1v8_i50n_subth (symmetrical_ota, VDD=1.8V, CL=0.2pF, Iref=0.0083uA)
.include "pdk_opa.inc"
.temp 27
.option gmin=1e-12 rshunt=1e12 reltol=1e-3 abstol=1e-12 vntol=1e-5 method=gear
* Post-PEX R+C extracted netlist for symmetrical_ota_1v8_i50n_subth
.subckt opamp_dut vdd vss inp inn out ib
XMpar0 a_4314_2776.t4 ib.t0 vss.t16 vss.t15 nfet_03v3 w=0.4u l=5u ad=1.1200e-13 pd=9.6000e-07 as=1.7600e-13 ps=1.4800e-06 nf=1 m=4 par=4
XMpar1 out.t0 a_1724_4646.t2 vdd.t1 vdd.t0 pfet_03v3 w=0.4u l=6.5u ad=2.4000e-13 pd=2.0000e-06 as=1.7600e-13 ps=1.4800e-06 nf=1 m=4 par=4
XMpar2 out.t1 a_4438_7576.t0 vss.t3 vss.t2 nfet_03v3 w=0.4u l=6.5u ad=2.4000e-13 pd=2.0000e-06 as=1.1200e-13 ps=9.6000e-07 nf=1 m=4 par=4
XMpar3 a_1724_4646.t3 a_1724_4646.t2 vdd.t1 vdd.t0 pfet_03v3 w=0.4u l=6.5u ad=2.4000e-13 pd=2.0000e-06 as=1.1200e-13 ps=9.6000e-07 nf=1 m=2 par=2
XMpar4 a_4438_7576.t8 a_7796_4646.t2 vdd.t1 vdd.t0 pfet_03v3 w=0.4u l=6.5u ad=2.4000e-13 pd=2.0000e-06 as=1.7600e-13 ps=1.4800e-06 nf=1 m=4 par=4
XMpar5 a_1724_4646.t0 inp.t0 a_4314_2776.t0 vss.t0 nfet_03v3 w=1.07u l=5.5u ad=2.9960e-13 pd=1.6300e-06 as=6.4200e-13 ps=3.3400e-06 nf=1 m=2 par=2
XMpar6 a_7796_4646.t3 a_7796_4646.t2 vdd.t1 vdd.t0 pfet_03v3 w=0.4u l=6.5u ad=2.4000e-13 pd=2.0000e-06 as=1.1200e-13 ps=9.6000e-07 nf=1 m=2 par=2
XMpar7 a_4438_7576.t1 a_4438_7576.t0 vss.t3 vss.t2 nfet_03v3 w=0.4u l=6.5u ad=1.1200e-13 pd=9.6000e-07 as=1.1200e-13 ps=9.6000e-07 nf=1 m=4 par=4
XMpar8 a_4314_2776.t0 inn.t0 a_7796_4646.t0 vss.t0 nfet_03v3 w=1.07u l=5.5u ad=6.4200e-13 pd=3.3400e-06 as=2.9960e-13 ps=1.6300e-06 nf=1 m=2 par=2
XMpar9 ib.t1 ib.t0 vss.t16 vss.t15 nfet_03v3 w=0.4u l=5u ad=1.1200e-13 pd=9.6000e-07 as=1.1200e-13 ps=9.6000e-07 nf=1 m=2 par=2
X7 out.t8 vss.t11 cap_mim_2f0fF c_width=10u c_length=10u
Rpar0 a_1724_4646.t0 a_1724_4646.t2 100.5236
Rpar1 a_1724_4646.t0 a_1724_4646.t3 150.9209
Rpar2 a_1724_4646.t2 a_1724_4646.t3 15.8979
Rpar3 a_4314_2776.t0 a_4314_2776.t4 68.7540
Rpar4 a_4438_7576.t0 a_4438_7576.t1 15.1327
Rpar5 a_4438_7576.t0 a_4438_7576.t8 91.7056
Rpar6 a_4438_7576.t1 a_4438_7576.t8 86.1064
Rpar7 a_7796_4646.t0 a_7796_4646.t2 101.0932
Rpar8 a_7796_4646.t0 a_7796_4646.t3 151.7768
Rpar9 a_7796_4646.t2 a_7796_4646.t3 15.8922
Rpar10 ib ib.t0 20.6792
Rpar11 ib ib.t1 19.4542
Rpar12 ib.t0 ib.t1 91.1607
Rpar13 inn inn.t0 3.4777
Rpar14 inp inp.t0 3.5263
Rpar15 out out.t0 6.2977
Rpar16 out out.t1 54.9940
Rpar17 out out.t8 65.2340
Rpar18 out.t1 out.t8 271.6196
Rpar19 vdd vdd.t0 174.7615
Rpar20 vdd vdd.t1 75.7374
Rpar21 vdd.t0 vdd.t1 7.6089
Rpar22 vss vss.t0 414.7191
Rpar23 vss vss.t3 206.6520
Rpar24 vss vss.t11 81.8340
Rpar25 vss vss.t2 502.0277
Rpar26 vss vss.t15 101.2049
Rpar27 vss vss.t16 444.9445
Rpar28 vss.t0 vss.t3 2715.6087
Rpar29 vss.t0 vss.t11 1100.2080
Rpar30 vss.t0 vss.t15 8.8274
Rpar31 vss.t0 vss.t16 37.7483
Rpar32 vss.t3 vss.t11 222.9508
Rpar33 vss.t3 vss.t2 17.7769
Rpar34 vss.t3 vss.t15 661.7826
Rpar35 vss.t3 vss.t16 2905.6546
Rpar36 vss.t11 vss.t2 542.0233
Rpar37 vss.t11 vss.t15 268.4836
Rpar38 vss.t11 vss.t16 1180.3676
Rpar39 vss.t2 vss.t15 1352.0272
Rpar40 vss.t15 vss.t16 9.0188
Cpar0 a_1724_4646.t0 vss 3.89759e-15
Cpar1 a_1724_4646.t2 vss 2.68801e-14
Cpar2 a_1724_4646.t3 vss 6.10118e-15
Cpar3 a_4314_2776.t0 vss 4.84320e-15
Cpar4 a_4314_2776.t4 vss 4.81980e-15
Cpar5 a_4438_7576.t0 vss 1.46483e-14
Cpar6 a_4438_7576.t1 vss 3.03359e-15
Cpar7 a_4438_7576.t8 vss 4.91041e-15
Cpar8 a_7796_4646.t0 vss 3.96821e-15
Cpar9 a_7796_4646.t2 vss 2.66970e-14
Cpar10 a_7796_4646.t3 vss 6.09247e-15
Cpar11 ib inn 2.49900e-17
Cpar12 ib inp 2.45300e-17
Cpar13 ib vss 2.13391e-14
Cpar14 ib.t0 vss 2.64923e-15
Cpar15 ib.t1 vss 1.21094e-16
Cpar16 inn inp 5.23500e-17
Cpar17 inn vss 5.98031e-15
Cpar18 inn.t0 vss 5.48155e-16
Cpar19 inp vss 5.83297e-15
Cpar20 inp.t0 vss 5.87400e-16
Cpar21 out vdd 7.61800e-15
Cpar22 out vss 2.26294e-14
Cpar23 out.t0 vss 1.01039e-15
Cpar24 out.t1 vss 3.11340e-15
Cpar25 out.t8 vss 1.43886e-14
Cpar26 vdd vss 1.14954e-13
Cpar27 vdd.t0 vss 5.26518e-14
Cpar28 vdd.t1 vss 1.17982e-14
.ends opamp_dut

Vdd vdd 0 1.800000
Vss vss 0 0
Ibias vdd ib 8.300000e-09
Vinp inp 0 DC 0.895000 AC 1 PWL(0 0.895000 7.736032e-07 0.895000 8.509636e-07 0.905000)
Rfb out inn 1m
Cload out 0 2.000000e-13
Xdut vdd vss inp inn out ib opamp_dut
.end
