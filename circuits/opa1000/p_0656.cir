* opa1000[0656]: 2p/pmos_miller_3v3_i2u_subth (pmos_miller, VDD=3.3V, CL=2.0pF, Iref=0.2875uA)
.include "pdk_opa.inc"
.temp 27
.option gmin=1e-12 rshunt=1e12 reltol=1e-3 abstol=1e-12 vntol=1e-5 method=gear
* Post-PEX R+C extracted netlist for pmos_miller_3v3_i2u_subth
.subckt opamp_dut vdd vss inp inn out ib
XMpar0 a_3549_6095.t0 a_1877_5887.t0 vdd.t1 vdd.t0 pfet_03v3 w=7.21u l=3.9u ad=4.3260e-12 pd=1.5620e-05 as=2.0188e-12 ps=7.7700e-06 nf=1 m=4 par=4
XMpar1 a_3549_6095.t1 inp.t0 a_3946_1339.t1 vdd.t11 pfet_03v3 w=1.9u l=1.14u ad=5.7877e-13 pd=2.6554e-06 as=5.7877e-13 ps=2.6554e-06 nf=1 m=26 par=26
XMpar2 a_3549_6095.t1 inn.t0 a_7888_4107.t0 vdd.t11 pfet_03v3 w=1.9u l=1.14u ad=5.7877e-13 pd=2.6554e-06 as=5.7877e-13 ps=2.6554e-06 nf=1 m=26 par=26
XMpar3 out.t0 a_1877_5887.t0 vdd.t1 vdd.t0 pfet_03v3 w=7.21u l=3.9u ad=3.4031e-12 pd=1.2480e-05 as=2.9417e-12 ps=1.0910e-05 nf=1 m=10 par=10
XMpar4 out.t1 a_3946_1339.t29 vss.t1 vss.t0 nfet_03v3 w=1u l=0.81u ad=3.4400e-13 pd=1.8880e-06 as=3.4400e-13 ps=1.8880e-06 nf=1 m=10 par=10
XMpar5 a_7888_4107.t27 a_7888_4107.t26 vss.t1 vss.t0 nfet_03v3 w=1u l=0.81u ad=2.8000e-13 pd=1.5600e-06 as=2.8000e-13 ps=1.5600e-06 nf=1 m=2 par=2
XMpar6 a_3946_1339.t27 a_7888_4107.t26 vss.t1 vss.t0 nfet_03v3 w=1u l=0.81u ad=6.0000e-13 pd=3.2000e-06 as=2.8000e-13 ps=1.5600e-06 nf=1 m=2 par=2
XMpar7 ib.t1 ib.t0 vss.t9 vss.t8 nfet_03v3 w=1.67u l=3.9u ad=1.0020e-12 pd=4.5400e-06 as=4.6760e-13 ps=2.2300e-06 nf=1 m=2 par=2
XMpar8 a_1877_5887.t1 a_1877_5887.t0 vdd.t1 vdd.t0 pfet_03v3 w=7.21u l=3.9u ad=4.3260e-12 pd=1.5620e-05 as=2.0188e-12 ps=7.7700e-06 nf=1 m=2 par=2
XMpar9 a_1877_5887.t4 ib.t0 vss.t9 vss.t8 nfet_03v3 w=1.67u l=3.9u ad=4.6760e-13 pd=2.2300e-06 as=4.6760e-13 ps=2.2300e-06 nf=1 m=2 par=2
X1 a_11399_13238.t1 out.t14 cap_mim_2f0fF c_width=14.37u c_length=14.36u
X4 a_11399_13238.t1 out.t14 cap_mim_2f0fF c_width=14.37u c_length=14.36u
X29 a_8505_12718.t0 a_11399_13238.t0 vss.t22 ppolyf_u_1k r_width=1u r_length=13.81u
X38 a_8505_12718.t0 a_11399_12198.t0 vss.t22 ppolyf_u_1k r_width=1u r_length=13.81u
X74 a_3946_1339.t0 a_11399_12198.t0 vss.t22 ppolyf_u_1k r_width=1u r_length=13.81u
Rpar0 a_11399_13238.t0 a_11399_13238.t1 69.7384
Rpar1 a_1877_5887.t0 a_1877_5887.t1 12.8648
Rpar2 a_1877_5887.t0 a_1877_5887.t4 182.0776
Rpar3 a_1877_5887.t1 a_1877_5887.t4 64.6825
Rpar4 a_3549_6095.t0 a_3549_6095.t1 50.0933
Rpar5 a_3946_1339.t0 a_3946_1339.t1 566.2963
Rpar6 a_3946_1339.t0 a_3946_1339.t27 551.7443
Rpar7 a_3946_1339.t0 a_3946_1339.t29 167.2205
Rpar8 a_3946_1339.t1 a_3946_1339.t27 68.5501
Rpar9 a_3946_1339.t1 a_3946_1339.t29 139.9460
Rpar10 a_3946_1339.t27 a_3946_1339.t29 136.3498
Rpar11 a_7888_4107.t0 a_7888_4107.t26 119.8506
Rpar12 a_7888_4107.t0 a_7888_4107.t27 94.5639
Rpar13 a_7888_4107.t26 a_7888_4107.t27 31.8864
Rpar14 ib ib.t0 12.0989
Rpar15 ib ib.t1 5.2709
Rpar16 inn inn.t0 1.6586
Rpar17 inp inp.t0 1.6586
Rpar18 out out.t0 3.8503
Rpar19 out out.t1 1205.5944
Rpar20 out out.t14 4969.6063
Rpar21 out.t0 out.t1 42.2782
Rpar22 out.t0 out.t14 174.2759
Rpar23 out.t1 out.t14 99.9318
Rpar24 vdd vdd.t0 7481.9255
Rpar25 vdd vdd.t1 133.4752
Rpar26 vdd vdd.t11 303.7151
Rpar27 vdd.t0 vdd.t1 12.5935
Rpar28 vdd.t0 vdd.t11 7531.5603
Rpar29 vdd.t1 vdd.t11 134.3606
Rpar30 vss vss.t0 136.4563
Rpar31 vss vss.t1 207.3712
Rpar32 vss vss.t8 256.6841
Rpar33 vss vss.t9 717.0323
Rpar34 vss vss.t22 547.7026
Rpar35 vss.t0 vss.t1 8.0532
Rpar36 vss.t0 vss.t8 1.7526
Rpar37 vss.t0 vss.t9 14.3505
Rpar38 vss.t0 vss.t22 44.7127
Rpar39 vss.t1 vss.t8 31.7652
Rpar40 vss.t1 vss.t9 160.2979
Rpar41 vss.t1 vss.t22 282.3324
Rpar42 vss.t8 vss.t9 19.7792
Rpar43 vss.t8 vss.t22 64.2109
Rpar44 vss.t9 vss.t22 178.6769
Cpar0 a_11399_12198.t0 vss 3.75200e-17
Cpar1 a_11399_13238.t0 vss 1.09711e-16
Cpar2 a_11399_13238.t1 vss 5.29938e-15
Cpar3 a_1877_5887.t0 vss 6.25123e-14
Cpar4 a_1877_5887.t1 vss 8.46946e-15
Cpar5 a_1877_5887.t4 vss 2.19088e-15
Cpar6 a_3549_6095.t0 vss 2.49568e-14
Cpar7 a_3549_6095.t1 vss 3.46124e-14
Cpar8 a_3946_1339.t0 vss 4.72357e-15
Cpar9 a_3946_1339.t1 vss 1.36009e-14
Cpar10 a_3946_1339.t27 vss 3.18653e-15
Cpar11 a_3946_1339.t29 vss 8.54292e-15
Cpar12 a_7888_4107.t0 vss 1.77111e-14
Cpar13 a_7888_4107.t26 vss 3.52532e-15
Cpar14 a_7888_4107.t27 vss 1.96206e-15
Cpar15 a_8505_12718.t0 vss 5.10200e-17
Cpar16 ib vdd 1.43010e-16
Cpar17 ib vss 1.30801e-14
Cpar18 ib.t0 vss 1.71133e-15
Cpar19 ib.t1 vss 1.09880e-16
Cpar20 inn inp 1.03280e-16
Cpar21 inn vdd 1.61704e-14
Cpar22 inn vss 5.11473e-15
Cpar23 inn.t0 vss 2.05522e-14
Cpar24 inp vdd 1.61318e-14
Cpar25 inp vss 4.96844e-15
Cpar26 inp.t0 vss 2.04672e-14
Cpar27 out vdd 1.68420e-14
Cpar28 out vss 1.92160e-14
Cpar29 out.t0 vss 1.65837e-14
Cpar30 out.t1 vss 4.26937e-15
Cpar31 out.t14 vss 1.72969e-14
Cpar32 vdd vss 2.71706e-13
Cpar33 vdd.t0 vss 6.64574e-14
Cpar34 vdd.t1 vss 1.31930e-14
Cpar35 vdd.t11 vss 4.03496e-14
.ends opamp_dut

Vdd vdd 0 3.300000
Vss vss 0 0
Ibias vdd ib 2.875000e-07
Vinp inp 0 DC 1.480000 AC 1 PWL(0 1.480000 8.470873e-08 1.480000 9.317960e-08 1.490000)
Rfb out inn 1m
Cload out 0 2.000000e-12
Xdut vdd vss inp inn out ib opamp_dut
.end
