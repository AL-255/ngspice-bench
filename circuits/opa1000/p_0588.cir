* opa1000[0588]: 200f/pmos_miller_1v8_i200n_subth (pmos_miller, VDD=1.8V, CL=0.2pF, Iref=0.0287uA)
.include "pdk_opa.inc"
.temp 27
.option gmin=1e-12 rshunt=1e12 reltol=1e-3 abstol=1e-12 vntol=1e-5 method=gear
* Post-PEX R+C extracted netlist for pmos_miller_1v8_i200n_subth
.subckt opamp_dut vdd vss inp inn out ib
XMpar0 out.t0 a_1590_4485.t2 vdd.t1 vdd.t0 pfet_03v3 w=0.55u l=3u ad=2.5960e-13 pd=1.8240e-06 as=2.2440e-13 ps=1.5860e-06 nf=1 m=10 par=10
XMpar1 ib.t1 ib.t0 vss.t10 vss.t9 nfet_03v3 w=0.4u l=3u ad=2.4000e-13 pd=2.0000e-06 as=1.1200e-13 ps=9.6000e-07 nf=1 m=2 par=2
XMpar2 a_2902_4693.t0 a_1590_4485.t2 vdd.t1 vdd.t0 pfet_03v3 w=0.55u l=3u ad=3.3000e-13 pd=2.3000e-06 as=1.5400e-13 ps=1.1100e-06 nf=1 m=4 par=4
XMpar3 a_1590_4485.t0 ib.t0 vss.t10 vss.t9 nfet_03v3 w=0.4u l=3u ad=1.1200e-13 pd=9.6000e-07 as=1.1200e-13 ps=9.6000e-07 nf=1 m=2 par=2
XMpar4 a_1590_4485.t3 a_1590_4485.t2 vdd.t1 vdd.t0 pfet_03v3 w=0.55u l=3u ad=3.3000e-13 pd=2.3000e-06 as=1.5400e-13 ps=1.1100e-06 nf=1 m=2 par=2
XMpar5 a_2902_4693.t1 inn.t0 a_6164_1041.t0 vdd.t14 pfet_03v3 w=1.59u l=2.88u ad=6.9960e-13 pd=3.2650e-06 as=4.4520e-13 ps=2.1500e-06 nf=1 m=4 par=4
XMpar6 a_2902_4693.t1 inp.t0 a_4272_8088.t1 vdd.t14 pfet_03v3 w=1.59u l=2.88u ad=6.9960e-13 pd=3.2650e-06 as=4.4520e-13 ps=2.1500e-06 nf=1 m=4 par=4
XMpar7 out.t2 a_4272_8088.t7 vss.t2 vss.t1 nfet_03v3 w=0.4u l=1.92u ad=1.3760e-13 pd=1.1680e-06 as=1.3760e-13 ps=1.1680e-06 nf=1 m=10 par=10
XMpar8 a_4272_8088.t5 a_6164_1041.t4 vss.t2 vss.t1 nfet_03v3 w=0.4u l=1.92u ad=2.4000e-13 pd=2.0000e-06 as=1.1200e-13 ps=9.6000e-07 nf=1 m=2 par=2
XMpar9 a_6164_1041.t5 a_6164_1041.t4 vss.t2 vss.t1 nfet_03v3 w=0.4u l=1.92u ad=1.1200e-13 pd=9.6000e-07 as=1.1200e-13 ps=9.6000e-07 nf=1 m=2 par=2
X2 a_4272_11728.t0 a_8250_11208.t0 vss.t0 ppolyf_u_1k r_width=1u r_length=19.23u
X3 a_4272_8608.t0 a_8250_9128.t0 vss.t0 ppolyf_u_1k r_width=1u r_length=19.23u
X11 a_4272_13808.t0 a_8250_14328.t0 vss.t0 ppolyf_u_1k r_width=1u r_length=19.23u
X12 a_4272_8608.t0 a_8250_8088.t0 vss.t0 ppolyf_u_1k r_width=1u r_length=19.23u
X13 a_4272_10688.t0 a_8250_11208.t0 vss.t0 ppolyf_u_1k r_width=1u r_length=19.23u
X15 a_4272_13808.t0 a_8250_13288.t0 vss.t0 ppolyf_u_1k r_width=1u r_length=19.23u
X20 a_8250_14328.t1 out.t18 cap_mim_2f0fF c_width=11.46u c_length=11.46u
X33 a_4272_10688.t0 a_8250_10168.t0 vss.t0 ppolyf_u_1k r_width=1u r_length=19.23u
X34 a_4272_8088.t0 a_8250_8088.t0 vss.t0 ppolyf_u_1k r_width=1u r_length=19.23u
X44 a_4272_12768.t0 a_8250_13288.t0 vss.t0 ppolyf_u_1k r_width=1u r_length=19.23u
X45 a_4272_9648.t0 a_8250_10168.t0 vss.t0 ppolyf_u_1k r_width=1u r_length=19.23u
X48 a_4272_12768.t0 a_8250_12248.t0 vss.t0 ppolyf_u_1k r_width=1u r_length=19.23u
X53 a_4272_9648.t0 a_8250_9128.t0 vss.t0 ppolyf_u_1k r_width=1u r_length=19.23u
X54 a_4272_11728.t0 a_8250_12248.t0 vss.t0 ppolyf_u_1k r_width=1u r_length=19.23u
Rpar0 a_1590_4485.t0 a_1590_4485.t2 105.5288
Rpar1 a_1590_4485.t0 a_1590_4485.t3 96.5438
Rpar2 a_1590_4485.t2 a_1590_4485.t3 15.7192
Rpar3 a_2902_4693.t0 a_2902_4693.t1 51.2638
Rpar4 a_4272_8088.t0 a_4272_8088.t1 539.4026
Rpar5 a_4272_8088.t0 a_4272_8088.t7 66.2643
Rpar6 a_4272_8088.t0 a_4272_8088.t5 210.5848
Rpar7 a_4272_8088.t1 a_4272_8088.t7 652.3662
Rpar8 a_4272_8088.t1 a_4272_8088.t5 76.6367
Rpar9 a_4272_8088.t7 a_4272_8088.t5 254.6862
Rpar10 a_6164_1041.t0 a_6164_1041.t4 104.2249
Rpar11 a_6164_1041.t0 a_6164_1041.t5 107.2203
Rpar12 a_6164_1041.t4 a_6164_1041.t5 30.4749
Rpar13 a_8250_14328.t0 a_8250_14328.t1 61.5835
Rpar14 ib ib.t0 16.2559
Rpar15 ib ib.t1 9.0272
Rpar16 ib.t0 ib.t1 98.6297
Rpar17 inn inn.t0 2.2059
Rpar18 inp inp.t0 2.2545
Rpar19 out out.t0 163.2662
Rpar20 out out.t2 4.9738
Rpar21 out out.t18 1332.2865
Rpar22 out.t0 out.t2 52.1216
Rpar23 out.t0 out.t18 191.2447
Rpar24 out.t2 out.t18 425.3231
Rpar25 vdd vdd.t0 4923.8838
Rpar26 vdd vdd.t1 353.0161
Rpar27 vdd vdd.t14 85.8144
Rpar28 vdd.t0 vdd.t1 12.2050
Rpar29 vdd.t0 vdd.t14 1349.3516
Rpar30 vdd.t1 vdd.t14 96.7413
Rpar31 vss vss.t0 572.5463
Rpar32 vss vss.t1 83.2758
Rpar33 vss vss.t10 731.6120
Rpar34 vss vss.t9 453.9249
Rpar35 vss vss.t2 65.6205
Rpar36 vss.t0 vss.t1 204.6404
Rpar37 vss.t0 vss.t10 1309.9127
Rpar38 vss.t0 vss.t9 491.9739
Rpar39 vss.t0 vss.t2 66.7446
Rpar40 vss.t1 vss.t10 17.6044
Rpar41 vss.t1 vss.t9 5.5045
Rpar42 vss.t1 vss.t2 11.3478
Rpar43 vss.t10 vss.t9 32.1888
Rpar44 vss.t10 vss.t2 144.9226
Rpar45 vss.t9 vss.t2 44.6290
Cpar0 a_1590_4485.t0 vss 3.44656e-15
Cpar1 a_1590_4485.t2 vss 3.67681e-14
Cpar2 a_1590_4485.t3 vss 7.03918e-15
Cpar3 a_2902_4693.t0 vss 1.64831e-14
Cpar4 a_2902_4693.t1 vss 9.82809e-15
Cpar5 a_4272_10688.t0 vss 4.00800e-17
Cpar6 a_4272_11728.t0 vss 3.72600e-17
Cpar7 a_4272_12768.t0 vss 3.80000e-17
Cpar8 a_4272_13808.t0 vss 3.84600e-17
Cpar9 a_4272_8088.t0 vss 2.50567e-15
Cpar10 a_4272_8088.t1 vss 2.28306e-15
Cpar11 a_4272_8088.t5 vss 2.96272e-15
Cpar12 a_4272_8088.t7 vss 5.91764e-15
Cpar13 a_4272_8608.t0 vss 4.22000e-17
Cpar14 a_4272_9648.t0 vss 3.95400e-17
Cpar15 a_6164_1041.t0 vss 2.54989e-15
Cpar16 a_6164_1041.t4 vss 3.61518e-15
Cpar17 a_6164_1041.t5 vss 1.06510e-15
Cpar18 a_8250_10168.t0 vss 3.38200e-17
Cpar19 a_8250_11208.t0 vss 3.38200e-17
Cpar20 a_8250_12248.t0 vss 3.65400e-17
Cpar21 a_8250_13288.t0 vss 4.05600e-17
Cpar22 a_8250_14328.t0 vss 2.15220e-16
Cpar23 a_8250_14328.t1 vss 2.91737e-15
Cpar24 a_8250_8088.t0 vss 3.65000e-17
Cpar25 a_8250_9128.t0 vss 3.45600e-17
Cpar26 ib vdd 4.51600e-17
Cpar27 ib vss 1.03320e-14
Cpar28 ib.t0 vss 1.18864e-15
Cpar29 ib.t1 vss 8.12868e-17
Cpar30 inn inp 5.23000e-17
Cpar31 inn vdd 5.99459e-15
Cpar32 inn vss 3.14202e-15
Cpar33 inn.t0 vss 4.68661e-15
Cpar34 inp vdd 6.07892e-15
Cpar35 inp vss 3.06786e-15
Cpar36 inp.t0 vss 4.78765e-15
Cpar37 out vdd 1.33772e-14
Cpar38 out vss 2.18046e-14
Cpar39 out.t0 vss 1.00312e-14
Cpar40 out.t18 vss 1.11464e-14
Cpar41 out.t2 vss 3.59964e-15
Cpar42 vdd vss 1.30479e-13
Cpar43 vdd.t0 vss 4.06216e-14
Cpar44 vdd.t1 vss 8.16930e-15
Cpar45 vdd.t14 vss 1.94043e-14
.ends opamp_dut

Vdd vdd 0 1.800000
Vss vss 0 0
Ibias vdd ib 2.870000e-08
Vinp inp 0 DC 0.805000 AC 1 PWL(0 0.805000 2.739738e-07 0.805000 3.013712e-07 0.815000)
Rfb out inn 1m
Cload out 0 2.000000e-13
Xdut vdd vss inp inn out ib opamp_dut
.end
