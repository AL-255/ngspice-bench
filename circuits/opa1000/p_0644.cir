* opa1000[0644]: 2p/pmos_miller_1v8_i150u_subth (pmos_miller, VDD=1.8V, CL=2.0pF, Iref=15.9375uA)
.include "pdk_opa.inc"
.temp 27
.option gmin=1e-12 rshunt=1e12 reltol=1e-3 abstol=1e-12 vntol=1e-5 method=gear
* Post-PEX R+C extracted netlist for pmos_miller_1v8_i150u_subth
.subckt opamp_dut vdd vss inp inn out ib
XMpar0 a_1557_13385.t0 inp.t0 a_2388_16966.t6 vdd.t12 pfet_03v3 w=8u l=0.53u ad=2.4000e-12 pd=9.1000e-06 as=2.2400e-12 ps=8.5600e-06 nf=1 m=64 par=64
XMpar1 ib.t1 ib.t0 vss.t64 vss.t63 nfet_03v3 w=6.14u l=0.98u ad=2.3741e-12 pd=8.9600e-06 as=1.7192e-12 ps=6.7000e-06 nf=1 m=6 par=6
XMpar2 a_1557_13385.t0 inn.t0 a_8284_10175.t0 vdd.t12 pfet_03v3 w=8u l=0.53u ad=2.4000e-12 pd=9.1000e-06 as=2.2400e-12 ps=8.5600e-06 nf=1 m=64 par=64
XMpar3 a_1557_13385.t64 a_1053_13177.t0 vdd.t1 vdd.t0 pfet_03v3 w=10u l=0.98u ad=2.8000e-12 pd=1.0560e-05 as=2.8000e-12 ps=1.0560e-05 nf=1 m=12 par=12
XMpar4 a_2388_16966.t0 a_8284_10175.t64 vss.t1 vss.t0 nfet_03v3 w=7.11u l=0.5u ad=2.7492e-12 pd=1.0253e-05 as=1.9908e-12 ps=7.6700e-06 nf=1 m=6 par=6
XMpar5 out.t0 a_2388_16966.t71 vss.t1 vss.t0 nfet_03v3 w=7.11u l=0.5u ad=1.9908e-12 pd=7.6700e-06 as=2.4458e-12 ps=9.2200e-06 nf=1 m=30 par=30
XMpar6 a_8284_10175.t65 a_8284_10175.t64 vss.t1 vss.t0 nfet_03v3 w=7.11u l=0.5u ad=1.9908e-12 pd=7.6700e-06 as=1.9908e-12 ps=7.6700e-06 nf=1 m=6 par=6
XMpar7 a_1053_13177.t1 a_1053_13177.t0 vdd.t1 vdd.t0 pfet_03v3 w=10u l=0.98u ad=2.8000e-12 pd=1.0560e-05 as=3.8667e-12 ps=1.4107e-05 nf=1 m=6 par=6
XMpar8 out.t5 a_1053_13177.t0 vdd.t1 vdd.t0 pfet_03v3 w=10u l=0.98u ad=3.0133e-12 pd=1.1269e-05 as=2.8000e-12 ps=1.0560e-05 nf=1 m=30 par=30
XMpar9 a_1053_13177.t12 ib.t0 vss.t64 vss.t63 nfet_03v3 w=6.14u l=0.98u ad=1.7192e-12 pd=6.7000e-06 as=1.7192e-12 ps=6.7000e-06 nf=1 m=6 par=6
X9 a_2388_16966.t70 a_4429_9213.t0 vss.t62 ppolyf_u_1k r_width=1u r_length=1u
X37 a_4429_9213.t1 out.t35 cap_mim_2f0fF c_width=17.92u c_length=17.91u
X48 a_4429_9213.t1 out.t35 cap_mim_2f0fF c_width=17.92u c_length=17.91u
X218 a_4429_9213.t1 out.t35 cap_mim_2f0fF c_width=17.92u c_length=17.91u
Rpar0 a_1053_13177.t0 a_1053_13177.t1 19.3949
Rpar1 a_1053_13177.t0 a_1053_13177.t12 71.7988
Rpar2 a_1053_13177.t1 a_1053_13177.t12 37.8460
Rpar3 a_1557_13385.t0 a_1557_13385.t64 38.1212
Rpar4 a_2388_16966.t0 a_2388_16966.t6 234.8738
Rpar5 a_2388_16966.t0 a_2388_16966.t71 87.6664
Rpar6 a_2388_16966.t0 a_2388_16966.t70 95.7557
Rpar7 a_2388_16966.t6 a_2388_16966.t71 437.7441
Rpar8 a_2388_16966.t6 a_2388_16966.t70 115.7189
Rpar9 a_2388_16966.t71 a_2388_16966.t70 178.4639
Rpar10 a_4429_9213.t0 a_4429_9213.t1 70.5912
Rpar11 a_8284_10175.t0 a_8284_10175.t64 672.0194
Rpar12 a_8284_10175.t0 a_8284_10175.t65 61.1667
Rpar13 a_8284_10175.t64 a_8284_10175.t65 21.2218
Rpar14 ib ib.t0 13.8350
Rpar15 ib ib.t1 2.2875
Rpar16 inn inn.t0 2.6351
Rpar17 inp inp.t0 2.6351
Rpar18 out out.t0 1.8705
Rpar19 out out.t5 1317.5297
Rpar20 out out.t35 1348.7611
Rpar21 out.t0 out.t5 68.7986
Rpar22 out.t0 out.t35 70.4295
Rpar23 out.t5 out.t35 253.9037
Rpar24 vdd vdd.t0 44.3555
Rpar25 vdd vdd.t1 484.9775
Rpar26 vdd vdd.t12 33.3256
Rpar27 vdd.t0 vdd.t1 2.8143
Rpar28 vdd.t0 vdd.t12 126.1825
Rpar29 vdd.t1 vdd.t12 1379.6627
Rpar30 vss vss.t0 436.5861
Rpar31 vss vss.t1 104.0484
Rpar32 vss vss.t62 697.2990
Rpar33 vss vss.t63 60.4508
Rpar34 vss vss.t64 268.3132
Rpar35 vss.t0 vss.t1 3.3107
Rpar36 vss.t0 vss.t62 802.6407
Rpar37 vss.t0 vss.t63 82.2527
Rpar38 vss.t0 vss.t64 555.2710
Rpar39 vss.t1 vss.t62 585.5505
Rpar40 vss.t1 vss.t63 54.7761
Rpar41 vss.t1 vss.t64 285.5569
Rpar42 vss.t62 vss.t63 11.3877
Rpar43 vss.t62 vss.t64 77.1901
Rpar44 vss.t63 vss.t64 5.4587
Cpar0 a_1053_13177.t0 vss 6.33103e-14
Cpar1 a_1053_13177.t1 vss 8.41808e-15
Cpar2 a_1053_13177.t12 vss 5.83144e-15
Cpar3 a_1557_13385.t0 vss 2.01639e-13
Cpar4 a_1557_13385.t64 vss 2.95664e-14
Cpar5 a_2388_16966.t0 vss 1.19310e-14
Cpar6 a_2388_16966.t6 vss 7.66998e-14
Cpar7 a_2388_16966.t70 vss 4.14465e-15
Cpar8 a_2388_16966.t71 vss 2.95146e-14
Cpar9 a_4429_9213.t0 vss 7.60800e-17
Cpar10 a_4429_9213.t1 vss 8.69738e-15
Cpar11 a_8284_10175.t0 vss 8.68312e-14
Cpar12 a_8284_10175.t64 vss 1.05723e-14
Cpar13 a_8284_10175.t65 vss 1.24136e-14
Cpar14 ib vss 1.97891e-14
Cpar15 ib.t0 vss 2.08187e-15
Cpar16 ib.t1 vss 9.07701e-16
Cpar17 inn inp 1.03350e-16
Cpar18 inn vdd 2.53982e-14
Cpar19 inn vss 1.15704e-14
Cpar20 inn.t0 vss 4.39170e-14
Cpar21 inp vdd 2.57816e-14
Cpar22 inp vss 1.15953e-14
Cpar23 inp.t0 vss 4.42418e-14
Cpar24 out vdd 3.72567e-14
Cpar25 out vss 6.34169e-14
Cpar26 out.t0 vss 1.95255e-14
Cpar27 out.t35 vss 2.06803e-14
Cpar28 out.t5 vss 2.79423e-14
Cpar29 vdd vss 4.26417e-13
Cpar30 vdd.t0 vss 6.49975e-14
Cpar31 vdd.t1 vss 2.40174e-14
Cpar32 vdd.t12 vss 9.85142e-14
.ends opamp_dut

Vdd vdd 0 1.800000
Vss vss 0 0
Ibias vdd ib 1.593750e-05
Vinp inp 0 DC 0.805000 AC 1 PWL(0 0.805000 3.887383e-09 0.805000 4.276121e-09 0.815000)
Rfb out inn 1m
Cload out 0 2.000000e-12
Xdut vdd vss inp inn out ib opamp_dut
.end
