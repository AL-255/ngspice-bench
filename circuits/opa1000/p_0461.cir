* opa1000[0461]: 2p/nmos_miller_1v8_i50n_weak (nmos_miller, VDD=1.8V, CL=2.0pF, Iref=0.0071uA)
.include "pdk_opa.inc"
.temp 27
.option gmin=1e-12 rshunt=1e12 reltol=1e-3 abstol=1e-12 vntol=1e-5 method=gear
* Post-PEX R+C extracted netlist for nmos_miller_1v8_i50n_weak
.subckt opamp_dut vdd vss inp inn out ib
XMpar0 out.t10 ib.t0 vss.t4 vss.t3 nfet_03v3 w=0.4u l=5u ad=1.8880e-13 pd=1.5840e-06 as=1.6320e-13 ps=1.3760e-06 nf=1 m=10 par=10
XMpar1 a_7726_4590.t4 ib.t0 vss.t4 vss.t3 nfet_03v3 w=0.4u l=5u ad=2.4000e-13 pd=2.0000e-06 as=1.1200e-13 ps=9.6000e-07 nf=1 m=4 par=4
XMpar2 a_7732_6668.t1 a_7732_6668.t0 vdd.t1 vdd.t0 pfet_03v3 w=0.4u l=4u ad=1.1200e-13 pd=9.6000e-07 as=1.1200e-13 ps=9.6000e-07 nf=1 m=2 par=2
XMpar3 out.t0 a_1114_1290.t5 vdd.t1 vdd.t0 pfet_03v3 w=0.4u l=4u ad=1.3760e-13 pd=1.1680e-06 as=1.3760e-13 ps=1.1680e-06 nf=1 m=10 par=10
XMpar4 ib.t1 ib.t0 vss.t4 vss.t3 nfet_03v3 w=0.4u l=5u ad=2.4000e-13 pd=2.0000e-06 as=1.1200e-13 ps=9.6000e-07 nf=1 m=2 par=2
XMpar5 a_1114_1290.t0 inp.t0 a_7726_4590.t0 vss.t1 nfet_03v3 w=0.4u l=6.5u ad=2.4000e-13 pd=2.0000e-06 as=2.4000e-13 ps=2.0000e-06 nf=1 m=2 par=2
XMpar6 a_1114_1290.t2 a_7732_6668.t0 vdd.t1 vdd.t0 pfet_03v3 w=0.4u l=4u ad=2.4000e-13 pd=2.0000e-06 as=1.1200e-13 ps=9.6000e-07 nf=1 m=2 par=2
XMpar7 a_7726_4590.t0 inn.t0 a_7732_6668.t4 vss.t1 nfet_03v3 w=0.4u l=6.5u ad=2.4000e-13 pd=2.0000e-06 as=2.4000e-13 ps=2.0000e-06 nf=1 m=2 par=2
X0 a_1114_3890.t0 a_5092_4410.t0 vss.t0 ppolyf_u_1k r_width=1u r_length=19.23u
X6 a_1114_7010.t0 a_5092_6490.t0 vss.t0 ppolyf_u_1k r_width=1u r_length=19.23u
X7 a_5092_7530.t1 out.t6 cap_mim_2f0fF c_width=16.58u c_length=16.59u
X11 a_1114_1290.t4 a_5092_1290.t0 vss.t0 ppolyf_u_1k r_width=1u r_length=19.23u
X12 a_5092_7530.t1 out.t6 cap_mim_2f0fF c_width=16.58u c_length=16.59u
X14 a_1114_3890.t0 a_5092_3370.t0 vss.t0 ppolyf_u_1k r_width=1u r_length=19.23u
X21 a_1114_5970.t0 a_5092_6490.t0 vss.t0 ppolyf_u_1k r_width=1u r_length=19.23u
X23 a_1114_2850.t0 a_5092_3370.t0 vss.t0 ppolyf_u_1k r_width=1u r_length=19.23u
X28 a_1114_5970.t0 a_5092_5450.t0 vss.t0 ppolyf_u_1k r_width=1u r_length=19.23u
X29 a_1114_2850.t0 a_5092_2330.t0 vss.t0 ppolyf_u_1k r_width=1u r_length=19.23u
X37 a_1114_4930.t0 a_5092_5450.t0 vss.t0 ppolyf_u_1k r_width=1u r_length=19.23u
X38 a_1114_1810.t0 a_5092_2330.t0 vss.t0 ppolyf_u_1k r_width=1u r_length=19.23u
X41 a_1114_4930.t0 a_5092_4410.t0 vss.t0 ppolyf_u_1k r_width=1u r_length=19.23u
X44 a_1114_1810.t0 a_5092_1290.t0 vss.t0 ppolyf_u_1k r_width=1u r_length=19.23u
X47 a_1114_7010.t0 a_5092_7530.t0 vss.t0 ppolyf_u_1k r_width=1u r_length=19.23u
Rpar0 a_1114_1290.t0 a_1114_1290.t5 145.9467
Rpar1 a_1114_1290.t0 a_1114_1290.t2 125.7750
Rpar2 a_1114_1290.t0 a_1114_1290.t4 124.1531
Rpar3 a_1114_1290.t5 a_1114_1290.t2 169.6205
Rpar4 a_1114_1290.t5 a_1114_1290.t4 186.3770
Rpar5 a_1114_1290.t2 a_1114_1290.t4 160.6174
Rpar6 a_5092_7530.t0 a_5092_7530.t1 64.6881
Rpar7 a_7726_4590.t0 a_7726_4590.t4 53.0230
Rpar8 a_7732_6668.t0 a_7732_6668.t1 30.2251
Rpar9 a_7732_6668.t0 a_7732_6668.t4 100.1543
Rpar10 a_7732_6668.t1 a_7732_6668.t4 93.8641
Rpar11 ib ib.t0 16.4427
Rpar12 ib ib.t1 15.2951
Rpar13 ib.t0 ib.t1 34.2074
Rpar14 inn inn.t0 4.0085
Rpar15 inp inp.t0 4.0081
Rpar16 out out.t0 53.7790
Rpar17 out out.t10 111.8663
Rpar18 out out.t6 23.1104
Rpar19 out.t0 out.t10 154.7022
Rpar20 out.t0 out.t6 316.1864
Rpar21 out.t10 out.t6 657.7024
Rpar22 vdd vdd.t0 78.4606
Rpar23 vdd vdd.t1 45.2537
Rpar24 vdd.t0 vdd.t1 6.6095
Rpar25 vss vss.t0 45.7764
Rpar26 vss vss.t1 660.1607
Rpar27 vss vss.t4 111.1571
Rpar28 vss vss.t3 177.7792
Rpar29 vss.t0 vss.t1 567.0918
Rpar30 vss.t0 vss.t4 126.4488
Rpar31 vss.t0 vss.t3 153.3881
Rpar32 vss.t1 vss.t4 57.2886
Rpar33 vss.t1 vss.t3 5.9821
Rpar34 vss.t4 vss.t3 14.8956
Cpar0 a_1114_1290.t0 vss 5.31908e-15
Cpar1 a_1114_1290.t2 vss 4.70596e-15
Cpar2 a_1114_1290.t4 vss 4.75139e-15
Cpar3 a_1114_1290.t5 vss 2.20227e-14
Cpar4 a_1114_1810.t0 vss 3.20200e-17
Cpar5 a_1114_2850.t0 vss 2.93600e-17
Cpar6 a_1114_3890.t0 vss 2.93600e-17
Cpar7 a_1114_4930.t0 vss 2.93600e-17
Cpar8 a_1114_5970.t0 vss 3.00800e-17
Cpar9 a_1114_7010.t0 vss 2.83000e-17
Cpar10 a_5092_1290.t0 vss 3.45200e-17
Cpar11 a_5092_2330.t0 vss 3.79800e-17
Cpar12 a_5092_3370.t0 vss 3.93200e-17
Cpar13 a_5092_4410.t0 vss 3.74000e-17
Cpar14 a_5092_5450.t0 vss 3.87600e-17
Cpar15 a_5092_6490.t0 vss 4.02000e-17
Cpar16 a_5092_7530.t0 vss 1.19252e-16
Cpar17 a_5092_7530.t1 vss 5.65092e-15
Cpar18 a_7726_4590.t0 vss 9.62381e-15
Cpar19 a_7726_4590.t4 vss 1.71027e-14
Cpar20 a_7732_6668.t0 vss 1.04926e-14
Cpar21 a_7732_6668.t1 vss 2.49919e-15
Cpar22 a_7732_6668.t4 vss 4.39188e-15
Cpar23 ib inp 1.09600e-17
Cpar24 ib out 2.22955e-15
Cpar25 ib vss 5.72750e-14
Cpar26 ib.t0 vss 9.22757e-15
Cpar27 ib.t1 vss 7.04015e-16
Cpar28 inn inp 1.02720e-16
Cpar29 inn vss 7.00828e-15
Cpar30 inn.t0 vss 1.16148e-15
Cpar31 inp vss 7.09033e-15
Cpar32 inp.t0 vss 1.18018e-15
Cpar33 out vdd 1.31939e-14
Cpar34 out vss 2.66139e-14
Cpar35 out.t0 vss 5.12601e-15
Cpar36 out.t10 vss 8.96669e-15
Cpar37 out.t6 vss 1.72122e-14
Cpar38 vdd vss 8.65628e-14
Cpar39 vdd.t0 vss 3.13383e-14
Cpar40 vdd.t1 vss 9.13224e-15
.ends opamp_dut

Vdd vdd 0 1.800000
Vss vss 0 0
Ibias vdd ib 7.100000e-09
Vinp inp 0 DC 0.895000 AC 1 PWL(0 0.895000 4.759964e-06 0.895000 5.235960e-06 0.905000)
Rfb out inn 1m
Cload out 0 2.000000e-12
Xdut vdd vss inp inn out ib opamp_dut
.end
