* opa1000[0768]: 200f/symmetrical_ota_1v8_i150u_weak (symmetrical_ota, VDD=1.8V, CL=0.2pF, Iref=21.25uA)
.include "pdk_opa.inc"
.temp 27
.option gmin=1e-12 rshunt=1e12 reltol=1e-3 abstol=1e-12 vntol=1e-5 method=gear
* Post-PEX R+C extracted netlist for symmetrical_ota_1v8_i150u_weak
.subckt opamp_dut vdd vss inp inn out ib
XMpar0 a_1372_1041.t1 a_1372_1041.t0 vdd.t1 vdd.t0 pfet_03v3 w=3.72u l=0.56u ad=1.0416e-12 pd=4.2800e-06 as=1.0416e-12 ps=4.2800e-06 nf=1 m=6 par=6
XMpar1 a_1372_1041.t12 inp.t0 a_2802_5356.t0 vss.t0 nfet_03v3 w=1.89u l=0.68u ad=5.2920e-13 pd=2.4500e-06 as=6.3000e-13 ps=2.8717e-06 nf=1 m=12 par=12
XMpar2 out.t2 a_1372_1041.t0 vdd.t1 vdd.t0 pfet_03v3 w=3.72u l=0.56u ad=1.0416e-12 pd=4.2800e-06 as=1.2400e-12 ps=5.0067e-06 nf=1 m=12 par=12
XMpar3 a_2802_5356.t0 inn.t0 a_6350_5356.t0 vss.t0 nfet_03v3 w=1.89u l=0.68u ad=6.3000e-13 pd=2.8717e-06 as=5.2920e-13 ps=2.4500e-06 nf=1 m=12 par=12
XMpar4 a_2802_5356.t24 ib.t0 vss.t67 vss.t0 nfet_03v3 w=2.86u l=0.98u ad=8.0080e-13 pd=3.4200e-06 as=1.2584e-12 ps=5.1700e-06 nf=1 m=12 par=12
XMpar5 ib.t1 ib.t0 vss.t67 vss.t0 nfet_03v3 w=2.86u l=0.98u ad=8.0080e-13 pd=3.4200e-06 as=8.0080e-13 ps=3.4200e-06 nf=1 m=6 par=6
XMpar6 a_3508_3365.t0 a_6350_5356.t12 vdd.t1 vdd.t0 pfet_03v3 w=3.72u l=0.56u ad=1.0416e-12 pd=4.2800e-06 as=1.2400e-12 ps=5.0067e-06 nf=1 m=12 par=12
XMpar7 out.t0 a_3508_3365.t11 vss.t1 vss.t0 nfet_03v3 w=1.01u l=0.56u ad=2.8280e-13 pd=1.5700e-06 as=3.3667e-13 ps=1.8450e-06 nf=1 m=12 par=12
XMpar8 a_3508_3365.t12 a_3508_3365.t11 vss.t1 vss.t0 nfet_03v3 w=1.01u l=0.56u ad=2.8280e-13 pd=1.5700e-06 as=2.8280e-13 ps=1.5700e-06 nf=1 m=12 par=12
XMpar9 a_6350_5356.t13 a_6350_5356.t12 vdd.t1 vdd.t0 pfet_03v3 w=3.72u l=0.56u ad=1.0416e-12 pd=4.2800e-06 as=1.0416e-12 ps=4.2800e-06 nf=1 m=6 par=6
X79 out.t24 vss.t96 cap_mim_2f0fF c_width=16.58u c_length=16.59u
Rpar0 a_1372_1041.t0 a_1372_1041.t1 18.1597
Rpar1 a_1372_1041.t0 a_1372_1041.t12 177.1969
Rpar2 a_1372_1041.t1 a_1372_1041.t12 48.7724
Rpar3 a_2802_5356.t0 a_2802_5356.t24 56.4578
Rpar4 a_3508_3365.t0 a_3508_3365.t11 498.0208
Rpar5 a_3508_3365.t0 a_3508_3365.t12 52.2863
Rpar6 a_3508_3365.t11 a_3508_3365.t12 15.6112
Rpar7 a_6350_5356.t0 a_6350_5356.t12 177.1931
Rpar8 a_6350_5356.t0 a_6350_5356.t13 48.7728
Rpar9 a_6350_5356.t12 a_6350_5356.t13 18.1599
Rpar10 ib ib.t0 12.2489
Rpar11 ib ib.t1 5.7355
Rpar12 ib.t0 ib.t1 12.6731
Rpar13 inn inn.t0 2.7050
Rpar14 inp inp.t0 2.7536
Rpar15 out out.t0 126.5089
Rpar16 out out.t2 1.8571
Rpar17 out out.t24 612.8584
Rpar18 out.t0 out.t2 65.0154
Rpar19 out.t0 out.t24 114.4083
Rpar20 out.t2 out.t24 314.9602
Rpar21 vdd vdd.t0 104.5181
Rpar22 vdd vdd.t1 299.0269
Rpar23 vdd.t0 vdd.t1 1.9768
Rpar24 vss vss.t0 71.4054
Rpar25 vss vss.t1 1578.0185
Rpar26 vss vss.t67 3202.4264
Rpar27 vss vss.t96 1537.3030
Rpar28 vss.t0 vss.t1 3.3759
Rpar29 vss.t0 vss.t67 10.5981
Rpar30 vss.t0 vss.t96 41.2429
Rpar31 vss.t1 vss.t67 613.5297
Rpar32 vss.t1 vss.t96 1197.3854
Rpar33 vss.t67 vss.t96 823.8007
Cpar0 a_1372_1041.t0 vss 1.29865e-14
Cpar1 a_1372_1041.t1 vss 8.19810e-15
Cpar2 a_1372_1041.t12 vss 7.22423e-15
Cpar3 a_2802_5356.t0 vss 1.20364e-14
Cpar4 a_2802_5356.t24 vss 1.25217e-14
Cpar5 a_3508_3365.t0 vss 7.45844e-15
Cpar6 a_3508_3365.t11 vss 7.26791e-15
Cpar7 a_3508_3365.t12 vss 4.29188e-15
Cpar8 a_6350_5356.t0 vss 7.20728e-15
Cpar9 a_6350_5356.t12 vss 1.29555e-14
Cpar10 a_6350_5356.t13 vss 8.17858e-15
Cpar11 ib out 3.10400e-17
Cpar12 ib vdd 2.28890e-16
Cpar13 ib vss 2.66132e-14
Cpar14 ib.t0 vss 3.78724e-15
Cpar15 ib.t1 vss 1.22637e-15
Cpar16 inn inp 5.16800e-17
Cpar17 inn vdd 2.45100e-17
Cpar18 inn vss 7.59459e-15
Cpar19 inn.t0 vss 1.26929e-15
Cpar20 inp vss 7.75990e-15
Cpar21 inp.t0 vss 1.27095e-15
Cpar22 out vdd 1.11104e-14
Cpar23 out vss 1.92188e-14
Cpar24 out.t0 vss 1.48217e-15
Cpar25 out.t2 vss 1.77577e-15
Cpar26 out.t24 vss 2.06683e-14
Cpar27 vdd vss 8.37677e-14
Cpar28 vdd.t0 vss 3.40824e-14
Cpar29 vdd.t1 vss 1.51661e-14
.ends opamp_dut

Vdd vdd 0 1.800000
Vss vss 0 0
Ibias vdd ib 2.125000e-05
Vinp inp 0 DC 0.895000 AC 1 PWL(0 0.895000 3.000000e-09 0.895000 3.300000e-09 0.905000)
Rfb out inn 1m
Cload out 0 2.000000e-13
Xdut vdd vss inp inn out ib opamp_dut
.end
