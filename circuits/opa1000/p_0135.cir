* opa1000[0135]: 2p/current_reuse_1v8_1u_10u_weak (current_reuse, VDD=1.8V, CL=2.0pF, Iref=0.5uA)
.include "pdk_opa.inc"
.temp 27
.option gmin=1e-12 rshunt=1e12 reltol=1e-3 abstol=1e-12 vntol=1e-5 method=gear
* Post-PEX R+C extracted netlist for current_reuse_1v8_1u_10u_weak
.subckt opamp_dut vdd vss inp inn out ib
XMpar0 a_6066_10281.t0 inn.t2 a_9144_11730.t0 vdd.t4 pfet_03v3 w=1.63u l=2u ad=6.3027e-13 pd=2.9467e-06 as=4.5640e-13 ps=2.1900e-06 nf=1 m=6 par=6
XMpar1 a_1073_6546.t7 inp.t0 a_8114_6505.t0 vss.t1 nfet_03v3 w=2.06u l=2u ad=5.7680e-13 pd=2.6200e-06 as=1.2360e-12 ps=5.3200e-06 nf=1 m=2 par=2
XMpar2 a_8114_6505.t0 inn.t0 a_9144_11730.t6 vss.t1 nfet_03v3 w=2.06u l=2u ad=1.2360e-12 pd=5.3200e-06 as=5.7680e-13 ps=2.6200e-06 nf=1 m=2 par=2
XMpar3 a_1073_6546.t1 inp.t2 a_6066_10281.t0 vdd.t4 pfet_03v3 w=1.63u l=2u ad=4.5640e-13 pd=2.1900e-06 as=6.3027e-13 ps=2.9467e-06 nf=1 m=6 par=6
XMpar4 out.t9 ib.t0 vss.t6 vss.t5 nfet_03v3 w=0.8u l=3u ad=3.7760e-13 pd=2.2240e-06 as=3.2640e-13 ps=1.9360e-06 nf=1 m=10 par=10
XMpar5 a_8114_6505.t4 ib.t0 vss.t6 vss.t5 nfet_03v3 w=0.8u l=3u ad=4.8000e-13 pd=2.8000e-06 as=2.2400e-13 ps=1.3600e-06 nf=1 m=4 par=4
XMpar6 ib.t1 ib.t0 vss.t6 vss.t5 nfet_03v3 w=0.8u l=3u ad=4.8000e-13 pd=2.8000e-06 as=2.2400e-13 ps=1.3600e-06 nf=1 m=2 par=2
XMpar7 a_6066_10281.t6 a_9144_11730.t8 vdd.t1 vdd.t0 pfet_03v3 w=2.84u l=1.5u ad=7.9520e-13 pd=3.4000e-06 as=1.7040e-12 ps=6.8800e-06 nf=1 m=2 par=2
XMpar8 out.t1 a_1073_6546.t10 vdd.t1 vdd.t0 pfet_03v3 w=2.84u l=1.5u ad=7.9520e-13 pd=3.4000e-06 as=9.7696e-13 ps=4.0960e-06 nf=1 m=10 par=10
XMpar9 a_9144_11730.t9 a_9144_11730.t8 vdd.t1 vdd.t0 pfet_03v3 w=2.84u l=1.5u ad=1.7040e-12 pd=6.8800e-06 as=7.9520e-13 ps=3.4000e-06 nf=1 m=1
XMpar10 a_1073_6546.t0 a_9144_11730.t8 vdd.t1 vdd.t0 pfet_03v3 w=2.84u l=1.5u ad=1.7040e-12 pd=6.8800e-06 as=7.9520e-13 ps=3.4000e-06 nf=1 m=1
X4 a_4805_7586.t1 out.t0 cap_mim_2f0fF c_width=18.03u c_length=18.03u
X6 a_1073_7066.t0 a_4805_6546.t0 vss.t0 ppolyf_u_1k r_width=1u r_length=18u
X11 a_1073_6546.t9 a_4805_6546.t0 vss.t0 ppolyf_u_1k r_width=1u r_length=18u
X16 a_4805_7586.t1 out.t0 cap_mim_2f0fF c_width=18.03u c_length=18.03u
X49 a_1073_7066.t0 a_4805_7586.t0 vss.t0 ppolyf_u_1k r_width=1u r_length=18u
Rpar0 a_1073_6546.t0 a_1073_6546.t1 110.1366
Rpar1 a_1073_6546.t0 a_1073_6546.t10 143.3286
Rpar2 a_1073_6546.t0 a_1073_6546.t7 511.0334
Rpar3 a_1073_6546.t0 a_1073_6546.t9 481.1196
Rpar4 a_1073_6546.t1 a_1073_6546.t10 81.2225
Rpar5 a_1073_6546.t1 a_1073_6546.t7 289.5961
Rpar6 a_1073_6546.t1 a_1073_6546.t9 272.6443
Rpar7 a_1073_6546.t10 a_1073_6546.t7 79.1781
Rpar8 a_1073_6546.t10 a_1073_6546.t9 74.5433
Rpar9 a_1073_6546.t7 a_1073_6546.t9 224.8246
Rpar10 a_4805_7586.t0 a_4805_7586.t1 62.2183
Rpar11 a_6066_10281.t0 a_6066_10281.t6 59.9954
Rpar12 a_8114_6505.t0 a_8114_6505.t4 61.2124
Rpar13 a_9144_11730.t0 a_9144_11730.t8 72.6533
Rpar14 a_9144_11730.t0 a_9144_11730.t6 185.9926
Rpar15 a_9144_11730.t0 a_9144_11730.t9 86.3087
Rpar16 a_9144_11730.t8 a_9144_11730.t6 107.2243
Rpar17 a_9144_11730.t8 a_9144_11730.t9 27.4891
Rpar18 a_9144_11730.t6 a_9144_11730.t9 720.4935
Rpar19 ib ib.t0 14.3896
Rpar20 ib ib.t1 12.8698
Rpar21 ib.t0 ib.t1 31.0285
Rpar22 inn inn.t0 5.7665
Rpar23 inn inn.t2 34.5056
Rpar24 inp inp.t0 5.8151
Rpar25 inp inp.t2 34.4570
Rpar26 out out.t0 208.1622
Rpar27 out out.t1 196.6009
Rpar28 out out.t9 4.1309
Rpar29 out.t0 out.t1 361.6205
Rpar30 out.t0 out.t9 159.0319
Rpar31 out.t1 out.t9 150.1993
Rpar32 vdd vdd.t0 36.8136
Rpar33 vdd vdd.t1 42.1096
Rpar34 vdd vdd.t4 116.7735
Rpar35 vdd.t0 vdd.t1 3.3011
Rpar36 vdd.t0 vdd.t4 73.5011
Rpar37 vdd.t1 vdd.t4 84.5493
Rpar38 vss vss.t0 352.2807
Rpar39 vss vss.t1 184.2822
Rpar40 vss vss.t6 53.3382
Rpar41 vss vss.t5 172.7222
Rpar42 vss.t0 vss.t1 247.1802
Rpar43 vss.t0 vss.t6 457.3127
Rpar44 vss.t0 vss.t5 443.8347
Rpar45 vss.t1 vss.t6 59.3176
Rpar46 vss.t1 vss.t5 9.3629
Rpar47 vss.t6 vss.t5 15.5952
Cpar0 a_1073_6546.t0 vss 2.63370e-15
Cpar1 a_1073_6546.t1 vss 3.40708e-15
Cpar2 a_1073_6546.t10 vss 1.35067e-14
Cpar3 a_1073_6546.t7 vss 2.23252e-15
Cpar4 a_1073_6546.t9 vss 2.44180e-15
Cpar5 a_1073_7066.t0 vss 3.63800e-17
Cpar6 a_4805_6546.t0 vss 4.17200e-17
Cpar7 a_4805_7586.t0 vss 7.79195e-17
Cpar8 a_4805_7586.t1 vss 4.83781e-15
Cpar9 a_6066_10281.t0 vss 9.31207e-15
Cpar10 a_6066_10281.t6 vss 4.17369e-15
Cpar11 a_8114_6505.t0 vss 7.31456e-15
Cpar12 a_8114_6505.t4 vss 1.18901e-14
Cpar13 a_9144_11730.t0 vss 5.30262e-15
Cpar14 a_9144_11730.t6 vss 3.36074e-15
Cpar15 a_9144_11730.t8 vss 8.89952e-15
Cpar16 a_9144_11730.t9 vss 3.45804e-15
Cpar17 ib out 2.40632e-15
Cpar18 ib vss 3.95922e-14
Cpar19 ib.t0 vss 7.08649e-15
Cpar20 ib.t1 vss 6.17270e-16
Cpar21 inn inp 1.04240e-16
Cpar22 inn out 1.04280e-16
Cpar23 inn vdd 6.82575e-15
Cpar24 inn vss 6.12977e-15
Cpar25 inn.t0 vss 1.52134e-15
Cpar26 inn.t2 vss 8.13949e-15
Cpar27 inp out 3.08900e-17
Cpar28 inp vdd 6.61254e-15
Cpar29 inp vss 6.50276e-15
Cpar30 inp.t0 vss 1.47296e-15
Cpar31 inp.t2 vss 7.83347e-15
Cpar32 out vdd 8.31128e-15
Cpar33 out vss 2.56357e-14
Cpar34 out.t0 vss 1.60409e-14
Cpar35 out.t1 vss 4.57754e-15
Cpar36 out.t9 vss 3.92732e-15
Cpar37 vdd vss 1.01732e-13
Cpar38 vdd.t0 vss 1.45058e-14
Cpar39 vdd.t1 vss 1.07278e-14
Cpar40 vdd.t4 vss 1.67373e-14
.ends opamp_dut

Vdd vdd 0 1.800000
Vss vss 0 0
Ibias vdd ib 5.000000e-07
Vinp inp 0 DC 0.895000 AC 1 PWL(0 0.895000 6.431853e-08 0.895000 7.075039e-08 0.905000)
Rfb out inn 1m
Cload out 0 2.000000e-12
Xdut vdd vss inp inn out ib opamp_dut
.end
