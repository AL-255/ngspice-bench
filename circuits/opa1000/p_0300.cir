* opa1000[0300]: 2p/folded_cascode_pmos_1v8_i1u_weak (folded_cascode_pmos, VDD=1.8V, CL=2.0pF, Iref=0.2889uA)
.include "pdk_opa.inc"
.temp 27
.option gmin=1e-12 rshunt=1e12 reltol=1e-3 abstol=1e-12 vntol=1e-5 method=gear
* Post-PEX R+C extracted netlist for folded_cascode_pmos_1v8_i1u_weak
.subckt opamp_dut vdd vss inp inn out ib
XMpar0 a_3722_8020.t0 a_2550_1249.t10 a_4212_4624.t0 vss.t0 nfet_03v3 w=0.73u l=2.55u ad=4.3800e-13 pd=2.6600e-06 as=2.0440e-13 ps=1.2900e-06 nf=1 m=2 par=2
XMpar1 a_2602_8020.t0 inp.t0 a_3722_8020.t2 vdd.t4 pfet_03v3 w=1.78u l=5u ad=6.8827e-13 pd=3.1467e-06 as=6.8827e-13 ps=3.1467e-06 nf=1 m=12 par=12
XMpar2 a_6254_6544.t14 ib vss.t4 vss.t3 nfet_03v3 w=0.4u l=2.8u ad=1.1200e-13 pd=9.6000e-07 as=1.7600e-13 ps=1.4800e-06 nf=1 m=4 par=4
XMpar3 a_6254_6544.t12 a_2550_1249.t10 out.t1 vss.t0 nfet_03v3 w=0.73u l=2.55u ad=4.3800e-13 pd=2.6600e-06 as=2.0440e-13 ps=1.2900e-06 nf=1 m=2 par=2
XMpar4 ib.t1 ib vss.t4 vss.t3 nfet_03v3 w=0.4u l=2.8u ad=2.4000e-13 pd=2.0000e-06 as=1.1200e-13 ps=9.6000e-07 nf=1 m=2 par=2
XMpar5 a_2602_8020.t12 a_2550_1249.t0 vdd.t1 vdd.t0 pfet_03v3 w=2.14u l=4.5u ad=5.9920e-13 pd=2.7000e-06 as=9.4160e-13 ps=4.0900e-06 nf=1 m=4 par=4
XMpar6 a_3722_8020.t14 ib vss.t4 vss.t3 nfet_03v3 w=0.4u l=2.8u ad=1.1200e-13 pd=9.6000e-07 as=1.7600e-13 ps=1.4800e-06 nf=1 m=4 par=4
XMpar7 a_2550_1249.t4 ib vss.t4 vss.t3 nfet_03v3 w=0.4u l=2.8u ad=1.1200e-13 pd=9.6000e-07 as=1.1200e-13 ps=9.6000e-07 nf=1 m=2 par=2
XMpar8 a_2602_8020.t0 inn.t0 a_6254_6544.t0 vdd.t4 pfet_03v3 w=1.78u l=5u ad=6.8827e-13 pd=3.1467e-06 as=6.8827e-13 ps=3.1467e-06 nf=1 m=12 par=12
XMpar9 a_4212_4624.t3 a_4212_4624.t2 vdd.t1 vdd.t0 pfet_03v3 w=2.14u l=4.5u ad=1.2840e-12 pd=5.4800e-06 as=5.9920e-13 ps=2.7000e-06 nf=1 m=2 par=2
XMpar10 out.t0 a_4212_4624.t2 vdd.t1 vdd.t0 pfet_03v3 w=2.14u l=4.5u ad=5.9920e-13 pd=2.7000e-06 as=5.9920e-13 ps=2.7000e-06 nf=1 m=2 par=2
XMpar11 a_2550_1249.t1 a_2550_1249.t0 vdd.t1 vdd.t0 pfet_03v3 w=2.14u l=4.5u ad=5.9920e-13 pd=2.7000e-06 as=5.9920e-13 ps=2.7000e-06 nf=1 m=2 par=2
Rpar0 a_2550_1249.t0 a_2550_1249.t1 26.7623
Rpar1 a_2550_1249.t0 a_2550_1249.t10 189.1647
Rpar2 a_2550_1249.t0 a_2550_1249.t4 100.4090
Rpar3 a_2550_1249.t1 a_2550_1249.t10 169.2025
Rpar4 a_2550_1249.t1 a_2550_1249.t4 89.8131
Rpar5 a_2550_1249.t10 a_2550_1249.t4 146.7042
Rpar6 a_2602_8020.t0 a_2602_8020.t12 53.5634
Rpar7 a_3722_8020.t0 a_3722_8020.t2 113.9921
Rpar8 a_3722_8020.t0 a_3722_8020.t14 61.1985
Rpar9 a_3722_8020.t2 a_3722_8020.t14 83.7712
Rpar10 a_4212_4624.t0 a_4212_4624.t2 203.5057
Rpar11 a_4212_4624.t0 a_4212_4624.t3 76.9757
Rpar12 a_4212_4624.t2 a_4212_4624.t3 17.6826
Rpar13 a_6254_6544.t0 a_6254_6544.t12 113.9921
Rpar14 a_6254_6544.t0 a_6254_6544.t14 83.7712
Rpar15 a_6254_6544.t12 a_6254_6544.t14 61.1985
Rpar16 ib ib.t1 16.4422
Rpar17 inn inn.t0 2.1122
Rpar18 inp inp.t0 2.1122
Rpar19 out out.t0 9.5051
Rpar20 out out.t1 70.1127
Rpar21 out.t0 out.t1 272.7292
Rpar22 vdd vdd.t0 95.9026
Rpar23 vdd vdd.t1 125.1006
Rpar24 vdd vdd.t4 22.9385
Rpar25 vdd.t0 vdd.t1 4.4685
Rpar26 vdd.t0 vdd.t4 319.0254
Rpar27 vdd.t1 vdd.t4 416.1542
Rpar28 vss vss.t0 220.5988
Rpar29 vss vss.t4 87.5737
Rpar30 vss vss.t3 34.7893
Rpar31 vss.t0 vss.t4 201.0157
Rpar32 vss.t0 vss.t3 71.2631
Rpar33 vss.t4 vss.t3 5.2179
Cpar0 a_2550_1249.t0 vss 1.66284e-14
Cpar1 a_2550_1249.t1 vss 3.16837e-15
Cpar2 a_2550_1249.t10 vss 5.70468e-15
Cpar3 a_2550_1249.t4 vss 2.02452e-15
Cpar4 a_2602_8020.t0 vss 3.44532e-14
Cpar5 a_2602_8020.t12 vss 1.01007e-14
Cpar6 a_3722_8020.t0 vss 3.80409e-15
Cpar7 a_3722_8020.t14 vss 5.02623e-15
Cpar8 a_3722_8020.t2 vss 1.69626e-14
Cpar9 a_4212_4624.t0 vss 1.48421e-15
Cpar10 a_4212_4624.t2 vss 1.21778e-14
Cpar11 a_4212_4624.t3 vss 4.12952e-15
Cpar12 a_6254_6544.t0 vss 1.73878e-14
Cpar13 a_6254_6544.t12 vss 3.89946e-15
Cpar14 a_6254_6544.t14 vss 5.15225e-15
Cpar15 ib vdd 1.23770e-16
Cpar16 ib vss 2.74916e-14
Cpar17 ib.t1 vss 3.86410e-16
Cpar18 inn inp 2.05300e-16
Cpar19 inn out 2.33400e-17
Cpar20 inn vdd 2.28025e-14
Cpar21 inn vss 4.45095e-15
Cpar22 inn.t0 vss 3.02852e-14
Cpar23 inp vdd 2.27731e-14
Cpar24 inp vss 4.46306e-15
Cpar25 inp.t0 vss 3.02619e-14
Cpar26 out vdd 2.80732e-15
Cpar27 out vss 5.32249e-15
Cpar28 out.t0 vss 1.43660e-15
Cpar29 out.t1 vss 1.91250e-15
Cpar30 vdd vss 2.17907e-13
Cpar31 vdd.t0 vss 2.11992e-14
Cpar32 vdd.t1 vss 1.56712e-14
Cpar33 vdd.t4 vss 5.62295e-14
.ends opamp_dut

Vdd vdd 0 1.800000
Vss vss 0 0
Ibias vdd ib 2.889000e-07
Vinp inp 0 DC 0.751000 AC 1 PWL(0 0.751000 2.552774e-07 0.751000 2.808051e-07 0.761000)
Rfb out inn 1m
Cload out 0 2.000000e-12
Xdut vdd vss inp inn out ib opamp_dut
.end
