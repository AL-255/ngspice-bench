* opa1000[0778]: 200f/symmetrical_ota_3v3_i1u_subth (symmetrical_ota, VDD=3.3V, CL=0.2pF, Iref=0.1167uA)
.include "pdk_opa.inc"
.temp 27
.option gmin=1e-12 rshunt=1e12 reltol=1e-3 abstol=1e-12 vntol=1e-5 method=gear
* Post-PEX R+C extracted netlist for symmetrical_ota_3v3_i1u_subth
.subckt opamp_dut vdd vss inp inn out ib
XMpar0 a_1829_7035.t11 a_1829_7035.t10 vdd.t1 vdd.t0 pfet_03v3 w=1.91u l=4.5u ad=1.1460e-12 pd=5.0200e-06 as=5.3480e-13 ps=2.4700e-06 nf=1 m=2 par=2
XMpar1 a_1641_4038.t4 inp.t0 a_1829_7035.t0 vss.t18 nfet_03v3 w=1.99u l=2.08u ad=6.8456e-13 pd=3.0760e-06 as=6.8456e-13 ps=3.0760e-06 nf=1 m=10 par=10
XMpar2 out.t2 a_1829_7035.t10 vdd.t1 vdd.t0 pfet_03v3 w=1.91u l=4.5u ad=1.1460e-12 pd=5.0200e-06 as=8.4040e-13 ps=3.7450e-06 nf=1 m=4 par=4
XMpar3 a_1641_4038.t0 ib.t0 vss.t1 vss.t0 nfet_03v3 w=0.4u l=2.1u ad=1.1200e-13 pd=9.6000e-07 as=1.7600e-13 ps=1.4800e-06 nf=1 m=4 par=4
XMpar4 a_1641_4038.t4 inn.t0 a_6094_1205.t4 vss.t18 nfet_03v3 w=1.99u l=2.08u ad=6.8456e-13 pd=3.0760e-06 as=6.8456e-13 ps=3.0760e-06 nf=1 m=10 par=10
XMpar5 out.t0 a_2148_5400.t4 vss.t13 vss.t12 nfet_03v3 w=0.5u l=4.5u ad=1.4000e-13 pd=1.0600e-06 as=2.2000e-13 ps=1.6300e-06 nf=1 m=4 par=4
XMpar6 a_6094_1205.t1 a_6094_1205.t0 vdd.t1 vdd.t0 pfet_03v3 w=1.91u l=4.5u ad=1.1460e-12 pd=5.0200e-06 as=5.3480e-13 ps=2.4700e-06 nf=1 m=2 par=2
XMpar7 ib.t1 ib.t0 vss.t1 vss.t0 nfet_03v3 w=0.4u l=2.1u ad=1.1200e-13 pd=9.6000e-07 as=1.1200e-13 ps=9.6000e-07 nf=1 m=2 par=2
XMpar8 a_2148_5400.t0 a_6094_1205.t0 vdd.t1 vdd.t0 pfet_03v3 w=1.91u l=4.5u ad=1.1460e-12 pd=5.0200e-06 as=8.4040e-13 ps=3.7450e-06 nf=1 m=4 par=4
XMpar9 a_2148_5400.t5 a_2148_5400.t4 vss.t13 vss.t12 nfet_03v3 w=0.5u l=4.5u ad=1.4000e-13 pd=1.0600e-06 as=1.4000e-13 ps=1.0600e-06 nf=1 m=4 par=4
X22 out.t8 vss.t29 cap_mim_2f0fF c_width=19.27u c_length=19.27u
Rpar0 a_1641_4038.t0 a_1641_4038.t4 50.4736
Rpar1 a_1829_7035.t0 a_1829_7035.t10 114.6365
Rpar2 a_1829_7035.t0 a_1829_7035.t11 99.2933
Rpar3 a_1829_7035.t10 a_1829_7035.t11 12.4202
Rpar4 a_2148_5400.t0 a_2148_5400.t4 143.7303
Rpar5 a_2148_5400.t0 a_2148_5400.t5 59.5357
Rpar6 a_2148_5400.t4 a_2148_5400.t5 23.2563
Rpar7 a_6094_1205.t0 a_6094_1205.t1 12.4202
Rpar8 a_6094_1205.t0 a_6094_1205.t4 114.6361
Rpar9 a_6094_1205.t1 a_6094_1205.t4 99.2935
Rpar10 ib ib.t0 15.9595
Rpar11 ib ib.t1 16.5591
Rpar12 ib.t0 ib.t1 143.8888
Rpar13 inn inn.t0 2.2430
Rpar14 inp inp.t0 2.2430
Rpar15 out out.t0 74.1299
Rpar16 out out.t2 4.3221
Rpar17 out out.t8 90.1905
Rpar18 out.t0 out.t8 194.8384
Rpar19 vdd vdd.t0 157.7041
Rpar20 vdd vdd.t1 40.5945
Rpar21 vdd.t0 vdd.t1 6.8101
Rpar22 vss vss.t0 183.9304
Rpar23 vss vss.t1 826.8793
Rpar24 vss vss.t12 116.9242
Rpar25 vss vss.t13 1002.4884
Rpar26 vss vss.t18 94.8217
Rpar27 vss vss.t29 3787.5986
Rpar28 vss.t0 vss.t1 16.7935
Rpar29 vss.t0 vss.t12 4.1194
Rpar30 vss.t0 vss.t13 26.1453
Rpar31 vss.t0 vss.t18 3.6752
Rpar32 vss.t0 vss.t29 298.0107
Rpar33 vss.t1 vss.t12 23.5432
Rpar34 vss.t1 vss.t13 181.6145
Rpar35 vss.t1 vss.t18 18.8627
Rpar36 vss.t1 vss.t29 1801.0259
Rpar37 vss.t12 vss.t13 16.0593
Rpar38 vss.t12 vss.t18 2.4096
Rpar39 vss.t12 vss.t29 185.7040
Rpar40 vss.t13 vss.t18 14.9801
Rpar41 vss.t13 vss.t29 1009.2154
Rpar42 vss.t18 vss.t29 173.1706
Cpar0 a_1641_4038.t0 vss 2.92516e-15
Cpar1 a_1641_4038.t4 vss 1.51796e-14
Cpar2 a_1829_7035.t0 vss 1.06023e-14
Cpar3 a_1829_7035.t10 vss 2.19299e-14
Cpar4 a_1829_7035.t11 vss 6.48514e-15
Cpar5 a_2148_5400.t0 vss 5.19270e-15
Cpar6 a_2148_5400.t4 vss 9.69506e-15
Cpar7 a_2148_5400.t5 vss 2.18066e-15
Cpar8 a_6094_1205.t0 vss 2.00185e-14
Cpar9 a_6094_1205.t1 vss 5.91983e-15
Cpar10 a_6094_1205.t4 vss 9.67814e-15
Cpar11 ib vss 1.10646e-14
Cpar12 ib.t0 vss 1.55194e-15
Cpar13 ib.t1 vss 7.22535e-17
Cpar14 inn inp 1.03670e-16
Cpar15 inn vss 1.17495e-14
Cpar16 inn.t0 vss 3.95209e-15
Cpar17 inp vss 1.19262e-14
Cpar18 inp.t0 vss 3.95828e-15
Cpar19 out vdd 7.08281e-15
Cpar20 out vss 1.85792e-14
Cpar21 out.t0 vss 7.11519e-16
Cpar22 out.t2 vss 5.60087e-16
Cpar23 out.t8 vss 1.74779e-14
Cpar24 vdd vss 1.05791e-13
Cpar25 vdd.t0 vss 4.13283e-14
Cpar26 vdd.t1 vss 8.72562e-15
.ends opamp_dut

Vdd vdd 0 3.300000
Vss vss 0 0
Ibias vdd ib 1.167000e-07
Vinp inp 0 DC 1.645000 AC 1 PWL(0 1.645000 1.153016e-07 1.645000 1.268318e-07 1.655000)
Rfb out inn 1m
Cload out 0 2.000000e-13
Xdut vdd vss inp inn out ib opamp_dut
.end
