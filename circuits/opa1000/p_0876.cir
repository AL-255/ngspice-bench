* opa1000[0876]: 2p/telescopic_nmos_1v8_ulp_lt0p1uw_weak (telescopic_nmos, VDD=1.8V, CL=2.0pF, Iref=0.0038uA)
.include "pdk_opa.inc"
.temp 27
.option gmin=1e-12 rshunt=1e12 reltol=1e-3 abstol=1e-12 vntol=1e-5 method=gear
* Post-PEX R+C extracted netlist for telescopic_nmos_1v8_ulp_lt0p1uw_weak
.subckt opamp_dut vdd vss inp inn out ib
XMpar0 a_6184_9425.t0 a_4216_9217.t0 out.t1 vdd.t0 pfet_03v3 w=0.4u l=8.5u ad=2.4000e-13 pd=2.0000e-06 as=1.1200e-13 ps=9.6000e-07 nf=1 m=2 par=2
XMpar1 a_4874_5817.t4 ib.t0 vss.t7 vss.t6 nfet_03v3 w=0.4u l=5u ad=1.1200e-13 pd=9.6000e-07 as=2.0800e-13 ps=1.7400e-06 nf=1 m=8 par=8
XMpar2 a_6184_9425.t2 a_4216_9217.t8 vdd.t4 vdd.t3 pfet_03v3 w=0.4u l=6.5u ad=1.1200e-13 pd=9.6000e-07 as=1.1200e-13 ps=9.6000e-07 nf=1 m=2 par=2
XMpar3 a_4096_9425.t0 a_4216_9217.t0 a_4216_9217.t1 vdd.t0 pfet_03v3 w=0.4u l=8.5u ad=2.4000e-13 pd=2.0000e-06 as=2.4000e-13 ps=2.0000e-06 nf=1 m=2 par=2
XMpar4 a_9434_5817.t2 vdd.t12 out.t0 vss.t21 nfet_03v3 w=0.4u l=8.5u ad=2.4000e-13 pd=2.0000e-06 as=2.4000e-13 ps=2.0000e-06 nf=1 m=2 par=2
XMpar5 a_4096_9425.t1 a_4216_9217.t8 vdd.t4 vdd.t3 pfet_03v3 w=0.4u l=6.5u ad=2.4000e-13 pd=2.0000e-06 as=1.1200e-13 ps=9.6000e-07 nf=1 m=2 par=2
XMpar6 ib.t1 ib.t0 vss.t7 vss.t6 nfet_03v3 w=0.4u l=5u ad=2.4000e-13 pd=2.0000e-06 as=1.1200e-13 ps=9.6000e-07 nf=1 m=2 par=2
XMpar7 a_4216_9217.t4 vdd.t12 a_5886_7228.t2 vss.t21 nfet_03v3 w=0.4u l=8.5u ad=2.4000e-13 pd=2.0000e-06 as=2.4000e-13 ps=2.0000e-06 nf=1 m=2 par=2
XMpar8 a_4874_5817.t0 inp.t0 a_5886_7228.t0 vss.t0 nfet_03v3 w=0.4u l=6.5u ad=2.4000e-13 pd=2.0000e-06 as=1.1200e-13 ps=9.6000e-07 nf=1 m=2 par=2
XMpar9 a_4874_5817.t0 inn.t0 a_9434_5817.t0 vss.t0 nfet_03v3 w=0.4u l=6.5u ad=2.4000e-13 pd=2.0000e-06 as=1.1200e-13 ps=9.6000e-07 nf=1 m=2 par=2
X3 out.t4 vss.t2 cap_mim_2f0fF c_width=14.82u c_length=14.81u
X8 out.t4 vss.t2 cap_mim_2f0fF c_width=14.82u c_length=14.81u
Rpar0 a_4096_9425.t0 a_4096_9425.t1 68.4982
Rpar1 a_4216_9217.t0 a_4216_9217.t1 27.8603
Rpar2 a_4216_9217.t0 a_4216_9217.t8 123.6870
Rpar3 a_4216_9217.t0 a_4216_9217.t4 204.4505
Rpar4 a_4216_9217.t1 a_4216_9217.t8 103.9237
Rpar5 a_4216_9217.t1 a_4216_9217.t4 171.7826
Rpar6 a_4216_9217.t8 a_4216_9217.t4 185.7739
Rpar7 a_4874_5817.t0 a_4874_5817.t4 85.5536
Rpar8 a_5886_7228.t0 a_5886_7228.t2 54.7427
Rpar9 a_6184_9425.t0 a_6184_9425.t2 65.7755
Rpar10 a_9434_5817.t0 a_9434_5817.t2 54.7427
Rpar11 ib ib.t0 13.2767
Rpar12 ib ib.t1 14.2348
Rpar13 ib.t0 ib.t1 33.8818
Rpar14 inn inn.t0 3.2172
Rpar15 inp inp.t0 3.2658
Rpar16 out out.t0 48.0829
Rpar17 out out.t1 16.3803
Rpar18 out out.t4 121.4604
Rpar19 out.t0 out.t4 192.6402
Rpar20 vdd vdd.t0 98.0750
Rpar21 vdd vdd.t3 75.7476
Rpar22 vdd vdd.t4 141.1078
Rpar23 vdd vdd.t12 147.6368
Rpar24 vdd.t0 vdd.t3 412.4296
Rpar25 vdd.t0 vdd.t4 768.3019
Rpar26 vdd.t0 vdd.t12 83.3568
Rpar27 vdd.t3 vdd.t4 14.8467
Rpar28 vdd.t3 vdd.t12 620.8490
Rpar29 vdd.t4 vdd.t12 1156.5597
Rpar30 vss vss.t0 224.4379
Rpar31 vss vss.t6 110.0524
Rpar32 vss vss.t7 64.9205
Rpar33 vss vss.t2 103.3346
Rpar34 vss vss.t21 531.7591
Rpar35 vss.t0 vss.t6 3.1913
Rpar36 vss.t0 vss.t7 45.8273
Rpar37 vss.t0 vss.t2 544.6750
Rpar38 vss.t0 vss.t21 14.7356
Rpar39 vss.t6 vss.t7 19.5321
Rpar40 vss.t6 vss.t2 256.0370
Rpar41 vss.t6 vss.t21 7.9883
Rpar42 vss.t7 vss.t2 95.3256
Rpar43 vss.t7 vss.t21 121.9095
Rpar44 vss.t2 vss.t21 1332.2495
Cpar0 a_4096_9425.t0 vss 8.90062e-15
Cpar1 a_4096_9425.t1 vss 7.66877e-15
Cpar2 a_4216_9217.t0 vss 2.07727e-14
Cpar3 a_4216_9217.t1 vss 6.05611e-15
Cpar4 a_4216_9217.t4 vss 6.39767e-15
Cpar5 a_4216_9217.t8 vss 1.64808e-14
Cpar6 a_4874_5817.t0 vss 7.05026e-15
Cpar7 a_4874_5817.t4 vss 1.06535e-14
Cpar8 a_5886_7228.t0 vss 2.93578e-15
Cpar9 a_5886_7228.t2 vss 4.50022e-15
Cpar10 a_6184_9425.t0 vss 1.06420e-14
Cpar11 a_6184_9425.t2 vss 7.22611e-15
Cpar12 a_9434_5817.t0 vss 3.06181e-15
Cpar13 a_9434_5817.t2 vss 4.69340e-15
Cpar14 ib out 1.46000e-17
Cpar15 ib vss 3.78799e-14
Cpar16 ib.t0 vss 5.24853e-15
Cpar17 ib.t1 vss 4.35177e-16
Cpar18 inn inp 5.16000e-17
Cpar19 inn out 3.71500e-17
Cpar20 inn vdd 1.72900e-17
Cpar21 inn vss 6.87058e-15
Cpar22 inn.t0 vss 4.78805e-16
Cpar23 inp out 6.31100e-17
Cpar24 inp vdd 1.85300e-17
Cpar25 inp vss 6.79411e-15
Cpar26 inp.t0 vss 5.04705e-16
Cpar27 out vdd 5.46436e-15
Cpar28 out vss 1.99603e-14
Cpar29 out.t0 vss 3.90209e-16
Cpar30 out.t1 vss 6.76760e-17
Cpar31 out.t4 vss 1.50495e-14
Cpar32 vdd vss 1.05628e-13
Cpar33 vdd.t0 vss 2.05767e-14
Cpar34 vdd.t12 vss 6.69611e-15
Cpar35 vdd.t3 vss 1.07073e-14
Cpar36 vdd.t4 vss 5.50029e-15
.ends opamp_dut

Vdd vdd 0 1.800000
Vss vss 0 0
Ibias vdd ib 3.800000e-09
Vinp inp 0 DC 0.931000 AC 1 PWL(0 0.931000 1.087755e-05 0.931000 1.196531e-05 0.941000)
Rfb out inn 1m
Cload out 0 2.000000e-12
Xdut vdd vss inp inn out ib opamp_dut
.end
