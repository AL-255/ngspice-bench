* opa1000[0762]: 200f/symmetrical_ota_1v8_1u_10u_weak (symmetrical_ota, VDD=1.8V, CL=0.2pF, Iref=0.7083uA)
.include "pdk_opa.inc"
.temp 27
.option gmin=1e-12 rshunt=1e12 reltol=1e-3 abstol=1e-12 vntol=1e-5 method=gear
* Post-PEX R+C extracted netlist for symmetrical_ota_1v8_1u_10u_weak
.subckt opamp_dut vdd vss inp inn out ib
XMpar0 out.t1 a_3348_9725.t0 vss.t5 vss.t4 nfet_03v3 w=0.4u l=2u ad=1.1200e-13 pd=9.6000e-07 as=1.7600e-13 ps=1.4800e-06 nf=1 m=4 par=4
XMpar1 a_1756_4628.t0 inp.t0 a_2930_8263.t0 vss.t0 nfet_03v3 w=1.47u l=2u ad=4.1160e-13 pd=2.0300e-06 as=6.4680e-13 ps=3.0850e-06 nf=1 m=4 par=4
XMpar2 a_5814_8263.t5 a_5814_8263.t4 vdd.t1 vdd.t0 pfet_03v3 w=1.53u l=2u ad=9.1800e-13 pd=4.2600e-06 as=4.2840e-13 ps=2.0900e-06 nf=1 m=2 par=2
XMpar3 a_2930_8263.t0 inn.t0 a_5814_8263.t0 vss.t0 nfet_03v3 w=1.47u l=2u ad=6.4680e-13 pd=3.0850e-06 as=4.1160e-13 ps=2.0300e-06 nf=1 m=4 par=4
XMpar4 out.t0 a_1756_4628.t4 vdd.t1 vdd.t0 pfet_03v3 w=1.53u l=2u ad=9.1800e-13 pd=4.2600e-06 as=6.7320e-13 ps=3.1750e-06 nf=1 m=4 par=4
XMpar5 a_2930_8263.t8 ib.t0 vss.t15 vss.t14 nfet_03v3 w=0.65u l=2u ad=1.8200e-13 pd=1.2100e-06 as=2.8600e-13 ps=1.8550e-06 nf=1 m=4 par=4
XMpar6 a_1756_4628.t5 a_1756_4628.t4 vdd.t1 vdd.t0 pfet_03v3 w=1.53u l=2u ad=9.1800e-13 pd=4.2600e-06 as=4.2840e-13 ps=2.0900e-06 nf=1 m=2 par=2
XMpar7 a_3348_9725.t8 a_5814_8263.t4 vdd.t1 vdd.t0 pfet_03v3 w=1.53u l=2u ad=9.1800e-13 pd=4.2600e-06 as=6.7320e-13 ps=3.1750e-06 nf=1 m=4 par=4
XMpar8 a_3348_9725.t1 a_3348_9725.t0 vss.t5 vss.t4 nfet_03v3 w=0.4u l=2u ad=1.1200e-13 pd=9.6000e-07 as=1.1200e-13 ps=9.6000e-07 nf=1 m=4 par=4
XMpar9 ib.t1 ib.t0 vss.t15 vss.t14 nfet_03v3 w=0.65u l=2u ad=1.8200e-13 pd=1.2100e-06 as=1.8200e-13 ps=1.2100e-06 nf=1 m=2 par=2
X29 out.t8 vss.t26 cap_mim_2f0fF c_width=9.69u c_length=9.68u
Rpar0 a_1756_4628.t0 a_1756_4628.t4 99.8461
Rpar1 a_1756_4628.t0 a_1756_4628.t5 74.7053
Rpar2 a_1756_4628.t4 a_1756_4628.t5 12.8177
Rpar3 a_2930_8263.t0 a_2930_8263.t8 66.1466
Rpar4 a_3348_9725.t0 a_3348_9725.t1 21.3737
Rpar5 a_3348_9725.t0 a_3348_9725.t8 160.7265
Rpar6 a_3348_9725.t1 a_3348_9725.t8 80.1161
Rpar7 a_5814_8263.t0 a_5814_8263.t4 99.8461
Rpar8 a_5814_8263.t0 a_5814_8263.t5 74.7053
Rpar9 a_5814_8263.t4 a_5814_8263.t5 12.8177
Rpar10 ib ib.t0 15.9433
Rpar11 ib ib.t1 15.5341
Rpar12 ib.t0 ib.t1 140.0242
Rpar13 inn inn.t0 2.6665
Rpar14 inp inp.t0 2.7151
Rpar15 out out.t0 72.8119
Rpar16 out out.t1 105.5142
Rpar17 out out.t8 15.0070
Rpar18 out.t0 out.t1 252.6230
Rpar19 out.t0 out.t8 963.6479
Rpar20 out.t1 out.t8 1396.4547
Rpar21 vdd vdd.t0 548.4585
Rpar22 vdd vdd.t1 100.0818
Rpar23 vdd.t0 vdd.t1 8.1131
Rpar24 vss vss.t0 233.3719
Rpar25 vss vss.t4 167.3054
Rpar26 vss vss.t5 320.6094
Rpar27 vss vss.t14 96.5808
Rpar28 vss vss.t15 157.3767
Rpar29 vss vss.t26 68.7947
Rpar30 vss.t0 vss.t4 2.6880
Rpar31 vss.t0 vss.t5 15.4789
Rpar32 vss.t0 vss.t14 492.9134
Rpar33 vss.t0 vss.t15 804.2016
Rpar34 vss.t0 vss.t26 881.4315
Rpar35 vss.t4 vss.t5 11.0978
Rpar36 vss.t4 vss.t14 352.6037
Rpar37 vss.t4 vss.t15 575.3500
Rpar38 vss.t4 vss.t26 631.9023
Rpar39 vss.t5 vss.t14 678.1124
Rpar40 vss.t5 vss.t15 1106.3215
Rpar41 vss.t5 vss.t26 1210.9223
Rpar42 vss.t14 vss.t15 8.5161
Rpar43 vss.t14 vss.t26 364.7797
Rpar44 vss.t15 vss.t26 594.4023
Cpar0 a_1756_4628.t0 vss 3.27966e-15
Cpar1 a_1756_4628.t4 vss 1.18534e-14
Cpar2 a_1756_4628.t5 vss 5.01972e-15
Cpar3 a_2930_8263.t0 vss 5.32266e-15
Cpar4 a_2930_8263.t8 vss 3.36194e-15
Cpar5 a_3348_9725.t0 vss 6.74114e-15
Cpar6 a_3348_9725.t1 vss 2.46308e-15
Cpar7 a_3348_9725.t8 vss 5.27582e-15
Cpar8 a_5814_8263.t0 vss 3.37873e-15
Cpar9 a_5814_8263.t4 vss 1.22115e-14
Cpar10 a_5814_8263.t5 vss 5.17137e-15
Cpar11 ib vss 1.07506e-14
Cpar12 ib.t0 vss 1.32800e-15
Cpar13 ib.t1 vss 6.08557e-17
Cpar14 inn inp 5.13900e-17
Cpar15 inn vdd 2.30200e-17
Cpar16 inn vss 5.08576e-15
Cpar17 inn.t0 vss 8.19858e-16
Cpar18 inp vdd 1.65800e-17
Cpar19 inp vss 5.18764e-15
Cpar20 inp.t0 vss 7.82203e-16
Cpar21 out vdd 6.44104e-15
Cpar22 out vss 1.46773e-14
Cpar23 out.t0 vss 1.89905e-15
Cpar24 out.t1 vss 1.39238e-15
Cpar25 out.t8 vss 9.67696e-15
Cpar26 vdd vss 7.35851e-14
Cpar27 vdd.t0 vss 2.34797e-14
Cpar28 vdd.t1 vss 1.15137e-14
.ends opamp_dut

Vdd vdd 0 1.800000
Vss vss 0 0
Ibias vdd ib 7.083000e-07
Vinp inp 0 DC 0.895000 AC 1 PWL(0 0.895000 1.233148e-08 0.895000 1.356463e-08 0.905000)
Rfb out inn 1m
Cload out 0 2.000000e-13
Xdut vdd vss inp inn out ib opamp_dut
.end
