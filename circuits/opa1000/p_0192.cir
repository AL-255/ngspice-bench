* opa1000[0192]: 200f/folded_cascode_nmos_3v3_0p1u_1u_weak (folded_cascode_nmos, VDD=3.3V, CL=0.2pF, Iref=0.1278uA)
.include "pdk_opa.inc"
.temp 27
.option gmin=1e-12 rshunt=1e12 reltol=1e-3 abstol=1e-12 vntol=1e-5 method=gear
* Post-PEX R+C extracted netlist for folded_cascode_nmos_3v3_0p1u_1u_weak
.subckt opamp_dut vdd vss inp inn out ib
XMpar0 a_1210_7365.t3 a_1210_7365.t2 vdd.t1 vdd.t0 pfet_03v3 w=0.93u l=3.9u ad=2.6040e-13 pd=1.4900e-06 as=5.5800e-13 ps=3.0600e-06 nf=1 m=2 par=2
XMpar1 a_2434_1205.t0 ib.t0 vss.t1 vss.t0 nfet_03v3 w=0.4u l=4u ad=1.1200e-13 pd=9.6000e-07 as=1.1200e-13 ps=9.6000e-07 nf=1 m=4 par=4
XMpar2 a_2434_1205.t4 inn.t0 a_4974_6033.t3 vss.t18 nfet_03v3 w=0.53u l=5u ad=3.1800e-13 pd=2.2600e-06 as=1.4840e-13 ps=1.0900e-06 nf=1 m=2 par=2
XMpar3 a_1210_7365.t0 ib.t0 vss.t1 vss.t0 nfet_03v3 w=0.4u l=4u ad=1.1200e-13 pd=9.6000e-07 as=1.1200e-13 ps=9.6000e-07 nf=1 m=2 par=2
XMpar4 a_1990_7573.t0 a_1210_7365.t2 vdd.t1 vdd.t0 pfet_03v3 w=0.93u l=3.9u ad=2.6040e-13 pd=1.4900e-06 as=4.0920e-13 ps=2.2750e-06 nf=1 m=4 par=4
XMpar5 a_4974_6033.t0 a_1210_7365.t2 vdd.t1 vdd.t0 pfet_03v3 w=0.93u l=3.9u ad=2.6040e-13 pd=1.4900e-06 as=4.0920e-13 ps=2.2750e-06 nf=1 m=4 par=4
XMpar6 a_1990_7573.t5 inp.t0 a_2434_1205.t4 vss.t18 nfet_03v3 w=0.53u l=5u ad=1.4840e-13 pd=1.0900e-06 as=3.1800e-13 ps=2.2600e-06 nf=1 m=2 par=2
XMpar7 out.t2 a_3132_4462.t2 vss.t1 vss.t0 nfet_03v3 w=0.4u l=4u ad=1.1200e-13 pd=9.6000e-07 as=1.1200e-13 ps=9.6000e-07 nf=1 m=2 par=2
XMpar8 a_1990_7573.t1 ib.t10 a_3132_4462.t0 vdd.t6 pfet_03v3 w=0.82u l=1.6u ad=4.9200e-13 pd=2.8400e-06 as=2.2960e-13 ps=1.3800e-06 nf=1 m=2 par=2
XMpar9 a_4974_6033.t1 ib.t10 out.t0 vdd.t6 pfet_03v3 w=0.82u l=1.6u ad=4.9200e-13 pd=2.8400e-06 as=2.2960e-13 ps=1.3800e-06 nf=1 m=2 par=2
XMpar10 ib.t1 ib.t0 vss.t1 vss.t0 nfet_03v3 w=0.4u l=4u ad=2.4000e-13 pd=2.0000e-06 as=1.1200e-13 ps=9.6000e-07 nf=1 m=2 par=2
XMpar11 a_3132_4462.t3 a_3132_4462.t2 vss.t1 vss.t0 nfet_03v3 w=0.4u l=4u ad=2.4000e-13 pd=2.0000e-06 as=1.1200e-13 ps=9.6000e-07 nf=1 m=2 par=2
Rpar0 a_1210_7365.t0 a_1210_7365.t2 130.4815
Rpar1 a_1210_7365.t0 a_1210_7365.t3 258.0434
Rpar2 a_1210_7365.t2 a_1210_7365.t3 23.6164
Rpar3 a_1990_7573.t0 a_1990_7573.t1 74.6616
Rpar4 a_1990_7573.t0 a_1990_7573.t5 102.0774
Rpar5 a_1990_7573.t1 a_1990_7573.t5 103.8797
Rpar6 a_2434_1205.t0 a_2434_1205.t4 73.5944
Rpar7 a_3132_4462.t0 a_3132_4462.t2 131.9484
Rpar8 a_3132_4462.t0 a_3132_4462.t3 98.5442
Rpar9 a_3132_4462.t2 a_3132_4462.t3 21.8137
Rpar10 a_4974_6033.t0 a_4974_6033.t1 74.6616
Rpar11 a_4974_6033.t0 a_4974_6033.t3 102.0774
Rpar12 a_4974_6033.t1 a_4974_6033.t3 103.8797
Rpar13 ib ib.t0 22.7501
Rpar14 ib ib.t1 10.5777
Rpar15 ib ib.t10 155.7145
Rpar16 ib.t0 ib.t1 53.8874
Rpar17 ib.t0 ib.t10 253.8261
Rpar18 ib.t1 ib.t10 368.8358
Rpar19 inn inn.t0 3.1521
Rpar20 inp inp.t0 3.2006
Rpar21 out out.t0 11.8879
Rpar22 out out.t2 54.7060
Rpar23 vdd vdd.t0 61.7090
Rpar24 vdd vdd.t1 62.3713
Rpar25 vdd vdd.t6 238.5253
Rpar26 vdd.t0 vdd.t1 6.6097
Rpar27 vdd.t0 vdd.t6 158.3334
Rpar28 vdd.t1 vdd.t6 230.9865
Rpar29 vss vss.t0 35.9440
Rpar30 vss vss.t1 111.8686
Rpar31 vss vss.t18 62.6913
Rpar32 vss.t0 vss.t1 7.6499
Rpar33 vss.t0 vss.t18 4.0082
Rpar34 vss.t1 vss.t18 11.2741
Cpar0 a_1210_7365.t0 vss 7.39787e-15
Cpar1 a_1210_7365.t2 vss 2.66991e-14
Cpar2 a_1210_7365.t3 vss 3.35333e-15
Cpar3 a_1990_7573.t0 vss 4.91313e-15
Cpar4 a_1990_7573.t1 vss 3.83362e-15
Cpar5 a_1990_7573.t5 vss 3.38825e-15
Cpar6 a_2434_1205.t0 vss 6.90885e-15
Cpar7 a_2434_1205.t4 vss 6.38742e-15
Cpar8 a_3132_4462.t0 vss 6.86684e-16
Cpar9 a_3132_4462.t2 vss 3.24155e-15
Cpar10 a_3132_4462.t3 vss 1.05864e-15
Cpar11 a_4974_6033.t0 vss 4.63426e-15
Cpar12 a_4974_6033.t1 vss 3.61603e-15
Cpar13 a_4974_6033.t3 vss 3.19595e-15
Cpar14 ib inn 1.19100e-17
Cpar15 ib inp 1.19100e-17
Cpar16 ib out 1.64620e-16
Cpar17 ib vdd 4.03043e-15
Cpar18 ib vss 2.66218e-14
Cpar19 ib.t0 vss 6.49125e-15
Cpar20 ib.t1 vss 5.34307e-16
Cpar21 ib.t10 vss 2.62792e-15
Cpar22 inn inp 5.12600e-17
Cpar23 inn vss 5.39032e-15
Cpar24 inn.t0 vss 4.11640e-16
Cpar25 inp vss 5.34787e-15
Cpar26 inp.t0 vss 4.25579e-16
Cpar27 out vdd 1.06102e-15
Cpar28 out vss 5.60601e-15
Cpar29 out.t0 vss 1.42662e-16
Cpar30 out.t2 vss 2.13936e-15
Cpar31 vdd vss 7.12419e-14
Cpar32 vdd.t0 vss 1.81433e-14
Cpar33 vdd.t1 vss 1.27237e-14
Cpar34 vdd.t6 vss 8.13190e-15
.ends opamp_dut

Vdd vdd 0 3.300000
Vss vss 0 0
Ibias vdd ib 1.278000e-07
Vinp inp 0 DC 1.810000 AC 1 PWL(0 1.810000 7.007943e-08 1.810000 7.708737e-08 1.820000)
Rfb out inn 1m
Cload out 0 2.000000e-13
Xdut vdd vss inp inn out ib opamp_dut
.end
