* opa1000[0003]: 200f/cherry_hooper_1v8_i200n_subth (cherry_hooper, VDD=1.8V, CL=0.2pF, Iref=0.013uA)
.include "pdk_opa.inc"
.temp 27
.option gmin=1e-12 rshunt=1e12 reltol=1e-3 abstol=1e-12 vntol=1e-5 method=gear
* Post-PEX R+C extracted netlist for cherry_hooper_1v8_i200n_subth
.subckt opamp_dut vdd vss inp inn out ib
XMpar0 a_4091_1294.t0 a_4211_1086.t1 a_4211_1086.t2 vdd.t6 pfet_03v3 w=8.89u l=1u ad=3.4375e-12 pd=1.2627e-05 as=2.4892e-12 ps=9.4500e-06 nf=1 m=6 par=6
XMpar1 a_8144_1086.t2 a_8144_1086.t1 vdd.t1 vdd.t0 pfet_03v3 w=0.78u l=1.3u ad=3.0160e-13 pd=1.8133e-06 as=3.0160e-13 ps=1.8133e-06 nf=1 m=3 par=3
XMpar2 a_16785_6526.t0 ib.t0 vss.t2 vss.t1 nfet_03v3 w=0.4u l=4u ad=1.1200e-13 pd=9.6000e-07 as=1.1200e-13 ps=9.6000e-07 nf=1 m=4 par=4
XMpar3 a_14961_6526.t0 a_19274_16496.t5 a_8144_1086.t0 vss.t0 nfet_03v3 w=2.17u l=2.88u ad=1.3020e-12 pd=5.5400e-06 as=1.3020e-12 ps=5.5400e-06 nf=1 m=1
XMpar4 a_16785_6526.t4 inp.t0 a_19274_16496.t0 vss.t0 nfet_03v3 w=0.72u l=2.88u ad=4.3200e-13 pd=2.6400e-06 as=2.0160e-13 ps=1.2800e-06 nf=1 m=1
XMpar5 a_20494_18042.t2 a_4105_4374.t1 vdd.t3 vdd.t2 pfet_03v3 w=0.4u l=4u ad=1.1200e-13 pd=9.6000e-07 as=2.4000e-13 ps=2.0000e-06 nf=1 m=2 par=2
XMpar6 a_19108_10315.t0 a_8144_1086.t8 a_5205_6526.t8 vss.t0 nfet_03v3 w=2.89u l=2.88u ad=1.7340e-12 pd=6.9800e-06 as=1.7340e-12 ps=6.9800e-06 nf=1 m=1
XMpar7 a_14961_6526.t1 ib.t0 vss.t2 vss.t1 nfet_03v3 w=0.4u l=4u ad=1.1200e-13 pd=9.6000e-07 as=1.5467e-13 ps=1.3067e-06 nf=1 m=6 par=6
XMpar8 out.t1 a_19108_10315.t1 vdd.t1 vdd.t0 pfet_03v3 w=0.78u l=1.3u ad=2.1840e-13 pd=1.3400e-06 as=2.1840e-13 ps=1.3400e-06 nf=1 m=4 par=4
XMpar9 a_5205_6526.t0 ib.t0 vss.t2 vss.t1 nfet_03v3 w=0.4u l=4u ad=1.4400e-13 pd=1.2200e-06 as=1.7600e-13 ps=1.4800e-06 nf=1 m=8 par=8
XMpar10 a_19108_10315.t2 a_19108_10315.t1 vdd.t1 vdd.t0 pfet_03v3 w=0.78u l=1.3u ad=2.1840e-13 pd=1.3400e-06 as=3.4320e-13 ps=2.0500e-06 nf=1 m=4 par=4
XMpar11 a_20494_4582.t2 a_20494_4582.t1 vdd.t1 vdd.t0 pfet_03v3 w=0.78u l=1.3u ad=3.0160e-13 pd=1.8133e-06 as=3.0160e-13 ps=1.8133e-06 nf=1 m=3 par=3
XMpar12 a_16785_6526.t4 inn.t0 a_20494_18042.t0 vss.t41 nfet_03v3 w=0.72u l=2.88u ad=4.3200e-13 pd=2.6400e-06 as=2.0160e-13 ps=1.2800e-06 nf=1 m=1
XMpar13 a_19274_16496.t4 a_4211_1086.t13 a_8144_1086.t7 vdd.t40 pfet_03v3 w=5.6u l=1u ad=3.3600e-12 pd=1.2400e-05 as=3.3600e-12 ps=1.2400e-05 nf=1 m=1
XMpar14 a_20494_18042.t4 a_4211_1086.t13 a_20494_4582.t7 vdd.t40 pfet_03v3 w=5.6u l=1u ad=3.3600e-12 pd=1.2400e-05 as=3.3600e-12 ps=1.2400e-05 nf=1 m=1
XMpar15 a_19274_16496.t2 a_4105_4374.t1 vdd.t3 vdd.t2 pfet_03v3 w=0.4u l=4u ad=1.1200e-13 pd=9.6000e-07 as=2.4000e-13 ps=2.0000e-06 nf=1 m=2 par=2
XMpar16 a_4091_1294.t7 a_4091_1294.t6 vdd.t1 vdd.t0 pfet_03v3 w=0.78u l=1.3u ad=4.6800e-13 pd=2.7600e-06 as=4.6800e-13 ps=2.7600e-06 nf=1 m=1
XMpar17 a_16785_6526.t4 inp.t0 a_19274_16496.t0 vss.t41 nfet_03v3 w=0.72u l=2.88u ad=4.3200e-13 pd=2.6400e-06 as=2.0160e-13 ps=1.2800e-06 nf=1 m=1
XMpar18 ib.t1 ib.t0 vss.t2 vss.t1 nfet_03v3 w=0.4u l=4u ad=2.4000e-13 pd=2.0000e-06 as=1.1200e-13 ps=9.6000e-07 nf=1 m=1
XMpar19 a_14961_6526.t0 a_20494_18042.t5 a_20494_4582.t0 vss.t0 nfet_03v3 w=2.17u l=2.88u ad=1.3020e-12 pd=5.5400e-06 as=1.3020e-12 ps=5.5400e-06 nf=1 m=1
XMpar20 a_16785_6526.t4 inn.t0 a_20494_18042.t0 vss.t0 nfet_03v3 w=0.72u l=2.88u ad=4.3200e-13 pd=2.6400e-06 as=2.0160e-13 ps=1.2800e-06 nf=1 m=1
XMpar21 a_4105_4374.t2 a_4105_4374.t1 vdd.t3 vdd.t2 pfet_03v3 w=0.4u l=4u ad=2.4000e-13 pd=2.0000e-06 as=2.4000e-13 ps=2.0000e-06 nf=1 m=1
XMpar22 a_5205_6526.t8 a_20494_4582.t8 out.t0 vss.t0 nfet_03v3 w=2.89u l=2.88u ad=1.7340e-12 pd=6.9800e-06 as=1.7340e-12 ps=6.9800e-06 nf=1 m=1
XMpar23 a_4105_4374.t0 ib.t0 vss.t2 vss.t1 nfet_03v3 w=0.4u l=4u ad=2.4000e-13 pd=2.0000e-06 as=1.1200e-13 ps=9.6000e-07 nf=1 m=1
XMpar24 a_4211_1086.t0 ib.t0 vss.t2 vss.t1 nfet_03v3 w=0.4u l=4u ad=2.4000e-13 pd=2.0000e-06 as=2.4000e-13 ps=2.0000e-06 nf=1 m=1
X29 out.t5 vss.t43 cap_mim_2f0fF c_width=20u c_length=20u
X56 out.t5 vss.t43 cap_mim_2f0fF c_width=20u c_length=20u
X57 out.t5 vss.t43 cap_mim_2f0fF c_width=20u c_length=20u
Rpar0 a_14961_6526.t0 a_14961_6526.t1 51.8405
Rpar1 a_16785_6526.t0 a_16785_6526.t4 66.3154
Rpar2 a_19108_10315.t0 a_19108_10315.t1 164.1052
Rpar3 a_19108_10315.t0 a_19108_10315.t2 98.2281
Rpar4 a_19108_10315.t1 a_19108_10315.t2 19.4247
Rpar5 a_19274_16496.t0 a_19274_16496.t2 463.3628
Rpar6 a_19274_16496.t0 a_19274_16496.t4 579.2724
Rpar7 a_19274_16496.t0 a_19274_16496.t5 58.2963
Rpar8 a_19274_16496.t2 a_19274_16496.t4 60.6399
Rpar9 a_19274_16496.t2 a_19274_16496.t5 249.5577
Rpar10 a_19274_16496.t4 a_19274_16496.t5 311.9842
Rpar11 a_20494_18042.t0 a_20494_18042.t2 463.3775
Rpar12 a_20494_18042.t0 a_20494_18042.t4 579.2908
Rpar13 a_20494_18042.t0 a_20494_18042.t5 58.2949
Rpar14 a_20494_18042.t2 a_20494_18042.t4 60.6399
Rpar15 a_20494_18042.t2 a_20494_18042.t5 249.5516
Rpar16 a_20494_18042.t4 a_20494_18042.t5 311.9766
Rpar17 a_20494_4582.t0 a_20494_4582.t1 207.9259
Rpar18 a_20494_4582.t0 a_20494_4582.t2 97.9627
Rpar19 a_20494_4582.t0 a_20494_4582.t7 525.2630
Rpar20 a_20494_4582.t0 a_20494_4582.t8 321.2752
Rpar21 a_20494_4582.t1 a_20494_4582.t2 23.5350
Rpar22 a_20494_4582.t1 a_20494_4582.t7 1081.8802
Rpar23 a_20494_4582.t1 a_20494_4582.t8 661.7281
Rpar24 a_20494_4582.t2 a_20494_4582.t7 509.7198
Rpar25 a_20494_4582.t2 a_20494_4582.t8 311.7683
Rpar26 a_20494_4582.t7 a_20494_4582.t8 80.3100
Rpar27 a_4091_1294.t0 a_4091_1294.t6 298.8725
Rpar28 a_4091_1294.t0 a_4091_1294.t7 135.6072
Rpar29 a_4091_1294.t6 a_4091_1294.t7 46.9929
Rpar30 a_4105_4374.t0 a_4105_4374.t1 78.7630
Rpar31 a_4105_4374.t0 a_4105_4374.t2 183.8366
Rpar32 a_4105_4374.t1 a_4105_4374.t2 33.0990
Rpar33 a_4211_1086.t0 a_4211_1086.t1 1203.5398
Rpar34 a_4211_1086.t0 a_4211_1086.t2 105.2871
Rpar35 a_4211_1086.t0 a_4211_1086.t13 151.8484
Rpar36 a_4211_1086.t1 a_4211_1086.t2 22.0809
Rpar37 a_4211_1086.t1 a_4211_1086.t13 2155.2267
Rpar38 a_4211_1086.t2 a_4211_1086.t13 188.5419
Rpar39 a_5205_6526.t0 a_5205_6526.t8 58.1547
Rpar40 a_8144_1086.t0 a_8144_1086.t1 207.9257
Rpar41 a_8144_1086.t0 a_8144_1086.t2 97.9626
Rpar42 a_8144_1086.t0 a_8144_1086.t7 525.2523
Rpar43 a_8144_1086.t0 a_8144_1086.t8 321.2817
Rpar44 a_8144_1086.t1 a_8144_1086.t2 23.5350
Rpar45 a_8144_1086.t1 a_8144_1086.t7 1081.8581
Rpar46 a_8144_1086.t1 a_8144_1086.t8 661.7415
Rpar47 a_8144_1086.t2 a_8144_1086.t7 509.7095
Rpar48 a_8144_1086.t2 a_8144_1086.t8 311.7746
Rpar49 a_8144_1086.t7 a_8144_1086.t8 80.3116
Rpar50 ib ib.t0 2.3733
Rpar51 ib ib.t1 1676.0048
Rpar52 ib.t0 ib.t1 25.1533
Rpar53 inn inn.t0 3.7107
Rpar54 inp inp.t0 3.7593
Rpar55 out out.t0 59.1881
Rpar56 out out.t1 7.2541
Rpar57 out out.t5 104.1997
Rpar58 out.t0 out.t1 236.1710
Rpar59 out.t0 out.t5 196.9604
Rpar60 out.t1 out.t5 415.7754
Rpar61 vdd vdd.t0 582.4230
Rpar62 vdd vdd.t1 918.2664
Rpar63 vdd vdd.t6 2482.2417
Rpar64 vdd vdd.t2 554.8748
Rpar65 vdd vdd.t3 289.1210
Rpar66 vdd vdd.t40 65.9078
Rpar67 vdd.t0 vdd.t1 3.2502
Rpar68 vdd.t0 vdd.t6 143.1780
Rpar69 vdd.t0 vdd.t2 289.8246
Rpar70 vdd.t0 vdd.t3 141.8808
Rpar71 vdd.t0 vdd.t40 172.5167
Rpar72 vdd.t1 vdd.t6 139.1760
Rpar73 vdd.t1 vdd.t2 372.1112
Rpar74 vdd.t1 vdd.t3 179.4510
Rpar75 vdd.t1 vdd.t40 271.9952
Rpar76 vdd.t6 vdd.t2 462.0585
Rpar77 vdd.t6 vdd.t3 215.2282
Rpar78 vdd.t6 vdd.t40 735.2527
Rpar79 vdd.t2 vdd.t3 10.3446
Rpar80 vdd.t2 vdd.t40 164.3568
Rpar81 vdd.t3 vdd.t40 85.6391
Rpar82 vss vss.t0 223.4086
Rpar83 vss vss.t1 48.3240
Rpar84 vss vss.t2 195.6514
Rpar85 vss vss.t41 195.4092
Rpar86 vss vss.t43 1102.2556
Rpar87 vss.t0 vss.t1 4.4649
Rpar88 vss.t0 vss.t2 50.6091
Rpar89 vss.t0 vss.t41 19.1223
Rpar90 vss.t0 vss.t43 200.0171
Rpar91 vss.t1 vss.t2 3.3499
Rpar92 vss.t1 vss.t41 3.8297
Rpar93 vss.t1 vss.t43 94.8131
Rpar94 vss.t2 vss.t41 30.8335
Rpar95 vss.t2 vss.t43 694.2354
Rpar96 vss.t41 vss.t43 247.3504
Cpar0 a_14961_6526.t0 vss 3.36925e-15
Cpar1 a_14961_6526.t1 vss 5.18404e-15
Cpar2 a_16785_6526.t0 vss 5.48475e-15
Cpar3 a_16785_6526.t4 vss 4.27016e-15
Cpar4 a_19108_10315.t0 vss 3.23052e-15
Cpar5 a_19108_10315.t1 vss 8.46073e-15
Cpar6 a_19108_10315.t2 vss 3.27995e-15
Cpar7 a_19274_16496.t0 vss 3.75984e-15
Cpar8 a_19274_16496.t2 vss 6.30150e-15
Cpar9 a_19274_16496.t4 vss 6.46734e-15
Cpar10 a_19274_16496.t5 vss 7.10574e-15
Cpar11 a_20494_18042.t0 vss 3.49712e-15
Cpar12 a_20494_18042.t2 vss 5.86134e-15
Cpar13 a_20494_18042.t4 vss 6.01560e-15
Cpar14 a_20494_18042.t5 vss 6.60957e-15
Cpar15 a_20494_4582.t0 vss 5.39396e-15
Cpar16 a_20494_4582.t1 vss 3.60705e-15
Cpar17 a_20494_4582.t2 vss 5.16083e-15
Cpar18 a_20494_4582.t7 vss 5.78868e-15
Cpar19 a_20494_4582.t8 vss 7.02940e-15
Cpar20 a_4091_1294.t0 vss 1.12226e-14
Cpar21 a_4091_1294.t6 vss 1.72303e-15
Cpar22 a_4091_1294.t7 vss 3.18174e-15
Cpar23 a_4105_4374.t0 vss 5.49196e-15
Cpar24 a_4105_4374.t1 vss 1.89621e-14
Cpar25 a_4105_4374.t2 vss 2.76992e-15
Cpar26 a_4211_1086.t0 vss 3.96524e-15
Cpar27 a_4211_1086.t1 vss 7.52470e-15
Cpar28 a_4211_1086.t13 vss 4.45668e-15
Cpar29 a_4211_1086.t2 vss 1.01531e-14
Cpar30 a_5205_6526.t0 vss 2.86167e-15
Cpar31 a_5205_6526.t8 vss 1.63596e-15
Cpar32 a_8144_1086.t0 vss 6.47330e-15
Cpar33 a_8144_1086.t1 vss 4.32883e-15
Cpar34 a_8144_1086.t2 vss 6.19355e-15
Cpar35 a_8144_1086.t7 vss 6.94707e-15
Cpar36 a_8144_1086.t8 vss 8.43584e-15
Cpar37 ib vdd 2.33030e-16
Cpar38 ib vss 5.71844e-14
Cpar39 ib.t0 vss 6.97105e-15
Cpar40 ib.t1 vss 2.88752e-16
Cpar41 inn inp 5.16800e-17
Cpar42 inn vss 3.48933e-15
Cpar43 inn.t0 vss 3.79326e-16
Cpar44 inp vss 3.48437e-15
Cpar45 inp.t0 vss 3.82986e-16
Cpar46 out vdd 2.78208e-15
Cpar47 out vss 2.94124e-14
Cpar48 out.t0 vss 5.53325e-17
Cpar49 out.t1 vss 1.66251e-17
Cpar50 out.t5 vss 8.99429e-15
Cpar51 vdd vss 1.64602e-13
Cpar52 vdd.t0 vss 1.37827e-14
Cpar53 vdd.t1 vss 9.77580e-15
Cpar54 vdd.t2 vss 7.36433e-15
Cpar55 vdd.t3 vss 6.40931e-15
Cpar56 vdd.t40 vss 6.00889e-15
Cpar57 vdd.t6 vss 1.14361e-14
.ends opamp_dut

Vdd vdd 0 1.800000
Vss vss 0 0
Ibias vdd ib 1.300000e-08
Vinp inp 0 DC 1.187100 AC 1 PWL(0 1.187100 3.497092e-07 1.187100 3.846802e-07 1.197100)
Rfb out inn 1m
Cload out 0 2.000000e-13
Xdut vdd vss inp inn out ib opamp_dut
.end
