* opa1000[0126]: 2p/current_reuse_1v8_i50n_weak (current_reuse, VDD=1.8V, CL=2.0pF, Iref=0.0082uA)
.include "pdk_opa.inc"
.temp 27
.option gmin=1e-12 rshunt=1e12 reltol=1e-3 abstol=1e-12 vntol=1e-5 method=gear
* Post-PEX R+C extracted netlist for current_reuse_1v8_i50n_weak
.subckt opamp_dut vdd vss inp inn out ib
XMpar0 a_3443_11769.t2 ib.t0 vss.t6 vss.t5 nfet_03v3 w=0.4u l=4u ad=2.4000e-13 pd=2.0000e-06 as=1.1200e-13 ps=9.6000e-07 nf=1 m=4 par=4
XMpar1 out.t1 a_8204_15108.t6 vdd.t1 vdd.t0 pfet_03v3 w=0.4u l=4u ad=1.3760e-13 pd=1.1680e-06 as=1.6320e-13 ps=1.3760e-06 nf=1 m=10 par=10
XMpar2 a_8204_15108.t4 a_9764_9900.t4 vdd.t1 vdd.t0 pfet_03v3 w=0.4u l=4u ad=2.4000e-13 pd=2.0000e-06 as=1.1200e-13 ps=9.6000e-07 nf=1 m=1
XMpar3 out.t0 ib.t0 vss.t6 vss.t5 nfet_03v3 w=0.4u l=4u ad=1.8880e-13 pd=1.5840e-06 as=1.6320e-13 ps=1.3760e-06 nf=1 m=10 par=10
XMpar4 a_6134_15108.t0 a_9764_9900.t4 vdd.t1 vdd.t0 pfet_03v3 w=0.4u l=4u ad=1.1200e-13 pd=9.6000e-07 as=2.4000e-13 ps=2.0000e-06 nf=1 m=2 par=2
XMpar5 a_3443_11769.t0 inp.t2 a_8204_15108.t0 vss.t1 nfet_03v3 w=0.4u l=9.75u ad=2.4000e-13 pd=2.0000e-06 as=2.4000e-13 ps=2.0000e-06 nf=1 m=2 par=2
XMpar6 a_6134_15108.t1 inn.t0 a_9764_9900.t0 vdd.t7 pfet_03v3 w=0.4u l=9.75u ad=2.4000e-13 pd=2.0000e-06 as=1.1200e-13 ps=9.6000e-07 nf=1 m=2 par=2
XMpar7 a_3443_11769.t0 inn.t2 a_9764_9900.t2 vss.t1 nfet_03v3 w=0.4u l=9.75u ad=2.4000e-13 pd=2.0000e-06 as=2.4000e-13 ps=2.0000e-06 nf=1 m=2 par=2
XMpar8 ib.t1 ib.t0 vss.t6 vss.t5 nfet_03v3 w=0.4u l=4u ad=2.4000e-13 pd=2.0000e-06 as=1.1200e-13 ps=9.6000e-07 nf=1 m=2 par=2
XMpar9 a_9764_9900.t5 a_9764_9900.t4 vdd.t1 vdd.t0 pfet_03v3 w=0.4u l=4u ad=2.4000e-13 pd=2.0000e-06 as=1.1200e-13 ps=9.6000e-07 nf=1 m=1
XMpar10 a_6134_15108.t1 inp.t0 a_8204_15108.t2 vdd.t7 pfet_03v3 w=0.4u l=9.75u ad=2.4000e-13 pd=2.0000e-06 as=1.1200e-13 ps=9.6000e-07 nf=1 m=2 par=2
X3 a_8204_15108.t5 a_13653_1290.t0 vss.t0 ppolyf_u_1k r_width=1u r_length=19.23u
X4 a_13653_7530.t1 out.t4 cap_mim_2f0fF c_width=17.1u c_length=17.11u
X5 a_9675_3890.t0 a_13653_3370.t0 vss.t0 ppolyf_u_1k r_width=1u r_length=19.23u
X11 a_9675_5970.t0 a_13653_6490.t0 vss.t0 ppolyf_u_1k r_width=1u r_length=19.23u
X13 a_9675_2850.t0 a_13653_3370.t0 vss.t0 ppolyf_u_1k r_width=1u r_length=19.23u
X15 a_13653_7530.t1 out.t4 cap_mim_2f0fF c_width=17.1u c_length=17.11u
X17 a_9675_5970.t0 a_13653_5450.t0 vss.t0 ppolyf_u_1k r_width=1u r_length=19.23u
X19 a_9675_2850.t0 a_13653_2330.t0 vss.t0 ppolyf_u_1k r_width=1u r_length=19.23u
X28 a_9675_4930.t0 a_13653_5450.t0 vss.t0 ppolyf_u_1k r_width=1u r_length=19.23u
X30 a_9675_1810.t0 a_13653_2330.t0 vss.t0 ppolyf_u_1k r_width=1u r_length=19.23u
X33 a_9675_4930.t0 a_13653_4410.t0 vss.t0 ppolyf_u_1k r_width=1u r_length=19.23u
X37 a_9675_1810.t0 a_13653_1290.t0 vss.t0 ppolyf_u_1k r_width=1u r_length=19.23u
X41 a_9675_7010.t0 a_13653_7530.t0 vss.t0 ppolyf_u_1k r_width=1u r_length=19.23u
X43 a_9675_3890.t0 a_13653_4410.t0 vss.t0 ppolyf_u_1k r_width=1u r_length=19.23u
X46 a_13653_7530.t1 out.t4 cap_mim_2f0fF c_width=17.1u c_length=17.11u
X49 a_9675_7010.t0 a_13653_6490.t0 vss.t0 ppolyf_u_1k r_width=1u r_length=19.23u
Rpar0 a_13653_7530.t0 a_13653_7530.t1 61.2252
Rpar1 a_3443_11769.t0 a_3443_11769.t2 60.3871
Rpar2 a_6134_15108.t0 a_6134_15108.t1 71.0089
Rpar3 a_8204_15108.t0 a_8204_15108.t6 265.5544
Rpar4 a_8204_15108.t0 a_8204_15108.t2 83.2171
Rpar5 a_8204_15108.t0 a_8204_15108.t4 1709.3255
Rpar6 a_8204_15108.t0 a_8204_15108.t5 1420.7591
Rpar7 a_8204_15108.t6 a_8204_15108.t2 153.2894
Rpar8 a_8204_15108.t6 a_8204_15108.t4 178.6338
Rpar9 a_8204_15108.t6 a_8204_15108.t5 148.4770
Rpar10 a_8204_15108.t2 a_8204_15108.t4 986.6963
Rpar11 a_8204_15108.t2 a_8204_15108.t5 820.1234
Rpar12 a_8204_15108.t4 a_8204_15108.t5 122.9016
Rpar13 a_9764_9900.t0 a_9764_9900.t2 84.1977
Rpar14 a_9764_9900.t0 a_9764_9900.t4 157.0859
Rpar15 a_9764_9900.t0 a_9764_9900.t5 389.3500
Rpar16 a_9764_9900.t2 a_9764_9900.t4 274.8361
Rpar17 a_9764_9900.t2 a_9764_9900.t5 681.2033
Rpar18 a_9764_9900.t4 a_9764_9900.t5 27.3922
Rpar19 ib ib.t0 15.0825
Rpar20 ib ib.t1 14.9091
Rpar21 ib.t0 ib.t1 34.1143
Rpar22 inn inn.t0 54.8006
Rpar23 inn inn.t2 4.0784
Rpar24 inp inp.t0 53.6000
Rpar25 inp inp.t2 4.0781
Rpar26 out out.t0 229.3527
Rpar27 out out.t1 4.9503
Rpar28 out out.t4 589.0340
Rpar29 out.t0 out.t1 133.1017
Rpar30 out.t0 out.t4 213.5516
Rpar31 out.t1 out.t4 341.8379
Rpar32 vdd vdd.t0 456.3234
Rpar33 vdd vdd.t1 245.1640
Rpar34 vdd vdd.t7 50.8707
Rpar35 vdd.t0 vdd.t1 6.4466
Rpar36 vdd.t0 vdd.t7 203.4228
Rpar37 vdd.t1 vdd.t7 109.2908
Rpar38 vss vss.t0 36.3130
Rpar39 vss vss.t1 443.5136
Rpar40 vss vss.t6 231.9210
Rpar41 vss vss.t5 2857.3663
Rpar42 vss.t0 vss.t1 593.9003
Rpar43 vss.t0 vss.t6 280.4941
Rpar44 vss.t0 vss.t5 269.9916
Rpar45 vss.t1 vss.t6 115.6259
Rpar46 vss.t1 vss.t5 1103.4172
Rpar47 vss.t6 vss.t5 12.5855
Cpar0 a_13653_1290.t0 vss 2.64400e-17
Cpar1 a_13653_2330.t0 vss 3.00800e-17
Cpar2 a_13653_3370.t0 vss 2.93600e-17
Cpar3 a_13653_4410.t0 vss 2.93600e-17
Cpar4 a_13653_5450.t0 vss 2.93600e-17
Cpar5 a_13653_6490.t0 vss 3.20200e-17
Cpar6 a_13653_7530.t0 vss 8.76700e-17
Cpar7 a_13653_7530.t1 vss 7.98574e-15
Cpar8 a_3443_11769.t0 vss 1.05452e-14
Cpar9 a_3443_11769.t2 vss 1.46997e-14
Cpar10 a_6134_15108.t0 vss 4.32554e-15
Cpar11 a_6134_15108.t1 vss 9.24453e-15
Cpar12 a_8204_15108.t0 vss 6.16745e-15
Cpar13 a_8204_15108.t2 vss 5.75677e-15
Cpar14 a_8204_15108.t4 vss 4.62650e-15
Cpar15 a_8204_15108.t5 vss 6.38024e-15
Cpar16 a_8204_15108.t6 vss 2.64472e-14
Cpar17 a_9675_1810.t0 vss 4.36600e-17
Cpar18 a_9675_2850.t0 vss 4.10000e-17
Cpar19 a_9675_3890.t0 vss 4.10000e-17
Cpar20 a_9675_4930.t0 vss 3.83000e-17
Cpar21 a_9675_5970.t0 vss 3.83600e-17
Cpar22 a_9675_7010.t0 vss 3.87800e-17
Cpar23 a_9764_9900.t0 vss 5.86770e-15
Cpar24 a_9764_9900.t2 vss 6.82404e-15
Cpar25 a_9764_9900.t4 vss 1.35804e-14
Cpar26 a_9764_9900.t5 vss 2.74782e-15
Cpar27 ib inp 3.06400e-17
Cpar28 ib out 2.19286e-15
Cpar29 ib vdd 8.09600e-17
Cpar30 ib vss 4.82445e-14
Cpar31 ib.t0 vss 8.12842e-15
Cpar32 ib.t1 vss 6.51205e-16
Cpar33 inn inp 1.53980e-16
Cpar34 inn vdd 9.83004e-15
Cpar35 inn vss 1.48241e-14
Cpar36 inn.t0 vss 6.79945e-15
Cpar37 inn.t2 vss 3.52979e-15
Cpar38 inp vdd 8.88773e-15
Cpar39 inp vss 1.42940e-14
Cpar40 inp.t0 vss 6.65828e-15
Cpar41 inp.t2 vss 3.71809e-15
Cpar42 out vdd 1.66877e-14
Cpar43 out vss 3.01293e-14
Cpar44 out.t0 vss 9.11991e-15
Cpar45 out.t1 vss 4.50999e-15
Cpar46 out.t4 vss 2.73932e-14
Cpar47 vdd vss 1.41531e-13
Cpar48 vdd.t0 vss 3.76689e-14
Cpar49 vdd.t1 vss 1.47946e-14
Cpar50 vdd.t7 vss 2.12955e-14
.ends opamp_dut

Vdd vdd 0 1.800000
Vss vss 0 0
Ibias vdd ib 8.200000e-09
Vinp inp 0 DC 0.895000 AC 1 PWL(0 0.895000 4.743060e-06 0.895000 5.217365e-06 0.905000)
Rfb out inn 1m
Cload out 0 2.000000e-12
Xdut vdd vss inp inn out ib opamp_dut
.end
