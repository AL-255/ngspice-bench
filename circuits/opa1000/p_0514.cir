* opa1000[0514]: 200f/pmos_5t_1v8_i10u_weak (pmos_5t, VDD=1.8V, CL=0.2pF, Iref=2.6uA)
.include "pdk_opa.inc"
.temp 27
.option gmin=1e-12 rshunt=1e12 reltol=1e-3 abstol=1e-12 vntol=1e-5 method=gear
* Post-PEX R+C extracted netlist for pmos_5t_1v8_i10u_weak
.subckt opamp_dut vdd vss inp inn out ib
XMpar0 a_1514_5956.t3 inp.t0 a_2148_3838.t0 vdd.t6 pfet_03v3 w=2.01u l=0.78u ad=6.5469e-13 pd=2.9486e-06 as=6.5469e-13 ps=2.9486e-06 nf=1 m=14 par=14
XMpar1 a_1214_5747.t4 ib.t0 vss.t9 vss.t8 nfet_03v3 w=1.68u l=1.5u ad=4.7040e-13 pd=2.2400e-06 as=4.7040e-13 ps=2.2400e-06 nf=1 m=2 par=2
XMpar2 a_1514_5956.t0 a_1214_5747.t0 vdd.t1 vdd.t0 pfet_03v3 w=7.39u l=1.5u ad=2.0692e-12 pd=7.9500e-06 as=2.6604e-12 ps=9.9575e-06 nf=1 m=8 par=8
XMpar3 a_1514_5956.t3 inn.t0 out.t2 vdd.t6 pfet_03v3 w=2.01u l=0.78u ad=6.5469e-13 pd=2.9486e-06 as=6.5469e-13 ps=2.9486e-06 nf=1 m=14 par=14
XMpar4 a_2148_3838.t15 a_2148_3838.t14 vss.t1 vss.t0 nfet_03v3 w=2.09u l=2.7u ad=5.8520e-13 pd=2.6500e-06 as=9.1960e-13 ps=4.0150e-06 nf=1 m=4 par=4
XMpar5 ib.t1 ib.t0 vss.t9 vss.t8 nfet_03v3 w=1.68u l=1.5u ad=1.0080e-12 pd=4.5600e-06 as=4.7040e-13 ps=2.2400e-06 nf=1 m=2 par=2
XMpar6 out.t0 a_2148_3838.t14 vss.t1 vss.t0 nfet_03v3 w=2.09u l=2.7u ad=5.8520e-13 pd=2.6500e-06 as=5.8520e-13 ps=2.6500e-06 nf=1 m=4 par=4
XMpar7 a_1214_5747.t1 a_1214_5747.t0 vdd.t1 vdd.t0 pfet_03v3 w=7.39u l=1.5u ad=2.0692e-12 pd=7.9500e-06 as=2.0692e-12 ps=7.9500e-06 nf=1 m=2 par=2
Rpar0 a_1214_5747.t0 a_1214_5747.t1 23.9376
Rpar1 a_1214_5747.t0 a_1214_5747.t4 207.2902
Rpar2 a_1214_5747.t1 a_1214_5747.t4 77.3353
Rpar3 a_1514_5956.t0 a_1514_5956.t3 47.1149
Rpar4 a_2148_3838.t0 a_2148_3838.t14 82.2492
Rpar5 a_2148_3838.t0 a_2148_3838.t15 39.1544
Rpar6 a_2148_3838.t14 a_2148_3838.t15 19.2969
Rpar7 ib ib.t0 16.9386
Rpar8 ib ib.t1 5.1363
Rpar9 ib.t0 ib.t1 104.6899
Rpar10 inn inn.t0 3.4931
Rpar11 inp inp.t0 3.4931
Rpar12 out out.t0 6.1358
Rpar13 out out.t2 76.3728
Rpar14 out.t0 out.t2 114.7517
Rpar15 vdd vdd.t0 85.7130
Rpar16 vdd vdd.t1 274.4885
Rpar17 vdd vdd.t6 111.3715
Rpar18 vdd.t0 vdd.t1 5.3618
Rpar19 vdd.t0 vdd.t6 84.3508
Rpar20 vdd.t1 vdd.t6 270.1263
Rpar21 vss vss.t0 104.8406
Rpar22 vss vss.t1 205.6524
Rpar23 vss vss.t8 87.3952
Rpar24 vss vss.t9 220.1058
Rpar25 vss.t0 vss.t1 9.8684
Rpar26 vss.t0 vss.t8 5.2093
Rpar27 vss.t0 vss.t9 23.4996
Rpar28 vss.t1 vss.t8 11.5430
Rpar29 vss.t1 vss.t9 61.3011
Rpar30 vss.t8 vss.t9 14.2214
Cpar0 a_1214_5747.t0 vss 1.78336e-14
Cpar1 a_1214_5747.t1 vss 3.96843e-15
Cpar2 a_1214_5747.t4 vss 1.72626e-15
Cpar3 a_1514_5956.t0 vss 1.40746e-14
Cpar4 a_1514_5956.t3 vss 1.86012e-14
Cpar5 a_2148_3838.t0 vss 5.37873e-15
Cpar6 a_2148_3838.t14 vss 9.59620e-15
Cpar7 a_2148_3838.t15 vss 2.41209e-15
Cpar8 ib out 1.75700e-17
Cpar9 ib vdd 1.16230e-16
Cpar10 ib vss 7.22479e-15
Cpar11 ib.t0 vss 8.84275e-16
Cpar12 ib.t1 vss 1.16830e-16
Cpar13 inn inp 1.03020e-16
Cpar14 inn out 2.29127e-15
Cpar15 inn vdd 7.73225e-15
Cpar16 inn vss 4.10222e-15
Cpar17 inn.t0 vss 8.21888e-15
Cpar18 inp vdd 7.77481e-15
Cpar19 inp vss 4.08636e-15
Cpar20 inp.t0 vss 8.24987e-15
Cpar21 out vdd 3.19767e-15
Cpar22 out vss 9.10349e-15
Cpar23 out.t0 vss 2.61480e-15
Cpar24 out.t2 vss 1.04481e-14
Cpar25 vdd vss 1.06039e-13
Cpar26 vdd.t0 vss 1.62096e-14
Cpar27 vdd.t1 vss 6.97421e-15
Cpar28 vdd.t6 vss 2.25922e-14
.ends opamp_dut

Vdd vdd 0 1.800000
Vss vss 0 0
Ibias vdd ib 2.600000e-06
Vinp inp 0 DC 0.805000 AC 1 PWL(0 0.805000 3.000000e-09 0.805000 3.300000e-09 0.815000)
Rfb out inn 1m
Cload out 0 2.000000e-13
Xdut vdd vss inp inn out ib opamp_dut
.end
