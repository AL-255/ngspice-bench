* opa1000[0618]: 200f/pmos_miller_3v3_i10u_weak (pmos_miller, VDD=3.3V, CL=0.2pF, Iref=1.25uA)
.include "pdk_opa.inc"
.temp 27
.option gmin=1e-12 rshunt=1e12 reltol=1e-3 abstol=1e-12 vntol=1e-5 method=gear
* Post-PEX R+C extracted netlist for pmos_miller_3v3_i10u_weak
.subckt opamp_dut vdd vss inp inn out ib
XMpar0 a_2709_2955.t0 inn.t0 a_5360_6573.t0 vdd.t4 pfet_03v3 w=1.95u l=1.95u ad=6.7080e-13 pd=3.0280e-06 as=6.7080e-13 ps=3.0280e-06 nf=1 m=10 par=10
XMpar1 out.t0 a_1413_2746.t2 vdd.t1 vdd.t0 pfet_03v3 w=2.73u l=1.2u ad=9.3912e-13 pd=3.9640e-06 as=7.6440e-13 ps=3.2900e-06 nf=1 m=10 par=10
XMpar2 a_1546_5033.t3 inp.t0 a_2709_2955.t0 vdd.t4 pfet_03v3 w=1.95u l=1.95u ad=6.7080e-13 pd=3.0280e-06 as=6.7080e-13 ps=3.0280e-06 nf=1 m=10 par=10
XMpar3 a_5360_6573.t11 a_5360_6573.t10 vss.t2 vss.t1 nfet_03v3 w=0.85u l=1.13u ad=2.3800e-13 pd=1.4100e-06 as=2.3800e-13 ps=1.4100e-06 nf=1 m=2 par=2
XMpar4 out.t2 a_1546_5033.t13 vss.t2 vss.t1 nfet_03v3 w=0.85u l=1.13u ad=2.9240e-13 pd=1.7080e-06 as=2.9240e-13 ps=1.7080e-06 nf=1 m=10 par=10
XMpar5 ib.t1 ib.t0 vss.t23 vss.t22 nfet_03v3 w=0.62u l=1.2u ad=3.7200e-13 pd=2.4400e-06 as=1.7360e-13 ps=1.1800e-06 nf=1 m=2 par=2
XMpar6 a_1413_2746.t0 ib.t0 vss.t23 vss.t22 nfet_03v3 w=0.62u l=1.2u ad=1.7360e-13 pd=1.1800e-06 as=1.7360e-13 ps=1.1800e-06 nf=1 m=2 par=2
XMpar7 a_1546_5033.t1 a_5360_6573.t10 vss.t2 vss.t1 nfet_03v3 w=0.85u l=1.13u ad=5.1000e-13 pd=2.9000e-06 as=2.3800e-13 ps=1.4100e-06 nf=1 m=2 par=2
XMpar8 a_2709_2955.t20 a_1413_2746.t2 vdd.t1 vdd.t0 pfet_03v3 w=2.73u l=1.2u ad=7.6440e-13 pd=3.2900e-06 as=7.6440e-13 ps=3.2900e-06 nf=1 m=4 par=4
XMpar9 a_1413_2746.t3 a_1413_2746.t2 vdd.t1 vdd.t0 pfet_03v3 w=2.73u l=1.2u ad=7.6440e-13 pd=3.2900e-06 as=7.6440e-13 ps=3.2900e-06 nf=1 m=2 par=2
X21 a_1546_5033.t0 a_7283_5282.t0 vss.t0 ppolyf_u_1k r_width=1u r_length=11.43u
X30 a_7283_5282.t1 out.t5 cap_mim_2f0fF c_width=11.46u c_length=11.46u
Rpar0 a_1413_2746.t0 a_1413_2746.t2 86.9660
Rpar1 a_1413_2746.t0 a_1413_2746.t3 73.5843
Rpar2 a_1413_2746.t2 a_1413_2746.t3 24.8767
Rpar3 a_1546_5033.t0 a_1546_5033.t1 113.1011
Rpar4 a_1546_5033.t0 a_1546_5033.t3 284.5180
Rpar5 a_1546_5033.t0 a_1546_5033.t13 86.3850
Rpar6 a_1546_5033.t1 a_1546_5033.t3 211.7688
Rpar7 a_1546_5033.t1 a_1546_5033.t13 77.1026
Rpar8 a_1546_5033.t3 a_1546_5033.t13 193.9598
Rpar9 a_2709_2955.t0 a_2709_2955.t20 94.9905
Rpar10 a_5360_6573.t0 a_5360_6573.t10 113.6265
Rpar11 a_5360_6573.t0 a_5360_6573.t11 99.0962
Rpar12 a_5360_6573.t10 a_5360_6573.t11 30.3813
Rpar13 a_7283_5282.t0 a_7283_5282.t1 46.7464
Rpar14 ib ib.t0 15.6914
Rpar15 ib ib.t1 7.6028
Rpar16 ib.t0 ib.t1 173.4317
Rpar17 inn inn.t0 2.3351
Rpar18 inp inp.t0 2.3351
Rpar19 out out.t0 2.1619
Rpar20 out out.t2 396.6802
Rpar21 out out.t5 241.2961
Rpar22 out.t0 out.t2 130.5302
Rpar23 out.t0 out.t5 79.4000
Rpar24 out.t2 out.t5 296.5678
Rpar25 vdd vdd.t0 224.9510
Rpar26 vdd vdd.t1 927.6625
Rpar27 vdd vdd.t4 23.8272
Rpar28 vdd.t0 vdd.t1 4.4578
Rpar29 vdd.t0 vdd.t4 112.2035
Rpar30 vdd.t1 vdd.t4 462.7095
Rpar31 vss vss.t0 237.4567
Rpar32 vss vss.t1 194.3177
Rpar33 vss vss.t2 246.4158
Rpar34 vss vss.t22 87.2076
Rpar35 vss vss.t23 122.3257
Rpar36 vss.t0 vss.t1 4.3411
Rpar37 vss.t0 vss.t2 27.3960
Rpar38 vss.t0 vss.t22 668.5532
Rpar39 vss.t0 vss.t23 937.8068
Rpar40 vss.t1 vss.t2 6.9361
Rpar41 vss.t1 vss.t22 534.6891
Rpar42 vss.t1 vss.t23 750.0617
Rpar43 vss.t2 vss.t22 697.2850
Rpar44 vss.t2 vss.t23 978.0981
Rpar45 vss.t22 vss.t23 14.7523
Cpar0 a_1413_2746.t0 vss 1.98101e-15
Cpar1 a_1413_2746.t2 vss 1.98961e-14
Cpar2 a_1413_2746.t3 vss 3.94464e-15
Cpar3 a_1546_5033.t0 vss 2.08522e-15
Cpar4 a_1546_5033.t1 vss 2.22033e-15
Cpar5 a_1546_5033.t13 vss 7.38177e-15
Cpar6 a_1546_5033.t3 vss 7.86068e-15
Cpar7 a_2709_2955.t0 vss 2.09404e-14
Cpar8 a_2709_2955.t20 vss 9.68129e-15
Cpar9 a_5360_6573.t0 vss 8.38099e-15
Cpar10 a_5360_6573.t10 vss 3.35645e-15
Cpar11 a_5360_6573.t11 vss 1.46153e-15
Cpar12 a_7283_5282.t0 vss 1.01100e-16
Cpar13 a_7283_5282.t1 vss 2.09230e-15
Cpar14 ib out 4.63800e-17
Cpar15 ib vss 6.06187e-15
Cpar16 ib.t0 vss 6.47952e-16
Cpar17 ib.t1 vss 7.76664e-17
Cpar18 inn inp 1.03130e-16
Cpar19 inn vdd 9.89982e-15
Cpar20 inn vss 3.61567e-15
Cpar21 inn.t0 vss 1.16224e-14
Cpar22 inp vdd 9.97998e-15
Cpar23 inp vss 3.63492e-15
Cpar24 inp.t0 vss 1.16696e-14
Cpar25 out vdd 9.55314e-15
Cpar26 out vss 2.02116e-14
Cpar27 out.t0 vss 5.44787e-15
Cpar28 out.t2 vss 4.85882e-15
Cpar29 out.t5 vss 6.47535e-15
Cpar30 vdd vss 1.18239e-13
Cpar31 vdd.t0 vss 1.92672e-14
Cpar32 vdd.t1 vss 6.58077e-15
Cpar33 vdd.t4 vss 3.06405e-14
.ends opamp_dut

Vdd vdd 0 3.300000
Vss vss 0 0
Ibias vdd ib 1.250000e-06
Vinp inp 0 DC 1.480000 AC 1 PWL(0 1.480000 8.685425e-09 1.480000 9.553968e-09 1.490000)
Rfb out inn 1m
Cload out 0 2.000000e-13
Xdut vdd vss inp inn out ib opamp_dut
.end
