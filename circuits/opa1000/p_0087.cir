* opa1000[0087]: 200f/current_reuse_1v8_i200n_subth (current_reuse, VDD=1.8V, CL=0.2pF, Iref=0.0371uA)
.include "pdk_opa.inc"
.temp 27
.option gmin=1e-12 rshunt=1e12 reltol=1e-3 abstol=1e-12 vntol=1e-5 method=gear
* Post-PEX R+C extracted netlist for current_reuse_1v8_i200n_subth
.subckt opamp_dut vdd vss inp inn out ib
XMpar0 out.t0 a_3953_17437.t16 vdd.t1 vdd.t0 pfet_03v3 w=2.04u l=1.92u ad=7.0176e-13 pd=3.1360e-06 as=7.0176e-13 ps=3.1360e-06 nf=1 m=10 par=10
XMpar1 a_1182_13326.t8 inn.t8 a_7634_13534.t0 vss.t1 nfet_03v3 w=2.13u l=7.2u ad=5.9640e-13 pd=2.6900e-06 as=1.2780e-12 ps=5.4600e-06 nf=1 m=6 par=6
XMpar2 a_3953_17437.t8 inp.t8 a_7634_13534.t0 vss.t1 nfet_03v3 w=2.13u l=7.2u ad=5.9640e-13 pd=2.6900e-06 as=1.2780e-12 ps=5.4600e-06 nf=1 m=6 par=6
XMpar3 a_1182_13326.t0 inn.t0 a_1566_13534.t1 vdd.t2 pfet_03v3 w=5.83u l=7.2u ad=1.6324e-12 pd=6.3900e-06 as=2.5652e-12 ps=9.6250e-06 nf=1 m=8 par=8
XMpar4 out.t5 ib.t0 vss.t4 vss.t3 nfet_03v3 w=0.4u l=4u ad=1.8880e-13 pd=1.5840e-06 as=1.6320e-13 ps=1.3760e-06 nf=1 m=10 par=10
XMpar5 ib.t1 ib.t0 vss.t4 vss.t3 nfet_03v3 w=0.4u l=4u ad=2.4000e-13 pd=2.0000e-06 as=1.1200e-13 ps=9.6000e-07 nf=1 m=2 par=2
XMpar6 a_1566_13534.t1 inp.t0 a_3953_17437.t0 vdd.t2 pfet_03v3 w=5.83u l=7.2u ad=2.5652e-12 pd=9.6250e-06 as=1.6324e-12 ps=6.3900e-06 nf=1 m=8 par=8
XMpar7 a_7634_13534.t6 ib.t0 vss.t4 vss.t3 nfet_03v3 w=0.4u l=4u ad=2.4000e-13 pd=2.0000e-06 as=1.1200e-13 ps=9.6000e-07 nf=1 m=4 par=4
XMpar8 a_1566_13534.t0 a_1182_13326.t14 vdd.t1 vdd.t0 pfet_03v3 w=2.04u l=1.92u ad=5.7120e-13 pd=2.6000e-06 as=1.2240e-12 ps=5.2800e-06 nf=1 m=2 par=2
XMpar9 a_1182_13326.t15 a_1182_13326.t14 vdd.t1 vdd.t0 pfet_03v3 w=2.04u l=1.92u ad=1.2240e-12 pd=5.2800e-06 as=5.7120e-13 ps=2.6000e-06 nf=1 m=1
XMpar10 a_3953_17437.t14 a_1182_13326.t14 vdd.t1 vdd.t0 pfet_03v3 w=2.04u l=1.92u ad=1.2240e-12 pd=5.2800e-06 as=5.7120e-13 ps=2.6000e-06 nf=1 m=1
X4 a_5918_4930.t0 a_9896_5450.t0 vss.t0 ppolyf_u_1k r_width=1u r_length=19.23u
X6 a_5918_1810.t0 a_9896_2330.t0 vss.t0 ppolyf_u_1k r_width=1u r_length=19.23u
X13 a_5918_4930.t0 a_9896_4410.t0 vss.t0 ppolyf_u_1k r_width=1u r_length=19.23u
X14 a_5918_1810.t0 a_9896_1290.t0 vss.t0 ppolyf_u_1k r_width=1u r_length=19.23u
X25 a_5918_7010.t0 a_9896_7530.t0 vss.t0 ppolyf_u_1k r_width=1u r_length=19.23u
X27 a_5918_3890.t0 a_9896_4410.t0 vss.t0 ppolyf_u_1k r_width=1u r_length=19.23u
X33 a_5918_7010.t0 a_9896_6490.t0 vss.t0 ppolyf_u_1k r_width=1u r_length=19.23u
X40 a_3953_17437.t15 a_9896_1290.t0 vss.t0 ppolyf_u_1k r_width=1u r_length=19.23u
X47 a_5918_3890.t0 a_9896_3370.t0 vss.t0 ppolyf_u_1k r_width=1u r_length=19.23u
X49 a_9896_7530.t1 out.t20 cap_mim_2f0fF c_width=17.43u c_length=17.43u
X56 a_5918_5970.t0 a_9896_6490.t0 vss.t0 ppolyf_u_1k r_width=1u r_length=19.23u
X57 a_5918_2850.t0 a_9896_3370.t0 vss.t0 ppolyf_u_1k r_width=1u r_length=19.23u
X61 a_5918_5970.t0 a_9896_5450.t0 vss.t0 ppolyf_u_1k r_width=1u r_length=19.23u
X67 a_5918_2850.t0 a_9896_2330.t0 vss.t0 ppolyf_u_1k r_width=1u r_length=19.23u
Rpar0 a_1182_13326.t0 a_1182_13326.t8 67.5453
Rpar1 a_1182_13326.t0 a_1182_13326.t14 335.3609
Rpar2 a_1182_13326.t0 a_1182_13326.t15 359.4014
Rpar3 a_1182_13326.t8 a_1182_13326.t14 131.6860
Rpar4 a_1182_13326.t8 a_1182_13326.t15 141.1260
Rpar5 a_1182_13326.t14 a_1182_13326.t15 24.2113
Rpar6 a_1566_13534.t0 a_1566_13534.t1 69.3168
Rpar7 a_3953_17437.t0 a_3953_17437.t8 95.9837
Rpar8 a_3953_17437.t0 a_3953_17437.t14 427.8348
Rpar9 a_3953_17437.t0 a_3953_17437.t15 121.5162
Rpar10 a_3953_17437.t0 a_3953_17437.t16 101.3699
Rpar11 a_3953_17437.t8 a_3953_17437.t14 335.2787
Rpar12 a_3953_17437.t8 a_3953_17437.t15 489.2415
Rpar13 a_3953_17437.t8 a_3953_17437.t16 79.4399
Rpar14 a_3953_17437.t14 a_3953_17437.t15 2180.7306
Rpar15 a_3953_17437.t14 a_3953_17437.t16 82.7370
Rpar16 a_3953_17437.t15 a_3953_17437.t16 516.6957
Rpar17 a_7634_13534.t0 a_7634_13534.t6 129.0964
Rpar18 a_9896_7530.t0 a_9896_7530.t1 60.8286
Rpar19 ib ib.t0 15.0827
Rpar20 ib ib.t1 14.9093
Rpar21 ib.t0 ib.t1 34.1138
Rpar22 inn inn.t0 45.8809
Rpar23 inn inn.t8 2.9692
Rpar24 inp inp.t0 73.6963
Rpar25 inp inp.t8 2.9692
Rpar26 out out.t0 255.1743
Rpar27 out out.t5 4.6456
Rpar28 out out.t20 195.3653
Rpar29 out.t0 out.t5 183.4957
Rpar30 out.t0 out.t20 393.8589
Rpar31 out.t5 out.t20 140.4871
Rpar32 vdd vdd.t0 74.1154
Rpar33 vdd vdd.t1 23.9300
Rpar34 vdd vdd.t2 264.5031
Rpar35 vdd.t0 vdd.t1 6.4739
Rpar36 vdd.t0 vdd.t2 221.5237
Rpar37 vdd.t1 vdd.t2 69.4013
Rpar38 vss vss.t0 95.5794
Rpar39 vss vss.t1 340.2376
Rpar40 vss vss.t4 37.3945
Rpar41 vss vss.t3 126.2943
Rpar42 vss.t0 vss.t1 85.0444
Rpar43 vss.t0 vss.t4 140.5871
Rpar44 vss.t0 vss.t3 286.3837
Rpar45 vss.t1 vss.t4 503.4331
Rpar46 vss.t1 vss.t3 1232.9851
Rpar47 vss.t4 vss.t3 13.3670
Cpar0 a_1182_13326.t0 vss 1.69066e-14
Cpar1 a_1182_13326.t14 vss 1.25071e-14
Cpar2 a_1182_13326.t15 vss 4.85683e-15
Cpar3 a_1182_13326.t8 vss 1.20119e-14
Cpar4 a_1566_13534.t0 vss 2.66828e-15
Cpar5 a_1566_13534.t1 vss 3.58212e-14
Cpar6 a_3953_17437.t0 vss 1.77766e-14
Cpar7 a_3953_17437.t14 vss 2.94571e-15
Cpar8 a_3953_17437.t15 vss 6.13482e-15
Cpar9 a_3953_17437.t16 vss 1.82711e-14
Cpar10 a_3953_17437.t8 vss 1.01775e-14
Cpar11 a_5918_1810.t0 vss 4.46600e-17
Cpar12 a_5918_2850.t0 vss 4.18400e-17
Cpar13 a_5918_3890.t0 vss 4.06800e-17
Cpar14 a_5918_4930.t0 vss 4.18200e-17
Cpar15 a_5918_5970.t0 vss 3.86800e-17
Cpar16 a_5918_7010.t0 vss 3.98800e-17
Cpar17 a_7634_13534.t0 vss 2.82683e-14
Cpar18 a_7634_13534.t6 vss 1.75181e-14
Cpar19 a_9896_1290.t0 vss 3.93400e-17
Cpar20 a_9896_2330.t0 vss 3.94600e-17
Cpar21 a_9896_3370.t0 vss 3.53600e-17
Cpar22 a_9896_4410.t0 vss 2.93600e-17
Cpar23 a_9896_5450.t0 vss 2.93600e-17
Cpar24 a_9896_6490.t0 vss 3.34400e-17
Cpar25 a_9896_7530.t0 vss 1.17510e-16
Cpar26 a_9896_7530.t1 vss 3.78795e-15
Cpar27 ib out 2.39266e-15
Cpar28 ib vss 4.83954e-14
Cpar29 ib.t0 vss 8.09324e-15
Cpar30 ib.t1 vss 6.48400e-16
Cpar31 inn inp 2.58720e-16
Cpar32 inn out 2.19836e-15
Cpar33 inn vdd 2.27793e-14
Cpar34 inn vss 2.52490e-14
Cpar35 inn.t0 vss 3.11179e-14
Cpar36 inn.t8 vss 1.02612e-14
Cpar37 inp vdd 2.36199e-14
Cpar38 inp vss 2.25720e-14
Cpar39 inp.t0 vss 3.26693e-14
Cpar40 inp.t8 vss 1.06912e-14
Cpar41 out vdd 1.10786e-14
Cpar42 out vss 3.54257e-14
Cpar43 out.t0 vss 1.03684e-14
Cpar44 out.t20 vss 1.11472e-14
Cpar45 out.t5 vss 7.17075e-15
Cpar46 vdd vss 2.68152e-13
Cpar47 vdd.t0 vss 1.52959e-14
Cpar48 vdd.t1 vss 1.15022e-14
Cpar49 vdd.t2 vss 7.10600e-14
.ends opamp_dut

Vdd vdd 0 1.800000
Vss vss 0 0
Ibias vdd ib 3.710000e-08
Vinp inp 0 DC 0.895000 AC 1 PWL(0 0.895000 2.960098e-07 0.895000 3.256108e-07 0.905000)
Rfb out inn 1m
Cload out 0 2.000000e-13
Xdut vdd vss inp inn out ib opamp_dut
.end
