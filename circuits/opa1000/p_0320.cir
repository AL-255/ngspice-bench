* opa1000[0320]: 2p/folded_cascode_pmos_3v3_i2u_subth (folded_cascode_pmos, VDD=3.3V, CL=2.0pF, Iref=0.5778uA)
.include "pdk_opa.inc"
.temp 27
.option gmin=1e-12 rshunt=1e12 reltol=1e-3 abstol=1e-12 vntol=1e-5 method=gear
* Post-PEX R+C extracted netlist for folded_cascode_pmos_3v3_i2u_subth
.subckt opamp_dut vdd vss inp inn out ib
XMpar0 a_1490_1204.t0 inp.t0 a_2086_1204.t0 vdd.t2 pfet_03v3 w=8u l=2.38u ad=2.5600e-12 pd=9.6400e-06 as=2.2400e-12 ps=8.5600e-06 nf=1 m=64 par=64
XMpar1 a_11214_19815.t5 inn.t0 a_1490_1204.t0 vdd.t2 pfet_03v3 w=8u l=2.38u ad=2.2400e-12 pd=8.5600e-06 as=2.5600e-12 ps=9.6400e-06 nf=1 m=64 par=64
XMpar2 a_8932_21446.t1 a_8932_21446.t0 vdd.t1 vdd.t0 pfet_03v3 w=10u l=5.1u ad=6.0000e-12 pd=2.1200e-05 as=2.8000e-12 ps=1.0560e-05 nf=1 m=2 par=2
XMpar3 a_2086_1204.t64 a_1318_16026.t10 a_8932_21446.t4 vss.t0 nfet_03v3 w=1.28u l=1.04u ad=5.6320e-13 pd=2.8000e-06 as=3.5840e-13 ps=1.8400e-06 nf=1 m=4 par=4
XMpar4 a_11214_19815.t0 a_1318_16026.t10 out.t1 vss.t0 nfet_03v3 w=1.28u l=1.04u ad=5.6320e-13 pd=2.8000e-06 as=3.5840e-13 ps=1.8400e-06 nf=1 m=4 par=4
XMpar5 a_11214_19815.t1 ib.t0 vss.t5 vss.t0 nfet_03v3 w=3.35u l=3.9u ad=9.3800e-13 pd=3.9100e-06 as=1.4740e-12 ps=5.9050e-06 nf=1 m=4 par=4
XMpar6 a_1490_1204.t64 a_1318_16026.t2 vdd.t1 vdd.t0 pfet_03v3 w=10u l=5.1u ad=2.8000e-12 pd=1.0560e-05 as=4.4000e-12 ps=1.5880e-05 nf=1 m=4 par=4
XMpar7 a_1318_16026.t0 ib.t0 vss.t5 vss.t0 nfet_03v3 w=3.35u l=3.9u ad=9.3800e-13 pd=3.9100e-06 as=9.3800e-13 ps=3.9100e-06 nf=1 m=2 par=2
XMpar8 a_2086_1204.t66 ib.t0 vss.t5 vss.t0 nfet_03v3 w=3.35u l=3.9u ad=9.3800e-13 pd=3.9100e-06 as=1.4740e-12 ps=5.9050e-06 nf=1 m=4 par=4
XMpar9 ib.t1 ib.t0 vss.t5 vss.t0 nfet_03v3 w=3.35u l=3.9u ad=2.0100e-12 pd=7.9000e-06 as=9.3800e-13 ps=3.9100e-06 nf=1 m=2 par=2
XMpar10 out.t0 a_8932_21446.t0 vdd.t1 vdd.t0 pfet_03v3 w=10u l=5.1u ad=2.8000e-12 pd=1.0560e-05 as=2.8000e-12 ps=1.0560e-05 nf=1 m=2 par=2
XMpar11 a_1318_16026.t3 a_1318_16026.t2 vdd.t1 vdd.t0 pfet_03v3 w=10u l=5.1u ad=2.8000e-12 pd=1.0560e-05 as=2.8000e-12 ps=1.0560e-05 nf=1 m=2 par=2
X24 out.t6 vss.t2 cap_mim_2f0fF c_width=17.43u c_length=17.43u
Rpar0 a_11214_19815.t0 a_11214_19815.t1 69.9987
Rpar1 a_11214_19815.t0 a_11214_19815.t5 195.0986
Rpar2 a_11214_19815.t1 a_11214_19815.t5 67.8048
Rpar3 a_1318_16026.t0 a_1318_16026.t10 138.9707
Rpar4 a_1318_16026.t0 a_1318_16026.t2 412.7212
Rpar5 a_1318_16026.t0 a_1318_16026.t3 143.0573
Rpar6 a_1318_16026.t10 a_1318_16026.t2 181.2510
Rpar7 a_1318_16026.t10 a_1318_16026.t3 62.8252
Rpar8 a_1318_16026.t2 a_1318_16026.t3 27.1213
Rpar9 a_1490_1204.t0 a_1490_1204.t64 55.2717
Rpar10 a_2086_1204.t0 a_2086_1204.t64 195.0986
Rpar11 a_2086_1204.t0 a_2086_1204.t66 67.8048
Rpar12 a_2086_1204.t64 a_2086_1204.t66 69.9987
Rpar13 a_8932_21446.t0 a_8932_21446.t1 19.8660
Rpar14 a_8932_21446.t0 a_8932_21446.t4 248.3310
Rpar15 a_8932_21446.t1 a_8932_21446.t4 63.2466
Rpar16 ib ib.t0 1.5664
Rpar17 ib ib.t1 54.1744
Rpar18 ib.t0 ib.t1 17.9371
Rpar19 inn inn.t0 1.5733
Rpar20 inp inp.t0 1.5733
Rpar21 out out.t0 136.3322
Rpar22 out out.t1 128.3061
Rpar23 out out.t6 15.2087
Rpar24 out.t0 out.t1 188.5323
Rpar25 vdd vdd.t0 28.3164
Rpar26 vdd vdd.t1 60.7093
Rpar27 vdd vdd.t2 308.1612
Rpar28 vdd.t0 vdd.t1 4.6663
Rpar29 vdd.t0 vdd.t2 104.5993
Rpar30 vdd.t1 vdd.t2 234.2016
Rpar31 vss vss.t0 157.7310
Rpar32 vss vss.t5 238.6349
Rpar33 vss vss.t2 317.5325
Rpar34 vss.t0 vss.t5 2.9549
Rpar35 vss.t0 vss.t2 105.8551
Rpar36 vss.t5 vss.t2 131.1532
Cpar0 a_11214_19815.t0 vss 3.78135e-15
Cpar1 a_11214_19815.t1 vss 7.13054e-15
Cpar2 a_11214_19815.t5 vss 9.09486e-14
Cpar3 a_1318_16026.t0 vss 2.04469e-15
Cpar4 a_1318_16026.t10 vss 3.34079e-15
Cpar5 a_1318_16026.t2 vss 2.96279e-14
Cpar6 a_1318_16026.t3 vss 3.57756e-15
Cpar7 a_1490_1204.t0 vss 1.70382e-13
Cpar8 a_1490_1204.t64 vss 9.90459e-15
Cpar9 a_2086_1204.t0 vss 9.33935e-14
Cpar10 a_2086_1204.t64 vss 3.88302e-15
Cpar11 a_2086_1204.t66 vss 7.32221e-15
Cpar12 a_8932_21446.t0 vss 2.03846e-14
Cpar13 a_8932_21446.t1 vss 5.36932e-15
Cpar14 a_8932_21446.t4 vss 1.28406e-15
Cpar15 ib inn 2.85000e-17
Cpar16 ib inp 2.75900e-17
Cpar17 ib vdd 8.96390e-16
Cpar18 ib vss 3.48626e-14
Cpar19 ib.t0 vss 4.27041e-15
Cpar20 ib.t1 vss 6.27549e-16
Cpar21 inn inp 2.05580e-16
Cpar22 inn vdd 6.05086e-14
Cpar23 inn vss 1.19651e-14
Cpar24 inn.t0 vss 1.27233e-13
Cpar25 inp vdd 6.03403e-14
Cpar26 inp vss 1.23232e-14
Cpar27 inp.t0 vss 1.27083e-13
Cpar28 out vdd 6.28198e-15
Cpar29 out vss 1.50198e-14
Cpar30 out.t0 vss 1.24257e-15
Cpar31 out.t1 vss 6.21063e-16
Cpar32 out.t6 vss 1.58655e-14
Cpar33 vdd vss 7.83491e-13
Cpar34 vdd.t0 vss 2.70806e-14
Cpar35 vdd.t1 vss 1.45798e-14
Cpar36 vdd.t2 vss 1.67475e-13
.ends opamp_dut

Vdd vdd 0 3.300000
Vss vss 0 0
Ibias vdd ib 5.778000e-07
Vinp inp 0 DC 1.381000 AC 1 PWL(0 1.381000 1.225538e-07 1.381000 1.348091e-07 1.391000)
Rfb out inn 1m
Cload out 0 2.000000e-12
Xdut vdd vss inp inn out ib opamp_dut
.end
