* opa1000[0729]: 2p/rail_to_rail_1v8_i500u_weak (rail_to_rail, VDD=1.8V, CL=2.0pF, Iref=62.5uA)
.include "pdk_opa.inc"
.temp 27
.option gmin=1e-12 rshunt=1e12 reltol=1e-3 abstol=1e-12 vntol=1e-5 method=gear
* Post-PEX R+C extracted netlist for rail_to_rail_1v8_i500u_weak
.subckt opamp_dut vdd vss inp inn out ib
XMpar0 out.t1 a_1602_9900.t51 vdd.t1 vdd.t0 pfet_03v3 w=6.49u l=0.35u ad=1.8172e-12 pd=7.0500e-06 as=1.9470e-12 ps=7.4956e-06 nf=1 m=64 par=64
XMpar1 out.t17 ib.t0 vss.t95 vss.t94 nfet_03v3 w=1.79u l=0.56u ad=5.3700e-13 pd=2.5019e-06 as=5.0120e-13 ps=2.3500e-06 nf=1 m=64 par=64
XMpar2 a_1602_9900.t22 a_10004_12926.t54 vss.t0 vss.t0 nfet_03v3 w=0.4u l=0.35u ad=1.1200e-13 pd=9.6000e-07 as=1.2800e-13 ps=1.0900e-06 nf=1 m=16 par=16
XMpar3 a_1602_9900.t19 a_10004_6759.t27 vdd.t1 vdd.t0 pfet_03v3 w=6.49u l=0.35u ad=1.8172e-12 pd=7.0500e-06 as=2.0768e-12 ps=7.9412e-06 nf=1 m=16 par=16
XMpar4 a_17452_5234.t32 ib.t0 vss.t95 vss.t94 nfet_03v3 w=1.79u l=0.56u ad=5.0120e-13 pd=2.3500e-06 as=5.7280e-13 ps=2.6537e-06 nf=1 m=16 par=16
XMpar5 a_9306_16545.t0 inp.t18 a_9512_16545.t0 vdd.t2 pfet_03v3 w=1.98u l=0.28u ad=9.2180e-13 pd=3.1311e-06 as=8.7487e-13 ps=2.9370e-06 nf=1 m=54 par=54
XMpar6 a_10004_6759.t28 a_10004_6759.t27 vdd.t1 vdd.t0 pfet_03v3 w=6.49u l=0.35u ad=1.8172e-12 pd=7.0500e-06 as=1.8172e-12 ps=7.0500e-06 nf=1 m=16 par=16
XMpar7 a_10004_12926.t0 inn.t18 a_9306_16545.t0 vdd.t2 pfet_03v3 w=1.98u l=0.28u ad=8.7487e-13 pd=2.9370e-06 as=9.2180e-13 ps=3.1311e-06 nf=1 m=54 par=54
XMpar8 a_10071_1294.t0 inp.t0 a_1602_9900.t0 vss.t0 nfet_03v3 w=1.91u l=0.28u ad=8.8921e-13 pd=3.0533e-06 as=8.8921e-13 ps=3.0533e-06 nf=1 m=18 par=18
XMpar9 a_10004_6759.t0 a_9512_16545.t54 vss.t0 vss.t0 nfet_03v3 w=0.4u l=0.35u ad=1.1200e-13 pd=9.6000e-07 as=1.1200e-13 ps=9.6000e-07 nf=1 m=16 par=16
XMpar10 a_9306_16545.t108 a_17452_5234.t0 vdd.t30 vdd.t29 pfet_03v3 w=6.71u l=0.56u ad=2.4156e-12 pd=9.1075e-06 as=1.8788e-12 ps=7.2700e-06 nf=1 m=16 par=16
XMpar11 a_10071_1294.t36 ib.t0 vss.t95 vss.t94 nfet_03v3 w=1.79u l=0.56u ad=7.8760e-13 pd=3.5650e-06 as=5.0120e-13 ps=2.3500e-06 nf=1 m=16 par=16
XMpar12 a_9512_16545.t55 a_9512_16545.t54 vss.t0 vss.t0 nfet_03v3 w=0.4u l=0.35u ad=1.1200e-13 pd=9.6000e-07 as=1.2800e-13 ps=1.0900e-06 nf=1 m=16 par=16
XMpar13 a_10004_12926.t55 a_10004_12926.t54 vss.t0 vss.t0 nfet_03v3 w=0.4u l=0.35u ad=1.1200e-13 pd=9.6000e-07 as=1.1200e-13 ps=9.6000e-07 nf=1 m=16 par=16
XMpar14 ib.t1 ib.t0 vss.t95 vss.t94 nfet_03v3 w=1.79u l=0.56u ad=5.0120e-13 pd=2.3500e-06 as=5.0120e-13 ps=2.3500e-06 nf=1 m=16 par=16
XMpar15 a_10004_6759.t1 inn.t0 a_10071_1294.t0 vss.t0 nfet_03v3 w=1.91u l=0.28u ad=8.8921e-13 pd=3.0533e-06 as=8.8921e-13 ps=3.0533e-06 nf=1 m=18 par=18
XMpar16 a_17452_5234.t1 a_17452_5234.t0 vdd.t30 vdd.t29 pfet_03v3 w=6.71u l=0.56u ad=2.1472e-12 pd=8.1887e-06 as=1.8788e-12 ps=7.2700e-06 nf=1 m=16 par=16
X132 a_1602_9900.t18 a_9591_5275.t0 vss.t64 ppolyf_u_1k r_width=1u r_length=1u
X200 a_9591_5275.t1 out.t0 cap_mim_2f0fF c_width=17.1u c_length=17.11u
X288 a_9591_5275.t1 out.t0 cap_mim_2f0fF c_width=17.1u c_length=17.11u
X395 a_9591_5275.t1 out.t0 cap_mim_2f0fF c_width=17.1u c_length=17.11u
Rpar0 a_10004_12926.t0 a_10004_12926.t54 829.8042
Rpar1 a_10004_12926.t0 a_10004_12926.t55 73.1391
Rpar2 a_10004_12926.t54 a_10004_12926.t55 14.4923
Rpar3 a_10004_6759.t0 a_10004_6759.t1 63.2104
Rpar4 a_10004_6759.t0 a_10004_6759.t27 5785.3780
Rpar5 a_10004_6759.t0 a_10004_6759.t28 125.9076
Rpar6 a_10004_6759.t1 a_10004_6759.t27 2038.3600
Rpar7 a_10004_6759.t1 a_10004_6759.t28 44.3610
Rpar8 a_10004_6759.t27 a_10004_6759.t28 16.4388
Rpar9 a_10071_1294.t0 a_10071_1294.t36 89.0296
Rpar10 a_1602_9900.t0 a_1602_9900.t51 94.9874
Rpar11 a_1602_9900.t0 a_1602_9900.t18 936.4903
Rpar12 a_1602_9900.t0 a_1602_9900.t19 249.2131
Rpar13 a_1602_9900.t0 a_1602_9900.t22 52.8328
Rpar14 a_1602_9900.t51 a_1602_9900.t18 465.7673
Rpar15 a_1602_9900.t51 a_1602_9900.t19 123.9471
Rpar16 a_1602_9900.t51 a_1602_9900.t22 61.7399
Rpar17 a_1602_9900.t18 a_1602_9900.t19 69.9179
Rpar18 a_1602_9900.t18 a_1602_9900.t22 608.6995
Rpar19 a_1602_9900.t19 a_1602_9900.t22 161.9834
Rpar20 a_17452_5234.t0 a_17452_5234.t1 6.9020
Rpar21 a_17452_5234.t0 a_17452_5234.t32 496.6827
Rpar22 a_17452_5234.t1 a_17452_5234.t32 45.5746
Rpar23 a_9306_16545.t0 a_9306_16545.t108 43.1642
Rpar24 a_9512_16545.t0 a_9512_16545.t54 238.0855
Rpar25 a_9512_16545.t0 a_9512_16545.t55 73.1283
Rpar26 a_9512_16545.t54 a_9512_16545.t55 14.9190
Rpar27 a_9591_5275.t0 a_9591_5275.t1 60.1233
Rpar28 ib ib.t0 12.9621
Rpar29 ib ib.t1 6.5034
Rpar30 ib.t0 ib.t1 11.9137
Rpar31 inn inn.t0 4.7886
Rpar32 inn inn.t18 38.4668
Rpar33 inp inp.t0 4.7886
Rpar34 inp inp.t18 38.4182
Rpar35 out out.t0 3353.7136
Rpar36 out out.t1 5328.1021
Rpar37 out out.t17 2.4555
Rpar38 out.t0 out.t1 339.5034
Rpar39 out.t0 out.t17 64.7511
Rpar40 out.t1 out.t17 102.8712
Rpar41 vdd vdd.t0 347.6241
Rpar42 vdd vdd.t1 117.2541
Rpar43 vdd vdd.t2 26.0586
Rpar44 vdd vdd.t29 2751.8845
Rpar45 vdd vdd.t30 229.9927
Rpar46 vdd.t0 vdd.t1 2.1554
Rpar47 vdd.t0 vdd.t2 1006.8672
Rpar48 vdd.t0 vdd.t30 328.9738
Rpar49 vdd.t1 vdd.t2 339.6178
Rpar50 vdd.t1 vdd.t29 1327.6871
Rpar51 vdd.t1 vdd.t30 110.9634
Rpar52 vdd.t2 vdd.t30 666.1568
Rpar53 vdd.t29 vdd.t30 11.2217
Rpar54 vss vss.t0 317.8664
Rpar55 vss vss.t94 98.9389
Rpar56 vss vss.t95 2418.8544
Rpar57 vss vss.t64 3240.0429
Rpar58 vss.t0 vss.t94 21.2868
Rpar59 vss.t0 vss.t95 921.8074
Rpar60 vss.t0 vss.t64 1205.7897
Rpar61 vss.t94 vss.t95 2.5347
Rpar62 vss.t94 vss.t64 30.4663
Rpar63 vss.t95 vss.t64 1403.3046
Cpar0 a_10004_12926.t0 vss 3.37937e-14
Cpar1 a_10004_12926.t54 vss 9.42860e-15
Cpar2 a_10004_12926.t55 vss 7.63251e-15
Cpar3 a_10004_6759.t0 vss 6.71038e-15
Cpar4 a_10004_6759.t1 vss 1.30176e-14
Cpar5 a_10004_6759.t27 vss 2.14938e-14
Cpar6 a_10004_6759.t28 vss 2.41996e-14
Cpar7 a_10071_1294.t0 vss 2.26396e-14
Cpar8 a_10071_1294.t36 vss 2.09636e-14
Cpar9 a_1602_9900.t0 vss 1.32543e-14
Cpar10 a_1602_9900.t18 vss 2.13320e-15
Cpar11 a_1602_9900.t19 vss 2.33105e-14
Cpar12 a_1602_9900.t22 vss 6.86614e-15
Cpar13 a_1602_9900.t51 vss 4.91718e-14
Cpar14 a_17452_5234.t0 vss 2.44069e-14
Cpar15 a_17452_5234.t1 vss 2.71324e-14
Cpar16 a_17452_5234.t32 vss 5.35397e-15
Cpar17 a_9306_16545.t0 vss 7.39477e-14
Cpar18 a_9306_16545.t108 vss 3.59833e-14
Cpar19 a_9512_16545.t0 vss 3.40651e-14
Cpar20 a_9512_16545.t54 vss 9.67144e-15
Cpar21 a_9512_16545.t55 vss 6.11003e-15
Cpar22 a_9591_5275.t0 vss 8.98000e-17
Cpar23 a_9591_5275.t1 vss 1.07997e-14
Cpar24 ib out 1.76181e-14
Cpar25 ib vss 8.96650e-14
Cpar26 ib.t0 vss 1.58665e-14
Cpar27 ib.t1 vss 3.91977e-15
Cpar28 inn inp 2.49180e-16
Cpar29 inn vdd 2.07872e-14
Cpar30 inn vss 1.74231e-14
Cpar31 inn.t0 vss 4.67718e-15
Cpar32 inn.t18 vss 2.84643e-14
Cpar33 inp out 1.61062e-15
Cpar34 inp vdd 2.33567e-14
Cpar35 inp vss 1.69995e-14
Cpar36 inp.t0 vss 5.01758e-15
Cpar37 inp.t18 vss 3.05321e-14
Cpar38 out vdd 1.04350e-13
Cpar39 out vss 4.38926e-14
Cpar40 out.t0 vss 4.65551e-14
Cpar41 out.t1 vss 8.07384e-14
Cpar42 out.t17 vss 2.81080e-14
Cpar43 vdd vss 4.04356e-13
Cpar44 vdd.t0 vss 1.11235e-13
Cpar45 vdd.t1 vss 4.86710e-14
Cpar46 vdd.t2 vss 8.98979e-14
Cpar47 vdd.t29 vss 6.63021e-14
Cpar48 vdd.t30 vss 1.87839e-14
.ends opamp_dut

Vdd vdd 0 1.800000
Vss vss 0 0
Ibias vdd ib 6.250000e-05
Vinp inp 0 DC 0.895000 AC 1 PWL(0 0.895000 3.000000e-09 0.895000 3.300000e-09 0.905000)
Rfb out inn 1m
Cload out 0 2.000000e-12
Xdut vdd vss inp inn out ib opamp_dut
.end
