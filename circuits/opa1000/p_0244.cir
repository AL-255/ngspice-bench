* opa1000[0244]: 2p/folded_cascode_nmos_3v3_10u_100u_weak (folded_cascode_nmos, VDD=3.3V, CL=2.0pF, Iref=11.1111uA)
.include "pdk_opa.inc"
.temp 27
.option gmin=1e-12 rshunt=1e12 reltol=1e-3 abstol=1e-12 vntol=1e-5 method=gear
* Post-PEX R+C extracted netlist for folded_cascode_nmos_3v3_10u_100u_weak
.subckt opamp_dut vdd vss inp inn out ib
XMpar0 a_7214_6383.t1 ib.t10 out.t0 vdd.t4 pfet_03v3 w=2.04u l=0.45u ad=6.6446e-13 pd=2.9829e-06 as=5.7120e-13 ps=2.6000e-06 nf=1 m=14 par=14
XMpar1 a_2149_1249.t4 inp.t0 a_3914_4556.t17 vss.t0 nfet_03v3 w=2.03u l=0.8u ad=6.7667e-13 pd=3.0350e-06 as=5.6840e-13 ps=2.5900e-06 nf=1 m=12 par=12
XMpar2 a_3914_4556.t1 ib.t10 a_4280_6383.t0 vdd.t4 pfet_03v3 w=2.04u l=0.45u ad=6.6446e-13 pd=2.9829e-06 as=5.7120e-13 ps=2.6000e-06 nf=1 m=14 par=14
XMpar3 a_2149_1249.t4 inn.t0 a_7214_6383.t17 vss.t0 nfet_03v3 w=2.03u l=0.8u ad=6.7667e-13 pd=3.0350e-06 as=5.6840e-13 ps=2.5900e-06 nf=1 m=12 par=12
XMpar4 a_1226_4303.t1 a_1226_4303.t0 vdd.t1 vdd.t0 pfet_03v3 w=10u l=1.5u ad=2.8000e-12 pd=1.0560e-05 as=6.0000e-12 ps=2.1200e-05 nf=1 m=2 par=2
XMpar5 a_3914_4556.t0 a_1226_4303.t0 vdd.t1 vdd.t0 pfet_03v3 w=10u l=1.5u ad=2.8000e-12 pd=1.0560e-05 as=4.4000e-12 ps=1.5880e-05 nf=1 m=4 par=4
XMpar6 a_7214_6383.t0 a_1226_4303.t0 vdd.t1 vdd.t0 pfet_03v3 w=10u l=1.5u ad=2.8000e-12 pd=1.0560e-05 as=4.4000e-12 ps=1.5880e-05 nf=1 m=4 par=4
XMpar7 out.t12 a_4280_6383.t14 vss.t1 vss.t0 nfet_03v3 w=7.83u l=1.5u ad=2.1924e-12 pd=8.3900e-06 as=2.1924e-12 ps=8.3900e-06 nf=1 m=2 par=2
XMpar8 a_4280_6383.t15 a_4280_6383.t14 vss.t1 vss.t0 nfet_03v3 w=7.83u l=1.5u ad=4.6980e-12 pd=1.6860e-05 as=2.1924e-12 ps=8.3900e-06 nf=1 m=2 par=2
XMpar9 a_1226_4303.t4 ib.t0 vss.t1 vss.t0 nfet_03v3 w=7.83u l=1.5u ad=2.1924e-12 pd=8.3900e-06 as=2.1924e-12 ps=8.3900e-06 nf=1 m=2 par=2
XMpar10 ib.t1 ib.t0 vss.t1 vss.t0 nfet_03v3 w=7.83u l=1.5u ad=4.6980e-12 pd=1.6860e-05 as=2.1924e-12 ps=8.3900e-06 nf=1 m=2 par=2
XMpar11 a_2149_1249.t0 ib.t0 vss.t1 vss.t0 nfet_03v3 w=7.83u l=1.5u ad=2.1924e-12 pd=8.3900e-06 as=2.1924e-12 ps=8.3900e-06 nf=1 m=4 par=4
Rpar0 a_1226_4303.t0 a_1226_4303.t1 26.9438
Rpar1 a_1226_4303.t0 a_1226_4303.t4 100.1379
Rpar2 a_1226_4303.t1 a_1226_4303.t4 71.0569
Rpar3 a_2149_1249.t0 a_2149_1249.t4 37.2979
Rpar4 a_3914_4556.t0 a_3914_4556.t1 66.0513
Rpar5 a_3914_4556.t0 a_3914_4556.t17 130.3216
Rpar6 a_3914_4556.t1 a_3914_4556.t17 40.5475
Rpar7 a_4280_6383.t0 a_4280_6383.t14 474.2228
Rpar8 a_4280_6383.t0 a_4280_6383.t15 90.3446
Rpar9 a_4280_6383.t14 a_4280_6383.t15 22.0809
Rpar10 a_7214_6383.t0 a_7214_6383.t1 66.0513
Rpar11 a_7214_6383.t0 a_7214_6383.t17 130.3216
Rpar12 a_7214_6383.t1 a_7214_6383.t17 40.5475
Rpar13 ib ib.t0 933.4335
Rpar14 ib ib.t1 143.0167
Rpar15 ib ib.t10 1.9678
Rpar16 ib.t0 ib.t1 18.9355
Rpar17 inn inn.t0 1.9374
Rpar18 inp inp.t0 1.9860
Rpar19 out out.t0 1.9561
Rpar20 out out.t12 59.6349
Rpar21 vdd vdd.t0 59.1947
Rpar22 vdd vdd.t1 45.8429
Rpar23 vdd vdd.t4 86.4020
Rpar24 vdd.t0 vdd.t1 4.1696
Rpar25 vdd.t0 vdd.t4 120.4819
Rpar26 vdd.t1 vdd.t4 56.1350
Rpar27 vss vss.t0 23.9981
Rpar28 vss vss.t1 252.3384
Rpar29 vss.t0 vss.t1 3.1518
Cpar0 a_1226_4303.t0 vss 1.89240e-14
Cpar1 a_1226_4303.t1 vss 3.97919e-15
Cpar2 a_1226_4303.t4 vss 3.23533e-15
Cpar3 a_2149_1249.t0 vss 6.59202e-15
Cpar4 a_2149_1249.t4 vss 1.18341e-14
Cpar5 a_3914_4556.t0 vss 9.04396e-15
Cpar6 a_3914_4556.t1 vss 8.57489e-15
Cpar7 a_3914_4556.t17 vss 7.39450e-15
Cpar8 a_4280_6383.t0 vss 5.07909e-15
Cpar9 a_4280_6383.t14 vss 5.53845e-15
Cpar10 a_4280_6383.t15 vss 5.66669e-15
Cpar11 a_7214_6383.t0 vss 8.78675e-15
Cpar12 a_7214_6383.t1 vss 8.33109e-15
Cpar13 a_7214_6383.t17 vss 7.18429e-15
Cpar14 ib inn 1.80660e-16
Cpar15 ib inp 8.14200e-17
Cpar16 ib out 2.87369e-15
Cpar17 ib vdd 1.27837e-14
Cpar18 ib vss 2.98279e-14
Cpar19 ib.t0 vss 1.07210e-14
Cpar20 ib.t1 vss 5.92149e-15
Cpar21 ib.t10 vss 3.50242e-15
Cpar22 inn inp 5.19700e-17
Cpar23 inn vss 8.28128e-15
Cpar24 inn.t0 vss 1.62821e-15
Cpar25 inp vdd 1.43500e-17
Cpar26 inp vss 8.30199e-15
Cpar27 inp.t0 vss 1.65279e-15
Cpar28 out vdd 2.53697e-15
Cpar29 out vss 8.62281e-15
Cpar30 out.t0 vss 5.40961e-15
Cpar31 out.t12 vss 5.71949e-15
Cpar32 vdd vss 1.06138e-13
Cpar33 vdd.t0 vss 1.82110e-14
Cpar34 vdd.t1 vss 1.16719e-14
Cpar35 vdd.t4 vss 1.41038e-14
.ends opamp_dut

Vdd vdd 0 3.300000
Vss vss 0 0
Ibias vdd ib 1.111110e-05
Vinp inp 0 DC 1.810000 AC 1 PWL(0 1.810000 6.358631e-09 1.810000 6.994494e-09 1.820000)
Rfb out inn 1m
Cload out 0 2.000000e-12
Xdut vdd vss inp inn out ib opamp_dut
.end
