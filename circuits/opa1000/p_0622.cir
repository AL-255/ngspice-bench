* opa1000[0622]: 200f/pmos_miller_3v3_i150u_weak (pmos_miller, VDD=3.3V, CL=0.2pF, Iref=13.125uA)
.include "pdk_opa.inc"
.temp 27
.option gmin=1e-12 rshunt=1e12 reltol=1e-3 abstol=1e-12 vntol=1e-5 method=gear
* Post-PEX R+C extracted netlist for pmos_miller_3v3_i150u_weak
.subckt opamp_dut vdd vss inp inn out ib
XMpar0 out.t0 a_1657_1204.t0 vdd.t1 vdd.t0 pfet_03v3 w=6.07u l=0.81u ad=2.0881e-12 pd=7.9720e-06 as=1.9586e-12 ps=7.5247e-06 nf=1 m=30 par=30
XMpar1 a_7204_11756.t31 a_7204_11756.t30 vss.t1 vss.t0 nfet_03v3 w=1.7u l=0.6u ad=4.7600e-13 pd=2.2600e-06 as=4.7600e-13 ps=2.2600e-06 nf=1 m=6 par=6
XMpar2 out.t1 a_4658_12050.t37 vss.t1 vss.t0 nfet_03v3 w=1.7u l=0.6u ad=4.7600e-13 pd=2.2600e-06 as=5.1227e-13 ps=2.4160e-06 nf=1 m=30 par=30
XMpar3 a_4658_12050.t0 inp.t0 a_5418_6493.t0 vdd.t4 pfet_03v3 w=2u l=0.36u ad=6.0267e-13 pd=2.7360e-06 as=6.0267e-13 ps=2.7360e-06 nf=1 m=30 par=30
XMpar4 a_1657_1204.t12 ib.t0 vss.t72 vss.t71 nfet_03v3 w=1.45u l=0.81u ad=4.0600e-13 pd=2.0100e-06 as=4.0600e-13 ps=2.0100e-06 nf=1 m=6 par=6
XMpar5 a_5418_6493.t0 inn.t0 a_7204_11756.t0 vdd.t4 pfet_03v3 w=2u l=0.36u ad=6.0267e-13 pd=2.7360e-06 as=6.0267e-13 ps=2.7360e-06 nf=1 m=30 par=30
XMpar6 a_1657_1204.t1 a_1657_1204.t0 vdd.t1 vdd.t0 pfet_03v3 w=6.07u l=0.81u ad=1.6996e-12 pd=6.6300e-06 as=2.3471e-12 ps=8.8667e-06 nf=1 m=6 par=6
XMpar7 a_4658_12050.t31 a_7204_11756.t30 vss.t1 vss.t0 nfet_03v3 w=1.7u l=0.6u ad=6.5733e-13 pd=3.0400e-06 as=4.7600e-13 ps=2.2600e-06 nf=1 m=6 par=6
XMpar8 a_5418_6493.t30 a_1657_1204.t0 vdd.t1 vdd.t0 pfet_03v3 w=6.07u l=0.81u ad=2.3471e-12 pd=8.8667e-06 as=2.0233e-12 ps=7.7483e-06 nf=1 m=12 par=12
XMpar9 ib.t1 ib.t0 vss.t72 vss.t71 nfet_03v3 w=1.45u l=0.81u ad=5.6067e-13 pd=2.7067e-06 as=4.0600e-13 ps=2.0100e-06 nf=1 m=6 par=6
X6 a_5000_12050.t1 out.t47 cap_mim_2f0fF c_width=13.23u c_length=13.23u
X52 a_4658_12050.t30 a_5000_12050.t0 vss.t40 ppolyf_u_1k r_width=1u r_length=1.05u
Rpar0 a_1657_1204.t0 a_1657_1204.t1 16.9197
Rpar1 a_1657_1204.t0 a_1657_1204.t12 99.8738
Rpar2 a_1657_1204.t1 a_1657_1204.t12 213.3326
Rpar3 a_4658_12050.t0 a_4658_12050.t30 167.3606
Rpar4 a_4658_12050.t0 a_4658_12050.t31 117.6020
Rpar5 a_4658_12050.t0 a_4658_12050.t37 39.0684
Rpar6 a_4658_12050.t30 a_4658_12050.t31 77.3519
Rpar7 a_4658_12050.t30 a_4658_12050.t37 298.5852
Rpar8 a_4658_12050.t31 a_4658_12050.t37 209.8118
Rpar9 a_5000_12050.t0 a_5000_12050.t1 46.4437
Rpar10 a_5418_6493.t0 a_5418_6493.t30 34.7771
Rpar11 a_7204_11756.t0 a_7204_11756.t30 423.4966
Rpar12 a_7204_11756.t0 a_7204_11756.t31 76.6000
Rpar13 a_7204_11756.t30 a_7204_11756.t31 17.5426
Rpar14 ib ib.t0 11.7303
Rpar15 ib ib.t1 3.8164
Rpar16 inn inn.t0 3.0177
Rpar17 inp inp.t0 3.0177
Rpar18 out out.t0 2.1361
Rpar19 out out.t1 9228.6303
Rpar20 out out.t47 6473.8513
Rpar21 out.t0 out.t1 127.1461
Rpar22 out.t0 out.t47 89.1925
Rpar23 out.t1 out.t47 102.5558
Rpar24 vdd vdd.t0 58.4419
Rpar25 vdd vdd.t1 224.6586
Rpar26 vdd vdd.t4 185.6021
Rpar27 vdd.t0 vdd.t1 4.0909
Rpar28 vdd.t0 vdd.t4 72.8677
Rpar29 vdd.t1 vdd.t4 462.4554
Rpar30 vss vss.t0 101.4166
Rpar31 vss vss.t1 356.7457
Rpar32 vss vss.t40 447.4362
Rpar33 vss vss.t71 44.0876
Rpar34 vss vss.t72 126.9344
Rpar35 vss.t0 vss.t1 2.0005
Rpar36 vss.t0 vss.t40 80.2798
Rpar37 vss.t0 vss.t71 442.1336
Rpar38 vss.t1 vss.t40 265.6580
Rpar39 vss.t40 vss.t71 1658.9989
Rpar40 vss.t40 vss.t72 5022.6106
Rpar41 vss.t71 vss.t72 5.5468
Cpar0 a_1657_1204.t0 vss 4.71850e-14
Cpar1 a_1657_1204.t1 vss 8.04672e-15
Cpar2 a_1657_1204.t12 vss 5.99803e-15
Cpar3 a_4658_12050.t0 vss 1.43164e-14
Cpar4 a_4658_12050.t30 vss 1.59733e-15
Cpar5 a_4658_12050.t31 vss 3.47595e-15
Cpar6 a_4658_12050.t37 vss 1.39903e-14
Cpar7 a_5000_12050.t0 vss 4.50300e-17
Cpar8 a_5000_12050.t1 vss 1.96194e-15
Cpar9 a_5418_6493.t0 vss 4.18603e-14
Cpar10 a_5418_6493.t30 vss 3.62245e-14
Cpar11 a_7204_11756.t0 vss 1.86275e-14
Cpar12 a_7204_11756.t30 vss 6.66018e-15
Cpar13 a_7204_11756.t31 vss 5.90812e-15
Cpar14 ib vss 1.35491e-14
Cpar15 ib.t0 vss 1.67883e-15
Cpar16 ib.t1 vss 2.23808e-16
Cpar17 inn inp 1.04390e-16
Cpar18 inn vdd 1.08232e-14
Cpar19 inn vss 5.95497e-15
Cpar20 inn.t0 vss 1.10784e-14
Cpar21 inp vdd 1.06727e-14
Cpar22 inp vss 5.93645e-15
Cpar23 inp.t0 vss 1.10052e-14
Cpar24 out vdd 3.37006e-14
Cpar25 out vss 2.83966e-14
Cpar26 out.t0 vss 3.41185e-14
Cpar27 out.t1 vss 7.08474e-15
Cpar28 out.t47 vss 1.03437e-14
Cpar29 vdd vss 2.14526e-13
Cpar30 vdd.t0 vss 7.20259e-14
Cpar31 vdd.t1 vss 2.23642e-14
Cpar32 vdd.t4 vss 3.58736e-14
.ends opamp_dut

Vdd vdd 0 3.300000
Vss vss 0 0
Ibias vdd ib 1.312500e-05
Vinp inp 0 DC 1.480000 AC 1 PWL(0 1.480000 3.000000e-09 1.480000 3.300000e-09 1.490000)
Rfb out inn 1m
Cload out 0 2.000000e-13
Xdut vdd vss inp inn out ib opamp_dut
.end
