* opa1000[0952]: 200f/telescopic_pmos_3v3_i20u_subth (telescopic_pmos, VDD=3.3V, CL=0.2pF, Iref=4.6uA)
.include "pdk_opa.inc"
.temp 27
.option gmin=1e-12 rshunt=1e12 reltol=1e-3 abstol=1e-12 vntol=1e-5 method=gear
* Post-PEX R+C extracted netlist for telescopic_pmos_3v3_i20u_subth
.subckt opamp_dut vdd vss inp inn out ib
XMpar0 a_9108_14788.t0 a_1774_8763.t0 out.t0 vss.t0 nfet_03v3 w=2.03u l=0.36u ad=6.6120e-13 pd=2.9714e-06 as=5.6840e-13 ps=2.5900e-06 nf=1 m=14 par=14
XMpar1 a_7544_14788.t0 a_1774_8763.t214 vss.t15 vss.t0 nfet_03v3 w=1.82u l=0.81u ad=7.0373e-13 pd=3.2000e-06 as=5.0960e-13 ps=2.3800e-06 nf=1 m=6 par=6
XMpar2 a_1774_8763.t29 a_1774_8763.t28 a_2299_8971.t0 vdd.t0 pfet_03v3 w=1.96u l=0.36u ad=6.4996e-13 pd=2.9394e-06 as=8.9275e-13 ps=3.9458e-06 nf=1 m=62 par=62
XMpar3 a_1539_12933.t4 inn.t0 a_1654_8971.t21 vdd.t39 pfet_03v3 w=8u l=0.98u ad=2.4000e-12 pd=9.1000e-06 as=2.3200e-12 ps=8.8300e-06 nf=1 m=64 par=64
XMpar4 a_1654_8971.t0 a_1774_8763.t28 out.t4 vdd.t0 pfet_03v3 w=1.96u l=0.36u ad=9.3321e-13 pd=4.1135e-06 as=6.4996e-13 ps=2.9394e-06 nf=1 m=62 par=62
XMpar5 a_9108_14788.t11 a_1774_8763.t214 vss.t15 vss.t0 nfet_03v3 w=1.82u l=0.81u ad=5.0960e-13 pd=2.3800e-06 as=5.0960e-13 ps=2.3800e-06 nf=1 m=6 par=6
XMpar6 a_1539_12933.t4 inp.t0 a_2299_8971.t15 vdd.t39 pfet_03v3 w=8u l=0.98u ad=2.4000e-12 pd=9.1000e-06 as=2.3200e-12 ps=8.8300e-06 nf=1 m=64 par=64
XMpar7 a_1774_8763.t1 a_1774_8763.t0 a_7544_14788.t2 vss.t0 nfet_03v3 w=2.03u l=0.36u ad=6.6120e-13 pd=2.9714e-06 as=6.6120e-13 ps=2.9714e-06 nf=1 m=14 par=14
XMpar8 ib.t1 ib.t0 vss.t5 vss.t4 nfet_03v3 w=9.09u l=1.5u ad=5.4540e-12 pd=1.9380e-05 as=2.5452e-12 ps=9.6500e-06 nf=1 m=2 par=2
XMpar9 a_1539_12933.t0 a_1239_12725.t2 vdd.t10 vdd.t9 pfet_03v3 w=10u l=1.5u ad=2.8000e-12 pd=1.0560e-05 as=3.6000e-12 ps=1.3220e-05 nf=1 m=8 par=8
XMpar10 a_1239_12725.t3 a_1239_12725.t2 vdd.t10 vdd.t9 pfet_03v3 w=10u l=1.5u ad=2.8000e-12 pd=1.0560e-05 as=2.8000e-12 ps=1.0560e-05 nf=1 m=2 par=2
XMpar11 a_1239_12725.t0 ib.t0 vss.t5 vss.t4 nfet_03v3 w=9.09u l=1.5u ad=2.5452e-12 pd=9.6500e-06 as=2.5452e-12 ps=9.6500e-06 nf=1 m=2 par=2
X35 out.t76 vss.t42 cap_mim_2f0fF c_width=17.75u c_length=17.75u
X146 out.t76 vss.t42 cap_mim_2f0fF c_width=17.75u c_length=17.75u
X275 out.t76 vss.t42 cap_mim_2f0fF c_width=17.75u c_length=17.75u
Rpar0 a_1239_12725.t0 a_1239_12725.t2 267.6388
Rpar1 a_1239_12725.t0 a_1239_12725.t3 93.6938
Rpar2 a_1239_12725.t2 a_1239_12725.t3 24.8040
Rpar3 a_1539_12933.t0 a_1539_12933.t4 62.5399
Rpar4 a_1654_8971.t0 a_1654_8971.t21 65.7253
Rpar5 a_1774_8763.t0 a_1774_8763.t1 14.9349
Rpar6 a_1774_8763.t0 a_1774_8763.t29 601.5837
Rpar7 a_1774_8763.t0 a_1774_8763.t214 562.4694
Rpar8 a_1774_8763.t1 a_1774_8763.t28 435.2310
Rpar9 a_1774_8763.t1 a_1774_8763.t29 90.9813
Rpar10 a_1774_8763.t1 a_1774_8763.t214 85.0658
Rpar11 a_1774_8763.t28 a_1774_8763.t29 8.6031
Rpar12 a_1774_8763.t28 a_1774_8763.t214 888.8797
Rpar13 a_1774_8763.t29 a_1774_8763.t214 185.8126
Rpar14 a_2299_8971.t0 a_2299_8971.t15 48.6066
Rpar15 a_7544_14788.t0 a_7544_14788.t2 44.7165
Rpar16 a_9108_14788.t0 a_9108_14788.t11 57.7596
Rpar17 ib ib.t0 25.3029
Rpar18 ib ib.t1 3.4628
Rpar19 ib.t0 ib.t1 103.7448
Rpar20 inn inn.t0 2.1403
Rpar21 inp inp.t0 2.1403
Rpar22 out out.t0 2.7632
Rpar23 out out.t4 60.3331
Rpar24 out out.t76 84.5894
Rpar25 out.t4 out.t76 195.5814
Rpar26 vdd vdd.t0 99.3345
Rpar27 vdd vdd.t10 539.3518
Rpar28 vdd vdd.t39 485.1158
Rpar29 vdd vdd.t9 135.1571
Rpar30 vdd.t0 vdd.t10 305.6965
Rpar31 vdd.t0 vdd.t39 64.6679
Rpar32 vdd.t0 vdd.t9 76.6050
Rpar33 vdd.t10 vdd.t39 1492.9172
Rpar34 vdd.t10 vdd.t9 5.6926
Rpar35 vdd.t39 vdd.t9 374.1127
Rpar36 vss vss.t0 243.8665
Rpar37 vss vss.t4 518.0375
Rpar38 vss vss.t5 1609.7258
Rpar39 vss vss.t15 4847.9215
Rpar40 vss vss.t42 287.0976
Rpar41 vss.t0 vss.t4 66.7126
Rpar42 vss.t0 vss.t5 207.2996
Rpar43 vss.t0 vss.t15 4.0005
Rpar44 vss.t0 vss.t42 101.9766
Rpar45 vss.t4 vss.t5 8.3641
Rpar46 vss.t4 vss.t15 1099.7832
Rpar47 vss.t4 vss.t42 216.6256
Rpar48 vss.t5 vss.t42 673.1323
Rpar49 vss.t15 vss.t42 2027.2351
Cpar0 a_1239_12725.t0 vss 3.99764e-15
Cpar1 a_1239_12725.t2 vss 1.96156e-14
Cpar2 a_1239_12725.t3 vss 4.96210e-15
Cpar3 a_1539_12933.t0 vss 1.61379e-14
Cpar4 a_1539_12933.t4 vss 1.68291e-13
Cpar5 a_1654_8971.t0 vss 5.93397e-14
Cpar6 a_1654_8971.t21 vss 1.08801e-13
Cpar7 a_1774_8763.t0 vss 1.46420e-14
Cpar8 a_1774_8763.t1 vss 1.69398e-14
Cpar9 a_1774_8763.t214 vss 1.39275e-14
Cpar10 a_1774_8763.t28 vss 6.38564e-14
Cpar11 a_1774_8763.t29 vss 6.74210e-14
Cpar12 a_2299_8971.t0 vss 6.87927e-14
Cpar13 a_2299_8971.t15 vss 1.19905e-13
Cpar14 a_7544_14788.t0 vss 4.71487e-15
Cpar15 a_7544_14788.t2 vss 1.20469e-14
Cpar16 a_9108_14788.t0 vss 1.58975e-14
Cpar17 a_9108_14788.t11 vss 6.52760e-15
Cpar18 ib out 2.11740e-16
Cpar19 ib vdd 3.13700e-17
Cpar20 ib vss 1.11514e-14
Cpar21 ib.t0 vss 1.19967e-15
Cpar22 ib.t1 vss 5.95936e-16
Cpar23 inn inp 9.49000e-17
Cpar24 inn vdd 3.42714e-14
Cpar25 inn vss 1.10143e-14
Cpar26 inn.t0 vss 7.07663e-14
Cpar27 inp vdd 3.44602e-14
Cpar28 inp vss 1.09528e-14
Cpar29 inp.t0 vss 7.09449e-14
Cpar30 out vdd 9.58715e-15
Cpar31 out vss 3.66000e-14
Cpar32 out.t0 vss 1.46020e-15
Cpar33 out.t4 vss 1.09813e-14
Cpar34 out.t76 vss 8.34950e-14
Cpar35 vdd vss 6.36413e-13
Cpar36 vdd.t0 vss 8.47587e-14
Cpar37 vdd.t10 vss 6.90318e-15
Cpar38 vdd.t39 vss 1.22275e-13
Cpar39 vdd.t9 vss 1.68497e-14
.ends opamp_dut

Vdd vdd 0 3.300000
Vss vss 0 0
Ibias vdd ib 4.600000e-06
Vinp inp 0 DC 1.480000 AC 1 PWL(0 1.480000 7.214159e-09 1.480000 7.935574e-09 1.490000)
Rfb out inn 1m
Cload out 0 2.000000e-13
Xdut vdd vss inp inn out ib opamp_dut
.end
