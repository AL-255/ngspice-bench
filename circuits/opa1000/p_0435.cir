* opa1000[0435]: 200f/nmos_miller_1v8_i150u_subth (nmos_miller, VDD=1.8V, CL=0.2pF, Iref=27.8571uA)
.include "pdk_opa.inc"
.temp 27
.option gmin=1e-12 rshunt=1e12 reltol=1e-3 abstol=1e-12 vntol=1e-5 method=gear
* Post-PEX R+C extracted netlist for nmos_miller_1v8_i150u_subth
.subckt opamp_dut vdd vss inp inn out ib
XMpar0 out.t3 a_1142_1086.t71 vdd.t1 vdd.t0 pfet_03v3 w=10u l=0.4u ad=2.8000e-12 pd=1.0560e-05 as=3.0133e-12 ps=1.1269e-05 nf=1 m=30 par=30
XMpar1 a_9044_7384.t65 a_9044_7384.t64 vdd.t1 vdd.t0 pfet_03v3 w=10u l=0.4u ad=2.8000e-12 pd=1.0560e-05 as=2.8000e-12 ps=1.0560e-05 nf=1 m=6 par=6
XMpar2 out.t0 ib.t0 vss.t44 vss.t0 nfet_03v3 w=5.37u l=0.52u ad=1.6182e-12 pd=6.3307e-06 as=1.5036e-12 ps=5.9300e-06 nf=1 m=30 par=30
XMpar3 a_5378_11172.t0 inn.t0 a_9044_7384.t0 vss.t0 nfet_03v3 w=3.25u l=0.44u ad=9.7500e-13 pd=4.0531e-06 as=9.4250e-13 ps=3.9316e-06 nf=1 m=64 par=64
XMpar4 a_1142_1086.t0 inp.t0 a_5378_11172.t0 vss.t0 nfet_03v3 w=3.25u l=0.44u ad=9.4250e-13 pd=3.9316e-06 as=9.7500e-13 ps=4.0531e-06 nf=1 m=64 par=64
XMpar5 ib.t1 ib.t0 vss.t44 vss.t0 nfet_03v3 w=5.37u l=0.52u ad=1.5036e-12 pd=5.9300e-06 as=2.0764e-12 ps=7.9333e-06 nf=1 m=6 par=6
XMpar6 a_1142_1086.t64 a_9044_7384.t64 vdd.t1 vdd.t0 pfet_03v3 w=10u l=0.4u ad=3.8667e-12 pd=1.4107e-05 as=2.8000e-12 ps=1.0560e-05 nf=1 m=6 par=6
XMpar7 a_5378_11172.t64 ib.t0 vss.t44 vss.t0 nfet_03v3 w=5.37u l=0.52u ad=1.5036e-12 pd=5.9300e-06 as=1.5036e-12 ps=5.9300e-06 nf=1 m=12 par=12
X17 a_6516_7633.t1 out.t18 cap_mim_2f0fF c_width=19.63u c_length=19.62u
X194 a_1142_1086.t70 a_6516_7633.t0 vss.t182 ppolyf_u_1k r_width=1u r_length=1u
Rpar0 a_1142_1086.t0 a_1142_1086.t71 355.7743
Rpar1 a_1142_1086.t0 a_1142_1086.t64 63.7276
Rpar2 a_1142_1086.t0 a_1142_1086.t70 235.3282
Rpar3 a_1142_1086.t71 a_1142_1086.t64 195.9593
Rpar4 a_1142_1086.t71 a_1142_1086.t70 73.1843
Rpar5 a_1142_1086.t64 a_1142_1086.t70 129.6180
Rpar6 a_5378_11172.t0 a_5378_11172.t64 39.3012
Rpar7 a_6516_7633.t0 a_6516_7633.t1 57.0310
Rpar8 a_9044_7384.t0 a_9044_7384.t64 818.3169
Rpar9 a_9044_7384.t0 a_9044_7384.t65 62.3071
Rpar10 a_9044_7384.t64 a_9044_7384.t65 25.1911
Rpar11 ib ib.t0 22.1176
Rpar12 ib ib.t1 2.2349
Rpar13 ib.t0 ib.t1 110.8811
Rpar14 inn inn.t0 2.3743
Rpar15 inp inp.t0 2.3743
Rpar16 out out.t0 1.6224
Rpar17 out out.t3 72.9420
Rpar18 out out.t18 69.1957
Rpar19 out.t3 out.t18 104.8648
Rpar20 vdd vdd.t0 82.3136
Rpar21 vdd vdd.t1 328.5348
Rpar22 vdd.t0 vdd.t1 2.0380
Rpar23 vss vss.t0 37.0989
Rpar24 vss vss.t44 199.7203
Rpar25 vss.t0 vss.t44 2.1257
Rpar26 vss.t0 vss.t182 3.5548
Rpar27 vss.t44 vss.t182 358.2111
Cpar0 a_1142_1086.t0 vss 4.76092e-14
Cpar1 a_1142_1086.t64 vss 1.86720e-14
Cpar2 a_1142_1086.t70 vss 4.62590e-15
Cpar3 a_1142_1086.t71 vss 3.56332e-14
Cpar4 a_5378_11172.t0 vss 9.88644e-14
Cpar5 a_5378_11172.t64 vss 1.94653e-14
Cpar6 a_6516_7633.t0 vss 5.09900e-17
Cpar7 a_6516_7633.t1 vss 3.74778e-15
Cpar8 a_9044_7384.t0 vss 5.18293e-14
Cpar9 a_9044_7384.t64 vss 1.30532e-14
Cpar10 a_9044_7384.t65 vss 1.82987e-14
Cpar11 ib out 5.01951e-15
Cpar12 ib vdd 8.21520e-16
Cpar13 ib vss 4.56203e-14
Cpar14 ib.t0 vss 6.62772e-15
Cpar15 ib.t1 vss 8.79954e-16
Cpar16 inn inp 1.05510e-16
Cpar17 inn vdd 5.16200e-17
Cpar18 inn vss 2.61749e-14
Cpar19 inn.t0 vss 1.44135e-14
Cpar20 inp vdd 1.18070e-16
Cpar21 inp vss 2.62878e-14
Cpar22 inp.t0 vss 1.43550e-14
Cpar23 out vdd 6.37583e-14
Cpar24 out vss 4.13707e-14
Cpar25 out.t0 vss 2.39850e-14
Cpar26 out.t18 vss 1.38826e-14
Cpar27 out.t3 vss 4.12350e-14
Cpar28 vdd vss 1.29782e-13
Cpar29 vdd.t0 vss 7.04415e-14
Cpar30 vdd.t1 vss 3.63963e-14
.ends opamp_dut

Vdd vdd 0 1.800000
Vss vss 0 0
Ibias vdd ib 2.785710e-05
Vinp inp 0 DC 0.895000 AC 1 PWL(0 0.895000 3.000000e-09 0.895000 3.300000e-09 0.905000)
Rfb out inn 1m
Cload out 0 2.000000e-13
Xdut vdd vss inp inn out ib opamp_dut
.end
