* opa1000[0358]: 200f/nmos_5t_3v3_i200n_subth (nmos_5t, VDD=3.3V, CL=0.2pF, Iref=0.0525uA)
.include "pdk_opa.inc"
.temp 27
.option gmin=1e-12 rshunt=1e12 reltol=1e-3 abstol=1e-12 vntol=1e-5 method=gear
* Post-PEX R+C extracted netlist for nmos_5t_3v3_i200n_subth
.subckt opamp_dut vdd vss inp inn out ib
XMpar0 a_1938_4497.t0 inp.t0 a_2826_4497.t0 vss.t0 nfet_03v3 w=1.86u l=3.84u ad=7.5888e-13 pd=3.4200e-06 as=6.3984e-13 ps=2.9200e-06 nf=1 m=10 par=10
XMpar1 a_1938_4497.t10 ib.t0 vss.t8 vss.t7 nfet_03v3 w=0.41u l=5u ad=1.1480e-13 pd=9.7000e-07 as=2.1320e-13 ps=1.7575e-06 nf=1 m=8 par=8
XMpar2 a_1938_4497.t0 inn.t0 out.t0 vss.t4 nfet_03v3 w=1.86u l=3.84u ad=5.2080e-13 pd=2.4200e-06 as=5.2080e-13 ps=2.4200e-06 nf=1 m=1
XMpar3 a_2826_4497.t11 a_2826_4497.t10 vdd.t1 vdd.t0 pfet_03v3 w=2.06u l=4.23u ad=1.2360e-12 pd=5.3200e-06 as=5.7680e-13 ps=2.6200e-06 nf=1 m=2 par=2
XMpar4 a_1938_4497.t0 inn.t0 out.t0 vss.t0 nfet_03v3 w=1.86u l=3.84u ad=7.8533e-13 pd=3.5311e-06 as=6.5307e-13 ps=2.9756e-06 nf=1 m=9 par=9
XMpar5 ib.t1 ib.t0 vss.t8 vss.t4 nfet_03v3 w=0.41u l=5u ad=2.4600e-13 pd=2.0200e-06 as=1.1480e-13 ps=9.7000e-07 nf=1 m=2 par=2
XMpar6 out.t10 a_2826_4497.t10 vdd.t1 vdd.t0 pfet_03v3 w=2.06u l=4.23u ad=5.7680e-13 pd=2.6200e-06 as=5.7680e-13 ps=2.6200e-06 nf=1 m=2 par=2
X2 out.t12 vss.t21 cap_mim_2f0fF c_width=7.99u c_length=7.99u
Rpar0 a_1938_4497.t0 a_1938_4497.t10 41.5677
Rpar1 a_2826_4497.t0 a_2826_4497.t10 145.7274
Rpar2 a_2826_4497.t0 a_2826_4497.t11 54.8232
Rpar3 a_2826_4497.t10 a_2826_4497.t11 18.1392
Rpar4 ib ib.t0 13.2964
Rpar5 ib ib.t1 14.1572
Rpar6 ib.t0 ib.t1 33.7097
Rpar7 inn inn.t0 2.5407
Rpar8 inp inp.t0 2.5407
Rpar9 out out.t0 72.2285
Rpar10 out out.t10 79.8561
Rpar11 out out.t12 14.5125
Rpar12 out.t0 out.t10 264.1348
Rpar13 vdd vdd.t0 45.2098
Rpar14 vdd vdd.t1 44.0879
Rpar15 vdd.t0 vdd.t1 14.7406
Rpar16 vss vss.t0 157.2896
Rpar17 vss vss.t8 109.3331
Rpar18 vss vss.t7 540.5188
Rpar19 vss vss.t21 78.6526
Rpar20 vss vss.t4 736.8424
Rpar21 vss.t0 vss.t8 16.9277
Rpar22 vss.t0 vss.t7 2.5957
Rpar23 vss.t0 vss.t21 215.7842
Rpar24 vss.t0 vss.t4 3.6836
Rpar25 vss.t8 vss.t7 55.4358
Rpar26 vss.t8 vss.t21 149.9932
Rpar27 vss.t8 vss.t4 63.2031
Rpar28 vss.t7 vss.t21 741.5330
Rpar29 vss.t7 vss.t4 12.0708
Rpar30 vss.t21 vss.t4 1010.8676
Cpar0 a_1938_4497.t0 vss 2.15260e-14
Cpar1 a_1938_4497.t10 vss 7.83548e-15
Cpar2 a_2826_4497.t0 vss 1.12548e-14
Cpar3 a_2826_4497.t10 vss 1.22497e-14
Cpar4 a_2826_4497.t11 vss 4.52534e-15
Cpar5 ib inn 2.28200e-17
Cpar6 ib out 1.04380e-16
Cpar7 ib vss 3.75803e-14
Cpar8 ib.t0 vss 5.35249e-15
Cpar9 ib.t1 vss 4.44955e-16
Cpar10 inn inp 7.35400e-17
Cpar11 inn out 4.73690e-15
Cpar12 inn vss 1.79968e-14
Cpar13 inn.t0 vss 7.06792e-15
Cpar14 inp out 2.81930e-16
Cpar15 inp vss 1.80618e-14
Cpar16 inp.t0 vss 7.14177e-15
Cpar17 out vdd 2.88801e-15
Cpar18 out vss 1.76224e-14
Cpar19 out.t0 vss 5.45110e-15
Cpar20 out.t10 vss 2.09400e-15
Cpar21 out.t12 vss 9.78540e-15
Cpar22 vdd vss 3.83153e-14
Cpar23 vdd.t0 vss 4.93769e-15
Cpar24 vdd.t1 vss 5.05871e-15
.ends opamp_dut

Vdd vdd 0 3.300000
Vss vss 0 0
Ibias vdd ib 5.250000e-08
Vinp inp 0 DC 1.645000 AC 1 PWL(0 1.645000 9.896531e-08 1.645000 1.088618e-07 1.655000)
Rfb out inn 1m
Cload out 0 2.000000e-13
Xdut vdd vss inp inn out ib opamp_dut
.end
