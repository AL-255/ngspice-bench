* opa1000[0278]: 200f/folded_cascode_pmos_3v3_i1u_weak (folded_cascode_pmos, VDD=3.3V, CL=0.2pF, Iref=0.2889uA)
.include "pdk_opa.inc"
.temp 27
.option gmin=1e-12 rshunt=1e12 reltol=1e-3 abstol=1e-12 vntol=1e-5 method=gear
* Post-PEX R+C extracted netlist for folded_cascode_pmos_3v3_i1u_weak
.subckt opamp_dut vdd vss inp inn out ib
XMpar0 a_2626_16198.t1 inp.t0 a_4250_11254.t0 vdd.t10 pfet_03v3 w=1.81u l=6u ad=7.5503e-13 pd=3.4200e-06 as=5.8954e-13 ps=2.7200e-06 nf=1 m=14 par=14
XMpar1 a_4250_11254.t14 ib.t0 vss.t5 vss.t4 nfet_03v3 w=0.78u l=5.25u ad=2.1840e-13 pd=1.3400e-06 as=3.4320e-13 ps=2.0500e-06 nf=1 m=4 par=4
XMpar2 a_4250_11254.t18 a_1276_15989.t6 a_5552_9274.t0 vss.t2 nfet_03v3 w=0.58u l=2.13u ad=3.4800e-13 pd=2.3600e-06 as=1.6240e-13 ps=1.1400e-06 nf=1 m=2 par=2
XMpar3 a_5552_9274.t3 a_5552_9274.t2 vdd.t1 vdd.t0 pfet_03v3 w=2.22u l=6.75u ad=1.3320e-12 pd=5.6400e-06 as=6.2160e-13 ps=2.7800e-06 nf=1 m=2 par=2
XMpar4 a_2626_16198.t1 inn.t0 a_8494_6071.t2 vdd.t10 pfet_03v3 w=1.81u l=6u ad=7.5503e-13 pd=3.4200e-06 as=5.8954e-13 ps=2.7200e-06 nf=1 m=14 par=14
XMpar5 ib.t1 ib.t0 vss.t5 vss.t4 nfet_03v3 w=0.78u l=5.25u ad=4.6800e-13 pd=2.7600e-06 as=2.1840e-13 ps=1.3400e-06 nf=1 m=2 par=2
XMpar6 a_2626_16198.t0 a_1276_15989.t0 vdd.t1 vdd.t0 pfet_03v3 w=2.22u l=6.75u ad=6.2160e-13 pd=2.7800e-06 as=9.7680e-13 ps=4.2100e-06 nf=1 m=4 par=4
XMpar7 a_8494_6071.t0 a_1276_15989.t6 out.t1 vss.t2 nfet_03v3 w=0.58u l=2.13u ad=3.4800e-13 pd=2.3600e-06 as=1.6240e-13 ps=1.1400e-06 nf=1 m=2 par=2
XMpar8 a_8494_6071.t16 ib.t0 vss.t5 vss.t4 nfet_03v3 w=0.78u l=5.25u ad=2.1840e-13 pd=1.3400e-06 as=3.4320e-13 ps=2.0500e-06 nf=1 m=4 par=4
XMpar9 a_1276_15989.t1 a_1276_15989.t0 vdd.t1 vdd.t0 pfet_03v3 w=2.22u l=6.75u ad=6.2160e-13 pd=2.7800e-06 as=6.2160e-13 ps=2.7800e-06 nf=1 m=2 par=2
XMpar10 out.t0 a_5552_9274.t2 vdd.t1 vdd.t0 pfet_03v3 w=2.22u l=6.75u ad=6.2160e-13 pd=2.7800e-06 as=6.2160e-13 ps=2.7800e-06 nf=1 m=2 par=2
XMpar11 a_1276_15989.t4 ib.t0 vss.t5 vss.t4 nfet_03v3 w=0.78u l=5.25u ad=4.6800e-13 pd=2.7600e-06 as=2.1840e-13 ps=1.3400e-06 nf=1 m=2 par=2
X23 out.t4 vss.t0 cap_mim_2f0fF c_width=15.41u c_length=15.41u
X37 out.t4 vss.t0 cap_mim_2f0fF c_width=15.41u c_length=15.41u
Rpar0 a_1276_15989.t0 a_1276_15989.t1 25.0160
Rpar1 a_1276_15989.t0 a_1276_15989.t4 744.9854
Rpar2 a_1276_15989.t0 a_1276_15989.t6 350.3214
Rpar3 a_1276_15989.t1 a_1276_15989.t4 342.4047
Rpar4 a_1276_15989.t1 a_1276_15989.t6 161.0121
Rpar5 a_1276_15989.t4 a_1276_15989.t6 61.9595
Rpar6 a_2626_16198.t0 a_2626_16198.t1 50.6927
Rpar7 a_4250_11254.t0 a_4250_11254.t14 72.2016
Rpar8 a_4250_11254.t0 a_4250_11254.t18 169.4876
Rpar9 a_4250_11254.t14 a_4250_11254.t18 75.0702
Rpar10 a_5552_9274.t0 a_5552_9274.t2 217.9063
Rpar11 a_5552_9274.t0 a_5552_9274.t3 86.5300
Rpar12 a_5552_9274.t2 a_5552_9274.t3 17.8603
Rpar13 a_8494_6071.t0 a_8494_6071.t2 169.4876
Rpar14 a_8494_6071.t0 a_8494_6071.t16 75.0702
Rpar15 a_8494_6071.t2 a_8494_6071.t16 72.2016
Rpar16 ib ib.t0 7.9831
Rpar17 ib ib.t1 10.3051
Rpar18 ib.t0 ib.t1 38.4608
Rpar19 inn inn.t0 2.3790
Rpar20 inp inp.t0 2.3790
Rpar21 out out.t0 104.6466
Rpar22 out out.t1 13.3863
Rpar23 out out.t4 89.3981
Rpar24 out.t0 out.t4 165.1783
Rpar25 vdd vdd.t0 171.0842
Rpar26 vdd vdd.t1 244.5111
Rpar27 vdd vdd.t10 46.7209
Rpar28 vdd.t0 vdd.t1 4.8522
Rpar29 vdd.t0 vdd.t10 47.0290
Rpar30 vdd.t1 vdd.t10 67.2133
Rpar31 vss vss.t0 69.7111
Rpar32 vss vss.t4 220.6387
Rpar33 vss vss.t5 151.6945
Rpar34 vss vss.t2 371.7914
Rpar35 vss.t0 vss.t4 328.6742
Rpar36 vss.t0 vss.t5 225.9715
Rpar37 vss.t0 vss.t2 553.8385
Rpar38 vss.t4 vss.t5 8.1057
Rpar39 vss.t4 vss.t2 3.0210
Rpar40 vss.t5 vss.t2 14.1224
Cpar0 a_1276_15989.t0 vss 2.44122e-14
Cpar1 a_1276_15989.t1 vss 5.89254e-15
Cpar2 a_1276_15989.t4 vss 5.46415e-15
Cpar3 a_1276_15989.t6 vss 7.83108e-15
Cpar4 a_2626_16198.t0 vss 1.07797e-14
Cpar5 a_2626_16198.t1 vss 4.49370e-14
Cpar6 a_4250_11254.t0 vss 2.06649e-14
Cpar7 a_4250_11254.t14 vss 6.64391e-15
Cpar8 a_4250_11254.t18 vss 4.37226e-15
Cpar9 a_5552_9274.t0 vss 2.43353e-15
Cpar10 a_5552_9274.t2 vss 1.67172e-14
Cpar11 a_5552_9274.t3 vss 5.31595e-15
Cpar12 a_8494_6071.t0 vss 4.97207e-15
Cpar13 a_8494_6071.t16 vss 7.55535e-15
Cpar14 a_8494_6071.t2 vss 2.34997e-14
Cpar15 ib out 7.67900e-17
Cpar16 ib vdd 2.97700e-17
Cpar17 ib vss 4.31609e-14
Cpar18 ib.t0 vss 5.35706e-15
Cpar19 ib.t1 vss 2.10580e-16
Cpar20 inn inp 1.09280e-16
Cpar21 inn out 1.26200e-17
Cpar22 inn vdd 3.13707e-14
Cpar23 inn vss 4.78103e-15
Cpar24 inn.t0 vss 4.16514e-14
Cpar25 inp vdd 3.08946e-14
Cpar26 inp vss 4.71306e-15
Cpar27 inp.t0 vss 4.12691e-14
Cpar28 out vdd 3.79427e-15
Cpar29 out vss 1.73862e-14
Cpar30 out.t0 vss 3.47002e-16
Cpar31 out.t4 vss 1.12018e-14
Cpar32 vdd vss 2.90735e-13
Cpar33 vdd.t0 vss 2.79095e-14
Cpar34 vdd.t1 vss 2.01872e-14
Cpar35 vdd.t10 vss 8.31321e-14
.ends opamp_dut

Vdd vdd 0 3.300000
Vss vss 0 0
Ibias vdd ib 2.889000e-07
Vinp inp 0 DC 1.381000 AC 1 PWL(0 1.381000 1.439502e-07 1.381000 1.583452e-07 1.391000)
Rfb out inn 1m
Cload out 0 2.000000e-13
Xdut vdd vss inp inn out ib opamp_dut
.end
