* opa1000[0550]: 2p/pmos_5t_1v8_i1u_weak (pmos_5t, VDD=1.8V, CL=2.0pF, Iref=0.26uA)
.include "pdk_opa.inc"
.temp 27
.option gmin=1e-12 rshunt=1e12 reltol=1e-3 abstol=1e-12 vntol=1e-5 method=gear
* Post-PEX R+C extracted netlist for pmos_5t_1v8_i1u_weak
.subckt opamp_dut vdd vss inp inn out ib
XMpar0 a_2290_8473.t32 a_1638_2626.t2 vdd.t1 vdd.t0 pfet_03v3 w=2.75u l=5.25u ad=7.7000e-13 pd=3.3100e-06 as=1.4300e-12 ps=5.8525e-06 nf=1 m=8 par=8
XMpar1 a_2290_8473.t0 inp.t0 a_3210_8473.t0 vdd.t13 pfet_03v3 w=1.92u l=4u ad=8.4480e-13 pd=3.7600e-06 as=5.3760e-13 ps=2.4800e-06 nf=1 m=16 par=16
XMpar2 a_2290_8473.t0 inn.t0 out.t0 vdd.t13 pfet_03v3 w=1.92u l=4u ad=8.4480e-13 pd=3.7600e-06 as=5.3760e-13 ps=2.4800e-06 nf=1 m=16 par=16
XMpar3 out.t1 a_3210_8473.t16 vss.t1 vss.t0 nfet_03v3 w=1.39u l=6.75u ad=3.8920e-13 pd=1.9500e-06 as=3.8920e-13 ps=1.9500e-06 nf=1 m=2 par=2
XMpar4 a_1638_2626.t0 ib.t0 vss.t7 vss.t6 nfet_03v3 w=0.7u l=5.25u ad=1.9600e-13 pd=1.2600e-06 as=1.9600e-13 ps=1.2600e-06 nf=1 m=2 par=2
XMpar5 a_3210_8473.t17 a_3210_8473.t16 vss.t1 vss.t0 nfet_03v3 w=1.39u l=6.75u ad=8.3400e-13 pd=3.9800e-06 as=3.8920e-13 ps=1.9500e-06 nf=1 m=2 par=2
XMpar6 a_1638_2626.t3 a_1638_2626.t2 vdd.t1 vdd.t0 pfet_03v3 w=2.75u l=5.25u ad=1.6500e-12 pd=6.7000e-06 as=7.7000e-13 ps=3.3100e-06 nf=1 m=2 par=2
XMpar7 ib.t1 ib.t0 vss.t7 vss.t6 nfet_03v3 w=0.7u l=5.25u ad=4.2000e-13 pd=2.6000e-06 as=1.9600e-13 ps=1.2600e-06 nf=1 m=2 par=2
X35 out.t18 vss.t14 cap_mim_2f0fF c_width=12.99u c_length=12.99u
Rpar0 a_1638_2626.t0 a_1638_2626.t2 163.1257
Rpar1 a_1638_2626.t0 a_1638_2626.t3 75.3395
Rpar2 a_1638_2626.t2 a_1638_2626.t3 12.0216
Rpar3 a_2290_8473.t0 a_2290_8473.t32 49.5603
Rpar4 a_3210_8473.t0 a_3210_8473.t16 158.3541
Rpar5 a_3210_8473.t0 a_3210_8473.t17 98.4241
Rpar6 a_3210_8473.t16 a_3210_8473.t17 20.7001
Rpar7 ib ib.t0 11.6704
Rpar8 ib ib.t1 7.7543
Rpar9 inn inn.t0 1.9360
Rpar10 inp inp.t0 1.9360
Rpar11 out out.t0 75.2163
Rpar12 out out.t1 67.5888
Rpar13 out out.t18 14.8608
Rpar14 out.t0 out.t1 79.0100
Rpar15 vdd vdd.t0 57.8382
Rpar16 vdd vdd.t1 716.5214
Rpar17 vdd vdd.t13 24.0198
Rpar18 vdd.t0 vdd.t1 11.9282
Rpar19 vdd.t0 vdd.t13 181.8928
Rpar20 vdd.t1 vdd.t13 2253.3556
Rpar21 vss vss.t0 249.4770
Rpar22 vss vss.t1 151.4888
Rpar23 vss vss.t6 77.7932
Rpar24 vss vss.t7 161.0981
Rpar25 vss vss.t14 74.9166
Rpar26 vss.t0 vss.t1 25.4218
Rpar27 vss.t0 vss.t6 1056.9694
Rpar28 vss.t0 vss.t7 2188.9200
Rpar29 vss.t0 vss.t14 490.6291
Rpar30 vss.t1 vss.t6 642.8256
Rpar31 vss.t1 vss.t7 1331.2511
Rpar32 vss.t1 vss.t14 297.9141
Rpar33 vss.t6 vss.t7 13.7463
Rpar34 vss.t6 vss.t14 332.0797
Rpar35 vss.t7 vss.t14 687.6874
Cpar0 a_1638_2626.t0 vss 2.81801e-15
Cpar1 a_1638_2626.t2 vss 3.85610e-14
Cpar2 a_1638_2626.t3 vss 7.57179e-15
Cpar3 a_2290_8473.t0 vss 4.41194e-14
Cpar4 a_2290_8473.t32 vss 1.61940e-14
Cpar5 a_3210_8473.t0 vss 1.30466e-14
Cpar6 a_3210_8473.t16 vss 1.28470e-14
Cpar7 a_3210_8473.t17 vss 3.22427e-15
Cpar8 ib vdd 1.81800e-17
Cpar9 ib vss 1.56910e-14
Cpar10 ib.t0 vss 1.69900e-15
Cpar11 ib.t1 vss 9.60500e-17
Cpar12 inn inp 2.05580e-16
Cpar13 inn out 7.87871e-15
Cpar14 inn vdd 2.46256e-14
Cpar15 inn vss 4.55334e-15
Cpar16 inn.t0 vss 3.39766e-14
Cpar17 inp vdd 2.47242e-14
Cpar18 inp vss 4.58830e-15
Cpar19 inp.t0 vss 3.40064e-14
Cpar20 out vdd 5.44299e-15
Cpar21 out vss 1.41581e-14
Cpar22 out.t0 vss 5.26683e-15
Cpar23 out.t1 vss 1.10541e-15
Cpar24 out.t18 vss 1.92176e-14
Cpar25 vdd vss 2.38861e-13
Cpar26 vdd.t0 vss 3.95428e-14
Cpar27 vdd.t1 vss 6.86370e-15
Cpar28 vdd.t13 vss 6.22617e-14
.ends opamp_dut

Vdd vdd 0 1.800000
Vss vss 0 0
Ibias vdd ib 2.600000e-07
Vinp inp 0 DC 0.805000 AC 1 PWL(0 0.805000 1.654822e-07 0.805000 1.820304e-07 0.815000)
Rfb out inn 1m
Cload out 0 2.000000e-12
Xdut vdd vss inp inn out ib opamp_dut
.end
