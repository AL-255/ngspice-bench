* opa1000[0666]: 2p/pmos_miller_3v3_i500u_weak (pmos_miller, VDD=3.3V, CL=2.0pF, Iref=53.125uA)
.include "pdk_opa.inc"
.temp 27
.option gmin=1e-12 rshunt=1e12 reltol=1e-3 abstol=1e-12 vntol=1e-5 method=gear
* Post-PEX R+C extracted netlist for pmos_miller_3v3_i500u_weak
.subckt opamp_dut vdd vss inp inn out ib
XMpar0 a_1036_7456.t123 a_7508_7208.t122 vss.t46 vss.t45 nfet_03v3 w=2.24u l=0.48u ad=6.2720e-13 pd=2.8000e-06 as=7.1680e-13 ps=3.1600e-06 nf=1 m=16 par=16
XMpar1 out.t0 a_7439_9191.t16 vdd.t1 vdd.t0 pfet_03v3 w=7.08u l=0.68u ad=2.3222e-12 pd=8.7980e-06 as=1.9824e-12 ps=7.6400e-06 nf=1 m=80 par=80
XMpar2 a_7508_7208.t123 a_7508_7208.t122 vss.t46 vss.t45 nfet_03v3 w=2.24u l=0.48u ad=6.2720e-13 pd=2.8000e-06 as=6.2720e-13 ps=2.8000e-06 nf=1 m=16 par=16
XMpar3 out.t36 a_1036_7456.t139 vss.t46 vss.t45 nfet_03v3 w=2.24u l=0.48u ad=6.2720e-13 pd=2.8000e-06 as=6.9888e-13 ps=3.0880e-06 nf=1 m=80 par=80
XMpar4 a_1036_7456.t1 inp.t0 a_5368_1205.t9 vdd.t68 pfet_03v3 w=2.01u l=0.45u ad=5.7334e-13 pd=2.6134e-06 as=6.0498e-13 ps=2.7438e-06 nf=1 m=122 par=122
XMpar5 a_5368_1205.t9 inn.t0 a_7508_7208.t0 vdd.t68 pfet_03v3 w=2.01u l=0.45u ad=6.0498e-13 pd=2.7438e-06 as=5.7334e-13 ps=2.6134e-06 nf=1 m=122 par=122
XMpar6 a_5368_1205.t0 a_7439_9191.t16 vdd.t1 vdd.t0 pfet_03v3 w=7.08u l=0.68u ad=2.1240e-12 pd=8.1225e-06 as=2.2656e-12 ps=8.6050e-06 nf=1 m=32 par=32
XMpar7 ib.t1 ib.t0 vss.t2 vss.t1 nfet_03v3 w=1.79u l=0.68u ad=6.4440e-13 pd=2.9575e-06 as=5.0120e-13 ps=2.3500e-06 nf=1 m=16 par=16
XMpar8 a_7439_9191.t17 a_7439_9191.t16 vdd.t1 vdd.t0 pfet_03v3 w=7.08u l=0.68u ad=1.9824e-12 pd=7.6400e-06 as=2.2656e-12 ps=8.6050e-06 nf=1 m=16 par=16
XMpar9 a_7439_9191.t0 ib.t0 vss.t2 vss.t1 nfet_03v3 w=1.79u l=0.68u ad=5.7280e-13 pd=2.6537e-06 as=5.0120e-13 ps=2.3500e-06 nf=1 m=16 par=16
X389 a_1368_7456.t1 out.t47 cap_mim_2f0fF c_width=19.27u c_length=19.27u
X427 a_1036_7456.t0 a_1368_7456.t0 vss.t0 ppolyf_u_1k r_width=1u r_length=1u
X431 a_1368_7456.t1 out.t47 cap_mim_2f0fF c_width=19.27u c_length=19.27u
Rpar0 a_1036_7456.t0 a_1036_7456.t1 100.4868
Rpar1 a_1036_7456.t0 a_1036_7456.t123 222.0766
Rpar2 a_1036_7456.t0 a_1036_7456.t139 212.0038
Rpar3 a_1036_7456.t1 a_1036_7456.t123 165.4433
Rpar4 a_1036_7456.t1 a_1036_7456.t139 157.9392
Rpar5 a_1036_7456.t123 a_1036_7456.t139 40.8172
Rpar6 a_1368_7456.t0 a_1368_7456.t1 90.4742
Rpar7 a_5368_1205.t0 a_5368_1205.t9 74.7580
Rpar8 a_7439_9191.t0 a_7439_9191.t16 50.0522
Rpar9 a_7439_9191.t0 a_7439_9191.t17 62.5696
Rpar10 a_7439_9191.t16 a_7439_9191.t17 15.0276
Rpar11 a_7508_7208.t0 a_7508_7208.t122 1339.9446
Rpar12 a_7508_7208.t0 a_7508_7208.t123 39.2731
Rpar13 a_7508_7208.t122 a_7508_7208.t123 14.5839
Rpar14 ib ib.t0 24.4522
Rpar15 ib ib.t1 4.4917
Rpar16 ib.t0 ib.t1 6.5706
Rpar17 inn inn.t0 1.8246
Rpar18 inp inp.t0 1.8246
Rpar19 out out.t0 4637.8955
Rpar20 out out.t36 1.7721
Rpar21 out out.t47 3906.5950
Rpar22 out.t0 out.t36 85.0132
Rpar23 out.t0 out.t47 127.7666
Rpar24 out.t36 out.t47 71.6084
Rpar25 vdd vdd.t0 31.6259
Rpar26 vdd vdd.t1 2978.1658
Rpar27 vdd vdd.t68 549.2612
Rpar28 vdd.t0 vdd.t1 3.1190
Rpar29 vdd.t0 vdd.t68 49.4395
Rpar30 vdd.t1 vdd.t68 343.4294
Rpar31 vss vss.t0 929.5028
Rpar32 vss vss.t1 62.2242
Rpar33 vss vss.t2 498.1541
Rpar34 vss vss.t46 579.9968
Rpar35 vss vss.t45 75.4213
Rpar36 vss.t0 vss.t1 2193.3848
Rpar37 vss.t0 vss.t46 208.3757
Rpar38 vss.t0 vss.t45 14.0128
Rpar39 vss.t1 vss.t2 10.0498
Rpar40 vss.t1 vss.t46 1028.6036
Rpar41 vss.t1 vss.t45 149.7052
Rpar42 vss.t2 vss.t45 1274.1735
Rpar43 vss.t46 vss.t45 2.4636
Cpar0 a_1036_7456.t0 vss 2.18139e-15
Cpar1 a_1036_7456.t1 vss 5.54596e-14
Cpar2 a_1036_7456.t123 vss 1.00859e-14
Cpar3 a_1036_7456.t139 vss 4.00779e-14
Cpar4 a_1368_7456.t0 vss 2.29218e-16
Cpar5 a_1368_7456.t1 vss 1.08780e-14
Cpar6 a_5368_1205.t0 vss 8.45263e-14
Cpar7 a_5368_1205.t9 vss 1.60363e-13
Cpar8 a_7439_9191.t0 vss 1.01930e-14
Cpar9 a_7439_9191.t16 vss 1.27603e-13
Cpar10 a_7439_9191.t17 vss 1.82593e-14
Cpar11 a_7508_7208.t0 vss 6.97145e-14
Cpar12 a_7508_7208.t122 vss 1.80276e-14
Cpar13 a_7508_7208.t123 vss 1.42050e-14
Cpar14 ib vdd 3.32500e-17
Cpar15 ib vss 3.60623e-14
Cpar16 ib.t0 vss 5.74699e-15
Cpar17 ib.t1 vss 2.72904e-15
Cpar18 inn inp 1.83540e-16
Cpar19 inn vdd 3.93179e-14
Cpar20 inn vss 8.48984e-15
Cpar21 inn.t0 vss 6.17105e-14
Cpar22 inp vdd 3.92513e-14
Cpar23 inp vss 8.53854e-15
Cpar24 inp.t0 vss 6.16236e-14
Cpar25 out vdd 9.99235e-14
Cpar26 out vss 7.69409e-14
Cpar27 out.t0 vss 8.84738e-14
Cpar28 out.t36 vss 3.06525e-14
Cpar29 out.t47 vss 2.61791e-14
Cpar30 vdd vss 5.55413e-13
Cpar31 vdd.t0 vss 1.89677e-13
Cpar32 vdd.t1 vss 5.59999e-14
Cpar33 vdd.t68 vss 1.28134e-13
.ends opamp_dut

Vdd vdd 0 3.300000
Vss vss 0 0
Ibias vdd ib 5.312500e-05
Vinp inp 0 DC 1.480000 AC 1 PWL(0 1.480000 3.000000e-09 1.480000 3.300000e-09 1.490000)
Rfb out inn 1m
Cload out 0 2.000000e-12
Xdut vdd vss inp inn out ib opamp_dut
.end
