* opa1000[0984]: 2p/telescopic_pmos_3v3_0p1u_1u_subth (telescopic_pmos, VDD=3.3V, CL=2.0pF, Iref=0.07uA)
.include "pdk_opa.inc"
.temp 27
.option gmin=1e-12 rshunt=1e12 reltol=1e-3 abstol=1e-12 vntol=1e-5 method=gear
* Post-PEX R+C extracted netlist for telescopic_pmos_3v3_0p1u_1u_subth
.subckt opamp_dut vdd vss inp inn out ib
XMpar0 a_2002_13005.t0 inn.t0 a_9533_7135.t0 vdd.t20 pfet_03v3 w=5.01u l=6.5u ad=1.8036e-12 pd=6.9825e-06 as=1.4028e-12 ps=5.5700e-06 nf=1 m=64 par=64
XMpar1 a_2002_13005.t0 inp.t0 a_3422_13005.t0 vdd.t20 pfet_03v3 w=5.01u l=6.5u ad=1.8036e-12 pd=6.9825e-06 as=1.4028e-12 ps=5.5700e-06 nf=1 m=64 par=64
XMpar2 a_3422_13005.t64 a_7967_5101.t8 a_7967_5101.t9 vdd.t0 pfet_03v3 w=1.94u l=4u ad=8.5360e-13 pd=3.7900e-06 as=8.5360e-13 ps=3.7900e-06 nf=1 m=16 par=16
XMpar3 a_2002_13005.t128 a_1382_10882.t2 vdd.t4 vdd.t3 pfet_03v3 w=1.45u l=3.25u ad=4.0600e-13 pd=2.0100e-06 as=5.2200e-13 ps=2.5325e-06 nf=1 m=8 par=8
XMpar4 a_9671_1294.t1 a_7967_5101.t44 vss.t11 vss.t10 nfet_03v3 w=1.11u l=8u ad=6.6600e-13 pd=3.4200e-06 as=3.1080e-13 ps=1.6700e-06 nf=1 m=2 par=2
XMpar5 a_9533_7135.t64 a_7967_5101.t8 out.t1 vdd.t0 pfet_03v3 w=1.94u l=4u ad=8.5360e-13 pd=3.7900e-06 as=7.7600e-13 ps=3.4675e-06 nf=1 m=16 par=16
XMpar6 a_1382_10882.t3 a_1382_10882.t2 vdd.t4 vdd.t3 pfet_03v3 w=1.45u l=3.25u ad=4.0600e-13 pd=2.0100e-06 as=4.0600e-13 ps=2.0100e-06 nf=1 m=2 par=2
XMpar7 a_11772_1294.t1 a_7967_5101.t44 vss.t11 vss.t10 nfet_03v3 w=1.11u l=8u ad=3.1080e-13 pd=1.6700e-06 as=3.1080e-13 ps=1.6700e-06 nf=1 m=2 par=2
XMpar8 a_11772_1294.t0 a_7967_5101.t0 out.t0 vss.t8 nfet_03v3 w=1.69u l=4u ad=7.4360e-13 pd=3.4150e-06 as=4.7320e-13 ps=2.2500e-06 nf=1 m=4 par=4
XMpar9 a_1382_10882.t0 ib.t0 vss.t1 vss.t0 nfet_03v3 w=0.4u l=3.25u ad=1.1200e-13 pd=9.6000e-07 as=1.1200e-13 ps=9.6000e-07 nf=1 m=2 par=2
XMpar10 a_7967_5101.t1 a_7967_5101.t0 a_9671_1294.t0 vss.t8 nfet_03v3 w=1.69u l=4u ad=4.7320e-13 pd=2.2500e-06 as=1.0140e-12 ps=4.5800e-06 nf=1 m=4 par=4
XMpar11 ib.t1 ib.t0 vss.t1 vss.t0 nfet_03v3 w=0.4u l=3.25u ad=2.4000e-13 pd=2.0000e-06 as=1.1200e-13 ps=9.6000e-07 nf=1 m=2 par=2
Rpar0 a_11772_1294.t0 a_11772_1294.t1 61.4904
Rpar1 a_1382_10882.t0 a_1382_10882.t2 147.3647
Rpar2 a_1382_10882.t0 a_1382_10882.t3 109.3853
Rpar3 a_1382_10882.t2 a_1382_10882.t3 28.6486
Rpar4 a_2002_13005.t0 a_2002_13005.t128 43.7306
Rpar5 a_3422_13005.t0 a_3422_13005.t64 72.3537
Rpar6 a_7967_5101.t0 a_7967_5101.t1 20.2929
Rpar7 a_7967_5101.t0 a_7967_5101.t8 1368.4981
Rpar8 a_7967_5101.t0 a_7967_5101.t9 559.9645
Rpar9 a_7967_5101.t0 a_7967_5101.t44 157.7207
Rpar10 a_7967_5101.t1 a_7967_5101.t8 771.8330
Rpar11 a_7967_5101.t1 a_7967_5101.t9 315.8200
Rpar12 a_7967_5101.t1 a_7967_5101.t44 88.9545
Rpar13 a_7967_5101.t8 a_7967_5101.t9 5.8068
Rpar14 a_7967_5101.t8 a_7967_5101.t44 280.7790
Rpar15 a_7967_5101.t9 a_7967_5101.t44 114.8897
Rpar16 a_9533_7135.t0 a_9533_7135.t64 50.0818
Rpar17 a_9671_1294.t0 a_9671_1294.t1 61.4737
Rpar18 ib ib.t0 16.5165
Rpar19 ib ib.t1 9.1025
Rpar20 ib.t0 ib.t1 93.6366
Rpar21 inn inn.t0 1.5667
Rpar22 inp inp.t0 1.5667
Rpar23 out out.t0 241.0403
Rpar24 out out.t1 4.4647
Rpar25 out.t0 out.t1 105.7950
Rpar26 vdd vdd.t0 458.3239
Rpar27 vdd vdd.t4 1337.3316
Rpar28 vdd vdd.t3 462.6988
Rpar29 vdd vdd.t20 25.3235
Rpar30 vdd.t0 vdd.t4 184.0356
Rpar31 vdd.t0 vdd.t3 63.6739
Rpar32 vdd.t0 vdd.t20 244.1417
Rpar33 vdd.t4 vdd.t3 6.0773
Rpar34 vdd.t4 vdd.t20 712.3750
Rpar35 vdd.t3 vdd.t20 246.4722
Rpar36 vss vss.t0 650.4473
Rpar37 vss vss.t1 1204.4195
Rpar38 vss vss.t10 81.0672
Rpar39 vss vss.t11 156.7140
Rpar40 vss vss.t8 32.9273
Rpar41 vss.t0 vss.t1 13.5201
Rpar42 vss.t0 vss.t10 336.0872
Rpar43 vss.t0 vss.t11 642.9878
Rpar44 vss.t0 vss.t8 137.5846
Rpar45 vss.t1 vss.t10 622.4943
Rpar46 vss.t1 vss.t11 1190.9213
Rpar47 vss.t1 vss.t8 254.8329
Rpar48 vss.t10 vss.t11 39.7655
Rpar49 vss.t10 vss.t8 8.6148
Rpar50 vss.t11 vss.t8 16.3070
Cpar0 a_11772_1294.t0 vss 9.31404e-15
Cpar1 a_11772_1294.t1 vss 5.74509e-15
Cpar2 a_1382_10882.t0 vss 2.79051e-15
Cpar3 a_1382_10882.t2 vss 2.42312e-14
Cpar4 a_1382_10882.t3 vss 3.27609e-15
Cpar5 a_2002_13005.t0 vss 2.23454e-13
Cpar6 a_2002_13005.t128 vss 6.87607e-15
Cpar7 a_3422_13005.t0 vss 1.26741e-13
Cpar8 a_3422_13005.t64 vss 3.84464e-14
Cpar9 a_7967_5101.t0 vss 1.80990e-14
Cpar10 a_7967_5101.t1 vss 4.19084e-15
Cpar11 a_7967_5101.t44 vss 1.54490e-14
Cpar12 a_7967_5101.t8 vss 7.53052e-14
Cpar13 a_7967_5101.t9 vss 2.32138e-14
Cpar14 a_9533_7135.t0 vss 1.33093e-13
Cpar15 a_9533_7135.t64 vss 4.05974e-14
Cpar16 a_9671_1294.t0 vss 6.94212e-15
Cpar17 a_9671_1294.t1 vss 5.25924e-15
Cpar18 ib inp 1.15900e-17
Cpar19 ib vdd 1.78950e-16
Cpar20 ib vss 1.07797e-14
Cpar21 ib.t0 vss 1.34264e-15
Cpar22 ib.t1 vss 8.92361e-17
Cpar23 inn inp 4.13430e-16
Cpar24 inn vdd 1.32430e-13
Cpar25 inn vss 9.61246e-15
Cpar26 inn.t0 vss 2.22422e-13
Cpar27 inp vdd 1.33470e-13
Cpar28 inp vss 9.48929e-15
Cpar29 inp.t0 vss 2.23204e-13
Cpar30 out vdd 2.20896e-14
Cpar31 out vss 2.13841e-14
Cpar32 out.t0 vss 1.23865e-14
Cpar33 out.t1 vss 3.30808e-14
Cpar34 vdd vss 1.34234e-12
Cpar35 vdd.t0 vss 8.50476e-14
Cpar36 vdd.t20 vss 3.51331e-13
Cpar37 vdd.t3 vss 1.39037e-14
Cpar38 vdd.t4 vss 4.60634e-15
.ends opamp_dut

Vdd vdd 0 3.300000
Vss vss 0 0
Ibias vdd ib 7.000000e-08
Vinp inp 0 DC 1.480000 AC 1 PWL(0 1.480000 3.815663e-07 1.480000 4.197230e-07 1.490000)
Rfb out inn 1m
Cload out 0 2.000000e-12
Xdut vdd vss inp inn out ib opamp_dut
.end
