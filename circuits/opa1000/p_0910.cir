* opa1000[0910]: 2p/telescopic_nmos_3v3_i20u_subth (telescopic_nmos, VDD=3.3V, CL=2.0pF, Iref=3.5uA)
.include "pdk_opa.inc"
.temp 27
.option gmin=1e-12 rshunt=1e12 reltol=1e-3 abstol=1e-12 vntol=1e-5 method=gear
* Post-PEX R+C extracted netlist for telescopic_nmos_3v3_i20u_subth
.subckt opamp_dut vdd vss inp inn out ib
XMpar0 a_2412_12614.t0 a_1552_17555.t276 vdd.t4 vdd.t0 pfet_03v3 w=1.97u l=2.03u ad=6.1681e-13 pd=2.8000e-06 as=5.5160e-13 ps=2.5300e-06 nf=1 m=58 par=58
XMpar1 a_2412_12614.t38 a_1552_17555.t0 out.t7 vdd.t0 pfet_03v3 w=5.15u l=0.9u ad=1.9570e-12 pd=7.5194e-06 as=1.8540e-12 ps=7.1575e-06 nf=1 m=64 par=64
XMpar2 a_7712_6251.t30 a_1552_17555.t128 out.t0 vss.t5 nfet_03v3 w=1.9u l=0.9u ad=5.3200e-13 pd=2.4600e-06 as=5.3200e-13 ps=2.4600e-06 nf=1 m=4 par=4
XMpar3 a_1552_17555.t129 a_1552_17555.t128 a_5391_6251.t0 vss.t0 nfet_03v3 w=1.9u l=0.9u ad=6.1886e-13 pd=2.8229e-06 as=6.1886e-13 ps=2.8229e-06 nf=1 m=28 par=28
XMpar4 a_1542_1204.t0 inn.t0 a_7712_6251.t0 vss.t0 nfet_03v3 w=1.94u l=0.52u ad=6.7623e-13 pd=3.0529e-06 as=5.8754e-13 ps=2.6843e-06 nf=1 m=28 par=28
XMpar5 a_1432_17764.t0 a_1552_17555.t0 a_1552_17555.t1 vdd.t0 pfet_03v3 w=5.15u l=0.9u ad=1.9570e-12 pd=7.5194e-06 as=1.8025e-12 ps=6.9766e-06 nf=1 m=64 par=64
XMpar6 a_7712_6251.t30 a_1552_17555.t128 out.t0 vss.t0 nfet_03v3 w=1.9u l=0.9u ad=6.3333e-13 pd=2.8833e-06 as=5.3200e-13 ps=2.4600e-06 nf=1 m=24 par=24
XMpar7 a_1542_1204.t0 inp.t0 a_5391_6251.t4 vss.t0 nfet_03v3 w=1.94u l=0.52u ad=6.7623e-13 pd=3.0529e-06 as=5.8754e-13 ps=2.6843e-06 nf=1 m=28 par=28
XMpar8 a_1432_17764.t3 a_1552_17555.t276 vdd.t4 vdd.t0 pfet_03v3 w=1.97u l=2.03u ad=6.6029e-13 pd=2.9800e-06 as=5.9508e-13 ps=2.7100e-06 nf=1 m=58 par=58
XMpar9 a_1542_1204.t0 inp.t0 a_5391_6251.t4 vss.t5 nfet_03v3 w=1.94u l=0.52u ad=5.4320e-13 pd=2.5000e-06 as=5.4320e-13 ps=2.5000e-06 nf=1 m=2 par=2
XMpar10 a_1542_1204.t30 ib.t0 vss.t16 vss.t15 nfet_03v3 w=8.47u l=1.8u ad=2.3716e-12 pd=9.0300e-06 as=3.0492e-12 ps=1.1307e-05 nf=1 m=8 par=8
XMpar11 a_1542_1204.t0 inn.t0 a_7712_6251.t0 vss.t5 nfet_03v3 w=1.94u l=0.52u ad=5.4320e-13 pd=2.5000e-06 as=5.4320e-13 ps=2.5000e-06 nf=1 m=2 par=2
XMpar12 ib.t1 ib.t0 vss.t16 vss.t15 nfet_03v3 w=8.47u l=1.8u ad=2.3716e-12 pd=9.0300e-06 as=2.3716e-12 ps=9.0300e-06 nf=1 m=2 par=2
Rpar0 a_1432_17764.t0 a_1432_17764.t3 37.1623
Rpar1 a_1542_1204.t0 a_1542_1204.t30 33.4294
Rpar2 a_1552_17555.t0 a_1552_17555.t1 5.5114
Rpar3 a_1552_17555.t1 a_1552_17555.t129 89.2753
Rpar4 a_1552_17555.t1 a_1552_17555.t276 73.0843
Rpar5 a_1552_17555.t128 a_1552_17555.t129 7.1210
Rpar6 a_1552_17555.t128 a_1552_17555.t276 4753.0239
Rpar7 a_1552_17555.t129 a_1552_17555.t276 130.8971
Rpar8 a_2412_12614.t0 a_2412_12614.t38 44.5233
Rpar9 a_5391_6251.t0 a_5391_6251.t4 39.3733
Rpar10 a_7712_6251.t0 a_7712_6251.t30 57.2942
Rpar11 ib ib.t0 14.0883
Rpar12 ib ib.t1 8.3143
Rpar13 inn inn.t0 3.5922
Rpar14 inp inp.t0 3.5922
Rpar15 out out.t7 2.7850
Rpar16 out.t0 out.t7 40.2234
Rpar17 vdd vdd.t0 51.0136
Rpar18 vdd vdd.t4 4287.0972
Rpar19 vdd.t0 vdd.t4 8.9642
Rpar20 vss vss.t0 19.9969
Rpar21 vss vss.t15 100.3023
Rpar22 vss vss.t16 471.4443
Rpar23 vss vss.t5 563.9185
Rpar24 vss.t0 vss.t15 1.5378
Rpar25 vss.t0 vss.t16 17.9483
Rpar26 vss.t0 vss.t5 3.9037
Rpar27 vss.t15 vss.t16 6.8553
Rpar28 vss.t15 vss.t5 98.9028
Rpar29 vss.t16 vss.t5 569.0056
Cpar0 a_1432_17764.t0 vss 1.21857e-13
Cpar1 a_1432_17764.t3 vss 7.60988e-14
Cpar2 a_1542_1204.t0 vss 3.33970e-14
Cpar3 a_1542_1204.t30 vss 1.27525e-14
Cpar4 a_1552_17555.t0 vss 1.41825e-13
Cpar5 a_1552_17555.t1 vss 8.41282e-14
Cpar6 a_1552_17555.t128 vss 3.60685e-14
Cpar7 a_1552_17555.t129 vss 2.13619e-14
Cpar8 a_1552_17555.t276 vss 1.56076e-13
Cpar9 a_2412_12614.t0 vss 7.82646e-14
Cpar10 a_2412_12614.t38 vss 1.25240e-13
Cpar11 a_5391_6251.t0 vss 2.54604e-14
Cpar12 a_5391_6251.t4 vss 2.17774e-14
Cpar13 a_7712_6251.t0 vss 2.43876e-14
Cpar14 a_7712_6251.t30 vss 2.96419e-14
Cpar15 ib vss 2.04355e-14
Cpar16 ib.t0 vss 4.55883e-15
Cpar17 ib.t1 vss 3.96510e-16
Cpar18 inn inp 1.54340e-16
Cpar19 inn vss 1.53532e-14
Cpar20 inn.t0 vss 7.21665e-15
Cpar21 inp vss 1.52811e-14
Cpar22 inp.t0 vss 7.24866e-15
Cpar23 out vdd 3.00879e-14
Cpar24 out vss 1.99588e-14
Cpar25 out.t0 vss 2.70154e-14
Cpar26 out.t7 vss 1.11872e-13
Cpar27 vdd vss 7.38993e-13
Cpar28 vdd.t0 vss 3.77036e-13
Cpar29 vdd.t4 vss 1.86551e-14
.ends opamp_dut

Vdd vdd 0 3.300000
Vss vss 0 0
Ibias vdd ib 3.500000e-06
Vinp inp 0 DC 1.711000 AC 1 PWL(0 1.711000 1.397808e-08 1.711000 1.537589e-08 1.721000)
Rfb out inn 1m
Cload out 0 2.000000e-12
Xdut vdd vss inp inn out ib opamp_dut
.end
