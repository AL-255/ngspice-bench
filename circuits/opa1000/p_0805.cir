* opa1000[0805]: 2p/symmetrical_ota_1v8_i10u_weak (symmetrical_ota, VDD=1.8V, CL=2.0pF, Iref=1.9167uA)
.include "pdk_opa.inc"
.temp 27
.option gmin=1e-12 rshunt=1e12 reltol=1e-3 abstol=1e-12 vntol=1e-5 method=gear
* Post-PEX R+C extracted netlist for symmetrical_ota_1v8_i10u_weak
.subckt opamp_dut vdd vss inp inn out ib
XMpar0 out.t0 a_1331_1041.t4 vdd.t1 vdd.t0 pfet_03v3 w=9.1u l=2.7u ad=2.5480e-12 pd=9.6600e-06 as=4.0040e-12 ps=1.4530e-05 nf=1 m=4 par=4
XMpar1 out.t1 a_3428_4396.t4 vss.t1 vss.t0 nfet_03v3 w=2.15u l=2.7u ad=6.0200e-13 pd=2.7100e-06 as=9.4600e-13 ps=4.1050e-06 nf=1 m=4 par=4
XMpar2 a_3428_4396.t0 a_6380_6526.t0 vdd.t1 vdd.t0 pfet_03v3 w=9.1u l=2.7u ad=2.5480e-12 pd=9.6600e-06 as=4.0040e-12 ps=1.4530e-05 nf=1 m=4 par=4
XMpar3 a_1437_8132.t0 inn.t0 a_6380_6526.t4 vss.t2 nfet_03v3 w=1.38u l=1.63u ad=6.0720e-13 pd=2.9500e-06 as=3.8640e-13 ps=1.9400e-06 nf=1 m=4 par=4
XMpar4 a_6380_6526.t1 a_6380_6526.t0 vdd.t1 vdd.t0 pfet_03v3 w=9.1u l=2.7u ad=2.5480e-12 pd=9.6600e-06 as=2.5480e-12 ps=9.6600e-06 nf=1 m=2 par=2
XMpar5 a_1331_1041.t0 inp.t0 a_1437_8132.t0 vss.t2 nfet_03v3 w=1.38u l=1.63u ad=3.8640e-13 pd=1.9400e-06 as=6.0720e-13 ps=2.9500e-06 nf=1 m=4 par=4
XMpar6 a_3428_4396.t5 a_3428_4396.t4 vss.t1 vss.t0 nfet_03v3 w=2.15u l=2.7u ad=6.0200e-13 pd=2.7100e-06 as=6.0200e-13 ps=2.7100e-06 nf=1 m=4 par=4
XMpar7 ib.t1 ib.t0 vss.t17 vss.t16 nfet_03v3 w=0.96u l=1.2u ad=2.6880e-13 pd=1.5200e-06 as=2.6880e-13 ps=1.5200e-06 nf=1 m=2 par=2
XMpar8 a_1437_8132.t8 ib.t0 vss.t17 vss.t16 nfet_03v3 w=0.96u l=1.2u ad=2.6880e-13 pd=1.5200e-06 as=4.2240e-13 ps=2.3200e-06 nf=1 m=4 par=4
XMpar9 a_1331_1041.t5 a_1331_1041.t4 vdd.t1 vdd.t0 pfet_03v3 w=9.1u l=2.7u ad=2.5480e-12 pd=9.6600e-06 as=2.5480e-12 ps=9.6600e-06 nf=1 m=2 par=2
Rpar0 a_1331_1041.t0 a_1331_1041.t4 129.7546
Rpar1 a_1331_1041.t0 a_1331_1041.t5 71.6483
Rpar2 a_1331_1041.t4 a_1331_1041.t5 25.5001
Rpar3 a_1437_8132.t0 a_1437_8132.t8 64.9172
Rpar4 a_3428_4396.t0 a_3428_4396.t4 299.5938
Rpar5 a_3428_4396.t0 a_3428_4396.t5 75.9995
Rpar6 a_3428_4396.t4 a_3428_4396.t5 18.4907
Rpar7 a_6380_6526.t0 a_6380_6526.t1 25.5001
Rpar8 a_6380_6526.t0 a_6380_6526.t4 129.7546
Rpar9 a_6380_6526.t1 a_6380_6526.t4 71.6483
Rpar10 ib ib.t0 12.3176
Rpar11 ib ib.t1 13.3354
Rpar12 inn inn.t0 3.0028
Rpar13 inp inp.t0 3.0514
Rpar14 out out.t0 4.1001
Rpar15 out out.t1 47.2430
Rpar16 vdd vdd.t0 129.9543
Rpar17 vdd vdd.t1 410.8834
Rpar18 vdd.t0 vdd.t1 3.1265
Rpar19 vss vss.t0 238.5102
Rpar20 vss vss.t1 996.3881
Rpar21 vss vss.t2 457.2612
Rpar22 vss vss.t16 581.3949
Rpar23 vss vss.t17 1042.8319
Rpar24 vss.t0 vss.t1 7.7838
Rpar25 vss.t0 vss.t2 2.6337
Rpar26 vss.t0 vss.t16 19.3115
Rpar27 vss.t0 vss.t17 42.5909
Rpar28 vss.t1 vss.t2 14.5465
Rpar29 vss.t1 vss.t16 60.5692
Rpar30 vss.t1 vss.t17 135.5006
Rpar31 vss.t2 vss.t16 36.4590
Rpar32 vss.t2 vss.t17 80.6416
Rpar33 vss.t16 vss.t17 9.4525
Cpar0 a_1331_1041.t0 vss 1.81104e-15
Cpar1 a_1331_1041.t4 vss 1.73080e-14
Cpar2 a_1331_1041.t5 vss 3.70781e-15
Cpar3 a_1437_8132.t0 vss 4.03963e-15
Cpar4 a_1437_8132.t8 vss 2.83701e-15
Cpar5 a_3428_4396.t0 vss 4.00532e-15
Cpar6 a_3428_4396.t4 vss 7.29882e-15
Cpar7 a_3428_4396.t5 vss 2.25705e-15
Cpar8 a_6380_6526.t0 vss 1.76139e-14
Cpar9 a_6380_6526.t1 vss 3.77336e-15
Cpar10 a_6380_6526.t4 vss 1.84303e-15
Cpar11 ib vss 8.19762e-15
Cpar12 ib.t0 vss 1.02690e-15
Cpar13 ib.t1 vss 4.68243e-17
Cpar14 inn inp 5.11900e-17
Cpar15 inn vss 4.39876e-15
Cpar16 inn.t0 vss 6.57975e-16
Cpar17 inp vss 4.39173e-15
Cpar18 inp.t0 vss 6.66809e-16
Cpar19 out vdd 4.10328e-15
Cpar20 out vss 9.27555e-15
Cpar21 out.t0 vss 4.73336e-15
Cpar22 out.t1 vss 4.45233e-15
Cpar23 vdd vss 1.11700e-13
Cpar24 vdd.t0 vss 2.53935e-14
Cpar25 vdd.t1 vss 1.05967e-14
.ends opamp_dut

Vdd vdd 0 1.800000
Vss vss 0 0
Ibias vdd ib 1.916700e-06
Vinp inp 0 DC 0.895000 AC 1 PWL(0 0.895000 2.543180e-08 0.895000 2.797498e-08 0.905000)
Rfb out inn 1m
Cload out 0 2.000000e-12
Xdut vdd vss inp inn out ib opamp_dut
.end
