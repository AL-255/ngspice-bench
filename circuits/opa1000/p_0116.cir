* opa1000[0116]: 200f/current_reuse_3v3_i10u_subth (current_reuse, VDD=3.3V, CL=0.2pF, Iref=1.2143uA)
.include "pdk_opa.inc"
.temp 27
.option gmin=1e-12 rshunt=1e12 reltol=1e-3 abstol=1e-12 vntol=1e-5 method=gear
* Post-PEX R+C extracted netlist for current_reuse_3v3_i10u_subth
.subckt opamp_dut vdd vss inp inn out ib
XMpar0 a_5098_11551.t0 inn.t6 a_8136_7672.t0 vdd.t4 pfet_03v3 w=1.99u l=0.9u ad=6.8456e-13 pd=3.0760e-06 as=5.5720e-13 ps=2.5500e-06 nf=1 m=20 par=20
XMpar1 a_2405_9465.t6 ib.t0 vss.t7 vss.t6 nfet_03v3 w=1.28u l=0.9u ad=3.5840e-13 pd=1.8400e-06 as=3.5840e-13 ps=1.8400e-06 nf=1 m=4 par=4
XMpar2 a_1008_5837.t21 inp.t0 a_2405_9465.t0 vss.t0 nfet_03v3 w=1.85u l=0.9u ad=5.1800e-13 pd=2.4100e-06 as=7.1533e-13 ps=3.2400e-06 nf=1 m=6 par=6
XMpar3 a_2405_9465.t0 inn.t0 a_8136_7672.t17 vss.t0 nfet_03v3 w=1.85u l=0.9u ad=7.1533e-13 pd=3.2400e-06 as=5.1800e-13 ps=2.4100e-06 nf=1 m=6 par=6
XMpar4 ib.t1 ib.t0 vss.t7 vss.t6 nfet_03v3 w=1.28u l=0.9u ad=3.5840e-13 pd=1.8400e-06 as=3.5840e-13 ps=1.8400e-06 nf=1 m=2 par=2
XMpar5 out.t0 a_1008_5837.t28 vdd.t1 vdd.t0 pfet_03v3 w=10u l=0.94u ad=2.8000e-12 pd=1.0560e-05 as=3.4400e-12 ps=1.2688e-05 nf=1 m=10 par=10
XMpar6 out.t2 ib.t0 vss.t7 vss.t6 nfet_03v3 w=1.28u l=0.9u ad=4.4032e-13 pd=2.2240e-06 as=3.5840e-13 ps=1.8400e-06 nf=1 m=10 par=10
XMpar7 a_5098_11551.t40 a_8136_7672.t26 vdd.t1 vdd.t0 pfet_03v3 w=10u l=0.94u ad=2.8000e-12 pd=1.0560e-05 as=6.0000e-12 ps=2.1200e-05 nf=1 m=2 par=2
XMpar8 a_1008_5837.t1 inp.t6 a_5098_11551.t0 vdd.t4 pfet_03v3 w=1.99u l=0.9u ad=5.5720e-13 pd=2.5500e-06 as=6.8456e-13 ps=3.0760e-06 nf=1 m=20 par=20
XMpar9 a_1008_5837.t27 a_8136_7672.t26 vdd.t1 vdd.t0 pfet_03v3 w=10u l=0.94u ad=6.0000e-12 pd=2.1200e-05 as=2.8000e-12 ps=1.0560e-05 nf=1 m=1
XMpar10 a_8136_7672.t27 a_8136_7672.t26 vdd.t1 vdd.t0 pfet_03v3 w=10u l=0.94u ad=6.0000e-12 pd=2.1200e-05 as=2.8000e-12 ps=1.0560e-05 nf=1 m=1
X3 a_1008_5837.t0 a_10701_14559.t0 vss.t38 ppolyf_u_1k r_width=1u r_length=16.27u
X26 a_10701_14559.t1 out.t13 cap_mim_2f0fF c_width=15.74u c_length=15.73u
X75 a_10701_14559.t1 out.t13 cap_mim_2f0fF c_width=15.74u c_length=15.73u
Rpar0 a_1008_5837.t0 a_1008_5837.t1 60.9471
Rpar1 a_1008_5837.t0 a_1008_5837.t21 398.9213
Rpar2 a_1008_5837.t0 a_1008_5837.t27 937.0374
Rpar3 a_1008_5837.t0 a_1008_5837.t28 231.4985
Rpar4 a_1008_5837.t1 a_1008_5837.t21 243.7869
Rpar5 a_1008_5837.t1 a_1008_5837.t27 572.6378
Rpar6 a_1008_5837.t1 a_1008_5837.t28 141.4722
Rpar7 a_1008_5837.t21 a_1008_5837.t27 83.8749
Rpar8 a_1008_5837.t21 a_1008_5837.t28 122.0940
Rpar9 a_1008_5837.t27 a_1008_5837.t28 286.7899
Rpar10 a_10701_14559.t0 a_10701_14559.t1 116.1496
Rpar11 a_2405_9465.t0 a_2405_9465.t6 70.9995
Rpar12 a_5098_11551.t0 a_5098_11551.t40 74.9621
Rpar13 a_8136_7672.t0 a_8136_7672.t17 202.5913
Rpar14 a_8136_7672.t0 a_8136_7672.t26 470.8146
Rpar15 a_8136_7672.t0 a_8136_7672.t27 131.0874
Rpar16 a_8136_7672.t17 a_8136_7672.t26 87.4434
Rpar17 a_8136_7672.t17 a_8136_7672.t27 62.6288
Rpar18 a_8136_7672.t26 a_8136_7672.t27 48.4268
Rpar19 ib ib.t0 18.2840
Rpar20 ib ib.t1 16.3303
Rpar21 ib.t0 ib.t1 103.3566
Rpar22 inn inn.t0 3.4414
Rpar23 inn inn.t6 57.2590
Rpar24 inp inp.t0 3.4900
Rpar25 inp inp.t6 57.2104
Rpar26 out out.t0 35.2553
Rpar27 out out.t13 199.4282
Rpar28 out out.t2 3.0220
Rpar29 out.t0 out.t13 113.3327
Rpar30 vdd vdd.t0 356.7967
Rpar31 vdd vdd.t1 438.0935
Rpar32 vdd vdd.t4 71.0248
Rpar33 vdd.t0 vdd.t1 3.3409
Rpar34 vdd.t0 vdd.t4 166.0155
Rpar35 vdd.t1 vdd.t4 203.8424
Rpar36 vss vss.t0 125.9629
Rpar37 vss vss.t6 380.4848
Rpar38 vss vss.t7 1380.8759
Rpar39 vss vss.t38 914.4605
Rpar40 vss.t0 vss.t6 53.1611
Rpar41 vss.t0 vss.t7 257.1436
Rpar42 vss.t0 vss.t38 191.3273
Rpar43 vss.t6 vss.t7 4.8221
Rpar44 vss.t6 vss.t38 260.4254
Rpar45 vss.t7 vss.t38 998.5361
Cpar0 a_1008_5837.t0 vss 3.11446e-15
Cpar1 a_1008_5837.t1 vss 1.09532e-14
Cpar2 a_1008_5837.t21 vss 5.26039e-15
Cpar3 a_1008_5837.t27 vss 4.68238e-15
Cpar4 a_1008_5837.t28 vss 1.81465e-14
Cpar5 a_10701_14559.t0 vss 6.76488e-16
Cpar6 a_10701_14559.t1 vss 1.57509e-14
Cpar7 a_2405_9465.t0 vss 1.06478e-14
Cpar8 a_2405_9465.t6 vss 5.42155e-15
Cpar9 a_5098_11551.t0 vss 2.86061e-14
Cpar10 a_5098_11551.t40 vss 7.95774e-15
Cpar11 a_8136_7672.t0 vss 1.31205e-14
Cpar12 a_8136_7672.t17 vss 6.82712e-15
Cpar13 a_8136_7672.t26 vss 9.39776e-15
Cpar14 a_8136_7672.t27 vss 7.60815e-15
Cpar15 ib inp 7.37800e-17
Cpar16 ib out 1.09301e-15
Cpar17 ib vdd 5.33800e-17
Cpar18 ib vss 1.60611e-14
Cpar19 ib.t0 vss 3.05946e-15
Cpar20 ib.t1 vss 1.39561e-16
Cpar21 inn inp 1.55610e-16
Cpar22 inn vdd 1.27491e-14
Cpar23 inn vss 1.05895e-14
Cpar24 inn.t0 vss 2.13008e-15
Cpar25 inn.t6 vss 1.69576e-14
Cpar26 inp out 5.35600e-17
Cpar27 inp vdd 1.17868e-14
Cpar28 inp vss 1.21748e-14
Cpar29 inp.t0 vss 2.11587e-15
Cpar30 inp.t6 vss 1.66563e-14
Cpar31 out vdd 1.30376e-14
Cpar32 out vss 1.61361e-14
Cpar33 out.t0 vss 9.28876e-15
Cpar34 out.t13 vss 1.46287e-14
Cpar35 out.t2 vss 8.98188e-16
Cpar36 vdd vss 1.59552e-13
Cpar37 vdd.t0 vss 2.62075e-14
Cpar38 vdd.t1 vss 1.87007e-14
Cpar39 vdd.t4 vss 3.43583e-14
.ends opamp_dut

Vdd vdd 0 3.300000
Vss vss 0 0
Ibias vdd ib 1.214300e-06
Vinp inp 0 DC 1.645000 AC 1 PWL(0 1.645000 1.511998e-08 1.645000 1.663198e-08 1.655000)
Rfb out inn 1m
Cload out 0 2.000000e-13
Xdut vdd vss inp inn out ib opamp_dut
.end
