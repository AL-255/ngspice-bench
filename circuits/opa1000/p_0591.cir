* opa1000[0591]: 200f/pmos_miller_1v8_i1u_weak (pmos_miller, VDD=1.8V, CL=0.2pF, Iref=0.125uA)
.include "pdk_opa.inc"
.temp 27
.option gmin=1e-12 rshunt=1e12 reltol=1e-3 abstol=1e-12 vntol=1e-5 method=gear
* Post-PEX R+C extracted netlist for pmos_miller_1v8_i1u_weak
.subckt opamp_dut vdd vss inp inn out ib
XMpar0 ib.t1 ib.t0 vss.t2 vss.t1 nfet_03v3 w=0.4u l=4.38u ad=2.4000e-13 pd=2.0000e-06 as=1.1200e-13 ps=9.6000e-07 nf=1 m=2 par=2
XMpar1 a_3410_6429.t0 a_1895_7984.t2 vdd.t1 vdd.t0 pfet_03v3 w=1.09u l=4.38u ad=6.5400e-13 pd=3.3800e-06 as=3.0520e-13 ps=1.6500e-06 nf=1 m=4 par=4
XMpar2 out.t5 a_4444_1290.t7 vss.t8 vss.t7 nfet_03v3 w=0.4u l=2.7u ad=1.3760e-13 pd=1.1680e-06 as=1.6320e-13 ps=1.3760e-06 nf=1 m=10 par=10
XMpar3 out.t0 a_1895_7984.t2 vdd.t1 vdd.t0 pfet_03v3 w=1.09u l=4.38u ad=5.1448e-13 pd=2.6880e-06 as=4.4472e-13 ps=2.3420e-06 nf=1 m=10 par=10
XMpar4 a_1895_7984.t3 a_1895_7984.t2 vdd.t1 vdd.t0 pfet_03v3 w=1.09u l=4.38u ad=6.5400e-13 pd=3.3800e-06 as=3.0520e-13 ps=1.6500e-06 nf=1 m=2 par=2
XMpar5 a_6972_11554.t5 a_6972_11554.t4 vss.t8 vss.t7 nfet_03v3 w=0.4u l=2.7u ad=1.1200e-13 pd=9.6000e-07 as=1.1200e-13 ps=9.6000e-07 nf=1 m=2 par=2
XMpar6 a_3410_6429.t2 inn.t0 a_6972_11554.t0 vdd.t12 pfet_03v3 w=1.71u l=5u ad=7.5240e-13 pd=3.4450e-06 as=4.7880e-13 ps=2.2700e-06 nf=1 m=4 par=4
XMpar7 a_3410_6429.t2 inp.t0 a_4444_1290.t0 vdd.t12 pfet_03v3 w=1.71u l=5u ad=7.5240e-13 pd=3.4450e-06 as=4.7880e-13 ps=2.2700e-06 nf=1 m=4 par=4
XMpar8 a_4444_1290.t4 a_6972_11554.t4 vss.t8 vss.t7 nfet_03v3 w=0.4u l=2.7u ad=2.4000e-13 pd=2.0000e-06 as=1.1200e-13 ps=9.6000e-07 nf=1 m=2 par=2
XMpar9 a_1895_7984.t0 ib.t0 vss.t2 vss.t1 nfet_03v3 w=0.4u l=4.38u ad=2.4000e-13 pd=2.0000e-06 as=1.1200e-13 ps=9.6000e-07 nf=1 m=2 par=2
X2 a_4444_3890.t0 a_8280_4410.t0 vss.t0 ppolyf_u_1k r_width=1u r_length=18.52u
X15 a_4444_1290.t6 a_8280_1290.t0 vss.t0 ppolyf_u_1k r_width=1u r_length=18.52u
X18 a_4444_3890.t0 a_8280_3370.t0 vss.t0 ppolyf_u_1k r_width=1u r_length=18.52u
X29 a_4444_2850.t0 a_8280_3370.t0 vss.t0 ppolyf_u_1k r_width=1u r_length=18.52u
X34 a_4444_2850.t0 a_8280_2330.t0 vss.t0 ppolyf_u_1k r_width=1u r_length=18.52u
X37 a_4444_4930.t1 out.t18 cap_mim_2f0fF c_width=11.46u c_length=11.46u
X43 a_4444_1810.t0 a_8280_2330.t0 vss.t0 ppolyf_u_1k r_width=1u r_length=18.52u
X46 a_4444_4930.t0 a_8280_4410.t0 vss.t0 ppolyf_u_1k r_width=1u r_length=18.52u
X49 a_4444_1810.t0 a_8280_1290.t0 vss.t0 ppolyf_u_1k r_width=1u r_length=18.52u
Rpar0 a_1895_7984.t0 a_1895_7984.t2 110.5913
Rpar1 a_1895_7984.t0 a_1895_7984.t3 81.6618
Rpar2 a_1895_7984.t2 a_1895_7984.t3 15.5528
Rpar3 a_3410_6429.t0 a_3410_6429.t2 60.5052
Rpar4 a_4444_1290.t0 a_4444_1290.t7 183.6680
Rpar5 a_4444_1290.t0 a_4444_1290.t4 104.7244
Rpar6 a_4444_1290.t0 a_4444_1290.t6 143.7938
Rpar7 a_4444_1290.t7 a_4444_1290.t4 355.6608
Rpar8 a_4444_1290.t7 a_4444_1290.t6 63.7865
Rpar9 a_4444_1290.t4 a_4444_1290.t6 278.4472
Rpar10 a_4444_4930.t0 a_4444_4930.t1 65.2387
Rpar11 a_6972_11554.t0 a_6972_11554.t4 141.4553
Rpar12 a_6972_11554.t0 a_6972_11554.t5 147.1267
Rpar13 a_6972_11554.t4 a_6972_11554.t5 29.1706
Rpar14 ib ib.t0 13.3156
Rpar15 ib ib.t1 16.3193
Rpar16 ib.t0 ib.t1 27.3885
Rpar17 inn inn.t0 1.9480
Rpar18 inp inp.t0 1.9965
Rpar19 out out.t0 5.5508
Rpar20 out out.t5 1459.1276
Rpar21 out out.t18 2696.0552
Rpar22 out.t0 out.t5 131.6498
Rpar23 out.t0 out.t18 243.2516
Rpar24 out.t5 out.t18 85.2531
Rpar25 vdd vdd.t0 36.8708
Rpar26 vdd vdd.t1 596.2170
Rpar27 vdd vdd.t12 206.6184
Rpar28 vdd.t0 vdd.t1 12.1587
Rpar29 vdd.t0 vdd.t12 112.3347
Rpar30 vdd.t1 vdd.t12 1816.5027
Rpar31 vss vss.t0 213.5765
Rpar32 vss vss.t1 182.6775
Rpar33 vss vss.t8 64.8138
Rpar34 vss vss.t7 207.9609
Rpar35 vss vss.t2 618.4826
Rpar36 vss.t0 vss.t1 182.7168
Rpar37 vss.t0 vss.t8 148.3004
Rpar38 vss.t0 vss.t7 329.2347
Rpar39 vss.t0 vss.t2 618.6325
Rpar40 vss.t1 vss.t8 92.6347
Rpar41 vss.t1 vss.t7 107.6201
Rpar42 vss.t1 vss.t2 22.7294
Rpar43 vss.t8 vss.t7 6.2873
Rpar44 vss.t8 vss.t2 314.3747
Rpar45 vss.t7 vss.t2 371.1789
Cpar0 a_1895_7984.t0 vss 5.93863e-15
Cpar1 a_1895_7984.t2 vss 5.10567e-14
Cpar2 a_1895_7984.t3 vss 8.09395e-15
Cpar3 a_3410_6429.t0 vss 2.08997e-14
Cpar4 a_3410_6429.t2 vss 1.32370e-14
Cpar5 a_4444_1290.t0 vss 3.71744e-15
Cpar6 a_4444_1290.t4 vss 3.41064e-15
Cpar7 a_4444_1290.t6 vss 2.92210e-15
Cpar8 a_4444_1290.t7 vss 1.01252e-14
Cpar9 a_4444_1810.t0 vss 4.57400e-17
Cpar10 a_4444_2850.t0 vss 4.18400e-17
Cpar11 a_4444_3890.t0 vss 4.27400e-17
Cpar12 a_4444_4930.t0 vss 1.32010e-16
Cpar13 a_4444_4930.t1 vss 2.07941e-15
Cpar14 a_6972_11554.t0 vss 3.37617e-15
Cpar15 a_6972_11554.t4 vss 3.82215e-15
Cpar16 a_6972_11554.t5 vss 1.44177e-15
Cpar17 a_8280_1290.t0 vss 3.90600e-17
Cpar18 a_8280_2330.t0 vss 4.15400e-17
Cpar19 a_8280_3370.t0 vss 3.88000e-17
Cpar20 a_8280_4410.t0 vss 3.59200e-17
Cpar21 ib out 7.60700e-17
Cpar22 ib vdd 3.57700e-17
Cpar23 ib vss 1.60436e-14
Cpar24 ib.t0 vss 2.59911e-15
Cpar25 ib.t1 vss 4.30257e-16
Cpar26 inn inp 5.13900e-17
Cpar27 inn out 1.35940e-16
Cpar28 inn vdd 9.34992e-15
Cpar29 inn vss 4.32866e-15
Cpar30 inn.t0 vss 7.59457e-15
Cpar31 inp vdd 9.47311e-15
Cpar32 inp vss 4.17007e-15
Cpar33 inp.t0 vss 7.73076e-15
Cpar34 out vdd 1.30349e-14
Cpar35 out vss 2.93458e-14
Cpar36 out.t0 vss 9.74272e-15
Cpar37 out.t18 vss 9.77026e-15
Cpar38 out.t5 vss 8.53829e-15
Cpar39 vdd vss 1.65861e-13
Cpar40 vdd.t0 vss 5.60675e-14
Cpar41 vdd.t1 vss 6.46975e-15
Cpar42 vdd.t12 vss 2.76937e-14
.ends opamp_dut

Vdd vdd 0 1.800000
Vss vss 0 0
Ibias vdd ib 1.250000e-07
Vinp inp 0 DC 0.805000 AC 1 PWL(0 0.805000 8.608205e-08 0.805000 9.469026e-08 0.815000)
Rfb out inn 1m
Cload out 0 2.000000e-13
Xdut vdd vss inp inn out ib opamp_dut
.end
