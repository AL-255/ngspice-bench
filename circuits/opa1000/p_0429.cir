* opa1000[0429]: 200f/nmos_miller_1v8_1u_10u_weak (nmos_miller, VDD=1.8V, CL=0.2pF, Iref=0.9286uA)
.include "pdk_opa.inc"
.temp 27
.option gmin=1e-12 rshunt=1e12 reltol=1e-3 abstol=1e-12 vntol=1e-5 method=gear
* Post-PEX R+C extracted netlist for nmos_miller_1v8_1u_10u_weak
.subckt opamp_dut vdd vss inp inn out ib
XMpar0 a_1014_5500.t0 inp.t0 a_4754_3547.t0 vss.t1 nfet_03v3 w=2.23u l=1.6u ad=6.2440e-13 pd=2.7900e-06 as=1.3380e-12 ps=5.6600e-06 nf=1 m=2 par=2
XMpar1 a_4754_3547.t2 ib.t0 vss.t4 vss.t3 nfet_03v3 w=0.86u l=2u ad=5.1600e-13 pd=2.9200e-06 as=2.4080e-13 ps=1.4200e-06 nf=1 m=4 par=4
XMpar2 out.t0 ib.t0 vss.t4 vss.t3 nfet_03v3 w=0.86u l=2u ad=4.0592e-13 pd=2.3200e-06 as=3.5088e-13 ps=2.0200e-06 nf=1 m=10 par=10
XMpar3 ib.t1 ib.t0 vss.t4 vss.t3 nfet_03v3 w=0.86u l=2u ad=5.1600e-13 pd=2.9200e-06 as=2.4080e-13 ps=1.4200e-06 nf=1 m=2 par=2
XMpar4 a_4754_3547.t0 inn.t0 a_5312_1041.t0 vss.t1 nfet_03v3 w=2.23u l=1.6u ad=1.3380e-12 pd=5.6600e-06 as=6.2440e-13 ps=2.7900e-06 nf=1 m=2 par=2
XMpar5 a_5312_1041.t3 a_5312_1041.t2 vdd.t1 vdd.t0 pfet_03v3 w=3.36u l=1.25u ad=9.4080e-13 pd=3.9200e-06 as=9.4080e-13 ps=3.9200e-06 nf=1 m=2 par=2
XMpar6 a_1014_5500.t3 a_5312_1041.t2 vdd.t1 vdd.t0 pfet_03v3 w=3.36u l=1.25u ad=2.0160e-12 pd=7.9200e-06 as=9.4080e-13 ps=3.9200e-06 nf=1 m=2 par=2
XMpar7 out.t1 a_1014_5500.t5 vdd.t1 vdd.t0 pfet_03v3 w=3.36u l=1.25u ad=9.4080e-13 pd=3.9200e-06 as=1.1558e-12 ps=4.7200e-06 nf=1 m=10 par=10
X3 a_1014_6020.t0 a_3454_5500.t0 vss.t0 ppolyf_u_1k r_width=1u r_length=11.54u
X6 a_1014_5500.t2 a_3454_5500.t0 vss.t0 ppolyf_u_1k r_width=1u r_length=11.54u
X11 a_1014_6020.t1 out.t9 cap_mim_2f0fF c_width=11.46u c_length=11.46u
Rpar0 a_1014_5500.t0 a_1014_5500.t5 65.5487
Rpar1 a_1014_5500.t0 a_1014_5500.t2 113.5512
Rpar2 a_1014_5500.t0 a_1014_5500.t3 90.1827
Rpar3 a_1014_5500.t5 a_1014_5500.t2 72.3910
Rpar4 a_1014_5500.t5 a_1014_5500.t3 127.2224
Rpar5 a_1014_5500.t2 a_1014_5500.t3 220.3899
Rpar6 a_1014_6020.t0 a_1014_6020.t1 58.3942
Rpar7 a_4754_3547.t0 a_4754_3547.t2 69.2769
Rpar8 a_5312_1041.t0 a_5312_1041.t2 150.0435
Rpar9 a_5312_1041.t0 a_5312_1041.t3 60.5993
Rpar10 a_5312_1041.t2 a_5312_1041.t3 25.7868
Rpar11 ib ib.t0 13.2618
Rpar12 ib ib.t1 12.2950
Rpar13 ib.t0 ib.t1 31.3883
Rpar14 inn inn.t0 6.7770
Rpar15 inp inp.t0 6.8256
Rpar16 out out.t0 69.6635
Rpar17 out out.t1 60.3448
Rpar18 out out.t9 19.9723
Rpar19 out.t0 out.t1 105.5666
Rpar20 out.t0 out.t9 1075.9777
Rpar21 out.t1 out.t9 932.0481
Rpar22 vdd vdd.t0 44.2844
Rpar23 vdd vdd.t1 100.8843
Rpar24 vdd.t0 vdd.t1 3.2950
Rpar25 vss vss.t0 79.2341
Rpar26 vss vss.t1 206.2440
Rpar27 vss vss.t4 252.3217
Rpar28 vss vss.t3 229.2352
Rpar29 vss.t0 vss.t1 83.0131
Rpar30 vss.t0 vss.t4 106.0248
Rpar31 vss.t0 vss.t3 92.4859
Rpar32 vss.t1 vss.t4 76.1579
Rpar33 vss.t1 vss.t3 33.1098
Rpar34 vss.t4 vss.t3 15.1865
Cpar0 a_1014_5500.t0 vss 1.86622e-15
Cpar1 a_1014_5500.t2 vss 1.56551e-15
Cpar2 a_1014_5500.t3 vss 3.37415e-15
Cpar3 a_1014_5500.t5 vss 1.06865e-14
Cpar4 a_1014_6020.t0 vss 2.44130e-16
Cpar5 a_1014_6020.t1 vss 4.10770e-15
Cpar6 a_3454_5500.t0 vss 2.80800e-17
Cpar7 a_4754_3547.t0 vss 6.97352e-15
Cpar8 a_4754_3547.t2 vss 9.70136e-15
Cpar9 a_5312_1041.t0 vss 1.96406e-15
Cpar10 a_5312_1041.t2 vss 5.15012e-15
Cpar11 a_5312_1041.t3 vss 2.67853e-15
Cpar12 ib out 2.38410e-15
Cpar13 ib vdd 2.48920e-16
Cpar14 ib vss 3.02862e-14
Cpar15 ib.t0 vss 5.89457e-15
Cpar16 ib.t1 vss 6.02327e-16
Cpar17 inn inp 5.19900e-17
Cpar18 inn vdd 4.84600e-17
Cpar19 inn vss 2.36279e-15
Cpar20 inn.t0 vss 4.62234e-16
Cpar21 inp vdd 1.42300e-17
Cpar22 inp vss 2.38378e-15
Cpar23 inp.t0 vss 4.35253e-16
Cpar24 out vdd 7.41258e-15
Cpar25 out vss 1.64801e-14
Cpar26 out.t0 vss 5.96652e-15
Cpar27 out.t1 vss 5.07051e-15
Cpar28 out.t9 vss 5.87148e-15
Cpar29 vdd vss 5.69915e-14
Cpar30 vdd.t0 vss 1.43872e-14
Cpar31 vdd.t1 vss 8.06137e-15
.ends opamp_dut

Vdd vdd 0 1.800000
Vss vss 0 0
Ibias vdd ib 9.286000e-07
Vinp inp 0 DC 0.895000 AC 1 PWL(0 0.895000 1.151486e-08 0.895000 1.266634e-08 0.905000)
Rfb out inn 1m
Cload out 0 2.000000e-13
Xdut vdd vss inp inn out ib opamp_dut
.end
