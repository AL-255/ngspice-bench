* opa1000[0562]: 2p/pmos_5t_1v8_i500u_subth (pmos_5t, VDD=1.8V, CL=2.0pF, Iref=115.0uA)
.include "pdk_opa.inc"
.temp 27
.option gmin=1e-12 rshunt=1e12 reltol=1e-3 abstol=1e-12 vntol=1e-5 method=gear
* Post-PEX R+C extracted netlist for pmos_5t_1v8_i500u_subth
.subckt opamp_dut vdd vss inp inn out ib
XMpar0 a_1330_9799.t0 inn.t0 out.t8 vdd.t56 pfet_03v3 w=14u l=0.38u ad=4.0320e-12 pd=1.4926e-05 as=3.9760e-12 ps=1.4743e-05 nf=1 m=160 par=160
XMpar1 a_1330_9799.t0 inp.t0 a_1742_16252.t0 vdd.t56 pfet_03v3 w=14u l=0.38u ad=4.0320e-12 pd=1.4926e-05 as=3.9760e-12 ps=1.4743e-05 nf=1 m=160 par=160
XMpar2 a_1742_16252.t161 a_1742_16252.t160 vss.t1 vss.t0 nfet_03v3 w=1.99u l=0.75u ad=6.2180e-13 pd=2.8168e-06 as=5.6643e-13 ps=2.5881e-06 nf=1 m=138 par=138
XMpar3 out.t0 a_1742_16252.t160 vss.t1 vss.t0 nfet_03v3 w=1.99u l=0.75u ad=6.0334e-13 pd=2.7406e-06 as=5.9412e-13 ps=2.7025e-06 nf=1 m=138 par=138
XMpar4 ib.t1 ib.t0 vss.t114 vss.t113 nfet_03v3 w=7.36u l=0.45u ad=2.0608e-12 pd=7.9200e-06 as=2.3552e-12 ps=8.9200e-06 nf=1 m=16 par=16
XMpar5 a_1240_9591.t0 ib.t0 vss.t114 vss.t113 nfet_03v3 w=7.36u l=0.45u ad=2.0608e-12 pd=7.9200e-06 as=2.0608e-12 ps=7.9200e-06 nf=1 m=16 par=16
XMpar6 a_1330_9799.t320 a_1240_9591.t16 vdd.t1 vdd.t0 pfet_03v3 w=10u l=0.45u ad=2.8000e-12 pd=1.0560e-05 as=2.9000e-12 ps=1.0893e-05 nf=1 m=64 par=64
XMpar7 a_1240_9591.t17 a_1240_9591.t16 vdd.t1 vdd.t0 pfet_03v3 w=10u l=0.45u ad=2.8000e-12 pd=1.0560e-05 as=2.8000e-12 ps=1.0560e-05 nf=1 m=16 par=16
X659 out.t298 vss.t58 cap_mim_2f0fF c_width=16.58u c_length=16.59u
Rpar0 a_1240_9591.t0 a_1240_9591.t16 118.5494
Rpar1 a_1240_9591.t0 a_1240_9591.t17 34.8332
Rpar2 a_1240_9591.t16 a_1240_9591.t17 19.0523
Rpar3 a_1330_9799.t0 a_1330_9799.t320 49.7788
Rpar4 a_1742_16252.t0 a_1742_16252.t160 310.8200
Rpar5 a_1742_16252.t0 a_1742_16252.t161 68.8122
Rpar6 a_1742_16252.t160 a_1742_16252.t161 2.8391
Rpar7 ib ib.t0 119.0710
Rpar8 ib ib.t1 1.9287
Rpar9 ib.t0 ib.t1 18.6454
Rpar10 inn inn.t0 2.8181
Rpar11 inp inp.t0 2.8181
Rpar12 out out.t0 2.7326
Rpar13 out.t0 out.t8 95.9476
Rpar14 out.t0 out.t298 81.5096
Rpar15 out.t8 out.t298 75.6286
Rpar16 vdd vdd.t0 250.3591
Rpar17 vdd vdd.t56 19.8584
Rpar18 vdd.t0 vdd.t1 3.9101
Rpar19 vdd.t0 vdd.t56 86.4172
Rpar20 vss vss.t0 58.7415
Rpar21 vss vss.t113 1125.4203
Rpar22 vss vss.t114 4521.8041
Rpar23 vss vss.t58 536.6305
Rpar24 vss.t0 vss.t1 9.0395
Rpar25 vss.t0 vss.t113 119.0792
Rpar26 vss.t0 vss.t114 478.4513
Rpar27 vss.t0 vss.t58 57.4644
Rpar28 vss.t113 vss.t114 4.2278
Rpar29 vss.t113 vss.t58 217.9407
Rpar30 vss.t114 vss.t58 875.6597
Cpar0 a_1240_9591.t0 vss 1.79274e-14
Cpar1 a_1240_9591.t16 vss 6.90624e-14
Cpar2 a_1240_9591.t17 vss 2.81077e-14
Cpar3 a_1330_9799.t0 vss 9.52386e-13
Cpar4 a_1330_9799.t320 vss 1.42834e-13
Cpar5 a_1742_16252.t0 vss 3.12218e-13
Cpar6 a_1742_16252.t160 vss 1.55386e-13
Cpar7 a_1742_16252.t161 vss 8.80268e-14
Cpar8 ib inp 3.53000e-17
Cpar9 ib vdd 1.45920e-16
Cpar10 ib vss 4.41216e-14
Cpar11 ib.t0 vss 3.28009e-15
Cpar12 ib.t1 vss 2.66986e-15
Cpar13 inn inp 1.07080e-16
Cpar14 inn out 4.74584e-14
Cpar15 inn vdd 5.20759e-14
Cpar16 inn vss 2.19268e-14
Cpar17 inn.t0 vss 1.20713e-13
Cpar18 inp vdd 5.16813e-14
Cpar19 inp vss 2.18674e-14
Cpar20 inp.t0 vss 1.20387e-13
Cpar21 out vdd 2.18002e-14
Cpar22 out vss 1.11585e-13
Cpar23 out.t0 vss 9.28473e-14
Cpar24 out.t298 vss 1.05299e-13
Cpar25 out.t8 vss 3.53442e-13
Cpar26 vdd vss 9.48664e-13
Cpar27 vdd.t0 vss 6.49666e-14
Cpar28 vdd.t1 vss 2.83977e-14
Cpar29 vdd.t56 vss 2.60733e-13
.ends opamp_dut

Vdd vdd 0 1.800000
Vss vss 0 0
Ibias vdd ib 1.150000e-04
Vinp inp 0 DC 0.805000 AC 1 PWL(0 0.805000 3.000000e-09 0.805000 3.300000e-09 0.815000)
Rfb out inn 1m
Cload out 0 2.000000e-12
Xdut vdd vss inp inn out ib opamp_dut
.end
