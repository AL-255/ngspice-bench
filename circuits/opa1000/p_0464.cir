* opa1000[0464]: 2p/nmos_miller_1v8_0p1u_1u_weak (nmos_miller, VDD=1.8V, CL=2.0pF, Iref=0.0929uA)
.include "pdk_opa.inc"
.temp 27
.option gmin=1e-12 rshunt=1e12 reltol=1e-3 abstol=1e-12 vntol=1e-5 method=gear
* Post-PEX R+C extracted netlist for nmos_miller_1v8_0p1u_1u_weak
.subckt opamp_dut vdd vss inp inn out ib
XMpar0 a_6480_11261.t1 a_6480_11261.t0 vdd.t1 vdd.t0 pfet_03v3 w=0.98u l=3.13u ad=2.7440e-13 pd=1.5400e-06 as=2.7440e-13 ps=1.5400e-06 nf=1 m=2 par=2
XMpar1 out.t1 ib.t0 vss.t1 vss.t0 nfet_03v3 w=0.4u l=6.25u ad=1.8880e-13 pd=1.5840e-06 as=1.6320e-13 ps=1.3760e-06 nf=1 m=10 par=10
XMpar2 a_4705_2905.t0 ib.t0 vss.t1 vss.t0 nfet_03v3 w=0.4u l=6.25u ad=2.4000e-13 pd=2.0000e-06 as=1.1200e-13 ps=9.6000e-07 nf=1 m=4 par=4
XMpar3 out.t0 a_1099_13037.t5 vdd.t1 vdd.t0 pfet_03v3 w=0.98u l=3.13u ad=2.7440e-13 pd=1.5400e-06 as=3.3712e-13 ps=1.8640e-06 nf=1 m=10 par=10
XMpar4 a_1099_13037.t0 inp.t0 a_4705_2905.t4 vss.t24 nfet_03v3 w=0.5u l=4u ad=1.4000e-13 pd=1.0600e-06 as=3.0000e-13 ps=2.2000e-06 nf=1 m=2 par=2
XMpar5 a_4705_2905.t4 inn.t0 a_6480_11261.t4 vss.t24 nfet_03v3 w=0.5u l=4u ad=3.0000e-13 pd=2.2000e-06 as=1.4000e-13 ps=1.0600e-06 nf=1 m=2 par=2
XMpar6 ib.t1 ib.t0 vss.t1 vss.t0 nfet_03v3 w=0.4u l=6.25u ad=2.4000e-13 pd=2.0000e-06 as=1.1200e-13 ps=9.6000e-07 nf=1 m=2 par=2
XMpar7 a_1099_13037.t3 a_6480_11261.t0 vdd.t1 vdd.t0 pfet_03v3 w=0.98u l=3.13u ad=5.8800e-13 pd=3.1600e-06 as=2.7440e-13 ps=1.5400e-06 nf=1 m=2 par=2
X0 a_8273_8930.t0 a_12119_8410.t0 vss.t26 ppolyf_u_1k r_width=1u r_length=18.57u
X6 a_8273_7890.t0 a_12119_8410.t0 vss.t26 ppolyf_u_1k r_width=1u r_length=18.57u
X18 a_8273_9970.t1 out.t11 cap_mim_2f0fF c_width=14.37u c_length=14.36u
X19 a_8273_9970.t1 out.t11 cap_mim_2f0fF c_width=14.37u c_length=14.36u
X21 a_8273_7890.t0 a_12119_7370.t0 vss.t26 ppolyf_u_1k r_width=1u r_length=18.57u
X27 a_8273_6850.t0 a_12119_7370.t0 vss.t26 ppolyf_u_1k r_width=1u r_length=18.57u
X33 a_8273_9970.t0 a_12119_9450.t0 vss.t26 ppolyf_u_1k r_width=1u r_length=18.57u
X34 a_8273_6850.t0 a_12119_6330.t0 vss.t26 ppolyf_u_1k r_width=1u r_length=18.57u
X40 a_8273_8930.t0 a_12119_9450.t0 vss.t26 ppolyf_u_1k r_width=1u r_length=18.57u
X41 a_1099_13037.t2 a_12119_6330.t0 vss.t26 ppolyf_u_1k r_width=1u r_length=18.57u
Rpar0 a_1099_13037.t0 a_1099_13037.t5 676.9510
Rpar1 a_1099_13037.t0 a_1099_13037.t2 149.5339
Rpar2 a_1099_13037.t0 a_1099_13037.t3 486.8853
Rpar3 a_1099_13037.t5 a_1099_13037.t2 178.0063
Rpar4 a_1099_13037.t5 a_1099_13037.t3 63.9459
Rpar5 a_1099_13037.t2 a_1099_13037.t3 128.0279
Rpar6 a_4705_2905.t0 a_4705_2905.t4 55.6670
Rpar7 a_6480_11261.t0 a_6480_11261.t1 26.6709
Rpar8 a_6480_11261.t0 a_6480_11261.t4 187.5711
Rpar9 a_6480_11261.t1 a_6480_11261.t4 156.4967
Rpar10 a_8273_9970.t0 a_8273_9970.t1 66.2727
Rpar11 ib ib.t0 18.1486
Rpar12 ib ib.t1 15.7665
Rpar13 ib.t0 ib.t1 34.3541
Rpar14 inn inn.t0 3.3425
Rpar15 inp inp.t0 3.3911
Rpar16 out out.t0 49.1166
Rpar17 out out.t1 44.1520
Rpar18 out out.t11 20.7981
Rpar19 out.t0 out.t1 144.1129
Rpar20 vdd vdd.t0 42.8515
Rpar21 vdd vdd.t1 80.9004
Rpar22 vdd.t0 vdd.t1 4.4289
Rpar23 vss vss.t0 57.1445
Rpar24 vss vss.t1 1088.2224
Rpar25 vss vss.t24 97.0803
Rpar26 vss vss.t26 650.5228
Rpar27 vss.t0 vss.t1 19.4009
Rpar28 vss.t0 vss.t24 1.7593
Rpar29 vss.t0 vss.t26 10.2967
Rpar30 vss.t1 vss.t24 37.4577
Rpar31 vss.t1 vss.t26 218.0109
Rpar32 vss.t24 vss.t26 22.6935
Cpar0 a_1099_13037.t0 vss 4.71667e-15
Cpar1 a_1099_13037.t2 vss 5.89359e-15
Cpar2 a_1099_13037.t3 vss 4.27837e-15
Cpar3 a_1099_13037.t5 vss 1.61187e-14
Cpar4 a_12119_6330.t0 vss 2.67400e-17
Cpar5 a_12119_7370.t0 vss 3.00800e-17
Cpar6 a_12119_8410.t0 vss 3.00800e-17
Cpar7 a_12119_9450.t0 vss 2.64400e-17
Cpar8 a_4705_2905.t0 vss 2.01498e-14
Cpar9 a_4705_2905.t4 vss 7.42700e-15
Cpar10 a_6480_11261.t0 vss 6.36593e-15
Cpar11 a_6480_11261.t1 vss 2.70761e-15
Cpar12 a_6480_11261.t4 vss 3.99514e-15
Cpar13 a_8273_6850.t0 vss 4.42600e-17
Cpar14 a_8273_7890.t0 vss 4.16000e-17
Cpar15 a_8273_8930.t0 vss 4.31600e-17
Cpar16 a_8273_9970.t0 vss 1.02081e-16
Cpar17 a_8273_9970.t1 vss 4.55409e-15
Cpar18 ib out 2.33634e-15
Cpar19 ib vss 6.89796e-14
Cpar20 ib.t0 vss 1.11736e-14
Cpar21 ib.t1 vss 8.29296e-16
Cpar22 inn inp 5.19700e-17
Cpar23 inn vss 4.59731e-15
Cpar24 inn.t0 vss 3.46487e-16
Cpar25 inp vss 4.49161e-15
Cpar26 inp.t0 vss 3.56860e-16
Cpar27 out vdd 8.85412e-15
Cpar28 out vss 2.82328e-14
Cpar29 out.t0 vss 3.45939e-15
Cpar30 out.t1 vss 8.45450e-15
Cpar31 out.t11 vss 1.36472e-14
Cpar32 vdd vss 6.96306e-14
Cpar33 vdd.t0 vss 2.01595e-14
Cpar34 vdd.t1 vss 1.03520e-14
.ends opamp_dut

Vdd vdd 0 1.800000
Vss vss 0 0
Ibias vdd ib 9.290000e-08
Vinp inp 0 DC 0.895000 AC 1 PWL(0 0.895000 3.988233e-07 0.895000 4.387056e-07 0.905000)
Rfb out inn 1m
Cload out 0 2.000000e-12
Xdut vdd vss inp inn out ib opamp_dut
.end
