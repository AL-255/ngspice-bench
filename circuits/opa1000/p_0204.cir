* opa1000[0204]: 200f/folded_cascode_nmos_3v3_i150u_subth (folded_cascode_nmos, VDD=3.3V, CL=0.2pF, Iref=28.3333uA)
.include "pdk_opa.inc"
.temp 27
.option gmin=1e-12 rshunt=1e12 reltol=1e-3 abstol=1e-12 vntol=1e-5 method=gear
* Post-PEX R+C extracted netlist for folded_cascode_nmos_3v3_i150u_subth
.subckt opamp_dut vdd vss inp inn out ib
XMpar0 out.t6 a_7280_13328.t64 vss.t1 vss.t0 nfet_03v3 w=8.93u l=0.81u ad=2.5004e-12 pd=9.4900e-06 as=2.5004e-12 ps=9.4900e-06 nf=1 m=6 par=6
XMpar1 a_1280_1250.t112 a_9786_6424.t6 vdd.t1 vdd.t0 pfet_03v3 w=10u l=0.42u ad=2.8000e-12 pd=1.0560e-05 as=3.3333e-12 ps=1.2333e-05 nf=1 m=12 par=12
XMpar2 a_1280_1250.t48 ib.t30 a_7280_13328.t0 vdd.t26 pfet_03v3 w=8u l=0.57u ad=2.4000e-12 pd=9.1000e-06 as=2.3200e-12 ps=8.8300e-06 nf=1 m=64 par=64
XMpar3 a_1074_1250.t48 ib.t0 vss.t1 vss.t0 nfet_03v3 w=8.93u l=0.81u ad=2.5004e-12 pd=9.4900e-06 as=2.5004e-12 ps=9.4900e-06 nf=1 m=12 par=12
XMpar4 a_12334_13328.t64 a_9786_6424.t6 vdd.t1 vdd.t0 pfet_03v3 w=10u l=0.42u ad=2.8000e-12 pd=1.0560e-05 as=3.3333e-12 ps=1.2333e-05 nf=1 m=12 par=12
XMpar5 a_1074_1250.t0 inp.t0 a_1280_1250.t0 vss.t0 nfet_03v3 w=1.95u l=0.28u ad=8.6450e-13 pd=2.9179e-06 as=8.3850e-13 ps=2.8100e-06 nf=1 m=48 par=48
XMpar6 a_12334_13328.t0 ib.t30 out.t0 vdd.t26 pfet_03v3 w=8u l=0.57u ad=2.4000e-12 pd=9.1000e-06 as=2.3200e-12 ps=8.8300e-06 nf=1 m=64 par=64
XMpar7 a_7280_13328.t65 a_7280_13328.t64 vss.t1 vss.t0 nfet_03v3 w=8.93u l=0.81u ad=3.4529e-12 pd=1.2680e-05 as=2.5004e-12 ps=9.4900e-06 nf=1 m=6 par=6
XMpar8 a_1074_1250.t0 inn.t0 a_12334_13328.t76 vss.t0 nfet_03v3 w=1.95u l=0.28u ad=8.6450e-13 pd=2.9179e-06 as=8.3850e-13 ps=2.8100e-06 nf=1 m=48 par=48
XMpar9 ib.t1 ib.t0 vss.t1 vss.t0 nfet_03v3 w=8.93u l=0.81u ad=3.4529e-12 pd=1.2680e-05 as=2.5004e-12 ps=9.4900e-06 nf=1 m=6 par=6
XMpar10 a_9786_6424.t7 a_9786_6424.t6 vdd.t1 vdd.t0 pfet_03v3 w=10u l=0.42u ad=2.8000e-12 pd=1.0560e-05 as=3.8667e-12 ps=1.4107e-05 nf=1 m=6 par=6
XMpar11 a_9786_6424.t0 ib.t0 vss.t1 vss.t0 nfet_03v3 w=8.93u l=0.81u ad=2.5004e-12 pd=9.4900e-06 as=2.5004e-12 ps=9.4900e-06 nf=1 m=6 par=6
X67 out.t70 vss.t114 cap_mim_2f0fF c_width=17.75u c_length=17.75u
X224 out.t70 vss.t114 cap_mim_2f0fF c_width=17.75u c_length=17.75u
X278 out.t70 vss.t114 cap_mim_2f0fF c_width=17.75u c_length=17.75u
Rpar0 a_1074_1250.t0 a_1074_1250.t48 80.4834
Rpar1 a_12334_13328.t0 a_12334_13328.t76 123.6194
Rpar2 a_12334_13328.t0 a_12334_13328.t64 67.8633
Rpar3 a_12334_13328.t76 a_12334_13328.t64 86.6382
Rpar4 a_1280_1250.t0 a_1280_1250.t48 123.6194
Rpar5 a_1280_1250.t0 a_1280_1250.t112 86.6382
Rpar6 a_1280_1250.t48 a_1280_1250.t112 67.8633
Rpar7 a_7280_13328.t0 a_7280_13328.t64 486.5264
Rpar8 a_7280_13328.t0 a_7280_13328.t65 68.4588
Rpar9 a_7280_13328.t64 a_7280_13328.t65 18.5317
Rpar10 a_9786_6424.t0 a_9786_6424.t6 53.9887
Rpar11 a_9786_6424.t0 a_9786_6424.t7 139.4562
Rpar12 a_9786_6424.t6 a_9786_6424.t7 23.3497
Rpar13 ib ib.t0 1071.5749
Rpar14 ib ib.t1 53.0820
Rpar15 ib ib.t30 2.0905
Rpar16 ib.t0 ib.t1 16.8749
Rpar17 inn inn.t0 1.4056
Rpar18 inp inp.t0 1.4542
Rpar19 out out.t0 177.5911
Rpar20 out out.t6 72.5466
Rpar21 out out.t70 17.9080
Rpar22 out.t0 out.t6 121.3490
Rpar23 out.t0 out.t70 735.3200
Rpar24 out.t6 out.t70 300.3807
Rpar25 vdd vdd.t0 470.8106
Rpar26 vdd vdd.t1 312.2413
Rpar27 vdd vdd.t26 20.4686
Rpar28 vdd.t0 vdd.t1 2.8439
Rpar29 vdd.t0 vdd.t26 171.6335
Rpar30 vdd.t1 vdd.t26 113.8273
Rpar31 vss vss.t0 160.9751
Rpar32 vss vss.t1 339.8414
Rpar33 vss vss.t114 4560.9726
Rpar34 vss.t0 vss.t1 2.5759
Rpar35 vss.t0 vss.t114 42.3162
Rpar36 vss.t1 vss.t114 603.6895
Cpar0 a_1074_1250.t0 vss 4.31717e-14
Cpar1 a_1074_1250.t48 vss 1.97454e-14
Cpar2 a_12334_13328.t0 vss 1.00242e-13
Cpar3 a_12334_13328.t64 vss 2.64064e-14
Cpar4 a_12334_13328.t76 vss 3.04309e-14
Cpar5 a_1280_1250.t0 vss 3.01683e-14
Cpar6 a_1280_1250.t112 vss 2.61788e-14
Cpar7 a_1280_1250.t48 vss 9.93786e-14
Cpar8 a_7280_13328.t0 vss 8.16994e-14
Cpar9 a_7280_13328.t64 vss 1.78185e-14
Cpar10 a_7280_13328.t65 vss 1.53676e-14
Cpar11 a_9786_6424.t0 vss 1.01827e-14
Cpar12 a_9786_6424.t6 vss 2.22456e-14
Cpar13 a_9786_6424.t7 vss 1.02083e-14
Cpar14 ib out 1.86097e-14
Cpar15 ib vdd 5.36529e-14
Cpar16 ib vss 5.22524e-14
Cpar17 ib.t0 vss 2.44238e-14
Cpar18 ib.t1 vss 1.11696e-14
Cpar19 ib.t30 vss 8.18469e-14
Cpar20 inn inp 5.06800e-17
Cpar21 inn vss 2.60352e-14
Cpar22 inn.t0 vss 2.92036e-15
Cpar23 inp vss 2.58566e-14
Cpar24 inp.t0 vss 3.02787e-15
Cpar25 out vdd 1.09421e-14
Cpar26 out vss 3.65037e-14
Cpar27 out.t0 vss 2.26314e-14
Cpar28 out.t6 vss 3.15603e-15
Cpar29 out.t70 vss 8.88321e-14
Cpar30 vdd vss 3.82708e-13
Cpar31 vdd.t0 vss 2.92854e-14
Cpar32 vdd.t1 vss 1.82672e-14
Cpar33 vdd.t26 vss 1.08507e-13
.ends opamp_dut

Vdd vdd 0 3.300000
Vss vss 0 0
Ibias vdd ib 2.833330e-05
Vinp inp 0 DC 1.810000 AC 1 PWL(0 1.810000 3.000000e-09 1.810000 3.300000e-09 1.820000)
Rfb out inn 1m
Cload out 0 2.000000e-13
Xdut vdd vss inp inn out ib opamp_dut
.end
