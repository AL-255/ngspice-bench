* opa1000[0580]: 2p/pmos_5t_3v3_i150u_subth (pmos_5t, VDD=3.3V, CL=2.0pF, Iref=39.0uA)
.include "pdk_opa.inc"
.temp 27
.option gmin=1e-12 rshunt=1e12 reltol=1e-3 abstol=1e-12 vntol=1e-5 method=gear
* Post-PEX R+C extracted netlist for pmos_5t_3v3_i150u_subth
.subckt opamp_dut vdd vss inp inn out ib
XMpar0 ib.t1 ib.t0 vss.t66 vss.t0 nfet_03v3 w=9.43u l=0.65u ad=3.6463e-12 pd=1.3347e-05 as=2.6404e-12 ps=9.9900e-06 nf=1 m=6 par=6
XMpar1 a_1513_15987.t6 inn.t0 out.t8 vdd.t14 pfet_03v3 w=14u l=0.44u ad=4.1440e-12 pd=1.5292e-05 as=3.9200e-12 ps=1.4560e-05 nf=1 m=160 par=160
XMpar2 a_1986_1249.t161 a_1986_1249.t160 vss.t1 vss.t0 nfet_03v3 w=1.94u l=0.7u ad=6.0528e-13 pd=2.7580e-06 as=5.4320e-13 ps=2.5000e-06 nf=1 m=40 par=40
XMpar3 a_1513_15987.t6 inp.t0 a_1986_1249.t0 vdd.t14 pfet_03v3 w=14u l=0.44u ad=4.1440e-12 pd=1.5292e-05 as=3.9200e-12 ps=1.4560e-05 nf=1 m=160 par=160
XMpar4 out.t0 a_1986_1249.t160 vss.t1 vss.t0 nfet_03v3 w=1.94u l=0.7u ad=5.4320e-13 pd=2.5000e-06 as=5.4320e-13 ps=2.5000e-06 nf=1 m=40 par=40
XMpar5 a_1513_15987.t0 a_1383_15779.t6 vdd.t1 vdd.t0 pfet_03v3 w=10u l=0.65u ad=2.8000e-12 pd=1.0560e-05 as=3.0667e-12 ps=1.1447e-05 nf=1 m=24 par=24
XMpar6 a_1383_15779.t0 ib.t0 vss.t66 vss.t0 nfet_03v3 w=9.43u l=0.65u ad=2.6404e-12 pd=9.9900e-06 as=2.6404e-12 ps=9.9900e-06 nf=1 m=6 par=6
XMpar7 a_1383_15779.t7 a_1383_15779.t6 vdd.t1 vdd.t0 pfet_03v3 w=10u l=0.65u ad=2.8000e-12 pd=1.0560e-05 as=2.8000e-12 ps=1.0560e-05 nf=1 m=6 par=6
X331 out.t200 vss.t48 cap_mim_2f0fF c_width=12.99u c_length=12.99u
Rpar0 a_1383_15779.t0 a_1383_15779.t6 1386.4532
Rpar1 a_1383_15779.t0 a_1383_15779.t7 105.2539
Rpar2 a_1383_15779.t6 a_1383_15779.t7 18.8641
Rpar3 a_1513_15987.t0 a_1513_15987.t6 48.1777
Rpar4 a_1986_1249.t0 a_1986_1249.t160 344.6371
Rpar5 a_1986_1249.t0 a_1986_1249.t161 76.1789
Rpar6 a_1986_1249.t160 a_1986_1249.t161 6.7617
Rpar7 ib ib.t0 38.4082
Rpar8 ib ib.t1 2.1972
Rpar9 ib.t0 ib.t1 39.2587
Rpar10 inn inn.t0 2.9632
Rpar11 inp inp.t0 2.9632
Rpar12 out out.t0 58.2937
Rpar13 out out.t8 87.0267
Rpar14 out out.t200 14.8608
Rpar15 out.t0 out.t8 150.9384
Rpar16 vdd vdd.t0 103.9542
Rpar17 vdd vdd.t1 978.9349
Rpar18 vdd vdd.t14 116.3069
Rpar19 vdd.t0 vdd.t1 4.3940
Rpar20 vdd.t0 vdd.t14 50.8781
Rpar21 vdd.t1 vdd.t14 479.1181
Rpar22 vss vss.t0 109.8474
Rpar23 vss vss.t1 4937.0950
Rpar24 vss vss.t48 254.4052
Rpar25 vss vss.t66 1313.0396
Rpar26 vss.t0 vss.t1 9.9724
Rpar27 vss.t0 vss.t48 49.5418
Rpar28 vss.t0 vss.t66 5.0835
Rpar29 vss.t1 vss.t48 2226.6593
Rpar30 vss.t1 vss.t66 691.6708
Rpar31 vss.t48 vss.t66 592.1887
Cpar0 a_1383_15779.t0 vss 1.17817e-14
Cpar1 a_1383_15779.t6 vss 3.24482e-14
Cpar2 a_1383_15779.t7 vss 1.62837e-14
Cpar3 a_1513_15987.t0 vss 5.02228e-14
Cpar4 a_1513_15987.t6 vss 8.77760e-13
Cpar5 a_1986_1249.t0 vss 3.87905e-13
Cpar6 a_1986_1249.t160 vss 5.31693e-14
Cpar7 a_1986_1249.t161 vss 3.21145e-14
Cpar8 ib inn 1.22400e-17
Cpar9 ib out 9.51600e-17
Cpar10 ib vdd 4.24900e-17
Cpar11 ib vss 2.21668e-14
Cpar12 ib.t0 vss 1.68715e-15
Cpar13 ib.t1 vss 1.30825e-15
Cpar14 inn inp 2.04490e-16
Cpar15 inn out 5.47207e-14
Cpar16 inn vdd 5.48953e-14
Cpar17 inn vss 2.05480e-14
Cpar18 inn.t0 vss 1.38138e-13
Cpar19 inp vdd 5.49243e-14
Cpar20 inp vss 2.00890e-14
Cpar21 inp.t0 vss 1.38196e-13
Cpar22 out vdd 1.58856e-14
Cpar23 out vss 4.69248e-14
Cpar24 out.t0 vss 2.97080e-14
Cpar25 out.t200 vss 6.58781e-14
Cpar26 out.t8 vss 3.70233e-13
Cpar27 vdd vss 9.04867e-13
Cpar28 vdd.t0 vss 2.16584e-14
Cpar29 vdd.t1 vss 9.07366e-15
Cpar30 vdd.t14 vss 2.02364e-13
.ends opamp_dut

Vdd vdd 0 3.300000
Vss vss 0 0
Ibias vdd ib 3.900000e-05
Vinp inp 0 DC 1.480000 AC 1 PWL(0 1.480000 3.000000e-09 1.480000 3.300000e-09 1.490000)
Rfb out inn 1m
Cload out 0 2.000000e-12
Xdut vdd vss inp inn out ib opamp_dut
.end
