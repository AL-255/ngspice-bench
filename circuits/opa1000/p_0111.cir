* opa1000[0111]: 200f/current_reuse_3v3_i1u_subth (current_reuse, VDD=3.3V, CL=0.2pF, Iref=0.1429uA)
.include "pdk_opa.inc"
.temp 27
.option gmin=1e-12 rshunt=1e12 reltol=1e-3 abstol=1e-12 vntol=1e-5 method=gear
* Post-PEX R+C extracted netlist for current_reuse_3v3_i1u_subth
.subckt opamp_dut vdd vss inp inn out ib
XMpar0 a_1220_12197.t9 inp.t8 a_4170_8222.t0 vss.t0 nfet_03v3 w=1.68u l=3.25u ad=4.7040e-13 pd=2.2400e-06 as=7.3920e-13 ps=3.4000e-06 nf=1 m=4 par=4
XMpar1 out.t0 a_1220_12197.t14 vdd.t1 vdd.t0 pfet_03v3 w=2.4u l=1.44u ad=6.7200e-13 pd=2.9600e-06 as=8.2560e-13 ps=3.5680e-06 nf=1 m=10 par=10
XMpar2 a_1022_7969.t1 a_1022_7969.t0 vdd.t1 vdd.t0 pfet_03v3 w=2.4u l=1.44u ad=1.4400e-12 pd=6.0000e-06 as=6.7200e-13 ps=2.9600e-06 nf=1 m=1
XMpar3 a_1022_7969.t2 inn.t0 a_1310_8177.t1 vdd.t6 pfet_03v3 w=2.23u l=3.25u ad=6.2440e-13 pd=2.7900e-06 as=9.8120e-13 ps=4.2250e-06 nf=1 m=8 par=8
XMpar4 ib.t1 ib.t0 vss.t14 vss.t13 nfet_03v3 w=1.15u l=5.25u ad=6.9000e-13 pd=3.5000e-06 as=3.2200e-13 ps=1.7100e-06 nf=1 m=2 par=2
XMpar5 a_1022_7969.t10 inn.t8 a_4170_8222.t0 vss.t0 nfet_03v3 w=1.68u l=3.25u ad=4.7040e-13 pd=2.2400e-06 as=7.3920e-13 ps=3.4000e-06 nf=1 m=4 par=4
XMpar6 out.t11 ib.t0 vss.t14 vss.t13 nfet_03v3 w=1.15u l=5.25u ad=5.4280e-13 pd=2.7840e-06 as=4.6920e-13 ps=2.4260e-06 nf=1 m=10 par=10
XMpar7 a_4170_8222.t8 ib.t0 vss.t14 vss.t13 nfet_03v3 w=1.15u l=5.25u ad=6.9000e-13 pd=3.5000e-06 as=3.2200e-13 ps=1.7100e-06 nf=1 m=4 par=4
XMpar8 a_1220_12197.t1 inp.t0 a_1310_8177.t1 vdd.t6 pfet_03v3 w=2.23u l=3.25u ad=6.2440e-13 pd=2.7900e-06 as=9.8120e-13 ps=4.2250e-06 nf=1 m=8 par=8
XMpar9 a_1220_12197.t0 a_1022_7969.t0 vdd.t1 vdd.t0 pfet_03v3 w=2.4u l=1.44u ad=1.4400e-12 pd=6.0000e-06 as=6.7200e-13 ps=2.9600e-06 nf=1 m=1
XMpar10 a_1310_8177.t0 a_1022_7969.t0 vdd.t1 vdd.t0 pfet_03v3 w=2.4u l=1.44u ad=6.7200e-13 pd=2.9600e-06 as=1.4400e-12 ps=6.0000e-06 nf=1 m=2 par=2
X7 a_1220_13757.t0 a_5332_14277.t0 vss.t8 ppolyf_u_1k r_width=1u r_length=19.9u
X13 a_1220_13757.t0 a_5332_13237.t0 vss.t8 ppolyf_u_1k r_width=1u r_length=19.9u
X20 a_1220_12717.t0 a_5332_13237.t0 vss.t8 ppolyf_u_1k r_width=1u r_length=19.9u
X25 a_1220_12717.t0 a_5332_12197.t0 vss.t8 ppolyf_u_1k r_width=1u r_length=19.9u
X55 a_5332_14277.t1 out.t2 cap_mim_2f0fF c_width=17.43u c_length=17.43u
X56 a_1220_12197.t13 a_5332_12197.t0 vss.t8 ppolyf_u_1k r_width=1u r_length=19.9u
Rpar0 a_1022_7969.t0 a_1022_7969.t1 25.1709
Rpar1 a_1022_7969.t0 a_1022_7969.t10 183.7154
Rpar2 a_1022_7969.t0 a_1022_7969.t2 349.8367
Rpar3 a_1022_7969.t1 a_1022_7969.t10 228.2226
Rpar4 a_1022_7969.t1 a_1022_7969.t2 434.5887
Rpar5 a_1022_7969.t10 a_1022_7969.t2 72.8257
Rpar6 a_1220_12197.t0 a_1220_12197.t1 291.1639
Rpar7 a_1220_12197.t0 a_1220_12197.t9 112.7288
Rpar8 a_1220_12197.t0 a_1220_12197.t13 111.1950
Rpar9 a_1220_12197.t0 a_1220_12197.t14 276.5018
Rpar10 a_1220_12197.t1 a_1220_12197.t9 90.8630
Rpar11 a_1220_12197.t1 a_1220_12197.t13 392.2799
Rpar12 a_1220_12197.t1 a_1220_12197.t14 111.6267
Rpar13 a_1220_12197.t9 a_1220_12197.t13 151.8775
Rpar14 a_1220_12197.t9 a_1220_12197.t14 86.2874
Rpar15 a_1220_12197.t13 a_1220_12197.t14 372.5258
Rpar16 a_1310_8177.t0 a_1310_8177.t1 49.8991
Rpar17 a_4170_8222.t0 a_4170_8222.t8 53.5256
Rpar18 a_5332_14277.t0 a_5332_14277.t1 67.1145
Rpar19 ib ib.t0 17.8507
Rpar20 ib ib.t1 13.2828
Rpar21 ib.t0 ib.t1 30.1298
Rpar22 inn inn.t0 41.7416
Rpar23 inn inn.t8 2.1323
Rpar24 inp inp.t0 41.9810
Rpar25 inp inp.t8 2.1809
Rpar26 out out.t0 101.7226
Rpar27 out out.t11 5.9924
Rpar28 out out.t2 263.4869
Rpar29 out.t0 out.t2 76.9837
Rpar30 vdd vdd.t0 70.9489
Rpar31 vdd vdd.t1 89.4803
Rpar32 vdd vdd.t6 268.8070
Rpar33 vdd.t0 vdd.t1 3.6371
Rpar34 vdd.t0 vdd.t6 110.0391
Rpar35 vdd.t1 vdd.t6 82.5768
Rpar36 vss vss.t0 148.5643
Rpar37 vss vss.t8 578.0740
Rpar38 vss vss.t13 91.5251
Rpar39 vss vss.t14 418.9137
Rpar40 vss.t0 vss.t8 40.7229
Rpar41 vss.t0 vss.t13 110.2461
Rpar42 vss.t0 vss.t14 504.3048
Rpar43 vss.t8 vss.t13 433.0993
Rpar44 vss.t8 vss.t14 1981.8700
Rpar45 vss.t13 vss.t14 14.6833
Cpar0 a_1022_7969.t0 vss 1.06769e-14
Cpar1 a_1022_7969.t1 vss 4.99241e-15
Cpar2 a_1022_7969.t10 vss 5.86903e-15
Cpar3 a_1022_7969.t2 vss 8.89332e-15
Cpar4 a_1220_12197.t0 vss 3.27276e-15
Cpar5 a_1220_12197.t1 vss 8.84081e-15
Cpar6 a_1220_12197.t13 vss 3.39035e-15
Cpar7 a_1220_12197.t14 vss 1.42381e-14
Cpar8 a_1220_12197.t9 vss 4.15195e-15
Cpar9 a_1220_12717.t0 vss 4.19800e-17
Cpar10 a_1220_13757.t0 vss 3.93200e-17
Cpar11 a_1310_8177.t0 vss 2.75125e-15
Cpar12 a_1310_8177.t1 vss 2.04696e-14
Cpar13 a_4170_8222.t0 vss 9.75868e-15
Cpar14 a_4170_8222.t8 vss 1.88628e-14
Cpar15 a_5332_12197.t0 vss 3.84600e-17
Cpar16 a_5332_13237.t0 vss 3.80400e-17
Cpar17 a_5332_14277.t0 vss 1.17950e-16
Cpar18 a_5332_14277.t1 vss 3.50799e-15
Cpar19 ib out 2.86462e-15
Cpar20 ib vdd 1.23100e-17
Cpar21 ib vss 6.00323e-14
Cpar22 ib.t0 vss 1.05897e-14
Cpar23 ib.t1 vss 7.46080e-16
Cpar24 inn inp 1.57550e-16
Cpar25 inn out 2.03400e-17
Cpar26 inn vdd 1.19036e-14
Cpar27 inn vss 1.10191e-14
Cpar28 inn.t0 vss 1.34319e-14
Cpar29 inn.t8 vss 3.32557e-15
Cpar30 inp out 1.61980e-16
Cpar31 inp vdd 1.25302e-14
Cpar32 inp vss 1.07954e-14
Cpar33 inp.t0 vss 1.45537e-14
Cpar34 inp.t8 vss 3.64441e-15
Cpar35 out vdd 8.66449e-15
Cpar36 out vss 2.89008e-14
Cpar37 out.t0 vss 6.58550e-15
Cpar38 out.t11 vss 6.49614e-15
Cpar39 out.t2 vss 1.05957e-14
Cpar40 vdd vss 1.35720e-13
Cpar41 vdd.t0 vss 1.47654e-14
Cpar42 vdd.t1 vss 1.30921e-14
Cpar43 vdd.t6 vss 3.63472e-14
.ends opamp_dut

Vdd vdd 0 3.300000
Vss vss 0 0
Ibias vdd ib 1.429000e-07
Vinp inp 0 DC 1.645000 AC 1 PWL(0 1.645000 8.180609e-08 1.645000 8.998670e-08 1.655000)
Rfb out inn 1m
Cload out 0 2.000000e-13
Xdut vdd vss inp inn out ib opamp_dut
.end
