* opa1000[0353]: 200f/nmos_5t_1v8_i500u_subth (nmos_5t, VDD=1.8V, CL=0.2pF, Iref=125.0uA)
.include "pdk_opa.inc"
.temp 27
.option gmin=1e-12 rshunt=1e12 reltol=1e-3 abstol=1e-12 vntol=1e-5 method=gear
* Post-PEX R+C extracted netlist for nmos_5t_1v8_i500u_subth
.subckt opamp_dut vdd vss inp inn out ib
XMpar0 a_1276_10310.t320 ib.t0 vss.t82 vss.t0 nfet_03v3 w=8u l=0.45u ad=2.2400e-12 pd=8.5600e-06 as=2.3200e-12 ps=8.8300e-06 nf=1 m=64 par=64
XMpar1 a_3348_1204.t161 a_3348_1204.t160 vdd.t1 vdd.t0 pfet_03v3 w=4.69u l=0.4u ad=1.4633e-12 pd=5.7830e-06 as=1.3132e-12 ps=5.2500e-06 nf=1 m=160 par=160
XMpar2 out.t160 a_3348_1204.t160 vdd.t1 vdd.t0 pfet_03v3 w=4.69u l=0.4u ad=1.4633e-12 pd=5.7830e-06 as=1.3882e-12 ps=5.5165e-06 nf=1 m=160 par=160
XMpar3 a_1276_10310.t0 inp.t0 a_3348_1204.t0 vss.t0 nfet_03v3 w=7.07u l=0.45u ad=2.0927e-12 pd=8.0155e-06 as=1.9796e-12 ps=7.6300e-06 nf=1 m=160 par=160
XMpar4 a_1276_10310.t0 inn.t0 out.t0 vss.t0 nfet_03v3 w=7.07u l=0.45u ad=2.0927e-12 pd=8.0155e-06 as=1.9796e-12 ps=7.6300e-06 nf=1 m=160 par=160
XMpar5 ib.t1 ib.t0 vss.t82 vss.t0 nfet_03v3 w=8u l=0.45u ad=2.2400e-12 pd=8.5600e-06 as=2.2400e-12 ps=8.5600e-06 nf=1 m=16 par=16
X488 out.t320 vss.t80 cap_mim_2f0fF c_width=18.88u c_length=18.88u
Rpar0 a_1276_10310.t0 a_1276_10310.t320 46.6533
Rpar1 a_3348_1204.t0 a_3348_1204.t160 408.6583
Rpar2 a_3348_1204.t0 a_3348_1204.t161 73.5203
Rpar3 a_3348_1204.t160 a_3348_1204.t161 3.6168
Rpar4 ib ib.t0 12.7319
Rpar5 ib ib.t1 3.6621
Rpar6 inn inn.t0 2.0860
Rpar7 inp inp.t0 2.0860
Rpar8 out out.t0 61.0794
Rpar9 out out.t160 60.1520
Rpar10 out out.t320 16.3077
Rpar11 out.t0 out.t160 121.6592
Rpar12 out.t0 out.t320 469.8388
Rpar13 out.t160 out.t320 462.7047
Rpar14 vdd vdd.t0 18.9303
Rpar15 vdd.t0 vdd.t1 8.7379
Rpar16 vss vss.t0 56.2163
Rpar17 vss vss.t82 7094.7134
Rpar18 vss vss.t80 317.2275
Rpar19 vss.t0 vss.t82 3.4837
Rpar20 vss.t0 vss.t80 41.5209
Rpar21 vss.t82 vss.t80 3660.8702
Cpar0 a_1276_10310.t0 vss 4.01552e-13
Cpar1 a_1276_10310.t320 vss 8.99115e-14
Cpar2 a_3348_1204.t0 vss 2.32246e-13
Cpar3 a_3348_1204.t160 vss 2.31561e-13
Cpar4 a_3348_1204.t161 vss 2.11788e-13
Cpar5 ib inn 1.32300e-17
Cpar6 ib inp 1.87700e-17
Cpar7 ib out 3.51700e-17
Cpar8 ib vss 8.16651e-14
Cpar9 ib.t0 vss 1.35693e-14
Cpar10 ib.t1 vss 4.67314e-15
Cpar11 inn inp 2.07340e-16
Cpar12 inn out 3.60965e-14
Cpar13 inn vss 6.23134e-14
Cpar14 inn.t0 vss 5.72494e-14
Cpar15 inp vss 6.18777e-14
Cpar16 inp.t0 vss 5.72586e-14
Cpar17 out vdd 1.90620e-13
Cpar18 out vss 3.81446e-14
Cpar19 out.t0 vss 1.93067e-13
Cpar20 out.t160 vss 1.66749e-13
Cpar21 out.t320 vss 1.34690e-13
Cpar22 vdd vss 4.83037e-13
Cpar23 vdd.t0 vss 4.16301e-13
Cpar24 vdd.t1 vss 1.20591e-13
.ends opamp_dut

Vdd vdd 0 1.800000
Vss vss 0 0
Ibias vdd ib 1.250000e-04
Vinp inp 0 DC 0.895000 AC 1 PWL(0 0.895000 3.000000e-09 0.895000 3.300000e-09 0.905000)
Rfb out inn 1m
Cload out 0 2.000000e-13
Xdut vdd vss inp inn out ib opamp_dut
.end
