* opa1000[0862]: 200f/telescopic_nmos_3v3_i2u_weak (telescopic_nmos, VDD=3.3V, CL=0.2pF, Iref=0.35uA)
.include "pdk_opa.inc"
.temp 27
.option gmin=1e-12 rshunt=1e12 reltol=1e-3 abstol=1e-12 vntol=1e-5 method=gear
* Post-PEX R+C extracted netlist for telescopic_nmos_3v3_i2u_weak
.subckt opamp_dut vdd vss inp inn out ib
XMpar0 a_1864_5715.t0 inn.t0 a_1916_1249.t0 vss.t0 nfet_03v3 w=1.61u l=3u ad=6.2253e-13 pd=2.9200e-06 as=6.2253e-13 ps=2.9200e-06 nf=1 m=6 par=6
XMpar1 ib.t1 ib.t0 vss.t11 vss.t10 nfet_03v3 w=0.57u l=3.25u ad=1.5960e-13 pd=1.1300e-06 as=1.5960e-13 ps=1.1300e-06 nf=1 m=2 par=2
XMpar2 a_1047_7520.t1 a_1047_7520.t0 a_1268_5715.t6 vss.t3 nfet_03v3 w=0.6u l=1.04u ad=3.6000e-13 pd=2.4000e-06 as=3.6000e-13 ps=2.4000e-06 nf=1 m=2 par=2
XMpar3 a_3821_7728.t2 a_1047_7520.t4 out.t0 vdd.t0 pfet_03v3 w=1.37u l=1.04u ad=6.0280e-13 pd=2.9350e-06 as=3.8360e-13 ps=1.9300e-06 nf=1 m=4 par=4
XMpar4 a_1916_1249.t12 ib.t0 vss.t11 vss.t10 nfet_03v3 w=0.57u l=3.25u ad=1.5960e-13 pd=1.1300e-06 as=2.0520e-13 ps=1.4325e-06 nf=1 m=8 par=8
XMpar5 a_1268_5715.t0 inp.t0 a_1916_1249.t0 vss.t0 nfet_03v3 w=1.61u l=3u ad=6.2253e-13 pd=2.9200e-06 as=6.2253e-13 ps=2.9200e-06 nf=1 m=6 par=6
XMpar6 a_3821_7728.t0 a_1047_7520.t18 vdd.t2 vdd.t1 pfet_03v3 w=1.86u l=4.25u ad=5.2080e-13 pd=2.4200e-06 as=5.2080e-13 ps=2.4200e-06 nf=1 m=4 par=4
XMpar7 a_1047_7520.t5 a_1047_7520.t4 a_1897_7728.t0 vdd.t0 pfet_03v3 w=1.37u l=1.04u ad=3.8360e-13 pd=1.9300e-06 as=8.2200e-13 ps=3.9400e-06 nf=1 m=4 par=4
XMpar8 a_1864_5715.t6 a_1047_7520.t0 out.t2 vss.t3 nfet_03v3 w=0.6u l=1.04u ad=3.6000e-13 pd=2.4000e-06 as=1.6800e-13 ps=1.1600e-06 nf=1 m=2 par=2
XMpar9 a_1897_7728.t2 a_1047_7520.t18 vdd.t2 vdd.t1 pfet_03v3 w=1.86u l=4.25u ad=5.2080e-13 pd=2.4200e-06 as=8.1840e-13 ps=3.6700e-06 nf=1 m=4 par=4
Rpar0 a_1047_7520.t0 a_1047_7520.t1 29.7479
Rpar1 a_1047_7520.t0 a_1047_7520.t4 671.0404
Rpar2 a_1047_7520.t0 a_1047_7520.t5 349.4860
Rpar3 a_1047_7520.t0 a_1047_7520.t18 93.6581
Rpar4 a_1047_7520.t1 a_1047_7520.t4 360.2393
Rpar5 a_1047_7520.t1 a_1047_7520.t5 187.6170
Rpar6 a_1047_7520.t1 a_1047_7520.t18 50.2791
Rpar7 a_1047_7520.t4 a_1047_7520.t5 22.1973
Rpar8 a_1047_7520.t4 a_1047_7520.t18 164.9605
Rpar9 a_1047_7520.t5 a_1047_7520.t18 85.9134
Rpar10 a_1268_5715.t0 a_1268_5715.t6 51.4355
Rpar11 a_1864_5715.t0 a_1864_5715.t6 114.3963
Rpar12 a_1897_7728.t0 a_1897_7728.t2 49.7655
Rpar13 a_1916_1249.t0 a_1916_1249.t12 39.5212
Rpar14 a_3821_7728.t0 a_3821_7728.t2 52.9247
Rpar15 ib ib.t0 21.9696
Rpar16 ib ib.t1 19.4461
Rpar17 ib.t0 ib.t1 80.9731
Rpar18 inn inn.t0 2.6328
Rpar19 inp inp.t0 2.6328
Rpar20 out out.t0 6.9901
Rpar21 out out.t2 124.3217
Rpar22 out.t0 out.t2 462.2429
Rpar23 vdd vdd.t0 50.4898
Rpar24 vdd vdd.t1 27.5047
Rpar25 vdd vdd.t2 161.7847
Rpar26 vdd.t0 vdd.t1 183.6996
Rpar27 vdd.t0 vdd.t2 1080.5360
Rpar28 vdd.t1 vdd.t2 5.2107
Rpar29 vss vss.t0 204.4232
Rpar30 vss vss.t10 55.5519
Rpar31 vss vss.t11 266.5532
Rpar32 vss vss.t3 683.4557
Rpar33 vss.t0 vss.t10 2.3151
Rpar34 vss.t0 vss.t11 27.2759
Rpar35 vss.t0 vss.t3 163.0939
Rpar36 vss.t10 vss.t11 7.3530
Rpar37 vss.t10 vss.t3 43.8551
Rpar38 vss.t11 vss.t3 210.0046
Cpar0 a_1047_7520.t0 vss 3.04224e-15
Cpar1 a_1047_7520.t1 vss 2.25274e-15
Cpar2 a_1047_7520.t18 vss 2.40447e-14
Cpar3 a_1047_7520.t4 vss 6.58899e-15
Cpar4 a_1047_7520.t5 vss 2.97472e-15
Cpar5 a_1268_5715.t0 vss 6.11741e-15
Cpar6 a_1268_5715.t6 vss 2.84971e-15
Cpar7 a_1864_5715.t0 vss 7.13229e-15
Cpar8 a_1864_5715.t6 vss 4.31585e-15
Cpar9 a_1897_7728.t0 vss 5.86178e-15
Cpar10 a_1897_7728.t2 vss 9.89168e-15
Cpar11 a_1916_1249.t0 vss 9.95290e-15
Cpar12 a_1916_1249.t12 vss 5.94793e-15
Cpar13 a_3821_7728.t0 vss 1.06849e-14
Cpar14 a_3821_7728.t2 vss 6.81829e-15
Cpar15 ib inn 2.01100e-17
Cpar16 ib inp 2.00200e-17
Cpar17 ib vss 2.39509e-14
Cpar18 ib.t0 vss 3.73225e-15
Cpar19 ib.t1 vss 1.67159e-16
Cpar20 inn inp 1.04090e-16
Cpar21 inn vdd 1.03500e-17
Cpar22 inn vss 9.68431e-15
Cpar23 inn.t0 vss 2.78306e-15
Cpar24 inp vss 9.88928e-15
Cpar25 inp.t0 vss 2.76792e-15
Cpar26 out vdd 7.54906e-15
Cpar27 out vss 1.15334e-14
Cpar28 out.t0 vss 2.26541e-15
Cpar29 out.t2 vss 7.25870e-15
Cpar30 vdd vss 7.65349e-14
Cpar31 vdd.t0 vss 1.26743e-14
Cpar32 vdd.t1 vss 2.17845e-14
Cpar33 vdd.t2 vss 5.23969e-15
.ends opamp_dut

Vdd vdd 0 3.300000
Vss vss 0 0
Ibias vdd ib 3.500000e-07
Vinp inp 0 DC 1.711000 AC 1 PWL(0 1.711000 1.615123e-08 1.711000 1.776635e-08 1.721000)
Rfb out inn 1m
Cload out 0 2.000000e-13
Xdut vdd vss inp inn out ib opamp_dut
.end
