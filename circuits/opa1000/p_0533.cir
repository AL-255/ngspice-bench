* opa1000[0533]: 200f/pmos_5t_3v3_i10u_subth (pmos_5t, VDD=3.3V, CL=0.2pF, Iref=2.0uA)
.include "pdk_opa.inc"
.temp 27
.option gmin=1e-12 rshunt=1e12 reltol=1e-3 abstol=1e-12 vntol=1e-5 method=gear
* Post-PEX R+C extracted netlist for pmos_5t_3v3_i10u_subth
.subckt opamp_dut vdd vss inp inn out ib
XMpar0 a_1754_8409.t0 inp.t0 a_2054_8409.t0 vdd.t8 pfet_03v3 w=8u l=0.9u ad=2.4000e-12 pd=9.1000e-06 as=2.3200e-12 ps=8.8300e-06 nf=1 m=64 par=64
XMpar1 a_1754_8409.t0 inn.t0 out.t0 vdd.t8 pfet_03v3 w=8u l=0.9u ad=2.4000e-12 pd=9.1000e-06 as=2.3200e-12 ps=8.8300e-06 nf=1 m=64 par=64
XMpar2 a_1754_8409.t128 a_6630_3165.t2 vdd.t1 vdd.t0 pfet_03v3 w=10u l=1.5u ad=2.8000e-12 pd=1.0560e-05 as=3.6000e-12 ps=1.3220e-05 nf=1 m=8 par=8
XMpar3 out.t21 a_2054_8409.t64 vss.t1 vss.t0 nfet_03v3 w=1.9u l=1.8u ad=5.3200e-13 pd=2.4600e-06 as=6.0800e-13 ps=2.7775e-06 nf=1 m=8 par=8
XMpar4 a_2054_8409.t65 a_2054_8409.t64 vss.t1 vss.t0 nfet_03v3 w=1.9u l=1.8u ad=5.3200e-13 pd=2.4600e-06 as=6.0800e-13 ps=2.7775e-06 nf=1 m=8 par=8
XMpar5 ib.t1 ib.t0 vss.t12 vss.t0 nfet_03v3 w=3.95u l=1.5u ad=2.3700e-12 pd=9.1000e-06 as=1.1060e-12 ps=4.5100e-06 nf=1 m=2 par=2
XMpar6 a_6630_3165.t3 a_6630_3165.t2 vdd.t1 vdd.t0 pfet_03v3 w=10u l=1.5u ad=2.8000e-12 pd=1.0560e-05 as=2.8000e-12 ps=1.0560e-05 nf=1 m=2 par=2
XMpar7 a_6630_3165.t0 ib.t0 vss.t12 vss.t0 nfet_03v3 w=3.95u l=1.5u ad=1.1060e-12 pd=4.5100e-06 as=1.1060e-12 ps=4.5100e-06 nf=1 m=2 par=2
X155 out.t72 vss.t2 cap_mim_2f0fF c_width=17.75u c_length=17.75u
Rpar0 a_1754_8409.t0 a_1754_8409.t128 69.0913
Rpar1 a_2054_8409.t0 a_2054_8409.t64 229.3072
Rpar2 a_2054_8409.t0 a_2054_8409.t65 91.3300
Rpar3 a_2054_8409.t64 a_2054_8409.t65 15.9119
Rpar4 a_6630_3165.t0 a_6630_3165.t2 118.9892
Rpar5 a_6630_3165.t0 a_6630_3165.t3 64.7347
Rpar6 a_6630_3165.t2 a_6630_3165.t3 26.5646
Rpar7 ib ib.t0 19.9386
Rpar8 ib ib.t1 3.7931
Rpar9 ib.t0 ib.t1 89.5616
Rpar10 inn inn.t0 2.2184
Rpar11 inp inp.t0 2.2184
Rpar12 out out.t0 179.5382
Rpar13 out out.t21 100.4260
Rpar14 out out.t72 15.2327
Rpar15 out.t0 out.t21 87.0297
Rpar16 vdd vdd.t0 717.2614
Rpar17 vdd vdd.t1 2851.4707
Rpar18 vdd vdd.t8 53.9617
Rpar19 vdd.t0 vdd.t1 5.6341
Rpar20 vdd.t0 vdd.t8 79.6321
Rpar21 vdd.t1 vdd.t8 316.5772
Rpar22 vss vss.t0 32.7173
Rpar23 vss vss.t1 164.1635
Rpar24 vss vss.t12 361.7721
Rpar25 vss vss.t2 212.5895
Rpar26 vss.t0 vss.t1 4.4667
Rpar27 vss.t0 vss.t12 7.4550
Rpar28 vss.t0 vss.t2 70.2416
Rpar29 vss.t1 vss.t12 73.6728
Rpar30 vss.t1 vss.t2 591.5405
Rpar31 vss.t12 vss.t2 346.1748
Cpar0 a_1754_8409.t0 vss 1.72285e-13
Cpar1 a_1754_8409.t128 vss 1.59369e-14
Cpar2 a_2054_8409.t0 vss 7.39148e-14
Cpar3 a_2054_8409.t64 vss 1.76700e-14
Cpar4 a_2054_8409.t65 vss 7.03106e-15
Cpar5 a_6630_3165.t0 vss 1.92546e-15
Cpar6 a_6630_3165.t2 vss 1.99232e-14
Cpar7 a_6630_3165.t3 vss 3.99420e-15
Cpar8 ib out 2.38100e-17
Cpar9 ib vss 8.48920e-15
Cpar10 ib.t0 vss 7.96377e-16
Cpar11 ib.t1 vss 2.91378e-16
Cpar12 inn inp 9.65700e-17
Cpar13 inn out 2.34316e-14
Cpar14 inn vdd 3.32112e-14
Cpar15 inn vss 1.08651e-14
Cpar16 inn.t0 vss 6.73806e-14
Cpar17 inp out 7.71600e-17
Cpar18 inp vdd 3.27540e-14
Cpar19 inp vss 1.08714e-14
Cpar20 inp.t0 vss 6.70621e-14
Cpar21 out vdd 1.29425e-14
Cpar22 out vss 2.82177e-14
Cpar23 out.t0 vss 4.33882e-14
Cpar24 out.t21 vss 5.01537e-15
Cpar25 out.t72 vss 5.34509e-14
Cpar26 vdd vss 4.09794e-13
Cpar27 vdd.t0 vss 1.40150e-14
Cpar28 vdd.t1 vss 5.84869e-15
Cpar29 vdd.t8 vss 9.93976e-14
.ends opamp_dut

Vdd vdd 0 3.300000
Vss vss 0 0
Ibias vdd ib 2.000000e-06
Vinp inp 0 DC 1.480000 AC 1 PWL(0 1.480000 8.635521e-09 1.480000 9.499073e-09 1.490000)
Rfb out inn 1m
Cload out 0 2.000000e-13
Xdut vdd vss inp inn out ib opamp_dut
.end
