* opa1000[0279]: 200f/folded_cascode_pmos_3v3_i2u_subth (folded_cascode_pmos, VDD=3.3V, CL=0.2pF, Iref=0.3778uA)
.include "pdk_opa.inc"
.temp 27
.option gmin=1e-12 rshunt=1e12 reltol=1e-3 abstol=1e-12 vntol=1e-5 method=gear
* Post-PEX R+C extracted netlist for folded_cascode_pmos_3v3_i2u_subth
.subckt opamp_dut vdd vss inp inn out ib
XMpar0 a_1626_5799.t0 inp.t0 a_4574_10989.t0 vdd.t10 pfet_03v3 w=1.97u l=2.85u ad=6.4166e-13 pd=2.9029e-06 as=6.4166e-13 ps=2.9029e-06 nf=1 m=42 par=42
XMpar1 a_1626_5799.t0 inn.t0 a_8974_3145.t4 vdd.t10 pfet_03v3 w=1.97u l=2.85u ad=6.4166e-13 pd=2.9029e-06 as=6.4166e-13 ps=2.9029e-06 nf=1 m=42 par=42
XMpar2 ib.t1 ib.t0 vss.t6 vss.t5 nfet_03v3 w=1.8u l=3.25u ad=1.0800e-12 pd=4.8000e-06 as=5.0400e-13 ps=2.3600e-06 nf=1 m=2 par=2
XMpar3 a_1626_5799.t42 a_1746_5591.t0 vdd.t1 vdd.t0 pfet_03v3 w=5.94u l=3.4u ad=3.5640e-12 pd=1.3080e-05 as=2.6136e-12 ps=9.7900e-06 nf=1 m=4 par=4
XMpar4 a_8974_3145.t0 a_1746_5591.t6 out.t0 vss.t0 nfet_03v3 w=1.43u l=1.63u ad=8.5800e-13 pd=4.0600e-06 as=4.0040e-13 ps=1.9900e-06 nf=1 m=4 par=4
XMpar5 a_1746_5591.t1 a_1746_5591.t0 vdd.t1 vdd.t0 pfet_03v3 w=5.94u l=3.4u ad=3.5640e-12 pd=1.3080e-05 as=1.6632e-12 ps=6.5000e-06 nf=1 m=2 par=2
XMpar6 a_4574_10989.t46 ib.t0 vss.t6 vss.t5 nfet_03v3 w=1.8u l=3.25u ad=5.0400e-13 pd=2.3600e-06 as=7.9200e-13 ps=3.5800e-06 nf=1 m=4 par=4
XMpar7 a_4574_10989.t42 a_1746_5591.t6 a_7372_6630.t0 vss.t0 nfet_03v3 w=1.43u l=1.63u ad=8.5800e-13 pd=4.0600e-06 as=4.0040e-13 ps=1.9900e-06 nf=1 m=4 par=4
XMpar8 a_8974_3145.t46 ib.t0 vss.t6 vss.t5 nfet_03v3 w=1.8u l=3.25u ad=5.0400e-13 pd=2.3600e-06 as=7.9200e-13 ps=3.5800e-06 nf=1 m=4 par=4
XMpar9 a_7372_6630.t5 a_7372_6630.t4 vdd.t1 vdd.t0 pfet_03v3 w=5.94u l=3.4u ad=3.5640e-12 pd=1.3080e-05 as=1.6632e-12 ps=6.5000e-06 nf=1 m=2 par=2
XMpar10 out.t3 a_7372_6630.t4 vdd.t1 vdd.t0 pfet_03v3 w=5.94u l=3.4u ad=1.6632e-12 pd=6.5000e-06 as=1.6632e-12 ps=6.5000e-06 nf=1 m=2 par=2
XMpar11 a_1746_5591.t4 ib.t0 vss.t6 vss.t5 nfet_03v3 w=1.8u l=3.25u ad=5.0400e-13 pd=2.3600e-06 as=5.0400e-13 ps=2.3600e-06 nf=1 m=2 par=2
X45 out.t6 vss.t2 cap_mim_2f0fF c_width=18.88u c_length=18.88u
Rpar0 a_1626_5799.t0 a_1626_5799.t42 40.1676
Rpar1 a_1746_5591.t0 a_1746_5591.t1 12.2348
Rpar2 a_1746_5591.t0 a_1746_5591.t6 273.8002
Rpar3 a_1746_5591.t0 a_1746_5591.t4 361.4388
Rpar4 a_1746_5591.t1 a_1746_5591.t6 103.0006
Rpar5 a_1746_5591.t1 a_1746_5591.t4 135.9693
Rpar6 a_1746_5591.t6 a_1746_5591.t4 59.2373
Rpar7 a_4574_10989.t0 a_4574_10989.t42 95.6244
Rpar8 a_4574_10989.t0 a_4574_10989.t46 179.3719
Rpar9 a_4574_10989.t42 a_4574_10989.t46 49.3697
Rpar10 a_7372_6630.t0 a_7372_6630.t4 158.6818
Rpar11 a_7372_6630.t0 a_7372_6630.t5 41.8615
Rpar12 a_7372_6630.t4 a_7372_6630.t5 19.2386
Rpar13 a_8974_3145.t0 a_8974_3145.t4 95.6244
Rpar14 a_8974_3145.t0 a_8974_3145.t46 49.3697
Rpar15 a_8974_3145.t4 a_8974_3145.t46 179.3719
Rpar16 ib ib.t0 10.0086
Rpar17 ib ib.t1 5.2667
Rpar18 ib.t0 ib.t1 181.9938
Rpar19 inn inn.t0 1.4970
Rpar20 inp inp.t0 1.4970
Rpar21 out out.t0 92.7451
Rpar22 out out.t3 95.9467
Rpar23 out out.t6 15.9079
Rpar24 out.t0 out.t3 48.9037
Rpar25 out.t0 out.t6 727.3130
Rpar26 out.t3 out.t6 752.4205
Rpar27 vdd vdd.t0 435.4005
Rpar28 vdd vdd.t1 462.2731
Rpar29 vdd vdd.t10 23.9444
Rpar30 vdd.t0 vdd.t1 5.0567
Rpar31 vdd.t0 vdd.t10 138.7034
Rpar32 vdd.t1 vdd.t10 147.2641
Rpar33 vss vss.t0 196.6875
Rpar34 vss vss.t6 65.9069
Rpar35 vss vss.t5 61.5812
Rpar36 vss vss.t2 83.8264
Rpar37 vss.t0 vss.t6 19.2769
Rpar38 vss.t0 vss.t5 4.5023
Rpar39 vss.t0 vss.t2 384.0926
Rpar40 vss.t6 vss.t5 4.8248
Rpar41 vss.t6 vss.t2 502.5532
Rpar42 vss.t5 vss.t2 205.3341
Cpar0 a_1626_5799.t0 vss 7.76168e-14
Cpar1 a_1626_5799.t42 vss 1.65428e-14
Cpar2 a_1746_5591.t0 vss 1.80771e-14
Cpar3 a_1746_5591.t1 vss 6.29012e-15
Cpar4 a_1746_5591.t4 vss 1.78507e-15
Cpar5 a_1746_5591.t6 vss 7.49928e-15
Cpar6 a_4574_10989.t0 vss 4.70435e-14
Cpar7 a_4574_10989.t42 vss 7.69187e-15
Cpar8 a_4574_10989.t46 vss 5.69269e-15
Cpar9 a_7372_6630.t0 vss 2.24168e-15
Cpar10 a_7372_6630.t4 vss 1.33390e-14
Cpar11 a_7372_6630.t5 vss 5.10580e-15
Cpar12 a_8974_3145.t0 vss 7.67268e-15
Cpar13 a_8974_3145.t4 vss 4.69261e-14
Cpar14 a_8974_3145.t46 vss 5.67847e-15
Cpar15 ib vss 2.89187e-14
Cpar16 ib.t0 vss 3.38005e-15
Cpar17 ib.t1 vss 1.01325e-16
Cpar18 inn inp 3.08080e-16
Cpar19 inn vdd 4.53174e-14
Cpar20 inn vss 5.13643e-15
Cpar21 inn.t0 vss 6.96390e-14
Cpar22 inp vdd 4.51438e-14
Cpar23 inp vss 5.11347e-15
Cpar24 inp.t0 vss 6.95591e-14
Cpar25 out vdd 2.55239e-15
Cpar26 out vss 1.22804e-14
Cpar27 out.t0 vss 2.47799e-16
Cpar28 out.t3 vss 3.41476e-16
Cpar29 out.t6 vss 9.71903e-15
Cpar30 vdd vss 3.65509e-13
Cpar31 vdd.t0 vss 3.74090e-14
Cpar32 vdd.t1 vss 1.20454e-14
Cpar33 vdd.t10 vss 1.10939e-13
.ends opamp_dut

Vdd vdd 0 3.300000
Vss vss 0 0
Ibias vdd ib 3.778000e-07
Vinp inp 0 DC 1.381000 AC 1 PWL(0 1.381000 7.714742e-08 1.381000 8.486217e-08 1.391000)
Rfb out inn 1m
Cload out 0 2.000000e-13
Xdut vdd vss inp inn out ib opamp_dut
.end
