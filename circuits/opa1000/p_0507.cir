* opa1000[0507]: 200f/pmos_5t_1v8_i1u_weak (pmos_5t, VDD=1.8V, CL=0.2pF, Iref=0.23uA)
.include "pdk_opa.inc"
.temp 27
.option gmin=1e-12 rshunt=1e12 reltol=1e-3 abstol=1e-12 vntol=1e-5 method=gear
* Post-PEX R+C extracted netlist for pmos_5t_1v8_i1u_weak
.subckt opamp_dut vdd vss inp inn out ib
XMpar0 a_1232_6600.t4 inp.t0 a_1490_4869.t6 vdd.t12 pfet_03v3 w=1.78u l=2.4u ad=4.9840e-13 pd=2.3400e-06 as=7.8320e-13 ps=3.5500e-06 nf=1 m=4 par=4
XMpar1 a_1490_4869.t0 a_1774_1041.t0 vdd.t1 vdd.t0 pfet_03v3 w=2.01u l=4.38u ad=5.6280e-13 pd=2.5700e-06 as=1.0452e-12 ps=4.5575e-06 nf=1 m=8 par=8
XMpar2 a_1232_6600.t1 a_1232_6600.t0 vss.t1 vss.t0 nfet_03v3 w=1.08u l=6.75u ad=6.4800e-13 pd=3.3600e-06 as=3.0240e-13 ps=1.6400e-06 nf=1 m=2 par=2
XMpar3 a_1774_1041.t4 ib.t0 vss.t7 vss.t6 nfet_03v3 w=0.52u l=4.38u ad=1.4560e-13 pd=1.0800e-06 as=1.4560e-13 ps=1.0800e-06 nf=1 m=2 par=2
XMpar4 a_1490_4869.t6 inn.t0 out.t2 vdd.t12 pfet_03v3 w=1.78u l=2.4u ad=7.8320e-13 pd=3.5500e-06 as=4.9840e-13 ps=2.3400e-06 nf=1 m=4 par=4
XMpar5 a_1774_1041.t1 a_1774_1041.t0 vdd.t1 vdd.t0 pfet_03v3 w=2.01u l=4.38u ad=1.2060e-12 pd=5.2200e-06 as=5.6280e-13 ps=2.5700e-06 nf=1 m=2 par=2
XMpar6 ib.t1 ib.t0 vss.t7 vss.t6 nfet_03v3 w=0.52u l=4.38u ad=3.1200e-13 pd=2.2400e-06 as=1.4560e-13 ps=1.0800e-06 nf=1 m=2 par=2
XMpar7 out.t0 a_1232_6600.t0 vss.t1 vss.t0 nfet_03v3 w=1.08u l=6.75u ad=3.0240e-13 pd=1.6400e-06 as=3.0240e-13 ps=1.6400e-06 nf=1 m=2 par=2
Rpar0 a_1232_6600.t0 a_1232_6600.t1 21.2141
Rpar1 a_1232_6600.t0 a_1232_6600.t4 125.2529
Rpar2 a_1232_6600.t1 a_1232_6600.t4 80.3384
Rpar3 a_1490_4869.t0 a_1490_4869.t6 37.5087
Rpar4 a_1774_1041.t0 a_1774_1041.t1 11.8847
Rpar5 a_1774_1041.t0 a_1774_1041.t4 131.9430
Rpar6 a_1774_1041.t1 a_1774_1041.t4 120.4913
Rpar7 ib ib.t0 11.5761
Rpar8 ib ib.t1 8.0668
Rpar9 inn inn.t0 2.5143
Rpar10 inp inp.t0 2.5629
Rpar11 out out.t0 14.8786
Rpar12 out out.t2 34.6692
Rpar13 vdd vdd.t0 331.2873
Rpar14 vdd vdd.t1 3365.7341
Rpar15 vdd vdd.t12 69.4623
Rpar16 vdd.t0 vdd.t1 12.0941
Rpar17 vdd.t0 vdd.t12 47.5389
Rpar18 vdd.t1 vdd.t12 482.9744
Rpar19 vss vss.t0 189.5373
Rpar20 vss vss.t1 232.1238
Rpar21 vss vss.t6 81.9998
Rpar22 vss vss.t7 211.3291
Rpar23 vss.t0 vss.t1 43.2634
Rpar24 vss.t0 vss.t6 13.2047
Rpar25 vss.t0 vss.t7 46.6887
Rpar26 vss.t1 vss.t6 20.2123
Rpar27 vss.t1 vss.t7 61.8764
Rpar28 vss.t6 vss.t7 19.1486
Cpar0 a_1232_6600.t0 vss 5.66159e-15
Cpar1 a_1232_6600.t1 vss 1.31131e-15
Cpar2 a_1232_6600.t4 vss 1.11123e-15
Cpar3 a_1490_4869.t0 vss 1.60396e-14
Cpar4 a_1490_4869.t6 vss 7.53999e-15
Cpar5 a_1774_1041.t0 vss 3.17428e-14
Cpar6 a_1774_1041.t1 vss 7.16533e-15
Cpar7 a_1774_1041.t4 vss 3.33513e-15
Cpar8 ib vdd 9.73700e-17
Cpar9 ib vss 1.35121e-14
Cpar10 ib.t0 vss 1.58189e-15
Cpar11 ib.t1 vss 9.02000e-17
Cpar12 inn inp 5.13900e-17
Cpar13 inn out 5.32410e-16
Cpar14 inn vdd 5.12751e-15
Cpar15 inn vss 2.70886e-15
Cpar16 inn.t0 vss 4.11092e-15
Cpar17 inp vdd 5.26930e-15
Cpar18 inp vss 2.70184e-15
Cpar19 inp.t0 vss 4.22759e-15
Cpar20 out vdd 2.76580e-15
Cpar21 out vss 8.77951e-15
Cpar22 out.t0 vss 7.33946e-16
Cpar23 out.t2 vss 2.75344e-15
Cpar24 vdd vss 1.03826e-13
Cpar25 vdd.t0 vss 3.30834e-14
Cpar26 vdd.t1 vss 6.25365e-15
Cpar27 vdd.t12 vss 1.54380e-14
.ends opamp_dut

Vdd vdd 0 1.800000
Vss vss 0 0
Ibias vdd ib 2.300000e-07
Vinp inp 0 DC 0.805000 AC 1 PWL(0 0.805000 2.330629e-08 0.805000 2.563692e-08 0.815000)
Rfb out inn 1m
Cload out 0 2.000000e-13
Xdut vdd vss inp inn out ib opamp_dut
.end
