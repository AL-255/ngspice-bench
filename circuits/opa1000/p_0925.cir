* opa1000[0925]: 200f/telescopic_pmos_1v8_i1u_subth (telescopic_pmos, VDD=1.8V, CL=0.2pF, Iref=0.23uA)
.include "pdk_opa.inc"
.temp 27
.option gmin=1e-12 rshunt=1e12 reltol=1e-3 abstol=1e-12 vntol=1e-5 method=gear
* Post-PEX R+C extracted netlist for telescopic_pmos_1v8_i1u_subth
.subckt opamp_dut vdd vss inp inn out ib
XMpar0 a_2337_1250.t0 inp.t0 a_6806_14603.t0 vdd.t2 pfet_03v3 w=3.45u l=3.25u ad=1.1040e-12 pd=4.5212e-06 as=1.0350e-12 ps=4.2656e-06 nf=1 m=64 par=64
XMpar1 a_14734_8378.t64 vss.t38 out.t0 vdd.t27 pfet_03v3 w=1.98u l=2.13u ad=7.3543e-13 pd=3.2886e-06 as=5.9966e-13 ps=2.7271e-06 nf=1 m=28 par=28
XMpar2 a_14734_8378.t0 inn.t0 a_2337_1250.t0 vdd.t2 pfet_03v3 w=3.45u l=3.25u ad=1.0350e-12 pd=4.2656e-06 as=1.1040e-12 ps=4.5212e-06 nf=1 m=64 par=64
XMpar3 a_10870_4392.t5 a_9744_4184.t40 vss.t16 vss.t0 nfet_03v3 w=1.72u l=5.63u ad=4.8160e-13 pd=2.2800e-06 as=7.5680e-13 ps=3.4600e-06 nf=1 m=4 par=4
XMpar4 a_6806_14603.t64 vss.t38 a_9744_4184.t12 vdd.t27 pfet_03v3 w=1.98u l=2.13u ad=7.3543e-13 pd=3.2886e-06 as=5.9966e-13 ps=2.7271e-06 nf=1 m=28 par=28
XMpar5 a_2337_1250.t128 a_1287_1041.t2 vdd.t1 vdd.t0 pfet_03v3 w=7.81u l=5.25u ad=2.1868e-12 pd=8.3700e-06 as=2.8116e-12 ps=1.0483e-05 nf=1 m=8 par=8
XMpar6 a_10870_4392.t0 a_9744_4184.t0 a_9744_4184.t1 vss.t0 nfet_03v3 w=1.6u l=2.13u ad=6.1867e-13 pd=2.9067e-06 as=6.1867e-13 ps=2.9067e-06 nf=1 m=6 par=6
XMpar7 a_13102_6317.t0 a_9744_4184.t40 vss.t16 vss.t0 nfet_03v3 w=1.72u l=5.63u ad=4.8160e-13 pd=2.2800e-06 as=4.8160e-13 ps=2.2800e-06 nf=1 m=4 par=4
XMpar8 a_13102_6317.t4 a_9744_4184.t0 out.t27 vss.t0 nfet_03v3 w=1.6u l=2.13u ad=6.1867e-13 pd=2.9067e-06 as=4.4800e-13 ps=2.1600e-06 nf=1 m=6 par=6
XMpar9 ib.t1 ib.t0 vss.t5 vss.t4 nfet_03v3 w=1.84u l=5.25u ad=1.1040e-12 pd=4.8800e-06 as=5.1520e-13 ps=2.4000e-06 nf=1 m=2 par=2
XMpar10 a_1287_1041.t3 a_1287_1041.t2 vdd.t1 vdd.t0 pfet_03v3 w=7.81u l=5.25u ad=2.1868e-12 pd=8.3700e-06 as=2.1868e-12 ps=8.3700e-06 nf=1 m=2 par=2
XMpar11 a_1287_1041.t0 ib.t0 vss.t5 vss.t4 nfet_03v3 w=1.84u l=5.25u ad=5.1520e-13 pd=2.4000e-06 as=5.1520e-13 ps=2.4000e-06 nf=1 m=2 par=2
X41 out.t34 vss.t2 cap_mim_2f0fF c_width=17.91u c_length=17.91u
X99 out.t34 vss.t2 cap_mim_2f0fF c_width=17.91u c_length=17.91u
Rpar0 a_10870_4392.t0 a_10870_4392.t5 59.9218
Rpar1 a_1287_1041.t0 a_1287_1041.t2 204.4629
Rpar2 a_1287_1041.t0 a_1287_1041.t3 67.3243
Rpar3 a_1287_1041.t2 a_1287_1041.t3 26.5432
Rpar4 a_13102_6317.t0 a_13102_6317.t4 53.6876
Rpar5 a_14734_8378.t0 a_14734_8378.t64 64.3364
Rpar6 a_2337_1250.t0 a_2337_1250.t128 62.3450
Rpar7 a_6806_14603.t0 a_6806_14603.t64 64.3364
Rpar8 a_9744_4184.t0 a_9744_4184.t1 16.7876
Rpar9 a_9744_4184.t0 a_9744_4184.t12 301.7713
Rpar10 a_9744_4184.t0 a_9744_4184.t40 280.6012
Rpar11 a_9744_4184.t1 a_9744_4184.t12 111.1006
Rpar12 a_9744_4184.t1 a_9744_4184.t40 103.3066
Rpar13 a_9744_4184.t12 a_9744_4184.t40 119.7743
Rpar14 ib ib.t0 21.9753
Rpar15 ib ib.t1 5.8470
Rpar16 ib.t0 ib.t1 47.7387
Rpar17 inn inn.t0 1.3546
Rpar18 inp inp.t0 1.3546
Rpar19 out out.t0 2.6424
Rpar20 out out.t27 70.4822
Rpar21 out out.t34 185.6285
Rpar22 out.t27 out.t34 102.9611
Rpar23 vdd vdd.t0 2081.4913
Rpar24 vdd vdd.t2 20.2952
Rpar25 vdd vdd.t27 223.1144
Rpar26 vdd.t0 vdd.t1 5.9188
Rpar27 vdd.t0 vdd.t2 751.0779
Rpar28 vdd.t0 vdd.t27 123.9103
Rpar29 vdd.t1 vdd.t2 3060.8030
Rpar30 vdd.t1 vdd.t27 504.9608
Rpar31 vdd.t2 vdd.t27 80.5078
Rpar32 vss vss.t0 41.7322
Rpar33 vss vss.t4 161.3671
Rpar34 vss vss.t5 603.4326
Rpar35 vss vss.t16 556.2251
Rpar36 vss vss.t2 481.3754
Rpar37 vss vss.t38 653.4475
Rpar38 vss.t0 vss.t4 1.8010
Rpar39 vss.t0 vss.t5 10.3009
Rpar40 vss.t0 vss.t16 6.4756
Rpar41 vss.t0 vss.t2 119.7090
Rpar42 vss.t0 vss.t38 162.5002
Rpar43 vss.t4 vss.t5 34.2682
Rpar44 vss.t4 vss.t16 27.0706
Rpar45 vss.t4 vss.t2 477.3322
Rpar46 vss.t4 vss.t38 647.9590
Rpar47 vss.t5 vss.t16 150.5278
Rpar48 vss.t5 vss.t2 3062.3585
Rpar49 vss.t5 vss.t38 4157.0273
Rpar50 vss.t16 vss.t2 1382.6311
Rpar51 vss.t16 vss.t38 1876.8657
Rpar52 vss.t2 vss.t38 122.6404
Cpar0 a_10870_4392.t0 vss 5.97717e-15
Cpar1 a_10870_4392.t5 vss 6.56891e-15
Cpar2 a_1287_1041.t0 vss 2.03326e-15
Cpar3 a_1287_1041.t2 vss 4.53598e-14
Cpar4 a_1287_1041.t3 vss 3.86380e-15
Cpar5 a_13102_6317.t0 vss 8.05299e-15
Cpar6 a_13102_6317.t4 vss 7.49677e-15
Cpar7 a_14734_8378.t0 vss 7.54530e-14
Cpar8 a_14734_8378.t64 vss 2.73361e-14
Cpar9 a_2337_1250.t0 vss 1.34258e-13
Cpar10 a_2337_1250.t128 vss 2.11102e-14
Cpar11 a_6806_14603.t0 vss 7.87224e-14
Cpar12 a_6806_14603.t64 vss 2.85204e-14
Cpar13 a_9744_4184.t0 vss 8.66492e-15
Cpar14 a_9744_4184.t1 vss 2.97721e-15
Cpar15 a_9744_4184.t12 vss 1.10387e-14
Cpar16 a_9744_4184.t40 vss 1.49478e-14
Cpar17 ib vdd 3.54600e-17
Cpar18 ib vss 1.60376e-14
Cpar19 ib.t0 vss 2.02226e-15
Cpar20 ib.t1 vss 2.16824e-16
Cpar21 inn inp 2.31360e-16
Cpar22 inn vdd 7.45245e-14
Cpar23 inn vss 6.51289e-15
Cpar24 inn.t0 vss 1.24737e-13
Cpar25 inp vdd 7.53497e-14
Cpar26 inp vss 6.55384e-15
Cpar27 inp.t0 vss 1.25442e-13
Cpar28 out vdd 7.51005e-15
Cpar29 out vss 3.73764e-14
Cpar30 out.t0 vss 1.79977e-15
Cpar31 out.t27 vss 9.75879e-16
Cpar32 out.t34 vss 2.73284e-14
Cpar33 vdd vss 8.63992e-13
Cpar34 vdd.t0 vss 3.26281e-14
Cpar35 vdd.t1 vss 1.04784e-14
Cpar36 vdd.t2 vss 1.64044e-13
Cpar37 vdd.t27 vss 5.46703e-14
.ends opamp_dut

Vdd vdd 0 1.800000
Vss vss 0 0
Ibias vdd ib 2.300000e-07
Vinp inp 0 DC 0.805000 AC 1 PWL(0 0.805000 9.718666e-08 0.805000 1.069053e-07 0.815000)
Rfb out inn 1m
Cload out 0 2.000000e-13
Xdut vdd vss inp inn out ib opamp_dut
.end
